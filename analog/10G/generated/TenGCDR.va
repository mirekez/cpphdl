// SIMULATION APPROXIMATION: controlled conductances are not physical MOS devices.
// Generated from elaborated C++HDL IC purposes; all contributions coexist.
// Capacitor initialization belongs to the host analysis; declared initial voltages appear below.
`include "disciplines.vams"

module TenGCDR(Vdd, Vss, P, N, VCM, CLOCK, LOCK);
    inout Vdd, Vss, P, N, VCM, CLOCK, LOCK;
    electrical Vdd, Vss, P, N, VCM, CLOCK, LOCK;
    electrical cpphdl_n10;
    electrical cpphdl_n11;
    electrical cpphdl_n21;
    electrical cpphdl_n23;
    electrical cpphdl_n24;
    electrical cpphdl_n28;
    electrical cpphdl_n33;
    electrical cpphdl_n34;
    electrical cpphdl_n40;
    electrical cpphdl_n41;
    electrical cpphdl_n42;
    electrical cpphdl_n44;
    electrical cpphdl_n45;
    electrical cpphdl_n70;
    electrical cpphdl_n85;
    electrical cpphdl_n101;
    electrical cpphdl_n102;
    electrical cpphdl_n118;
    electrical cpphdl_n119;
    electrical cpphdl_n120;
    electrical cpphdl_n135;
    electrical cpphdl_n138;
    electrical cpphdl_n141;
    electrical cpphdl_n144;
    electrical cpphdl_n146;
    electrical cpphdl_n147;
    electrical cpphdl_n155;
    electrical cpphdl_n160;
    electrical cpphdl_n161;

    // Square-law channel, including reverse conduction. This is not a BSIM model.
    analog function real cpphdl_channel;
        input vgs, vds, beta, threshold, polarity;
        real vgs, vds, beta, threshold, polarity;
        real gate, drain, direction, overdrive, current;
        begin
            gate = polarity * vgs;
            drain = polarity * vds;
            direction = 1.0;
            if (drain < 0.0) begin
                gate = gate - drain;
                drain = -drain;
                direction = -1.0;
            end
            overdrive = gate - threshold;
            current = 0.0;
            if (overdrive > 0.0) begin
                if (drain < overdrive)
                    current = beta * (overdrive * drain - drain * drain / 2.0);
                else
                    current = beta * overdrive * overdrive / 2.0;
            end
            cpphdl_channel = polarity * direction * current;
        end
    endfunction

    analog begin
        // device 0, IC IC6, analog/basic/gm_stage.hpp:18
        I(VCM, cpphdl_n101) <+ V(VCM, cpphdl_n101) / 1000.0;
        // device 1, IC IC6, analog/basic/gm_stage.hpp:19
        I(cpphdl_n101, VCM) <+ (-0.10000000000000001) * V(P, N);
        // device 2, IC IC6, analog/basic/gm_stage.hpp:20
        I(cpphdl_n101, VCM) <+ 1.0000000000000001e-15 * ddt(V(cpphdl_n101, VCM)); // Bench initial voltage = 0.0 V.
        // device 3, IC IC6, analog/basic/gm_stage.hpp:30
        I(cpphdl_n101, Vdd) <+ max(0.0, V(cpphdl_n101, Vdd) - 0.0) / 0.10000000000000001 + V(cpphdl_n101, Vdd) / 1000000000.0;
        // device 4, IC IC6, analog/basic/gm_stage.hpp:31
        I(Vss, cpphdl_n101) <+ max(0.0, V(Vss, cpphdl_n101) - 0.0) / 0.10000000000000001 + V(Vss, cpphdl_n101) / 1000000000.0;
        // device 5, IC IC9, analog/basic/sim_clocked_storage.hpp:19
        I(cpphdl_n70, Vss) <+ (1.0 - min(1.0, max(0.0, (V(CLOCK, Vss) - 0.25) / 0.20000000000000001))) * V(cpphdl_n70, cpphdl_n101) / 25.0; // sim_buffered_track
        // device 6, IC IC9, analog/basic/sim_clocked_storage.hpp:20
        I(cpphdl_n70, Vss) <+ 5e-15 * ddt(V(cpphdl_n70, Vss)); // Bench initial voltage = 0.0 V.
        // device 7, IC IC9, analog/basic/sim_clocked_storage.hpp:21
        I(cpphdl_n70, Vss) <+ V(cpphdl_n70, Vss) / 1000000000.0;
        // device 8, IC IC10, analog/basic/sim_clocked_storage.hpp:19
        I(cpphdl_n118, Vss) <+ min(1.0, max(0.0, (V(CLOCK, Vss) - 0.75) / 0.19999999999999996)) * V(cpphdl_n118, cpphdl_n70) / 25.0; // sim_buffered_track
        // device 9, IC IC10, analog/basic/sim_clocked_storage.hpp:20
        I(cpphdl_n118, Vss) <+ 5e-15 * ddt(V(cpphdl_n118, Vss)); // Bench initial voltage = 0.0 V.
        // device 10, IC IC10, analog/basic/sim_clocked_storage.hpp:21
        I(cpphdl_n118, Vss) <+ V(cpphdl_n118, Vss) / 1000000000.0;
        // device 11, IC IC12, analog/basic/sim_clocked_storage.hpp:19
        I(cpphdl_n85, Vss) <+ min(1.0, max(0.0, (V(CLOCK, Vss) - 0.75) / 0.19999999999999996)) * V(cpphdl_n85, cpphdl_n118) / 25.0; // sim_buffered_track
        // device 12, IC IC12, analog/basic/sim_clocked_storage.hpp:20
        I(cpphdl_n85, Vss) <+ 5e-15 * ddt(V(cpphdl_n85, Vss)); // Bench initial voltage = 0.0 V.
        // device 13, IC IC12, analog/basic/sim_clocked_storage.hpp:21
        I(cpphdl_n85, Vss) <+ V(cpphdl_n85, Vss) / 1000000000.0;
        // device 14, IC IC13, analog/basic/sim_clocked_storage.hpp:19
        I(cpphdl_n120, Vss) <+ (1.0 - min(1.0, max(0.0, (V(CLOCK, Vss) - 0.25) / 0.20000000000000001))) * V(cpphdl_n120, cpphdl_n85) / 25.0; // sim_buffered_track
        // device 15, IC IC13, analog/basic/sim_clocked_storage.hpp:20
        I(cpphdl_n120, Vss) <+ 5e-15 * ddt(V(cpphdl_n120, Vss)); // Bench initial voltage = 0.0 V.
        // device 16, IC IC13, analog/basic/sim_clocked_storage.hpp:21
        I(cpphdl_n120, Vss) <+ V(cpphdl_n120, Vss) / 1000000000.0;
        // device 17, IC IC15, analog/basic/gm_stage.hpp:18
        I(Vdd, cpphdl_n102) <+ V(Vdd, cpphdl_n102) / 50.0;
        // device 18, IC IC15, analog/basic/gm_stage.hpp:19
        I(cpphdl_n102, Vdd) <+ (-0.02) * V(Vss, cpphdl_n101);
        // device 19, IC IC15, analog/basic/gm_stage.hpp:20
        I(cpphdl_n102, Vdd) <+ 1.0000000000000001e-15 * ddt(V(cpphdl_n102, Vdd)); // Bench initial voltage = 0.0 V.
        // device 20, IC IC16, analog/basic/sim_clocked_storage.hpp:63
        I(cpphdl_n10, Vss) <+ (1.0 - min(1.0, max(0.0, (V(cpphdl_n118, Vss) - 0.25) / 0.20000000000000001))) * V(cpphdl_n10, cpphdl_n101) / 25.0; // sim_buffered_track
        // device 21, IC IC16, analog/basic/sim_clocked_storage.hpp:64
        I(cpphdl_n10, Vss) <+ min(1.0, max(0.0, (V(cpphdl_n118, Vss) - 0.75) / 0.19999999999999996)) * V(cpphdl_n10, cpphdl_n102) / 25.0; // sim_buffered_track
        // device 22, IC IC16, analog/basic/sim_clocked_storage.hpp:65
        I(cpphdl_n10, Vss) <+ 2.0000000000000002e-15 * ddt(V(cpphdl_n10, Vss)); // Bench initial voltage = 0.0 V.
        // device 23, IC IC16, analog/basic/sim_clocked_storage.hpp:66
        I(cpphdl_n10, Vss) <+ V(cpphdl_n10, Vss) / 1000000000.0;
        // device 24, IC IC18, analog/basic/gm_stage.hpp:18
        I(Vdd, cpphdl_n119) <+ V(Vdd, cpphdl_n119) / 50.0;
        // device 25, IC IC18, analog/basic/gm_stage.hpp:19
        I(cpphdl_n119, Vdd) <+ (-0.02) * V(Vss, cpphdl_n118);
        // device 26, IC IC18, analog/basic/gm_stage.hpp:20
        I(cpphdl_n119, Vdd) <+ 1.0000000000000001e-15 * ddt(V(cpphdl_n119, Vdd)); // Bench initial voltage = 0.0 V.
        // device 27, IC IC19, analog/basic/sim_clocked_storage.hpp:63
        I(cpphdl_n11, Vss) <+ (1.0 - min(1.0, max(0.0, (V(cpphdl_n120, Vss) - 0.25) / 0.20000000000000001))) * V(cpphdl_n11, cpphdl_n118) / 25.0; // sim_buffered_track
        // device 28, IC IC19, analog/basic/sim_clocked_storage.hpp:64
        I(cpphdl_n11, Vss) <+ min(1.0, max(0.0, (V(cpphdl_n120, Vss) - 0.75) / 0.19999999999999996)) * V(cpphdl_n11, cpphdl_n119) / 25.0; // sim_buffered_track
        // device 29, IC IC19, analog/basic/sim_clocked_storage.hpp:65
        I(cpphdl_n11, Vss) <+ 2.0000000000000002e-15 * ddt(V(cpphdl_n11, Vss)); // Bench initial voltage = 0.0 V.
        // device 30, IC IC19, analog/basic/sim_clocked_storage.hpp:66
        I(cpphdl_n11, Vss) <+ V(cpphdl_n11, Vss) / 1000000000.0;
        // device 31, IC TenGCDR, analog/10G/pll_cdr.hpp:111
        I(cpphdl_n44, Vss) <+ (-1.0000000000000001e-05) * V(cpphdl_n10, cpphdl_n11);
        // device 32, IC TenGCDR, analog/10G/pll_cdr.hpp:112
        I(cpphdl_n44, cpphdl_n45) <+ 2.0000000000000001e-13 * ddt(V(cpphdl_n44, cpphdl_n45)); // Bench initial voltage = 0.69999999999999996 V.
        // device 33, IC TenGCDR, analog/10G/pll_cdr.hpp:113
        I(cpphdl_n45, Vss) <+ V(cpphdl_n45, Vss) / 5000.0;
        // device 34, IC TenGCDR, analog/10G/pll_cdr.hpp:114
        I(cpphdl_n44, Vss) <+ V(cpphdl_n44, Vss) / 1000000000.0;
        // device 35, IC TenGCDR, analog/10G/pll_cdr.hpp:115
        I(cpphdl_n44, cpphdl_n146) <+ V(cpphdl_n44, cpphdl_n146) / 1000.0;
        // device 36, IC TenGCDR, analog/10G/pll_cdr.hpp:116
        I(cpphdl_n146, Vss) <+ 1e-13 * ddt(V(cpphdl_n146, Vss)); // Bench initial voltage = 0.69999999999999996 V.
        // device 37, IC TenGCDR, analog/10G/pll_cdr.hpp:117
        I(cpphdl_n146, VCM) <+ max(0.0, V(cpphdl_n146, VCM) - 0.34999999999999998) / 10.0 + V(cpphdl_n146, VCM) / 1000000000.0;
        // device 38, IC TenGCDR, analog/10G/pll_cdr.hpp:118
        I(VCM, cpphdl_n146) <+ max(0.0, V(VCM, cpphdl_n146) - 0.10000000000000001) / 10.0 + V(VCM, cpphdl_n146) / 1000000000.0;
        // device 39, IC IC22, analog/basic/ring_vco.hpp:18
        I(cpphdl_n138, Vdd) <+ cpphdl_channel(V(cpphdl_n161, Vdd), V(cpphdl_n138, Vdd), 0.001, 0.34999999999999998, -1.0);
        // device 40, IC IC22, analog/basic/ring_vco.hpp:19
        I(cpphdl_n138, cpphdl_n135) <+ cpphdl_channel(V(cpphdl_n161, cpphdl_n135), V(cpphdl_n138, cpphdl_n135), 0.001, 0.34999999999999998, 1.0);
        // device 41, IC IC22, analog/basic/ring_vco.hpp:20
        I(cpphdl_n135, Vss) <+ cpphdl_channel(V(cpphdl_n146, Vss), V(cpphdl_n135, Vss), 0.001, 0.34999999999999998, 1.0);
        // device 42, IC IC22, analog/basic/ring_vco.hpp:21
        I(cpphdl_n135, Vss) <+ V(cpphdl_n135, Vss) / 1000000000.0;
        // device 43, IC IC22, analog/basic/ring_vco.hpp:22
        I(cpphdl_n138, Vss) <+ 1.02e-15 * ddt(V(cpphdl_n138, Vss)); // Bench initial voltage = 0.0 V.
        // device 44, IC IC23, analog/basic/ring_vco.hpp:18
        I(cpphdl_n144, Vdd) <+ cpphdl_channel(V(cpphdl_n138, Vdd), V(cpphdl_n144, Vdd), 0.001, 0.34999999999999998, -1.0);
        // device 45, IC IC23, analog/basic/ring_vco.hpp:19
        I(cpphdl_n144, cpphdl_n141) <+ cpphdl_channel(V(cpphdl_n138, cpphdl_n141), V(cpphdl_n144, cpphdl_n141), 0.001, 0.34999999999999998, 1.0);
        // device 46, IC IC23, analog/basic/ring_vco.hpp:20
        I(cpphdl_n141, Vss) <+ cpphdl_channel(V(cpphdl_n146, Vss), V(cpphdl_n141, Vss), 0.001, 0.34999999999999998, 1.0);
        // device 47, IC IC23, analog/basic/ring_vco.hpp:21
        I(cpphdl_n141, Vss) <+ V(cpphdl_n141, Vss) / 1000000000.0;
        // device 48, IC IC23, analog/basic/ring_vco.hpp:22
        I(cpphdl_n144, Vss) <+ 1.02e-15 * ddt(V(cpphdl_n144, Vss)); // Bench initial voltage = 0.0 V.
        // device 49, IC IC24, analog/basic/ring_vco.hpp:18
        I(cpphdl_n161, Vdd) <+ cpphdl_channel(V(cpphdl_n144, Vdd), V(cpphdl_n161, Vdd), 0.001, 0.34999999999999998, -1.0);
        // device 50, IC IC24, analog/basic/ring_vco.hpp:19
        I(cpphdl_n161, cpphdl_n147) <+ cpphdl_channel(V(cpphdl_n144, cpphdl_n147), V(cpphdl_n161, cpphdl_n147), 0.001, 0.34999999999999998, 1.0);
        // device 51, IC IC24, analog/basic/ring_vco.hpp:20
        I(cpphdl_n147, Vss) <+ cpphdl_channel(V(cpphdl_n146, Vss), V(cpphdl_n147, Vss), 0.001, 0.34999999999999998, 1.0);
        // device 52, IC IC24, analog/basic/ring_vco.hpp:21
        I(cpphdl_n147, Vss) <+ V(cpphdl_n147, Vss) / 1000000000.0;
        // device 53, IC IC24, analog/basic/ring_vco.hpp:22
        I(cpphdl_n161, Vss) <+ 1.02e-15 * ddt(V(cpphdl_n161, Vss)); // Bench initial voltage = 1.2 V.
        // device 54, IC IC28, analog/basic/gm_stage.hpp:18
        I(Vdd, cpphdl_n155) <+ V(Vdd, cpphdl_n155) / 50.0;
        // device 55, IC IC28, analog/basic/gm_stage.hpp:19
        I(cpphdl_n155, Vdd) <+ (-0.02) * V(Vss, CLOCK);
        // device 56, IC IC28, analog/basic/gm_stage.hpp:20
        I(cpphdl_n155, Vdd) <+ 1.0000000000000001e-15 * ddt(V(cpphdl_n155, Vdd)); // Bench initial voltage = 0.0 V.
        // device 57, IC IC26, analog/basic/sim_clocked_storage.hpp:19
        I(cpphdl_n160, Vss) <+ (1.0 - min(1.0, max(0.0, (V(cpphdl_n161, Vss) - 0.25) / 0.20000000000000001))) * V(cpphdl_n160, cpphdl_n155) / 25.0; // sim_buffered_track
        // device 58, IC IC26, analog/basic/sim_clocked_storage.hpp:20
        I(cpphdl_n160, Vss) <+ 5e-15 * ddt(V(cpphdl_n160, Vss)); // Bench initial voltage = 0.0 V.
        // device 59, IC IC26, analog/basic/sim_clocked_storage.hpp:21
        I(cpphdl_n160, Vss) <+ V(cpphdl_n160, Vss) / 1000000000.0;
        // device 60, IC IC27, analog/basic/sim_clocked_storage.hpp:19
        I(CLOCK, Vss) <+ min(1.0, max(0.0, (V(cpphdl_n161, Vss) - 0.75) / 0.19999999999999996)) * V(CLOCK, cpphdl_n160) / 25.0; // sim_buffered_track
        // device 61, IC IC27, analog/basic/sim_clocked_storage.hpp:20
        I(CLOCK, Vss) <+ 5e-15 * ddt(V(CLOCK, Vss)); // Bench initial voltage = 0.0 V.
        // device 62, IC IC27, analog/basic/sim_clocked_storage.hpp:21
        I(CLOCK, Vss) <+ V(CLOCK, Vss) / 1000000000.0;
        // device 63, IC IC1, analog/10G/lock_monitor.hpp:22
        I(Vss, cpphdl_n21) <+ V(Vss, cpphdl_n21) / 1000.0;
        // device 64, IC IC1, analog/10G/lock_monitor.hpp:23
        I(cpphdl_n21, Vss) <+ (-0.001) * V(cpphdl_n10, cpphdl_n11);
        // device 65, IC IC1, analog/10G/lock_monitor.hpp:24
        I(cpphdl_n21, Vss) <+ 7.757575757575757e-13 * ddt(V(cpphdl_n21, Vss)); // Bench initial voltage = 0.0 V.
        // device 66, IC IC1, analog/10G/lock_monitor.hpp:25
        I(cpphdl_n11, cpphdl_n33) <+ V(cpphdl_n11, cpphdl_n33) / 1000.0;
        // device 67, IC IC1, analog/10G/lock_monitor.hpp:26
        I(cpphdl_n33, Vss) <+ 3.8787878787878785e-13 * ddt(V(cpphdl_n33, Vss)); // Bench initial voltage = 0.0 V.
        // device 68, IC IC2, analog/basic/bridge_rectifier.hpp:14
        I(cpphdl_n21, cpphdl_n23) <+ max(0.0, V(cpphdl_n21, cpphdl_n23) - 0.0) / 10.0 + V(cpphdl_n21, cpphdl_n23) / 1000000000.0;
        // device 69, IC IC2, analog/basic/bridge_rectifier.hpp:15
        I(Vss, cpphdl_n23) <+ max(0.0, V(Vss, cpphdl_n23) - 0.0) / 10.0 + V(Vss, cpphdl_n23) / 1000000000.0;
        // device 70, IC IC2, analog/basic/bridge_rectifier.hpp:16
        I(cpphdl_n24, cpphdl_n21) <+ max(0.0, V(cpphdl_n24, cpphdl_n21) - 0.0) / 10.0 + V(cpphdl_n24, cpphdl_n21) / 1000000000.0;
        // device 71, IC IC2, analog/basic/bridge_rectifier.hpp:17
        I(cpphdl_n24, Vss) <+ max(0.0, V(cpphdl_n24, Vss) - 0.0) / 10.0 + V(cpphdl_n24, Vss) / 1000000000.0;
        // device 72, IC IC2, analog/basic/bridge_rectifier.hpp:18
        I(cpphdl_n23, cpphdl_n24) <+ V(cpphdl_n23, cpphdl_n24) / 10000.0;
        // device 73, IC IC2, analog/basic/bridge_rectifier.hpp:19
        I(cpphdl_n24, Vss) <+ V(cpphdl_n24, Vss) / 1000000000.0;
        // device 74, IC IC1, analog/10G/lock_monitor.hpp:32
        I(Vss, cpphdl_n28) <+ V(Vss, cpphdl_n28) / 1000.0;
        // device 75, IC IC1, analog/10G/lock_monitor.hpp:33
        I(cpphdl_n28, Vss) <+ (-0.001) * V(cpphdl_n23, cpphdl_n24);
        // device 76, IC IC1, analog/10G/lock_monitor.hpp:34
        I(cpphdl_n28, Vss) <+ 3.8787878787878785e-13 * ddt(V(cpphdl_n28, Vss)); // Bench initial voltage = 0.0 V.
        // device 77, IC IC1, analog/10G/lock_monitor.hpp:35
        I(VCM, cpphdl_n34) <+ V(VCM, cpphdl_n34) / 100000.0;
        // device 78, IC IC1, analog/10G/lock_monitor.hpp:36
        I(cpphdl_n34, Vss) <+ V(cpphdl_n34, Vss) / 10000.0;
        // device 79, IC IC3, analog/basic/gm_stage.hpp:18
        I(VCM, cpphdl_n40) <+ V(VCM, cpphdl_n40) / 1000.0;
        // device 80, IC IC3, analog/basic/gm_stage.hpp:19
        I(cpphdl_n40, VCM) <+ (-0.10000000000000001) * V(cpphdl_n34, cpphdl_n28);
        // device 81, IC IC3, analog/basic/gm_stage.hpp:20
        I(cpphdl_n40, VCM) <+ 1.0000000000000001e-15 * ddt(V(cpphdl_n40, VCM)); // Bench initial voltage = 0.0 V.
        // device 82, IC IC3, analog/basic/gm_stage.hpp:30
        I(cpphdl_n40, Vdd) <+ max(0.0, V(cpphdl_n40, Vdd) - 0.0) / 0.10000000000000001 + V(cpphdl_n40, Vdd) / 1000000000.0;
        // device 83, IC IC3, analog/basic/gm_stage.hpp:31
        I(Vss, cpphdl_n40) <+ max(0.0, V(Vss, cpphdl_n40) - 0.0) / 0.10000000000000001 + V(Vss, cpphdl_n40) / 1000000000.0;
        // device 84, IC IC4, analog/basic/gm_stage.hpp:18
        I(VCM, cpphdl_n41) <+ V(VCM, cpphdl_n41) / 1000.0;
        // device 85, IC IC4, analog/basic/gm_stage.hpp:19
        I(cpphdl_n41, VCM) <+ (-0.10000000000000001) * V(cpphdl_n33, cpphdl_n34);
        // device 86, IC IC4, analog/basic/gm_stage.hpp:20
        I(cpphdl_n41, VCM) <+ 1.0000000000000001e-15 * ddt(V(cpphdl_n41, VCM)); // Bench initial voltage = 0.0 V.
        // device 87, IC IC4, analog/basic/gm_stage.hpp:30
        I(cpphdl_n41, Vdd) <+ max(0.0, V(cpphdl_n41, Vdd) - 0.0) / 0.10000000000000001 + V(cpphdl_n41, Vdd) / 1000000000.0;
        // device 88, IC IC4, analog/basic/gm_stage.hpp:31
        I(Vss, cpphdl_n41) <+ max(0.0, V(Vss, cpphdl_n41) - 0.0) / 0.10000000000000001 + V(Vss, cpphdl_n41) / 1000000000.0;
        // device 89, IC IC5, analog/basic/sim_clocked_storage.hpp:63
        I(cpphdl_n42, Vss) <+ (1.0 - min(1.0, max(0.0, (V(cpphdl_n41, Vss) - 0.25) / 0.20000000000000001))) * V(cpphdl_n42, Vss) / 25.0; // sim_buffered_track
        // device 90, IC IC5, analog/basic/sim_clocked_storage.hpp:64
        I(cpphdl_n42, Vss) <+ min(1.0, max(0.0, (V(cpphdl_n41, Vss) - 0.75) / 0.19999999999999996)) * V(cpphdl_n42, cpphdl_n40) / 25.0; // sim_buffered_track
        // device 91, IC IC5, analog/basic/sim_clocked_storage.hpp:65
        I(cpphdl_n42, Vss) <+ 2.0000000000000002e-15 * ddt(V(cpphdl_n42, Vss)); // Bench initial voltage = 0.0 V.
        // device 92, IC IC5, analog/basic/sim_clocked_storage.hpp:66
        I(cpphdl_n42, Vss) <+ V(cpphdl_n42, Vss) / 1000000000.0;
        // device 93, IC IC1, analog/10G/lock_monitor.hpp:56
        I(cpphdl_n42, LOCK) <+ V(cpphdl_n42, LOCK) / 1000.0;
        // device 94, IC IC1, analog/10G/lock_monitor.hpp:57
        I(LOCK, Vss) <+ 3.8787878787878785e-13 * ddt(V(LOCK, Vss)); // Bench initial voltage = 0.0 V.
    end
endmodule
