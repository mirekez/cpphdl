// SIMULATION APPROXIMATION: controlled conductances are not physical MOS devices.
// Generated from elaborated C++HDL IC purposes; all contributions coexist.
// Capacitor initialization belongs to the host analysis; declared initial voltages appear below.
`include "disciplines.vams"

module TenGVCO(Vdd, Vss, CONTROL, OUT);
    inout Vdd, Vss, CONTROL, OUT;
    electrical Vdd, Vss, CONTROL, OUT;
    electrical cpphdl_n14;
    electrical cpphdl_n17;
    electrical cpphdl_n20;
    electrical cpphdl_n23;
    electrical cpphdl_n26;
    electrical cpphdl_n34;
    electrical cpphdl_n39;
    electrical cpphdl_n40;

    // Square-law channel, including reverse conduction. This is not a BSIM model.
    analog function real cpphdl_channel;
        input vgs, vds, beta, threshold, polarity;
        real vgs, vds, beta, threshold, polarity;
        real gate, drain, direction, overdrive, current;
        begin
            gate = polarity * vgs;
            drain = polarity * vds;
            direction = 1.0;
            if (drain < 0.0) begin
                gate = gate - drain;
                drain = -drain;
                direction = -1.0;
            end
            overdrive = gate - threshold;
            current = 0.0;
            if (overdrive > 0.0) begin
                if (drain < overdrive)
                    current = beta * (overdrive * drain - drain * drain / 2.0);
                else
                    current = beta * overdrive * overdrive / 2.0;
            end
            cpphdl_channel = polarity * direction * current;
        end
    endfunction

    analog begin
        // device 0, IC IC2, analog/basic/ring_vco.hpp:18
        I(cpphdl_n17, Vdd) <+ cpphdl_channel(V(cpphdl_n40, Vdd), V(cpphdl_n17, Vdd), 0.001, 0.34999999999999998, -1.0);
        // device 1, IC IC2, analog/basic/ring_vco.hpp:19
        I(cpphdl_n17, cpphdl_n14) <+ cpphdl_channel(V(cpphdl_n40, cpphdl_n14), V(cpphdl_n17, cpphdl_n14), 0.001, 0.34999999999999998, 1.0);
        // device 2, IC IC2, analog/basic/ring_vco.hpp:20
        I(cpphdl_n14, Vss) <+ cpphdl_channel(V(CONTROL, Vss), V(cpphdl_n14, Vss), 0.001, 0.34999999999999998, 1.0);
        // device 3, IC IC2, analog/basic/ring_vco.hpp:21
        I(cpphdl_n14, Vss) <+ V(cpphdl_n14, Vss) / 1000000000.0;
        // device 4, IC IC2, analog/basic/ring_vco.hpp:22
        I(cpphdl_n17, Vss) <+ 1.02e-15 * ddt(V(cpphdl_n17, Vss)); // Bench initial voltage = 0.0 V.
        // device 5, IC IC3, analog/basic/ring_vco.hpp:18
        I(cpphdl_n23, Vdd) <+ cpphdl_channel(V(cpphdl_n17, Vdd), V(cpphdl_n23, Vdd), 0.001, 0.34999999999999998, -1.0);
        // device 6, IC IC3, analog/basic/ring_vco.hpp:19
        I(cpphdl_n23, cpphdl_n20) <+ cpphdl_channel(V(cpphdl_n17, cpphdl_n20), V(cpphdl_n23, cpphdl_n20), 0.001, 0.34999999999999998, 1.0);
        // device 7, IC IC3, analog/basic/ring_vco.hpp:20
        I(cpphdl_n20, Vss) <+ cpphdl_channel(V(CONTROL, Vss), V(cpphdl_n20, Vss), 0.001, 0.34999999999999998, 1.0);
        // device 8, IC IC3, analog/basic/ring_vco.hpp:21
        I(cpphdl_n20, Vss) <+ V(cpphdl_n20, Vss) / 1000000000.0;
        // device 9, IC IC3, analog/basic/ring_vco.hpp:22
        I(cpphdl_n23, Vss) <+ 1.02e-15 * ddt(V(cpphdl_n23, Vss)); // Bench initial voltage = 0.0 V.
        // device 10, IC IC4, analog/basic/ring_vco.hpp:18
        I(cpphdl_n40, Vdd) <+ cpphdl_channel(V(cpphdl_n23, Vdd), V(cpphdl_n40, Vdd), 0.001, 0.34999999999999998, -1.0);
        // device 11, IC IC4, analog/basic/ring_vco.hpp:19
        I(cpphdl_n40, cpphdl_n26) <+ cpphdl_channel(V(cpphdl_n23, cpphdl_n26), V(cpphdl_n40, cpphdl_n26), 0.001, 0.34999999999999998, 1.0);
        // device 12, IC IC4, analog/basic/ring_vco.hpp:20
        I(cpphdl_n26, Vss) <+ cpphdl_channel(V(CONTROL, Vss), V(cpphdl_n26, Vss), 0.001, 0.34999999999999998, 1.0);
        // device 13, IC IC4, analog/basic/ring_vco.hpp:21
        I(cpphdl_n26, Vss) <+ V(cpphdl_n26, Vss) / 1000000000.0;
        // device 14, IC IC4, analog/basic/ring_vco.hpp:22
        I(cpphdl_n40, Vss) <+ 1.02e-15 * ddt(V(cpphdl_n40, Vss)); // Bench initial voltage = 1.2 V.
        // device 15, IC IC8, analog/basic/gm_stage.hpp:18
        I(Vdd, cpphdl_n34) <+ V(Vdd, cpphdl_n34) / 50.0;
        // device 16, IC IC8, analog/basic/gm_stage.hpp:19
        I(cpphdl_n34, Vdd) <+ (-0.02) * V(Vss, OUT);
        // device 17, IC IC8, analog/basic/gm_stage.hpp:20
        I(cpphdl_n34, Vdd) <+ 1.0000000000000001e-15 * ddt(V(cpphdl_n34, Vdd)); // Bench initial voltage = 0.0 V.
        // device 18, IC IC6, analog/basic/sim_clocked_storage.hpp:19
        I(cpphdl_n39, Vss) <+ (1.0 - min(1.0, max(0.0, (V(cpphdl_n40, Vss) - 0.25) / 0.20000000000000001))) * V(cpphdl_n39, cpphdl_n34) / 25.0; // sim_buffered_track
        // device 19, IC IC6, analog/basic/sim_clocked_storage.hpp:20
        I(cpphdl_n39, Vss) <+ 5e-15 * ddt(V(cpphdl_n39, Vss)); // Bench initial voltage = 0.0 V.
        // device 20, IC IC6, analog/basic/sim_clocked_storage.hpp:21
        I(cpphdl_n39, Vss) <+ V(cpphdl_n39, Vss) / 1000000000.0;
        // device 21, IC IC7, analog/basic/sim_clocked_storage.hpp:19
        I(OUT, Vss) <+ min(1.0, max(0.0, (V(cpphdl_n40, Vss) - 0.75) / 0.19999999999999996)) * V(OUT, cpphdl_n39) / 25.0; // sim_buffered_track
        // device 22, IC IC7, analog/basic/sim_clocked_storage.hpp:20
        I(OUT, Vss) <+ 5e-15 * ddt(V(OUT, Vss)); // Bench initial voltage = 0.0 V.
        // device 23, IC IC7, analog/basic/sim_clocked_storage.hpp:21
        I(OUT, Vss) <+ V(OUT, Vss) / 1000000000.0;
    end
endmodule
