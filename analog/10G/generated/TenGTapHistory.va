// SIMULATION APPROXIMATION: controlled conductances are not physical MOS devices.
// Generated from elaborated C++HDL IC purposes; all contributions coexist.
// Capacitor initialization belongs to the host analysis; declared initial voltages appear below.
`include "disciplines.vams"

module TenGTapHistory(Vdd, Vss, IN, CLOCK, PRE, MAIN, POST);
    inout Vdd, Vss, IN, CLOCK, PRE, MAIN, POST;
    electrical Vdd, Vss, IN, CLOCK, PRE, MAIN, POST;
    electrical cpphdl_n17;
    electrical cpphdl_n32;
    electrical cpphdl_n47;

    analog begin
        // device 0, IC IC2, analog/basic/sim_clocked_storage.hpp:19
        I(cpphdl_n17, Vss) <+ (1.0 - min(1.0, max(0.0, (V(CLOCK, Vss) - 0.25) / 0.20000000000000001))) * V(cpphdl_n17, IN) / 25.0; // sim_buffered_track
        // device 1, IC IC2, analog/basic/sim_clocked_storage.hpp:20
        I(cpphdl_n17, Vss) <+ 5e-15 * ddt(V(cpphdl_n17, Vss)); // Bench initial voltage = 0.0 V.
        // device 2, IC IC2, analog/basic/sim_clocked_storage.hpp:21
        I(cpphdl_n17, Vss) <+ V(cpphdl_n17, Vss) / 1000000000.0;
        // device 3, IC IC3, analog/basic/sim_clocked_storage.hpp:19
        I(PRE, Vss) <+ min(1.0, max(0.0, (V(CLOCK, Vss) - 0.75) / 0.19999999999999996)) * V(PRE, cpphdl_n17) / 25.0; // sim_buffered_track
        // device 4, IC IC3, analog/basic/sim_clocked_storage.hpp:20
        I(PRE, Vss) <+ 5e-15 * ddt(V(PRE, Vss)); // Bench initial voltage = 0.0 V.
        // device 5, IC IC3, analog/basic/sim_clocked_storage.hpp:21
        I(PRE, Vss) <+ V(PRE, Vss) / 1000000000.0;
        // device 6, IC IC5, analog/basic/sim_clocked_storage.hpp:19
        I(cpphdl_n32, Vss) <+ (1.0 - min(1.0, max(0.0, (V(CLOCK, Vss) - 0.25) / 0.20000000000000001))) * V(cpphdl_n32, PRE) / 25.0; // sim_buffered_track
        // device 7, IC IC5, analog/basic/sim_clocked_storage.hpp:20
        I(cpphdl_n32, Vss) <+ 5e-15 * ddt(V(cpphdl_n32, Vss)); // Bench initial voltage = 0.0 V.
        // device 8, IC IC5, analog/basic/sim_clocked_storage.hpp:21
        I(cpphdl_n32, Vss) <+ V(cpphdl_n32, Vss) / 1000000000.0;
        // device 9, IC IC6, analog/basic/sim_clocked_storage.hpp:19
        I(MAIN, Vss) <+ min(1.0, max(0.0, (V(CLOCK, Vss) - 0.75) / 0.19999999999999996)) * V(MAIN, cpphdl_n32) / 25.0; // sim_buffered_track
        // device 10, IC IC6, analog/basic/sim_clocked_storage.hpp:20
        I(MAIN, Vss) <+ 5e-15 * ddt(V(MAIN, Vss)); // Bench initial voltage = 0.0 V.
        // device 11, IC IC6, analog/basic/sim_clocked_storage.hpp:21
        I(MAIN, Vss) <+ V(MAIN, Vss) / 1000000000.0;
        // device 12, IC IC8, analog/basic/sim_clocked_storage.hpp:19
        I(cpphdl_n47, Vss) <+ (1.0 - min(1.0, max(0.0, (V(CLOCK, Vss) - 0.25) / 0.20000000000000001))) * V(cpphdl_n47, MAIN) / 25.0; // sim_buffered_track
        // device 13, IC IC8, analog/basic/sim_clocked_storage.hpp:20
        I(cpphdl_n47, Vss) <+ 5e-15 * ddt(V(cpphdl_n47, Vss)); // Bench initial voltage = 0.0 V.
        // device 14, IC IC8, analog/basic/sim_clocked_storage.hpp:21
        I(cpphdl_n47, Vss) <+ V(cpphdl_n47, Vss) / 1000000000.0;
        // device 15, IC IC9, analog/basic/sim_clocked_storage.hpp:19
        I(POST, Vss) <+ min(1.0, max(0.0, (V(CLOCK, Vss) - 0.75) / 0.19999999999999996)) * V(POST, cpphdl_n47) / 25.0; // sim_buffered_track
        // device 16, IC IC9, analog/basic/sim_clocked_storage.hpp:20
        I(POST, Vss) <+ 5e-15 * ddt(V(POST, Vss)); // Bench initial voltage = 0.0 V.
        // device 17, IC IC9, analog/basic/sim_clocked_storage.hpp:21
        I(POST, Vss) <+ V(POST, Vss) / 1000000000.0;
    end
endmodule
