// Generated from elaborated C++HDL IC purposes; all contributions coexist.
// Capacitor initialization belongs to the host analysis; declared initial voltages appear below.
`include "disciplines.vams"

module Example_regulator_nominal(n0, n21, n22, n25, n26, n28, n29);
    inout n0, n21, n22, n25, n26, n28, n29;
    electrical n0, n21, n22, n25, n26, n28, n29;

    // Square-law channel, including reverse conduction. This is not a BSIM model.
    analog function real cpphdl_channel;
        input vgs, vds, beta, threshold, polarity;
        real vgs, vds, beta, threshold, polarity;
        real gate, drain, direction, overdrive, current;
        begin
            gate = polarity * vgs;
            drain = polarity * vds;
            direction = 1.0;
            if (drain < 0.0) begin
                gate = gate - drain;
                drain = -drain;
                direction = -1.0;
            end
            overdrive = gate - threshold;
            current = 0.0;
            if (overdrive > 0.0) begin
                if (drain < overdrive)
                    current = beta * (overdrive * drain - drain * drain / 2.0);
                else
                    current = beta * overdrive * overdrive / 2.0;
            end
            cpphdl_channel = polarity * direction * current;
        end
    endfunction

    analog begin
        // device 2, analog/examples/regulator/main.cpp:10
        I(n21, n0) <+ 1.0000000000000001e-07 * ddt(V(n21, n0)); // Bench initial voltage = 0.0 V.
        // device 3, IC supply, analog/basic/regulator.hpp:15
        I(n21, n26) <+ cpphdl_channel(V(n29, n26), V(n21, n26), 0.02, 0.34999999999999998, -1.0);
        // device 4, IC IC2, analog/basic/nmos_differential_pair.hpp:16
        I(n28, n25) <+ cpphdl_channel(V(n21, n25), V(n28, n25), 0.20000000000000001, 0.34999999999999998, 1.0);
        // device 5, IC IC2, analog/basic/nmos_differential_pair.hpp:17
        I(n29, n25) <+ cpphdl_channel(V(n22, n25), V(n29, n25), 0.20000000000000001, 0.34999999999999998, 1.0);
        // device 6, IC IC1, analog/basic/opamp.hpp:31
        I(n25, n0) <+ V(n25, n0) / 10.0;
        // device 7, IC IC3, analog/basic/pmos_current_mirror.hpp:14
        I(n28, n26) <+ cpphdl_channel(V(n28, n26), V(n28, n26), 0.20000000000000001, 0.34999999999999998, -1.0);
        // device 8, IC IC3, analog/basic/pmos_current_mirror.hpp:15
        I(n29, n26) <+ cpphdl_channel(V(n28, n26), V(n29, n26), 0.20000000000000001, 0.34999999999999998, -1.0);
        // device 9, IC IC3, analog/basic/pmos_current_mirror.hpp:16
        I(n28, n26) <+ V(n28, n26) / 1000000000.0;
        // device 10, IC IC1, analog/basic/opamp.hpp:39
        I(n29, n0) <+ 1e-08 * ddt(V(n29, n0)); // Bench initial voltage = 0.0 V.
        // device 11, IC IC1, analog/basic/opamp.hpp:40
        I(n29, n0) <+ V(n29, n0) / 100000.0;
        // device 12, analog/examples/regulator/main.cpp:20
        I(n21, n0) <+ V(n21, n0) / 100.0;
    end
endmodule
