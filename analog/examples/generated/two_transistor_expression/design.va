// Generated from elaborated C++HDL IC purposes; all contributions coexist.
// Capacitor initialization belongs to the host analysis; declared initial voltages appear below.
`include "disciplines.vams"

module Example_two_transistor_expression_nominal(n0, n9, n13, n15, n16);
    inout n0, n9, n13, n15, n16;
    electrical n0, n9, n13, n15, n16;

    // Square-law channel, including reverse conduction. This is not a BSIM model.
    analog function real cpphdl_channel;
        input vgs, vds, beta, threshold, polarity;
        real vgs, vds, beta, threshold, polarity;
        real gate, drain, direction, overdrive, current;
        begin
            gate = polarity * vgs;
            drain = polarity * vds;
            direction = 1.0;
            if (drain < 0.0) begin
                gate = gate - drain;
                drain = -drain;
                direction = -1.0;
            end
            overdrive = gate - threshold;
            current = 0.0;
            if (overdrive > 0.0) begin
                if (drain < overdrive)
                    current = beta * (overdrive * drain - drain * drain / 2.0);
                else
                    current = beta * overdrive * overdrive / 2.0;
            end
            cpphdl_channel = polarity * direction * current;
        end
    endfunction

    analog begin
        // device 2, IC wire_output, analog/examples/two_transistor_expression/main.cpp:10
        I(n9, n13) <+ cpphdl_channel(V(n15, n13), V(n9, n13), 0.001, 0.34999999999999998, -1.0);
        // device 3, IC wire_output, analog/examples/two_transistor_expression/main.cpp:11
        I(n9, n0) <+ cpphdl_channel(V(n15, n0), V(n9, n0), 0.001, 0.34999999999999998, 1.0);
        // device 4, analog/examples/two_transistor_expression/main.cpp:40
        I(n9, n0) <+ 9.9999999999999994e-12 * ddt(V(n9, n0)); // Bench initial voltage = 0.0 V.
        // device 5, analog/examples/two_transistor_expression/main.cpp:15
        I(n16, n0) <+ 9.9999999999999994e-12 * ddt(V(n16, n0)); // Bench initial voltage = 0.0 V.
        // device 6, IC active_output, analog/examples/two_transistor_expression/main.cpp:22
        I(n16, n13) <+ cpphdl_channel(V(n15, n13), V(n16, n13), 0.001, 0.34999999999999998, -1.0);
        // device 7, IC active_output, analog/examples/two_transistor_expression/main.cpp:23
        I(n16, n0) <+ cpphdl_channel(V(n15, n0), V(n16, n0), 0.001, 0.34999999999999998, 1.0);
    end
endmodule
