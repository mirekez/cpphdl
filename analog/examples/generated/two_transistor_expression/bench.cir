C++HDL Verilog-A independent transient experiment
* Sources, initial charges and observations come from the same elaborated C++ bench.
.model CircuitModel Example_two_transistor_expression_nominal
Ndesign 0 n9 n13 n15 n16 CircuitModel
Vsource0 n13 0 DC 1.2
Vsource1 n15 0 PWL(0 0.0 1.9999999999999999e-06 0.0 1.9999999999999999e-06 1.2 3.9999999999999998e-06 1.2)
.ic V(n9)=0.0
.ic V(n13)=1.2
.ic V(n15)=0.0
.ic V(n16)=0.0
.options method=gear maxord=2 reltol=1e-5 abstol=1e-12 vntol=1e-8 trtol=7
.control
pre_osdi design.osdi
set noaskquit
set wr_singlescale
set wr_vecnames
set numdgt=17
tran 1e-08 3.9999999999999998e-06 0 1e-08 uic
let observation0 = v(n9)
let observation1 = v(n16)
wrdata spice.dat observation0 observation1
quit
.endc
.end
