// Generated from elaborated C++HDL IC purposes; all contributions coexist.
// Capacitor initialization belongs to the host analysis; declared initial voltages appear below.
`include "disciplines.vams"

module ActiveOutput(Vdd, Vss, A, Y);
    inout Vdd, Vss, A, Y;
    electrical Vdd, Vss, A, Y;

    // Square-law channel, including reverse conduction. This is not a BSIM model.
    analog function real cpphdl_channel;
        input vgs, vds, beta, threshold, polarity;
        real vgs, vds, beta, threshold, polarity;
        real gate, drain, direction, overdrive, current;
        begin
            gate = polarity * vgs;
            drain = polarity * vds;
            direction = 1.0;
            if (drain < 0.0) begin
                gate = gate - drain;
                drain = -drain;
                direction = -1.0;
            end
            overdrive = gate - threshold;
            current = 0.0;
            if (overdrive > 0.0) begin
                if (drain < overdrive)
                    current = beta * (overdrive * drain - drain * drain / 2.0);
                else
                    current = beta * overdrive * overdrive / 2.0;
            end
            cpphdl_channel = polarity * direction * current;
        end
    endfunction

    analog begin
        // device 0, analog/examples/two_transistor_expression/main.cpp:15
        I(Y, Vss) <+ 9.9999999999999994e-12 * ddt(V(Y, Vss)); // Bench initial voltage = 0.0 V.
        // device 1, IC ActiveOutput, analog/examples/two_transistor_expression/main.cpp:22
        I(Y, Vdd) <+ cpphdl_channel(V(A, Vdd), V(Y, Vdd), 0.001, 0.34999999999999998, -1.0);
        // device 2, IC ActiveOutput, analog/examples/two_transistor_expression/main.cpp:23
        I(Y, Vss) <+ cpphdl_channel(V(A, Vss), V(Y, Vss), 0.001, 0.34999999999999998, 1.0);
    end
endmodule
