// Generated from elaborated C++HDL IC purposes; all contributions coexist.
// Capacitor initialization belongs to the host analysis; declared initial voltages appear below.
`include "disciplines.vams"

module Example_ldo_dropout(n0, n4, n5, n24, n25, n28, n29, n31, n32, n35);
    inout n0, n4, n5, n24, n25, n28, n29, n31, n32, n35;
    electrical n0, n4, n5, n24, n25, n28, n29, n31, n32, n35;

    // Square-law channel, including reverse conduction. This is not a BSIM model.
    analog function real cpphdl_channel;
        input vgs, vds, beta, threshold, polarity;
        real vgs, vds, beta, threshold, polarity;
        real gate, drain, direction, overdrive, current;
        begin
            gate = polarity * vgs;
            drain = polarity * vds;
            direction = 1.0;
            if (drain < 0.0) begin
                gate = gate - drain;
                drain = -drain;
                direction = -1.0;
            end
            overdrive = gate - threshold;
            current = 0.0;
            if (overdrive > 0.0) begin
                if (drain < overdrive)
                    current = beta * (overdrive * drain - drain * drain / 2.0);
                else
                    current = beta * overdrive * overdrive / 2.0;
            end
            cpphdl_channel = polarity * direction * current;
        end
    endfunction

    analog begin
        // device 3, IC ldo, analog/basic/ldo.hpp:17
        I(n35, n29) <+ cpphdl_channel(V(n32, n29), V(n35, n29), 0.20000000000000001, 0.34999999999999998, -1.0);
        // device 4, IC IC4, analog/basic/resistor_divider.hpp:15
        I(n35, n24) <+ V(n35, n24) / 10000.0;
        // device 5, IC IC4, analog/basic/resistor_divider.hpp:16
        I(n24, n0) <+ V(n24, n0) / 10000.0;
        // device 6, IC IC2, analog/basic/nmos_differential_pair.hpp:16
        I(n31, n28) <+ cpphdl_channel(V(n24, n28), V(n31, n28), 0.20000000000000001, 0.34999999999999998, 1.0);
        // device 7, IC IC2, analog/basic/nmos_differential_pair.hpp:17
        I(n32, n28) <+ cpphdl_channel(V(n25, n28), V(n32, n28), 0.20000000000000001, 0.34999999999999998, 1.0);
        // device 8, IC IC1, analog/basic/opamp.hpp:31
        I(n28, n0) <+ V(n28, n0) / 10.0;
        // device 9, IC IC3, analog/basic/pmos_current_mirror.hpp:14
        I(n31, n29) <+ cpphdl_channel(V(n31, n29), V(n31, n29), 0.20000000000000001, 0.34999999999999998, -1.0);
        // device 10, IC IC3, analog/basic/pmos_current_mirror.hpp:15
        I(n32, n29) <+ cpphdl_channel(V(n31, n29), V(n32, n29), 0.20000000000000001, 0.34999999999999998, -1.0);
        // device 11, IC IC3, analog/basic/pmos_current_mirror.hpp:16
        I(n31, n29) <+ V(n31, n29) / 1000000000.0;
        // device 12, IC IC1, analog/basic/opamp.hpp:39
        I(n32, n0) <+ 1e-08 * ddt(V(n32, n0)); // Bench initial voltage = 0.0 V.
        // device 13, IC IC1, analog/basic/opamp.hpp:40
        I(n32, n0) <+ V(n32, n0) / 100000.0;
        // device 14, analog/examples/ldo/main.cpp:21
        I(n35, n0) <+ 9.9999999999999995e-07 * ddt(V(n35, n0)); // Bench initial voltage = 0.0 V.
        // device 15, analog/examples/ldo/main.cpp:22
        I(n35, n0) <+ V(n35, n0) / 200.0;
        // device 16, analog/examples/ldo/main.cpp:23
        I(n35, n5) <+ V(n35, n5) / 200.0;
        // device 17, analog/examples/ldo/main.cpp:24
        I(n5, n0) <+ cpphdl_channel(V(n4, n0), V(n5, n0), 0.10000000000000001, 0.34999999999999998, 1.0);
    end
endmodule
