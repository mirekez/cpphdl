C++HDL Verilog-A independent transient experiment
* Sources, initial charges and observations come from the same elaborated C++ bench.
.model CircuitModel Example_pll_refined
Ndesign 0 n19 n22 n25 n29 n31 n34 n35 n37 n40 n42 n49 n52 n55 n58 n59 n61 n63 n64 bit0 CircuitModel
Vsource0 n59 0 DC 1.2
Vbit0 bit0 0 PULSE(0 1 4.1666666666666665e-05 5.0000000000000008e-11 5.0000000000000008e-11 4.1666616666666669e-05 8.3333333333333331e-05)
.ic V(n29)=0.0
.ic V(n34)=0.0
.ic V(n35)=0.0
.ic V(n40)=0.0
.ic V(n42)=0.0
.ic V(n49)=1.2
.ic V(n55)=0.0
.ic V(n59)=1.2
.ic V(n61)=0.0
.ic V(n63)=0.59999999999999998
.options method=gear maxord=2 reltol=1e-5 abstol=1e-12 vntol=1e-8 trtol=7
.control
pre_osdi design.osdi
set noaskquit
set wr_singlescale
set wr_vecnames
set numdgt=17
tran 5.0000000000000008e-07 0.014999999999999999 0 5.0000000000000008e-07 uic
let observation0 = v(n22)
let observation1 = v(n49)
let observation2 = v(n63)
let observation3 = v(n40)
wrdata spice.dat observation0 observation1 observation2 observation3
quit
.endc
.end
