C++HDL Verilog-A independent transient experiment
* Sources, initial charges and observations come from the same elaborated C++ bench.
.model CircuitModel Example_rc_filter_nominal
Ndesign 0 n6 n7 CircuitModel
Vsource0 n6 0 DC 1.0
.ic V(n6)=1.0
.ic V(n7)=0.0
.options method=gear maxord=2 reltol=1e-5 abstol=1e-12 vntol=1e-8 trtol=7
.control
pre_osdi design.osdi
set noaskquit
set wr_singlescale
set wr_vecnames
set numdgt=17
tran 5.0000000000000004e-08 4.9999999999999996e-06 0 5.0000000000000004e-08 uic
let observation0 = v(n6)
let observation1 = v(n7)
wrdata spice.dat observation0 observation1
quit
.endc
.end
