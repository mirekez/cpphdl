// Generated from elaborated C++HDL IC purposes; all contributions coexist.
// Capacitor initialization belongs to the host analysis; declared initial voltages appear below.
`include "disciplines.vams"

module Example_class_variants_nominal(n0, n13, n16, n18, n19);
    inout n0, n13, n16, n18, n19;
    electrical n0, n13, n16, n18, n19;

    // Square-law channel, including reverse conduction. This is not a BSIM model.
    analog function real cpphdl_channel;
        input vgs, vds, beta, threshold, polarity;
        real vgs, vds, beta, threshold, polarity;
        real gate, drain, direction, overdrive, current;
        begin
            gate = polarity * vgs;
            drain = polarity * vds;
            direction = 1.0;
            if (drain < 0.0) begin
                gate = gate - drain;
                drain = -drain;
                direction = -1.0;
            end
            overdrive = gate - threshold;
            current = 0.0;
            if (overdrive > 0.0) begin
                if (drain < overdrive)
                    current = beta * (overdrive * drain - drain * drain / 2.0);
                else
                    current = beta * overdrive * overdrive / 2.0;
            end
            cpphdl_channel = polarity * direction * current;
        end
    endfunction

    analog begin
        // device 2, IC IC1, analog/basic/level_inverter.hpp:16
        I(n16, n13) <+ (1.0 - min(1.0, max(0.0, (V(n18, n0) - 0.34999999999999998) / 0.5))) * V(n16, n13) / 2000.0; // sim_controlled_resistor
        // device 3, IC IC1, analog/basic/level_inverter.hpp:18
        I(n13, n0) <+ min(1.0, max(0.0, (V(n18, n0) - 0.34999999999999998) / 0.5)) * V(n13, n0) / 2000.0; // sim_controlled_resistor
        // device 4, IC channel, analog/basic/inverter.hpp:11
        I(n19, n16) <+ cpphdl_channel(V(n18, n16), V(n19, n16), 0.001, 0.34999999999999998, -1.0);
        // device 5, IC channel, analog/basic/inverter.hpp:12
        I(n19, n0) <+ cpphdl_channel(V(n18, n0), V(n19, n0), 0.001, 0.34999999999999998, 1.0);
        // device 6, analog/examples/class_variants/main.cpp:24
        I(n13, n0) <+ 9.9999999999999994e-12 * ddt(V(n13, n0)); // Bench initial voltage = 0.0 V.
        // device 7, analog/examples/class_variants/main.cpp:25
        I(n19, n0) <+ 9.9999999999999994e-12 * ddt(V(n19, n0)); // Bench initial voltage = 0.0 V.
    end
endmodule
