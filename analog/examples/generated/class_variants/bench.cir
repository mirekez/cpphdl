C++HDL Verilog-A independent transient experiment
* Sources, initial charges and observations come from the same elaborated C++ bench.
.model CircuitModel Example_class_variants_nominal
Ndesign 0 n13 n16 n18 n19 CircuitModel
Vsource0 n16 0 DC 1.2
Vsource1 n18 0 PWL(0 0.0 2.0000000000000002e-07 0.0 2.0000000000000002e-07 1.2 4.0000000000000003e-07 1.2)
.ic V(n13)=0.0
.ic V(n16)=1.2
.ic V(n18)=0.0
.ic V(n19)=0.0
.options method=gear maxord=2 reltol=1e-5 abstol=1e-12 vntol=1e-8 trtol=7
.control
pre_osdi design.osdi
set noaskquit
set wr_singlescale
set wr_vecnames
set numdgt=17
tran 1.0000000000000001e-09 4.0000000000000003e-07 0 1.0000000000000001e-09 uic
let observation0 = v(n13)
let observation1 = v(n19)
wrdata spice.dat observation0 observation1
quit
.endc
.end
