// SIMULATION APPROXIMATION: controlled conductances are not physical MOS devices.
// Generated from elaborated C++HDL IC purposes; all contributions coexist.
// Capacitor initialization belongs to the host analysis; declared initial voltages appear below.
`include "disciplines.vams"

module OneGIHPBalancedReceiveFrontend(Vdd, Vss, Vlogic, PLUS, MINUS, EVALUATE, CLEAR, TRACK0, CORE_DECISION0, BIT_N0_0, BIT_N0_1, BIT_N0_2, BIT_N0_3, BIT_N0_4, BIT_N0_5, BIT_N0_6, BIT_N0_7, TRACK1, CORE_DECISION1, BIT_N1_0, BIT_N1_1, BIT_N1_2, BIT_N1_3, BIT_N1_4, BIT_N1_5, BIT_N1_6, BIT_N1_7, TRACK2, CORE_DECISION2, BIT_N2_0, BIT_N2_1, BIT_N2_2, BIT_N2_3, BIT_N2_4, BIT_N2_5, BIT_N2_6, BIT_N2_7, TRACK3, CORE_DECISION3, BIT_N3_0, BIT_N3_1, BIT_N3_2, BIT_N3_3, BIT_N3_4, BIT_N3_5, BIT_N3_6, BIT_N3_7, TRACK4, CORE_DECISION4, BIT_N4_0, BIT_N4_1, BIT_N4_2, BIT_N4_3, BIT_N4_4, BIT_N4_5, BIT_N4_6, BIT_N4_7, TRACK5, CORE_DECISION5, BIT_N5_0, BIT_N5_1, BIT_N5_2, BIT_N5_3, BIT_N5_4, BIT_N5_5, BIT_N5_6, BIT_N5_7, TRACK6, CORE_DECISION6, BIT_N6_0, BIT_N6_1, BIT_N6_2, BIT_N6_3, BIT_N6_4, BIT_N6_5, BIT_N6_6, BIT_N6_7, TRACK7, CORE_DECISION7, BIT_N7_0, BIT_N7_1, BIT_N7_2, BIT_N7_3, BIT_N7_4, BIT_N7_5, BIT_N7_6, BIT_N7_7, TRACK8, CORE_DECISION8, BIT_N8_0, BIT_N8_1, BIT_N8_2, BIT_N8_3, BIT_N8_4, BIT_N8_5, BIT_N8_6, BIT_N8_7, TRACK9, CORE_DECISION9, BIT_N9_0, BIT_N9_1, BIT_N9_2, BIT_N9_3, BIT_N9_4, BIT_N9_5, BIT_N9_6, BIT_N9_7, TRACK10, CORE_DECISION10, BIT_N10_0, BIT_N10_1, BIT_N10_2, BIT_N10_3, BIT_N10_4, BIT_N10_5, BIT_N10_6, BIT_N10_7, TRACK11, CORE_DECISION11, BIT_N11_0, BIT_N11_1, BIT_N11_2, BIT_N11_3, BIT_N11_4, BIT_N11_5, BIT_N11_6, BIT_N11_7, TRACK12, CORE_DECISION12, BIT_N12_0, BIT_N12_1, BIT_N12_2, BIT_N12_3, BIT_N12_4, BIT_N12_5, BIT_N12_6, BIT_N12_7, TRACK13, CORE_DECISION13, BIT_N13_0, BIT_N13_1, BIT_N13_2, BIT_N13_3, BIT_N13_4, BIT_N13_5, BIT_N13_6, BIT_N13_7, TRACK14, CORE_DECISION14, BIT_N14_0, BIT_N14_1, BIT_N14_2, BIT_N14_3, BIT_N14_4, BIT_N14_5, BIT_N14_6, BIT_N14_7, TRACK15, CORE_DECISION15, BIT_N15_0, BIT_N15_1, BIT_N15_2, BIT_N15_3, BIT_N15_4, BIT_N15_5, BIT_N15_6, BIT_N15_7);
    inout Vdd, Vss, Vlogic, PLUS, MINUS, EVALUATE, CLEAR, TRACK0, CORE_DECISION0, BIT_N0_0, BIT_N0_1, BIT_N0_2, BIT_N0_3, BIT_N0_4, BIT_N0_5, BIT_N0_6, BIT_N0_7, TRACK1, CORE_DECISION1, BIT_N1_0, BIT_N1_1, BIT_N1_2, BIT_N1_3, BIT_N1_4, BIT_N1_5, BIT_N1_6, BIT_N1_7, TRACK2, CORE_DECISION2, BIT_N2_0, BIT_N2_1, BIT_N2_2, BIT_N2_3, BIT_N2_4, BIT_N2_5, BIT_N2_6, BIT_N2_7, TRACK3, CORE_DECISION3, BIT_N3_0, BIT_N3_1, BIT_N3_2, BIT_N3_3, BIT_N3_4, BIT_N3_5, BIT_N3_6, BIT_N3_7, TRACK4, CORE_DECISION4, BIT_N4_0, BIT_N4_1, BIT_N4_2, BIT_N4_3, BIT_N4_4, BIT_N4_5, BIT_N4_6, BIT_N4_7, TRACK5, CORE_DECISION5, BIT_N5_0, BIT_N5_1, BIT_N5_2, BIT_N5_3, BIT_N5_4, BIT_N5_5, BIT_N5_6, BIT_N5_7, TRACK6, CORE_DECISION6, BIT_N6_0, BIT_N6_1, BIT_N6_2, BIT_N6_3, BIT_N6_4, BIT_N6_5, BIT_N6_6, BIT_N6_7, TRACK7, CORE_DECISION7, BIT_N7_0, BIT_N7_1, BIT_N7_2, BIT_N7_3, BIT_N7_4, BIT_N7_5, BIT_N7_6, BIT_N7_7, TRACK8, CORE_DECISION8, BIT_N8_0, BIT_N8_1, BIT_N8_2, BIT_N8_3, BIT_N8_4, BIT_N8_5, BIT_N8_6, BIT_N8_7, TRACK9, CORE_DECISION9, BIT_N9_0, BIT_N9_1, BIT_N9_2, BIT_N9_3, BIT_N9_4, BIT_N9_5, BIT_N9_6, BIT_N9_7, TRACK10, CORE_DECISION10, BIT_N10_0, BIT_N10_1, BIT_N10_2, BIT_N10_3, BIT_N10_4, BIT_N10_5, BIT_N10_6, BIT_N10_7, TRACK11, CORE_DECISION11, BIT_N11_0, BIT_N11_1, BIT_N11_2, BIT_N11_3, BIT_N11_4, BIT_N11_5, BIT_N11_6, BIT_N11_7, TRACK12, CORE_DECISION12, BIT_N12_0, BIT_N12_1, BIT_N12_2, BIT_N12_3, BIT_N12_4, BIT_N12_5, BIT_N12_6, BIT_N12_7, TRACK13, CORE_DECISION13, BIT_N13_0, BIT_N13_1, BIT_N13_2, BIT_N13_3, BIT_N13_4, BIT_N13_5, BIT_N13_6, BIT_N13_7, TRACK14, CORE_DECISION14, BIT_N14_0, BIT_N14_1, BIT_N14_2, BIT_N14_3, BIT_N14_4, BIT_N14_5, BIT_N14_6, BIT_N14_7, TRACK15, CORE_DECISION15, BIT_N15_0, BIT_N15_1, BIT_N15_2, BIT_N15_3, BIT_N15_4, BIT_N15_5, BIT_N15_6, BIT_N15_7;
    electrical Vdd, Vss, Vlogic, PLUS, MINUS, EVALUATE, CLEAR, TRACK0, CORE_DECISION0, BIT_N0_0, BIT_N0_1, BIT_N0_2, BIT_N0_3, BIT_N0_4, BIT_N0_5, BIT_N0_6, BIT_N0_7, TRACK1, CORE_DECISION1, BIT_N1_0, BIT_N1_1, BIT_N1_2, BIT_N1_3, BIT_N1_4, BIT_N1_5, BIT_N1_6, BIT_N1_7, TRACK2, CORE_DECISION2, BIT_N2_0, BIT_N2_1, BIT_N2_2, BIT_N2_3, BIT_N2_4, BIT_N2_5, BIT_N2_6, BIT_N2_7, TRACK3, CORE_DECISION3, BIT_N3_0, BIT_N3_1, BIT_N3_2, BIT_N3_3, BIT_N3_4, BIT_N3_5, BIT_N3_6, BIT_N3_7, TRACK4, CORE_DECISION4, BIT_N4_0, BIT_N4_1, BIT_N4_2, BIT_N4_3, BIT_N4_4, BIT_N4_5, BIT_N4_6, BIT_N4_7, TRACK5, CORE_DECISION5, BIT_N5_0, BIT_N5_1, BIT_N5_2, BIT_N5_3, BIT_N5_4, BIT_N5_5, BIT_N5_6, BIT_N5_7, TRACK6, CORE_DECISION6, BIT_N6_0, BIT_N6_1, BIT_N6_2, BIT_N6_3, BIT_N6_4, BIT_N6_5, BIT_N6_6, BIT_N6_7, TRACK7, CORE_DECISION7, BIT_N7_0, BIT_N7_1, BIT_N7_2, BIT_N7_3, BIT_N7_4, BIT_N7_5, BIT_N7_6, BIT_N7_7, TRACK8, CORE_DECISION8, BIT_N8_0, BIT_N8_1, BIT_N8_2, BIT_N8_3, BIT_N8_4, BIT_N8_5, BIT_N8_6, BIT_N8_7, TRACK9, CORE_DECISION9, BIT_N9_0, BIT_N9_1, BIT_N9_2, BIT_N9_3, BIT_N9_4, BIT_N9_5, BIT_N9_6, BIT_N9_7, TRACK10, CORE_DECISION10, BIT_N10_0, BIT_N10_1, BIT_N10_2, BIT_N10_3, BIT_N10_4, BIT_N10_5, BIT_N10_6, BIT_N10_7, TRACK11, CORE_DECISION11, BIT_N11_0, BIT_N11_1, BIT_N11_2, BIT_N11_3, BIT_N11_4, BIT_N11_5, BIT_N11_6, BIT_N11_7, TRACK12, CORE_DECISION12, BIT_N12_0, BIT_N12_1, BIT_N12_2, BIT_N12_3, BIT_N12_4, BIT_N12_5, BIT_N12_6, BIT_N12_7, TRACK13, CORE_DECISION13, BIT_N13_0, BIT_N13_1, BIT_N13_2, BIT_N13_3, BIT_N13_4, BIT_N13_5, BIT_N13_6, BIT_N13_7, TRACK14, CORE_DECISION14, BIT_N14_0, BIT_N14_1, BIT_N14_2, BIT_N14_3, BIT_N14_4, BIT_N14_5, BIT_N14_6, BIT_N14_7, TRACK15, CORE_DECISION15, BIT_N15_0, BIT_N15_1, BIT_N15_2, BIT_N15_3, BIT_N15_4, BIT_N15_5, BIT_N15_6, BIT_N15_7;
    electrical cpphdl_n174;
    electrical cpphdl_n175;
    electrical cpphdl_n176;
    electrical cpphdl_n385;
    electrical cpphdl_n400;
    electrical cpphdl_n404;
    electrical cpphdl_n408;
    electrical cpphdl_n412;
    electrical cpphdl_n416;
    electrical cpphdl_n420;
    electrical cpphdl_n424;
    electrical cpphdl_n428;
    electrical cpphdl_n429;
    electrical cpphdl_n430;
    electrical cpphdl_n431;
    electrical cpphdl_n432;
    electrical cpphdl_n433;
    electrical cpphdl_n434;
    electrical cpphdl_n435;
    electrical cpphdl_n439;
    electrical cpphdl_n440;
    electrical cpphdl_n443;
    electrical cpphdl_n444;
    electrical cpphdl_n445;
    electrical cpphdl_n448;
    electrical cpphdl_n449;
    electrical cpphdl_n453;
    electrical cpphdl_n454;
    electrical cpphdl_n455;
    electrical cpphdl_n468;
    electrical cpphdl_n472;
    electrical cpphdl_n476;
    electrical cpphdl_n480;
    electrical cpphdl_n490;
    electrical cpphdl_n493;
    electrical cpphdl_n496;
    electrical cpphdl_n498;
    electrical cpphdl_n499;
    electrical cpphdl_n504;
    electrical cpphdl_n528;
    electrical cpphdl_n543;
    electrical cpphdl_n547;
    electrical cpphdl_n551;
    electrical cpphdl_n555;
    electrical cpphdl_n559;
    electrical cpphdl_n563;
    electrical cpphdl_n567;
    electrical cpphdl_n571;
    electrical cpphdl_n572;
    electrical cpphdl_n573;
    electrical cpphdl_n574;
    electrical cpphdl_n575;
    electrical cpphdl_n576;
    electrical cpphdl_n577;
    electrical cpphdl_n578;
    electrical cpphdl_n582;
    electrical cpphdl_n583;
    electrical cpphdl_n586;
    electrical cpphdl_n587;
    electrical cpphdl_n588;
    electrical cpphdl_n591;
    electrical cpphdl_n592;
    electrical cpphdl_n596;
    electrical cpphdl_n597;
    electrical cpphdl_n598;
    electrical cpphdl_n611;
    electrical cpphdl_n615;
    electrical cpphdl_n619;
    electrical cpphdl_n623;
    electrical cpphdl_n633;
    electrical cpphdl_n636;
    electrical cpphdl_n639;
    electrical cpphdl_n641;
    electrical cpphdl_n642;
    electrical cpphdl_n647;
    electrical cpphdl_n671;
    electrical cpphdl_n686;
    electrical cpphdl_n690;
    electrical cpphdl_n694;
    electrical cpphdl_n698;
    electrical cpphdl_n702;
    electrical cpphdl_n706;
    electrical cpphdl_n710;
    electrical cpphdl_n714;
    electrical cpphdl_n715;
    electrical cpphdl_n716;
    electrical cpphdl_n717;
    electrical cpphdl_n718;
    electrical cpphdl_n719;
    electrical cpphdl_n720;
    electrical cpphdl_n721;
    electrical cpphdl_n725;
    electrical cpphdl_n726;
    electrical cpphdl_n729;
    electrical cpphdl_n730;
    electrical cpphdl_n731;
    electrical cpphdl_n734;
    electrical cpphdl_n735;
    electrical cpphdl_n739;
    electrical cpphdl_n740;
    electrical cpphdl_n741;
    electrical cpphdl_n754;
    electrical cpphdl_n758;
    electrical cpphdl_n762;
    electrical cpphdl_n766;
    electrical cpphdl_n776;
    electrical cpphdl_n779;
    electrical cpphdl_n782;
    electrical cpphdl_n784;
    electrical cpphdl_n785;
    electrical cpphdl_n790;
    electrical cpphdl_n814;
    electrical cpphdl_n829;
    electrical cpphdl_n833;
    electrical cpphdl_n837;
    electrical cpphdl_n841;
    electrical cpphdl_n845;
    electrical cpphdl_n849;
    electrical cpphdl_n853;
    electrical cpphdl_n857;
    electrical cpphdl_n858;
    electrical cpphdl_n859;
    electrical cpphdl_n860;
    electrical cpphdl_n861;
    electrical cpphdl_n862;
    electrical cpphdl_n863;
    electrical cpphdl_n864;
    electrical cpphdl_n868;
    electrical cpphdl_n869;
    electrical cpphdl_n872;
    electrical cpphdl_n873;
    electrical cpphdl_n874;
    electrical cpphdl_n877;
    electrical cpphdl_n878;
    electrical cpphdl_n882;
    electrical cpphdl_n883;
    electrical cpphdl_n884;
    electrical cpphdl_n897;
    electrical cpphdl_n901;
    electrical cpphdl_n905;
    electrical cpphdl_n909;
    electrical cpphdl_n919;
    electrical cpphdl_n922;
    electrical cpphdl_n925;
    electrical cpphdl_n927;
    electrical cpphdl_n928;
    electrical cpphdl_n933;
    electrical cpphdl_n957;
    electrical cpphdl_n972;
    electrical cpphdl_n976;
    electrical cpphdl_n980;
    electrical cpphdl_n984;
    electrical cpphdl_n988;
    electrical cpphdl_n992;
    electrical cpphdl_n996;
    electrical cpphdl_n1000;
    electrical cpphdl_n1001;
    electrical cpphdl_n1002;
    electrical cpphdl_n1003;
    electrical cpphdl_n1004;
    electrical cpphdl_n1005;
    electrical cpphdl_n1006;
    electrical cpphdl_n1007;
    electrical cpphdl_n1011;
    electrical cpphdl_n1012;
    electrical cpphdl_n1015;
    electrical cpphdl_n1016;
    electrical cpphdl_n1017;
    electrical cpphdl_n1020;
    electrical cpphdl_n1021;
    electrical cpphdl_n1025;
    electrical cpphdl_n1026;
    electrical cpphdl_n1027;
    electrical cpphdl_n1040;
    electrical cpphdl_n1044;
    electrical cpphdl_n1048;
    electrical cpphdl_n1052;
    electrical cpphdl_n1062;
    electrical cpphdl_n1065;
    electrical cpphdl_n1068;
    electrical cpphdl_n1070;
    electrical cpphdl_n1071;
    electrical cpphdl_n1076;
    electrical cpphdl_n1100;
    electrical cpphdl_n1115;
    electrical cpphdl_n1119;
    electrical cpphdl_n1123;
    electrical cpphdl_n1127;
    electrical cpphdl_n1131;
    electrical cpphdl_n1135;
    electrical cpphdl_n1139;
    electrical cpphdl_n1143;
    electrical cpphdl_n1144;
    electrical cpphdl_n1145;
    electrical cpphdl_n1146;
    electrical cpphdl_n1147;
    electrical cpphdl_n1148;
    electrical cpphdl_n1149;
    electrical cpphdl_n1150;
    electrical cpphdl_n1154;
    electrical cpphdl_n1155;
    electrical cpphdl_n1158;
    electrical cpphdl_n1159;
    electrical cpphdl_n1160;
    electrical cpphdl_n1163;
    electrical cpphdl_n1164;
    electrical cpphdl_n1168;
    electrical cpphdl_n1169;
    electrical cpphdl_n1170;
    electrical cpphdl_n1183;
    electrical cpphdl_n1187;
    electrical cpphdl_n1191;
    electrical cpphdl_n1195;
    electrical cpphdl_n1205;
    electrical cpphdl_n1208;
    electrical cpphdl_n1211;
    electrical cpphdl_n1213;
    electrical cpphdl_n1214;
    electrical cpphdl_n1219;
    electrical cpphdl_n1243;
    electrical cpphdl_n1258;
    electrical cpphdl_n1262;
    electrical cpphdl_n1266;
    electrical cpphdl_n1270;
    electrical cpphdl_n1274;
    electrical cpphdl_n1278;
    electrical cpphdl_n1282;
    electrical cpphdl_n1286;
    electrical cpphdl_n1287;
    electrical cpphdl_n1288;
    electrical cpphdl_n1289;
    electrical cpphdl_n1290;
    electrical cpphdl_n1291;
    electrical cpphdl_n1292;
    electrical cpphdl_n1293;
    electrical cpphdl_n1297;
    electrical cpphdl_n1298;
    electrical cpphdl_n1301;
    electrical cpphdl_n1302;
    electrical cpphdl_n1303;
    electrical cpphdl_n1306;
    electrical cpphdl_n1307;
    electrical cpphdl_n1311;
    electrical cpphdl_n1312;
    electrical cpphdl_n1313;
    electrical cpphdl_n1326;
    electrical cpphdl_n1330;
    electrical cpphdl_n1334;
    electrical cpphdl_n1338;
    electrical cpphdl_n1348;
    electrical cpphdl_n1351;
    electrical cpphdl_n1354;
    electrical cpphdl_n1356;
    electrical cpphdl_n1357;
    electrical cpphdl_n1362;
    electrical cpphdl_n1386;
    electrical cpphdl_n1401;
    electrical cpphdl_n1405;
    electrical cpphdl_n1409;
    electrical cpphdl_n1413;
    electrical cpphdl_n1417;
    electrical cpphdl_n1421;
    electrical cpphdl_n1425;
    electrical cpphdl_n1429;
    electrical cpphdl_n1430;
    electrical cpphdl_n1431;
    electrical cpphdl_n1432;
    electrical cpphdl_n1433;
    electrical cpphdl_n1434;
    electrical cpphdl_n1435;
    electrical cpphdl_n1436;
    electrical cpphdl_n1440;
    electrical cpphdl_n1441;
    electrical cpphdl_n1444;
    electrical cpphdl_n1445;
    electrical cpphdl_n1446;
    electrical cpphdl_n1449;
    electrical cpphdl_n1450;
    electrical cpphdl_n1454;
    electrical cpphdl_n1455;
    electrical cpphdl_n1456;
    electrical cpphdl_n1469;
    electrical cpphdl_n1473;
    electrical cpphdl_n1477;
    electrical cpphdl_n1481;
    electrical cpphdl_n1491;
    electrical cpphdl_n1494;
    electrical cpphdl_n1497;
    electrical cpphdl_n1499;
    electrical cpphdl_n1500;
    electrical cpphdl_n1505;
    electrical cpphdl_n1529;
    electrical cpphdl_n1544;
    electrical cpphdl_n1548;
    electrical cpphdl_n1552;
    electrical cpphdl_n1556;
    electrical cpphdl_n1560;
    electrical cpphdl_n1564;
    electrical cpphdl_n1568;
    electrical cpphdl_n1572;
    electrical cpphdl_n1573;
    electrical cpphdl_n1574;
    electrical cpphdl_n1575;
    electrical cpphdl_n1576;
    electrical cpphdl_n1577;
    electrical cpphdl_n1578;
    electrical cpphdl_n1579;
    electrical cpphdl_n1583;
    electrical cpphdl_n1584;
    electrical cpphdl_n1587;
    electrical cpphdl_n1588;
    electrical cpphdl_n1589;
    electrical cpphdl_n1592;
    electrical cpphdl_n1593;
    electrical cpphdl_n1597;
    electrical cpphdl_n1598;
    electrical cpphdl_n1599;
    electrical cpphdl_n1612;
    electrical cpphdl_n1616;
    electrical cpphdl_n1620;
    electrical cpphdl_n1624;
    electrical cpphdl_n1634;
    electrical cpphdl_n1637;
    electrical cpphdl_n1640;
    electrical cpphdl_n1642;
    electrical cpphdl_n1643;
    electrical cpphdl_n1648;
    electrical cpphdl_n1672;
    electrical cpphdl_n1687;
    electrical cpphdl_n1691;
    electrical cpphdl_n1695;
    electrical cpphdl_n1699;
    electrical cpphdl_n1703;
    electrical cpphdl_n1707;
    electrical cpphdl_n1711;
    electrical cpphdl_n1715;
    electrical cpphdl_n1716;
    electrical cpphdl_n1717;
    electrical cpphdl_n1718;
    electrical cpphdl_n1719;
    electrical cpphdl_n1720;
    electrical cpphdl_n1721;
    electrical cpphdl_n1722;
    electrical cpphdl_n1726;
    electrical cpphdl_n1727;
    electrical cpphdl_n1730;
    electrical cpphdl_n1731;
    electrical cpphdl_n1732;
    electrical cpphdl_n1735;
    electrical cpphdl_n1736;
    electrical cpphdl_n1740;
    electrical cpphdl_n1741;
    electrical cpphdl_n1742;
    electrical cpphdl_n1755;
    electrical cpphdl_n1759;
    electrical cpphdl_n1763;
    electrical cpphdl_n1767;
    electrical cpphdl_n1777;
    electrical cpphdl_n1780;
    electrical cpphdl_n1783;
    electrical cpphdl_n1785;
    electrical cpphdl_n1786;
    electrical cpphdl_n1791;
    electrical cpphdl_n1815;
    electrical cpphdl_n1830;
    electrical cpphdl_n1834;
    electrical cpphdl_n1838;
    electrical cpphdl_n1842;
    electrical cpphdl_n1846;
    electrical cpphdl_n1850;
    electrical cpphdl_n1854;
    electrical cpphdl_n1858;
    electrical cpphdl_n1859;
    electrical cpphdl_n1860;
    electrical cpphdl_n1861;
    electrical cpphdl_n1862;
    electrical cpphdl_n1863;
    electrical cpphdl_n1864;
    electrical cpphdl_n1865;
    electrical cpphdl_n1869;
    electrical cpphdl_n1870;
    electrical cpphdl_n1873;
    electrical cpphdl_n1874;
    electrical cpphdl_n1875;
    electrical cpphdl_n1878;
    electrical cpphdl_n1879;
    electrical cpphdl_n1883;
    electrical cpphdl_n1884;
    electrical cpphdl_n1885;
    electrical cpphdl_n1898;
    electrical cpphdl_n1902;
    electrical cpphdl_n1906;
    electrical cpphdl_n1910;
    electrical cpphdl_n1920;
    electrical cpphdl_n1923;
    electrical cpphdl_n1926;
    electrical cpphdl_n1928;
    electrical cpphdl_n1929;
    electrical cpphdl_n1934;
    electrical cpphdl_n1958;
    electrical cpphdl_n1973;
    electrical cpphdl_n1977;
    electrical cpphdl_n1981;
    electrical cpphdl_n1985;
    electrical cpphdl_n1989;
    electrical cpphdl_n1993;
    electrical cpphdl_n1997;
    electrical cpphdl_n2001;
    electrical cpphdl_n2002;
    electrical cpphdl_n2003;
    electrical cpphdl_n2004;
    electrical cpphdl_n2005;
    electrical cpphdl_n2006;
    electrical cpphdl_n2007;
    electrical cpphdl_n2008;
    electrical cpphdl_n2012;
    electrical cpphdl_n2013;
    electrical cpphdl_n2016;
    electrical cpphdl_n2017;
    electrical cpphdl_n2018;
    electrical cpphdl_n2021;
    electrical cpphdl_n2022;
    electrical cpphdl_n2026;
    electrical cpphdl_n2027;
    electrical cpphdl_n2028;
    electrical cpphdl_n2041;
    electrical cpphdl_n2045;
    electrical cpphdl_n2049;
    electrical cpphdl_n2053;
    electrical cpphdl_n2063;
    electrical cpphdl_n2066;
    electrical cpphdl_n2069;
    electrical cpphdl_n2071;
    electrical cpphdl_n2072;
    electrical cpphdl_n2077;
    electrical cpphdl_n2101;
    electrical cpphdl_n2116;
    electrical cpphdl_n2120;
    electrical cpphdl_n2124;
    electrical cpphdl_n2128;
    electrical cpphdl_n2132;
    electrical cpphdl_n2136;
    electrical cpphdl_n2140;
    electrical cpphdl_n2144;
    electrical cpphdl_n2145;
    electrical cpphdl_n2146;
    electrical cpphdl_n2147;
    electrical cpphdl_n2148;
    electrical cpphdl_n2149;
    electrical cpphdl_n2150;
    electrical cpphdl_n2151;
    electrical cpphdl_n2155;
    electrical cpphdl_n2156;
    electrical cpphdl_n2159;
    electrical cpphdl_n2160;
    electrical cpphdl_n2161;
    electrical cpphdl_n2164;
    electrical cpphdl_n2165;
    electrical cpphdl_n2169;
    electrical cpphdl_n2170;
    electrical cpphdl_n2171;
    electrical cpphdl_n2184;
    electrical cpphdl_n2188;
    electrical cpphdl_n2192;
    electrical cpphdl_n2196;
    electrical cpphdl_n2206;
    electrical cpphdl_n2209;
    electrical cpphdl_n2212;
    electrical cpphdl_n2214;
    electrical cpphdl_n2215;
    electrical cpphdl_n2220;
    electrical cpphdl_n2244;
    electrical cpphdl_n2259;
    electrical cpphdl_n2263;
    electrical cpphdl_n2267;
    electrical cpphdl_n2271;
    electrical cpphdl_n2275;
    electrical cpphdl_n2279;
    electrical cpphdl_n2283;
    electrical cpphdl_n2287;
    electrical cpphdl_n2288;
    electrical cpphdl_n2289;
    electrical cpphdl_n2290;
    electrical cpphdl_n2291;
    electrical cpphdl_n2292;
    electrical cpphdl_n2293;
    electrical cpphdl_n2294;
    electrical cpphdl_n2298;
    electrical cpphdl_n2299;
    electrical cpphdl_n2302;
    electrical cpphdl_n2303;
    electrical cpphdl_n2304;
    electrical cpphdl_n2307;
    electrical cpphdl_n2308;
    electrical cpphdl_n2312;
    electrical cpphdl_n2313;
    electrical cpphdl_n2314;
    electrical cpphdl_n2327;
    electrical cpphdl_n2331;
    electrical cpphdl_n2335;
    electrical cpphdl_n2339;
    electrical cpphdl_n2349;
    electrical cpphdl_n2352;
    electrical cpphdl_n2355;
    electrical cpphdl_n2357;
    electrical cpphdl_n2358;
    electrical cpphdl_n2363;
    electrical cpphdl_n2387;
    electrical cpphdl_n2402;
    electrical cpphdl_n2406;
    electrical cpphdl_n2410;
    electrical cpphdl_n2414;
    electrical cpphdl_n2418;
    electrical cpphdl_n2422;
    electrical cpphdl_n2426;
    electrical cpphdl_n2430;
    electrical cpphdl_n2431;
    electrical cpphdl_n2432;
    electrical cpphdl_n2433;
    electrical cpphdl_n2434;
    electrical cpphdl_n2435;
    electrical cpphdl_n2436;
    electrical cpphdl_n2437;
    electrical cpphdl_n2441;
    electrical cpphdl_n2442;
    electrical cpphdl_n2445;
    electrical cpphdl_n2446;
    electrical cpphdl_n2447;
    electrical cpphdl_n2450;
    electrical cpphdl_n2451;
    electrical cpphdl_n2455;
    electrical cpphdl_n2456;
    electrical cpphdl_n2457;
    electrical cpphdl_n2470;
    electrical cpphdl_n2474;
    electrical cpphdl_n2478;
    electrical cpphdl_n2482;
    electrical cpphdl_n2492;
    electrical cpphdl_n2495;
    electrical cpphdl_n2498;
    electrical cpphdl_n2500;
    electrical cpphdl_n2501;
    electrical cpphdl_n2506;
    electrical cpphdl_n2530;
    electrical cpphdl_n2545;
    electrical cpphdl_n2549;
    electrical cpphdl_n2553;
    electrical cpphdl_n2557;
    electrical cpphdl_n2561;
    electrical cpphdl_n2565;
    electrical cpphdl_n2569;
    electrical cpphdl_n2573;
    electrical cpphdl_n2574;
    electrical cpphdl_n2575;
    electrical cpphdl_n2576;
    electrical cpphdl_n2577;
    electrical cpphdl_n2578;
    electrical cpphdl_n2579;
    electrical cpphdl_n2580;
    electrical cpphdl_n2584;
    electrical cpphdl_n2585;
    electrical cpphdl_n2588;
    electrical cpphdl_n2589;
    electrical cpphdl_n2590;
    electrical cpphdl_n2593;
    electrical cpphdl_n2594;
    electrical cpphdl_n2598;
    electrical cpphdl_n2599;
    electrical cpphdl_n2600;
    electrical cpphdl_n2613;
    electrical cpphdl_n2617;
    electrical cpphdl_n2621;
    electrical cpphdl_n2625;
    electrical cpphdl_n2635;
    electrical cpphdl_n2638;
    electrical cpphdl_n2641;
    electrical cpphdl_n2643;
    electrical cpphdl_n2644;
    electrical cpphdl_n2649;
    electrical cpphdl_n2669;
    electrical cpphdl_n2671;
    electrical cpphdl_n2674;
    electrical cpphdl_n2676;
    electrical cpphdl_n2679;
    electrical cpphdl_n2681;
    electrical cpphdl_n2684;
    electrical cpphdl_n2686;
    electrical cpphdl_n2689;
    electrical cpphdl_n2691;
    electrical cpphdl_n2694;
    electrical cpphdl_n2696;
    electrical cpphdl_n2699;
    electrical cpphdl_n2701;
    electrical cpphdl_n2704;
    electrical cpphdl_n2706;
    electrical cpphdl_n2709;
    electrical cpphdl_n2711;
    electrical cpphdl_n2714;
    electrical cpphdl_n2716;
    electrical cpphdl_n2719;
    electrical cpphdl_n2721;
    electrical cpphdl_n2724;
    electrical cpphdl_n2726;
    electrical cpphdl_n2729;
    electrical cpphdl_n2731;
    electrical cpphdl_n2734;
    electrical cpphdl_n2736;
    electrical cpphdl_n2739;
    electrical cpphdl_n2741;
    electrical cpphdl_n2744;
    electrical cpphdl_n2746;
    electrical cpphdl_n2752;
    electrical cpphdl_n2753;
    electrical cpphdl_n2754;
    electrical cpphdl_n2755;
    electrical cpphdl_n2758;
    electrical cpphdl_n2759;

    // Square-law channel, including reverse conduction. This is not a BSIM model.
    analog function real cpphdl_channel;
        input vgs, vds, beta, threshold, polarity;
        real vgs, vds, beta, threshold, polarity;
        real gate, drain, direction, overdrive, current;
        begin
            gate = polarity * vgs;
            drain = polarity * vds;
            direction = 1.0;
            if (drain < 0.0) begin
                gate = gate - drain;
                drain = -drain;
                direction = -1.0;
            end
            overdrive = gate - threshold;
            current = 0.0;
            if (overdrive > 0.0) begin
                if (drain < overdrive)
                    current = beta * (overdrive * drain - drain * drain / 2.0);
                else
                    current = beta * overdrive * overdrive / 2.0;
            end
            cpphdl_channel = polarity * direction * current;
        end
    endfunction

    analog begin
        // device 0, IC IC1, analog/basic/nmos_resistor_amplifier.hpp:23
        I(Vdd, cpphdl_n2752) <+ V(Vdd, cpphdl_n2752) / 500.0;
        // device 1, IC IC1, analog/basic/nmos_resistor_amplifier.hpp:24
        I(Vdd, cpphdl_n2758) <+ V(Vdd, cpphdl_n2758) / 500.0;
        // device 2, IC IC1, analog/basic/nmos_resistor_amplifier.hpp:25
        I(cpphdl_n2752, cpphdl_n174) <+ cpphdl_channel(V(PLUS, cpphdl_n174), V(cpphdl_n2752, cpphdl_n174), 0.014999999999999999, 0.69999999999999996, 1.0);
        // device 3, IC IC1, analog/basic/nmos_resistor_amplifier.hpp:26
        I(cpphdl_n2758, cpphdl_n175) <+ cpphdl_channel(V(MINUS, cpphdl_n175), V(cpphdl_n2758, cpphdl_n175), 0.014999999999999999, 0.69999999999999996, 1.0);
        // device 4, IC IC1, analog/basic/nmos_resistor_amplifier.hpp:27
        I(cpphdl_n176, cpphdl_n174) <+ V(cpphdl_n176, cpphdl_n174) / 50.0;
        // device 5, IC IC1, analog/basic/nmos_resistor_amplifier.hpp:28
        I(cpphdl_n176, cpphdl_n175) <+ V(cpphdl_n176, cpphdl_n175) / 50.0;
        // device 6, IC IC1, analog/basic/nmos_resistor_amplifier.hpp:29
        I(Vss, cpphdl_n176) <+ V(Vss, cpphdl_n176) / 150.0;
        // device 7, IC IC1, analog/basic/nmos_resistor_amplifier.hpp:30
        I(cpphdl_n2752, Vdd) <+ 1e-13 * ddt(V(cpphdl_n2752, Vdd)); // Bench initial voltage = 0.0 V.
        // device 8, IC IC1, analog/basic/nmos_resistor_amplifier.hpp:31
        I(cpphdl_n2758, Vdd) <+ 1e-13 * ddt(V(cpphdl_n2758, Vdd)); // Bench initial voltage = 0.0 V.
        // device 9, IC IC1, analog/basic/nmos_resistor_amplifier.hpp:32
        I(cpphdl_n176, Vss) <+ 4e-14 * ddt(V(cpphdl_n176, Vss)); // Bench initial voltage = 0.0 V.
        // device 10, IC IC1, analog/basic/nmos_resistor_amplifier.hpp:34
        I(PLUS, cpphdl_n174) <+ 1.4999999999999999e-13 * ddt(V(PLUS, cpphdl_n174)); // Bench initial voltage = 1.6499999999999999 V.
        // device 11, IC IC1, analog/basic/nmos_resistor_amplifier.hpp:35
        I(MINUS, cpphdl_n175) <+ 1.4999999999999999e-13 * ddt(V(MINUS, cpphdl_n175)); // Bench initial voltage = 1.6499999999999999 V.
        // device 12, IC IC1, analog/basic/nmos_resistor_amplifier.hpp:36
        I(PLUS, cpphdl_n2752) <+ 2e-14 * ddt(V(PLUS, cpphdl_n2752)); // Bench initial voltage = -1.6499999999999999 V.
        // device 13, IC IC1, analog/basic/nmos_resistor_amplifier.hpp:37
        I(MINUS, cpphdl_n2758) <+ 2e-14 * ddt(V(MINUS, cpphdl_n2758)); // Bench initial voltage = -1.6499999999999999 V.
        // device 14, IC IC2, analog/basic/nmos_source_follower.hpp:19
        I(Vdd, cpphdl_n2759) <+ cpphdl_channel(V(cpphdl_n2758, cpphdl_n2759), V(Vdd, cpphdl_n2759), 0.10000000000000001, 0.69999999999999996, 1.0);
        // device 15, IC IC2, analog/basic/nmos_source_follower.hpp:20
        I(Vss, cpphdl_n2759) <+ V(Vss, cpphdl_n2759) / 250.0;
        // device 16, IC IC2, analog/basic/nmos_source_follower.hpp:23
        I(cpphdl_n2758, cpphdl_n2759) <+ 4e-14 * ddt(V(cpphdl_n2758, cpphdl_n2759)); // Bench initial voltage = 1.6499999999999999 V.
        // device 17, IC IC2, analog/basic/nmos_source_follower.hpp:24
        I(cpphdl_n2758, Vdd) <+ 1e-14 * ddt(V(cpphdl_n2758, Vdd)); // Bench initial voltage = 0.0 V.
        // device 18, IC IC2, analog/basic/nmos_source_follower.hpp:25
        I(cpphdl_n2759, Vss) <+ 4e-14 * ddt(V(cpphdl_n2759, Vss)); // Bench initial voltage = 1.6499999999999999 V.
        // device 19, IC IC6, analog/basic/inverter.hpp:11
        I(cpphdl_n385, Vdd) <+ cpphdl_channel(V(TRACK0, Vdd), V(cpphdl_n385, Vdd), 0.0040000000000000001, 0.69999999999999996, -1.0);
        // device 20, IC IC6, analog/basic/inverter.hpp:12
        I(cpphdl_n385, Vss) <+ cpphdl_channel(V(TRACK0, Vss), V(cpphdl_n385, Vss), 0.0040000000000000001, 0.69999999999999996, 1.0);
        // device 21, IC IC5, analog/basic/mos_track_hold.hpp:31
        I(cpphdl_n385, Vss) <+ 2e-14 * ddt(V(cpphdl_n385, Vss)); // Bench initial voltage = 3.2999999999999998 V.
        // device 22, IC IC5, analog/basic/mos_track_hold.hpp:32
        I(cpphdl_n2759, cpphdl_n439) <+ cpphdl_channel(V(TRACK0, cpphdl_n439), V(cpphdl_n2759, cpphdl_n439), 0.080000000000000002, 0.69999999999999996, 1.0);
        // device 23, IC IC5, analog/basic/mos_track_hold.hpp:33
        I(cpphdl_n439, cpphdl_n2759) <+ cpphdl_channel(V(cpphdl_n385, cpphdl_n2759), V(cpphdl_n439, cpphdl_n2759), 0.040000000000000001, 0.69999999999999996, -1.0);
        // device 24, IC IC5, analog/basic/mos_track_hold.hpp:37
        I(cpphdl_n439, cpphdl_n439) <+ cpphdl_channel(V(cpphdl_n385, cpphdl_n439), V(cpphdl_n439, cpphdl_n439), 0.040000000000000001, 0.69999999999999996, 1.0);
        // device 25, IC IC5, analog/basic/mos_track_hold.hpp:38
        I(cpphdl_n439, cpphdl_n439) <+ cpphdl_channel(V(TRACK0, cpphdl_n439), V(cpphdl_n439, cpphdl_n439), 0.02, 0.69999999999999996, -1.0);
        // device 26, IC IC5, analog/basic/mos_track_hold.hpp:39
        I(cpphdl_n439, Vss) <+ 3.0000000000000001e-12 * ddt(V(cpphdl_n439, Vss)); // Bench initial voltage = 1.6499999999999999 V.
        // device 27, IC IC5, analog/basic/mos_track_hold.hpp:41
        I(Vss, cpphdl_n439) <+ V(Vss, cpphdl_n439) / 1000000000.0;
        // device 28, IC IC5, analog/basic/mos_track_hold.hpp:42
        I(TRACK0, cpphdl_n439) <+ 8.0000000000000006e-15 * ddt(V(TRACK0, cpphdl_n439)); // Bench initial voltage = -1.6499999999999999 V.
        // device 29, IC IC5, analog/basic/mos_track_hold.hpp:43
        I(cpphdl_n385, cpphdl_n439) <+ 8.0000000000000006e-15 * ddt(V(cpphdl_n385, cpphdl_n439)); // Bench initial voltage = 1.6499999999999999 V.
        // device 30, IC IC5, analog/basic/mos_track_hold.hpp:44
        I(cpphdl_n2759, cpphdl_n439) <+ 4.0000000000000003e-15 * ddt(V(cpphdl_n2759, cpphdl_n439)); // Bench initial voltage = 0.0 V.
        // device 31, IC IC8, analog/basic/inverter.hpp:11
        I(cpphdl_n400, Vdd) <+ cpphdl_channel(V(BIT_N0_0, Vdd), V(cpphdl_n400, Vdd), 0.080000000000000002, 0.69999999999999996, -1.0);
        // device 32, IC IC8, analog/basic/inverter.hpp:12
        I(cpphdl_n400, Vss) <+ cpphdl_channel(V(BIT_N0_0, Vss), V(cpphdl_n400, Vss), 0.080000000000000002, 0.69999999999999996, 1.0);
        // device 33, IC IC7, analog/basic/mos_r2r_dac.hpp:27
        I(cpphdl_n400, Vss) <+ 2.9999999999999998e-15 * ddt(V(cpphdl_n400, Vss)); // Bench initial voltage = 0.0 V.
        // device 34, IC IC7, analog/basic/mos_r2r_dac.hpp:28
        I(cpphdl_n400, cpphdl_n429) <+ V(cpphdl_n400, cpphdl_n429) / 2000.0;
        // device 35, IC IC7, analog/basic/mos_r2r_dac.hpp:29
        I(cpphdl_n429, Vss) <+ 2.9999999999999998e-15 * ddt(V(cpphdl_n429, Vss)); // Bench initial voltage = 0.0 V.
        // device 36, IC IC9, analog/basic/inverter.hpp:11
        I(cpphdl_n404, Vdd) <+ cpphdl_channel(V(BIT_N0_1, Vdd), V(cpphdl_n404, Vdd), 0.080000000000000002, 0.69999999999999996, -1.0);
        // device 37, IC IC9, analog/basic/inverter.hpp:12
        I(cpphdl_n404, Vss) <+ cpphdl_channel(V(BIT_N0_1, Vss), V(cpphdl_n404, Vss), 0.080000000000000002, 0.69999999999999996, 1.0);
        // device 38, IC IC7, analog/basic/mos_r2r_dac.hpp:27
        I(cpphdl_n404, Vss) <+ 2.9999999999999998e-15 * ddt(V(cpphdl_n404, Vss)); // Bench initial voltage = 0.0 V.
        // device 39, IC IC7, analog/basic/mos_r2r_dac.hpp:28
        I(cpphdl_n404, cpphdl_n430) <+ V(cpphdl_n404, cpphdl_n430) / 2000.0;
        // device 40, IC IC7, analog/basic/mos_r2r_dac.hpp:29
        I(cpphdl_n430, Vss) <+ 2.9999999999999998e-15 * ddt(V(cpphdl_n430, Vss)); // Bench initial voltage = 0.0 V.
        // device 41, IC IC7, analog/basic/mos_r2r_dac.hpp:31
        I(cpphdl_n429, cpphdl_n430) <+ V(cpphdl_n429, cpphdl_n430) / 1000.0;
        // device 42, IC IC10, analog/basic/inverter.hpp:11
        I(cpphdl_n408, Vdd) <+ cpphdl_channel(V(BIT_N0_2, Vdd), V(cpphdl_n408, Vdd), 0.080000000000000002, 0.69999999999999996, -1.0);
        // device 43, IC IC10, analog/basic/inverter.hpp:12
        I(cpphdl_n408, Vss) <+ cpphdl_channel(V(BIT_N0_2, Vss), V(cpphdl_n408, Vss), 0.080000000000000002, 0.69999999999999996, 1.0);
        // device 44, IC IC7, analog/basic/mos_r2r_dac.hpp:27
        I(cpphdl_n408, Vss) <+ 2.9999999999999998e-15 * ddt(V(cpphdl_n408, Vss)); // Bench initial voltage = 0.0 V.
        // device 45, IC IC7, analog/basic/mos_r2r_dac.hpp:28
        I(cpphdl_n408, cpphdl_n431) <+ V(cpphdl_n408, cpphdl_n431) / 2000.0;
        // device 46, IC IC7, analog/basic/mos_r2r_dac.hpp:29
        I(cpphdl_n431, Vss) <+ 2.9999999999999998e-15 * ddt(V(cpphdl_n431, Vss)); // Bench initial voltage = 0.0 V.
        // device 47, IC IC7, analog/basic/mos_r2r_dac.hpp:31
        I(cpphdl_n430, cpphdl_n431) <+ V(cpphdl_n430, cpphdl_n431) / 1000.0;
        // device 48, IC IC11, analog/basic/inverter.hpp:11
        I(cpphdl_n412, Vdd) <+ cpphdl_channel(V(BIT_N0_3, Vdd), V(cpphdl_n412, Vdd), 0.080000000000000002, 0.69999999999999996, -1.0);
        // device 49, IC IC11, analog/basic/inverter.hpp:12
        I(cpphdl_n412, Vss) <+ cpphdl_channel(V(BIT_N0_3, Vss), V(cpphdl_n412, Vss), 0.080000000000000002, 0.69999999999999996, 1.0);
        // device 50, IC IC7, analog/basic/mos_r2r_dac.hpp:27
        I(cpphdl_n412, Vss) <+ 2.9999999999999998e-15 * ddt(V(cpphdl_n412, Vss)); // Bench initial voltage = 0.0 V.
        // device 51, IC IC7, analog/basic/mos_r2r_dac.hpp:28
        I(cpphdl_n412, cpphdl_n432) <+ V(cpphdl_n412, cpphdl_n432) / 2000.0;
        // device 52, IC IC7, analog/basic/mos_r2r_dac.hpp:29
        I(cpphdl_n432, Vss) <+ 2.9999999999999998e-15 * ddt(V(cpphdl_n432, Vss)); // Bench initial voltage = 0.0 V.
        // device 53, IC IC7, analog/basic/mos_r2r_dac.hpp:31
        I(cpphdl_n431, cpphdl_n432) <+ V(cpphdl_n431, cpphdl_n432) / 1000.0;
        // device 54, IC IC12, analog/basic/inverter.hpp:11
        I(cpphdl_n416, Vdd) <+ cpphdl_channel(V(BIT_N0_4, Vdd), V(cpphdl_n416, Vdd), 0.080000000000000002, 0.69999999999999996, -1.0);
        // device 55, IC IC12, analog/basic/inverter.hpp:12
        I(cpphdl_n416, Vss) <+ cpphdl_channel(V(BIT_N0_4, Vss), V(cpphdl_n416, Vss), 0.080000000000000002, 0.69999999999999996, 1.0);
        // device 56, IC IC7, analog/basic/mos_r2r_dac.hpp:27
        I(cpphdl_n416, Vss) <+ 2.9999999999999998e-15 * ddt(V(cpphdl_n416, Vss)); // Bench initial voltage = 0.0 V.
        // device 57, IC IC7, analog/basic/mos_r2r_dac.hpp:28
        I(cpphdl_n416, cpphdl_n433) <+ V(cpphdl_n416, cpphdl_n433) / 2000.0;
        // device 58, IC IC7, analog/basic/mos_r2r_dac.hpp:29
        I(cpphdl_n433, Vss) <+ 2.9999999999999998e-15 * ddt(V(cpphdl_n433, Vss)); // Bench initial voltage = 0.0 V.
        // device 59, IC IC7, analog/basic/mos_r2r_dac.hpp:31
        I(cpphdl_n432, cpphdl_n433) <+ V(cpphdl_n432, cpphdl_n433) / 1000.0;
        // device 60, IC IC13, analog/basic/inverter.hpp:11
        I(cpphdl_n420, Vdd) <+ cpphdl_channel(V(BIT_N0_5, Vdd), V(cpphdl_n420, Vdd), 0.080000000000000002, 0.69999999999999996, -1.0);
        // device 61, IC IC13, analog/basic/inverter.hpp:12
        I(cpphdl_n420, Vss) <+ cpphdl_channel(V(BIT_N0_5, Vss), V(cpphdl_n420, Vss), 0.080000000000000002, 0.69999999999999996, 1.0);
        // device 62, IC IC7, analog/basic/mos_r2r_dac.hpp:27
        I(cpphdl_n420, Vss) <+ 2.9999999999999998e-15 * ddt(V(cpphdl_n420, Vss)); // Bench initial voltage = 0.0 V.
        // device 63, IC IC7, analog/basic/mos_r2r_dac.hpp:28
        I(cpphdl_n420, cpphdl_n434) <+ V(cpphdl_n420, cpphdl_n434) / 2000.0;
        // device 64, IC IC7, analog/basic/mos_r2r_dac.hpp:29
        I(cpphdl_n434, Vss) <+ 2.9999999999999998e-15 * ddt(V(cpphdl_n434, Vss)); // Bench initial voltage = 0.0 V.
        // device 65, IC IC7, analog/basic/mos_r2r_dac.hpp:31
        I(cpphdl_n433, cpphdl_n434) <+ V(cpphdl_n433, cpphdl_n434) / 1000.0;
        // device 66, IC IC14, analog/basic/inverter.hpp:11
        I(cpphdl_n424, Vdd) <+ cpphdl_channel(V(BIT_N0_6, Vdd), V(cpphdl_n424, Vdd), 0.080000000000000002, 0.69999999999999996, -1.0);
        // device 67, IC IC14, analog/basic/inverter.hpp:12
        I(cpphdl_n424, Vss) <+ cpphdl_channel(V(BIT_N0_6, Vss), V(cpphdl_n424, Vss), 0.080000000000000002, 0.69999999999999996, 1.0);
        // device 68, IC IC7, analog/basic/mos_r2r_dac.hpp:27
        I(cpphdl_n424, Vss) <+ 2.9999999999999998e-15 * ddt(V(cpphdl_n424, Vss)); // Bench initial voltage = 0.0 V.
        // device 69, IC IC7, analog/basic/mos_r2r_dac.hpp:28
        I(cpphdl_n424, cpphdl_n435) <+ V(cpphdl_n424, cpphdl_n435) / 2000.0;
        // device 70, IC IC7, analog/basic/mos_r2r_dac.hpp:29
        I(cpphdl_n435, Vss) <+ 2.9999999999999998e-15 * ddt(V(cpphdl_n435, Vss)); // Bench initial voltage = 0.0 V.
        // device 71, IC IC7, analog/basic/mos_r2r_dac.hpp:31
        I(cpphdl_n434, cpphdl_n435) <+ V(cpphdl_n434, cpphdl_n435) / 1000.0;
        // device 72, IC IC15, analog/basic/inverter.hpp:11
        I(cpphdl_n428, Vdd) <+ cpphdl_channel(V(BIT_N0_7, Vdd), V(cpphdl_n428, Vdd), 0.080000000000000002, 0.69999999999999996, -1.0);
        // device 73, IC IC15, analog/basic/inverter.hpp:12
        I(cpphdl_n428, Vss) <+ cpphdl_channel(V(BIT_N0_7, Vss), V(cpphdl_n428, Vss), 0.080000000000000002, 0.69999999999999996, 1.0);
        // device 74, IC IC7, analog/basic/mos_r2r_dac.hpp:27
        I(cpphdl_n428, Vss) <+ 2.9999999999999998e-15 * ddt(V(cpphdl_n428, Vss)); // Bench initial voltage = 0.0 V.
        // device 75, IC IC7, analog/basic/mos_r2r_dac.hpp:28
        I(cpphdl_n428, cpphdl_n440) <+ V(cpphdl_n428, cpphdl_n440) / 2000.0;
        // device 76, IC IC7, analog/basic/mos_r2r_dac.hpp:29
        I(cpphdl_n440, Vss) <+ 2.9999999999999998e-15 * ddt(V(cpphdl_n440, Vss)); // Bench initial voltage = 0.0 V.
        // device 77, IC IC7, analog/basic/mos_r2r_dac.hpp:31
        I(cpphdl_n435, cpphdl_n440) <+ V(cpphdl_n435, cpphdl_n440) / 1000.0;
        // device 78, IC IC7, analog/basic/mos_r2r_dac.hpp:33
        I(Vss, cpphdl_n429) <+ V(Vss, cpphdl_n429) / 2000.0;
        // device 79, IC IC16, analog/basic/nmos_resistor_amplifier.hpp:23
        I(Vdd, cpphdl_n449) <+ V(Vdd, cpphdl_n449) / 500.0;
        // device 80, IC IC16, analog/basic/nmos_resistor_amplifier.hpp:24
        I(Vdd, cpphdl_n448) <+ V(Vdd, cpphdl_n448) / 500.0;
        // device 81, IC IC16, analog/basic/nmos_resistor_amplifier.hpp:25
        I(cpphdl_n449, cpphdl_n443) <+ cpphdl_channel(V(cpphdl_n439, cpphdl_n443), V(cpphdl_n449, cpphdl_n443), 0.014999999999999999, 0.69999999999999996, 1.0);
        // device 82, IC IC16, analog/basic/nmos_resistor_amplifier.hpp:26
        I(cpphdl_n448, cpphdl_n444) <+ cpphdl_channel(V(cpphdl_n440, cpphdl_n444), V(cpphdl_n448, cpphdl_n444), 0.014999999999999999, 0.69999999999999996, 1.0);
        // device 83, IC IC16, analog/basic/nmos_resistor_amplifier.hpp:27
        I(cpphdl_n445, cpphdl_n443) <+ V(cpphdl_n445, cpphdl_n443) / 50.0;
        // device 84, IC IC16, analog/basic/nmos_resistor_amplifier.hpp:28
        I(cpphdl_n445, cpphdl_n444) <+ V(cpphdl_n445, cpphdl_n444) / 50.0;
        // device 85, IC IC16, analog/basic/nmos_resistor_amplifier.hpp:29
        I(Vss, cpphdl_n445) <+ V(Vss, cpphdl_n445) / 150.0;
        // device 86, IC IC16, analog/basic/nmos_resistor_amplifier.hpp:30
        I(cpphdl_n449, Vdd) <+ 2.9999999999999998e-13 * ddt(V(cpphdl_n449, Vdd)); // Bench initial voltage = 0.0 V.
        // device 87, IC IC16, analog/basic/nmos_resistor_amplifier.hpp:31
        I(cpphdl_n448, Vdd) <+ 2.9999999999999998e-13 * ddt(V(cpphdl_n448, Vdd)); // Bench initial voltage = 0.0 V.
        // device 88, IC IC16, analog/basic/nmos_resistor_amplifier.hpp:32
        I(cpphdl_n445, Vss) <+ 4e-14 * ddt(V(cpphdl_n445, Vss)); // Bench initial voltage = 0.0 V.
        // device 89, IC IC16, analog/basic/nmos_resistor_amplifier.hpp:34
        I(cpphdl_n439, cpphdl_n443) <+ 2e-14 * ddt(V(cpphdl_n439, cpphdl_n443)); // Bench initial voltage = 1.6499999999999999 V.
        // device 90, IC IC16, analog/basic/nmos_resistor_amplifier.hpp:35
        I(cpphdl_n440, cpphdl_n444) <+ 2e-14 * ddt(V(cpphdl_n440, cpphdl_n444)); // Bench initial voltage = 0.0 V.
        // device 91, IC IC16, analog/basic/nmos_resistor_amplifier.hpp:36
        I(cpphdl_n439, cpphdl_n449) <+ 2.9999999999999998e-15 * ddt(V(cpphdl_n439, cpphdl_n449)); // Bench initial voltage = -1.6499999999999999 V.
        // device 92, IC IC16, analog/basic/nmos_resistor_amplifier.hpp:37
        I(cpphdl_n440, cpphdl_n448) <+ 2.9999999999999998e-15 * ddt(V(cpphdl_n440, cpphdl_n448)); // Bench initial voltage = -3.2999999999999998 V.
        // device 93, IC IC17, analog/basic/strongarm_comparator.hpp:28
        I(cpphdl_n453, cpphdl_n455) <+ cpphdl_channel(V(cpphdl_n448, cpphdl_n455), V(cpphdl_n453, cpphdl_n455), 0.0080000000000000002, 0.69999999999999996, 1.0);
        // device 94, IC IC17, analog/basic/strongarm_comparator.hpp:29
        I(cpphdl_n454, cpphdl_n455) <+ cpphdl_channel(V(cpphdl_n449, cpphdl_n455), V(cpphdl_n454, cpphdl_n455), 0.0080000000000000002, 0.69999999999999996, 1.0);
        // device 95, IC IC17, analog/basic/strongarm_comparator.hpp:30
        I(cpphdl_n455, Vss) <+ cpphdl_channel(V(EVALUATE, Vss), V(cpphdl_n455, Vss), 0.0080000000000000002, 0.69999999999999996, 1.0);
        // device 96, IC IC17, analog/basic/strongarm_comparator.hpp:33
        I(cpphdl_n468, cpphdl_n453) <+ cpphdl_channel(V(cpphdl_n472, cpphdl_n453), V(cpphdl_n468, cpphdl_n453), 0.0040000000000000001, 0.69999999999999996, 1.0);
        // device 97, IC IC17, analog/basic/strongarm_comparator.hpp:34
        I(cpphdl_n472, cpphdl_n454) <+ cpphdl_channel(V(cpphdl_n468, cpphdl_n454), V(cpphdl_n472, cpphdl_n454), 0.0040000000000000001, 0.69999999999999996, 1.0);
        // device 98, IC IC17, analog/basic/strongarm_comparator.hpp:35
        I(cpphdl_n472, Vdd) <+ cpphdl_channel(V(cpphdl_n468, Vdd), V(cpphdl_n472, Vdd), 0.002, 0.69999999999999996, -1.0);
        // device 99, IC IC17, analog/basic/strongarm_comparator.hpp:36
        I(cpphdl_n468, Vdd) <+ cpphdl_channel(V(cpphdl_n472, Vdd), V(cpphdl_n468, Vdd), 0.002, 0.69999999999999996, -1.0);
        // device 100, IC IC17, analog/basic/strongarm_comparator.hpp:38
        I(cpphdl_n453, Vdd) <+ cpphdl_channel(V(EVALUATE, Vdd), V(cpphdl_n453, Vdd), 0.002, 0.69999999999999996, -1.0);
        // device 101, IC IC17, analog/basic/strongarm_comparator.hpp:39
        I(cpphdl_n454, Vdd) <+ cpphdl_channel(V(EVALUATE, Vdd), V(cpphdl_n454, Vdd), 0.002, 0.69999999999999996, -1.0);
        // device 102, IC IC17, analog/basic/strongarm_comparator.hpp:40
        I(cpphdl_n472, Vdd) <+ cpphdl_channel(V(EVALUATE, Vdd), V(cpphdl_n472, Vdd), 0.002, 0.69999999999999996, -1.0);
        // device 103, IC IC17, analog/basic/strongarm_comparator.hpp:41
        I(cpphdl_n468, Vdd) <+ cpphdl_channel(V(EVALUATE, Vdd), V(cpphdl_n468, Vdd), 0.002, 0.69999999999999996, -1.0);
        // device 104, IC IC17, analog/basic/strongarm_comparator.hpp:42
        I(cpphdl_n453, Vss) <+ 2.9999999999999998e-14 * ddt(V(cpphdl_n453, Vss)); // Bench initial voltage = 0.0 V.
        // device 105, IC IC17, analog/basic/strongarm_comparator.hpp:43
        I(cpphdl_n454, Vss) <+ 2.9999999999999998e-14 * ddt(V(cpphdl_n454, Vss)); // Bench initial voltage = 0.0 V.
        // device 106, IC IC17, analog/basic/strongarm_comparator.hpp:44
        I(cpphdl_n455, Vss) <+ 2.9999999999999998e-14 * ddt(V(cpphdl_n455, Vss)); // Bench initial voltage = 0.0 V.
        // device 107, IC IC17, analog/basic/strongarm_comparator.hpp:45
        I(cpphdl_n472, Vss) <+ 5.0000000000000002e-14 * ddt(V(cpphdl_n472, Vss)); // Bench initial voltage = 0.0 V.
        // device 108, IC IC17, analog/basic/strongarm_comparator.hpp:46
        I(cpphdl_n468, Vss) <+ 5.0000000000000002e-14 * ddt(V(cpphdl_n468, Vss)); // Bench initial voltage = 0.0 V.
        // device 109, IC IC17, analog/basic/strongarm_comparator.hpp:47
        I(cpphdl_n448, cpphdl_n455) <+ 2e-14 * ddt(V(cpphdl_n448, cpphdl_n455)); // Bench initial voltage = 3.2999999999999998 V.
        // device 110, IC IC17, analog/basic/strongarm_comparator.hpp:48
        I(cpphdl_n449, cpphdl_n455) <+ 2e-14 * ddt(V(cpphdl_n449, cpphdl_n455)); // Bench initial voltage = 3.2999999999999998 V.
        // device 111, IC IC17, analog/basic/strongarm_comparator.hpp:49
        I(cpphdl_n448, cpphdl_n453) <+ 2.9999999999999998e-15 * ddt(V(cpphdl_n448, cpphdl_n453)); // Bench initial voltage = 3.2999999999999998 V.
        // device 112, IC IC17, analog/basic/strongarm_comparator.hpp:50
        I(cpphdl_n449, cpphdl_n454) <+ 2.9999999999999998e-15 * ddt(V(cpphdl_n449, cpphdl_n454)); // Bench initial voltage = 3.2999999999999998 V.
        // device 113, IC IC19, analog/basic/inverter.hpp:11
        I(cpphdl_n476, Vdd) <+ cpphdl_channel(V(cpphdl_n468, Vdd), V(cpphdl_n476, Vdd), 0.001, 0.69999999999999996, -1.0);
        // device 114, IC IC19, analog/basic/inverter.hpp:12
        I(cpphdl_n476, Vss) <+ cpphdl_channel(V(cpphdl_n468, Vss), V(cpphdl_n476, Vss), 0.001, 0.69999999999999996, 1.0);
        // device 115, IC IC21, analog/basic/inverter.hpp:11
        I(cpphdl_n490, Vdd) <+ cpphdl_channel(V(cpphdl_n476, Vdd), V(cpphdl_n490, Vdd), 0.0040000000000000001, 0.69999999999999996, -1.0);
        // device 116, IC IC21, analog/basic/inverter.hpp:12
        I(cpphdl_n490, Vss) <+ cpphdl_channel(V(cpphdl_n476, Vss), V(cpphdl_n490, Vss), 0.0040000000000000001, 0.69999999999999996, 1.0);
        // device 117, IC IC18, analog/basic/buffered_nand_latch.hpp:34
        I(cpphdl_n468, Vss) <+ 2.0000000000000002e-15 * ddt(V(cpphdl_n468, Vss)); // Bench initial voltage = 0.0 V.
        // device 118, IC IC18, analog/basic/buffered_nand_latch.hpp:35
        I(cpphdl_n468, cpphdl_n476) <+ 1.0000000000000001e-15 * ddt(V(cpphdl_n468, cpphdl_n476)); // Bench initial voltage = 0.0 V.
        // device 119, IC IC18, analog/basic/buffered_nand_latch.hpp:36
        I(cpphdl_n476, Vss) <+ 5e-15 * ddt(V(cpphdl_n476, Vss)); // Bench initial voltage = 0.0 V.
        // device 120, IC IC18, analog/basic/buffered_nand_latch.hpp:37
        I(cpphdl_n476, Vss) <+ 8.0000000000000006e-15 * ddt(V(cpphdl_n476, Vss)); // Bench initial voltage = 0.0 V.
        // device 121, IC IC18, analog/basic/buffered_nand_latch.hpp:38
        I(cpphdl_n490, Vss) <+ 1e-14 * ddt(V(cpphdl_n490, Vss)); // Bench initial voltage = 0.0 V.
        // device 122, IC IC20, analog/basic/inverter.hpp:11
        I(cpphdl_n480, Vdd) <+ cpphdl_channel(V(cpphdl_n472, Vdd), V(cpphdl_n480, Vdd), 0.001, 0.69999999999999996, -1.0);
        // device 123, IC IC20, analog/basic/inverter.hpp:12
        I(cpphdl_n480, Vss) <+ cpphdl_channel(V(cpphdl_n472, Vss), V(cpphdl_n480, Vss), 0.001, 0.69999999999999996, 1.0);
        // device 124, IC IC22, analog/basic/inverter.hpp:11
        I(cpphdl_n496, Vdd) <+ cpphdl_channel(V(cpphdl_n480, Vdd), V(cpphdl_n496, Vdd), 0.0040000000000000001, 0.69999999999999996, -1.0);
        // device 125, IC IC22, analog/basic/inverter.hpp:12
        I(cpphdl_n496, Vss) <+ cpphdl_channel(V(cpphdl_n480, Vss), V(cpphdl_n496, Vss), 0.0040000000000000001, 0.69999999999999996, 1.0);
        // device 126, IC IC18, analog/basic/buffered_nand_latch.hpp:34
        I(cpphdl_n472, Vss) <+ 2.0000000000000002e-15 * ddt(V(cpphdl_n472, Vss)); // Bench initial voltage = 0.0 V.
        // device 127, IC IC18, analog/basic/buffered_nand_latch.hpp:35
        I(cpphdl_n472, cpphdl_n480) <+ 1.0000000000000001e-15 * ddt(V(cpphdl_n472, cpphdl_n480)); // Bench initial voltage = 0.0 V.
        // device 128, IC IC18, analog/basic/buffered_nand_latch.hpp:36
        I(cpphdl_n480, Vss) <+ 5e-15 * ddt(V(cpphdl_n480, Vss)); // Bench initial voltage = 0.0 V.
        // device 129, IC IC18, analog/basic/buffered_nand_latch.hpp:37
        I(cpphdl_n480, Vss) <+ 8.0000000000000006e-15 * ddt(V(cpphdl_n480, Vss)); // Bench initial voltage = 0.0 V.
        // device 130, IC IC18, analog/basic/buffered_nand_latch.hpp:38
        I(cpphdl_n496, Vss) <+ 1e-14 * ddt(V(cpphdl_n496, Vss)); // Bench initial voltage = 0.0 V.
        // device 131, IC IC24, analog/basic/cmos_logic.hpp:17
        I(cpphdl_n2669, Vss) <+ 5.0000000000000002e-14 * ddt(V(cpphdl_n2669, Vss)); // Bench initial voltage = 0.0 V.
        // device 132, IC IC24, analog/basic/cmos_logic.hpp:18
        I(cpphdl_n2669, Vdd) <+ cpphdl_channel(V(cpphdl_n490, Vdd), V(cpphdl_n2669, Vdd), 0.01, 0.69999999999999996, -1.0);
        // device 133, IC IC24, analog/basic/cmos_logic.hpp:19
        I(cpphdl_n2669, Vdd) <+ cpphdl_channel(V(cpphdl_n498, Vdd), V(cpphdl_n2669, Vdd), 0.01, 0.69999999999999996, -1.0);
        // device 134, IC IC24, analog/basic/cmos_logic.hpp:20
        I(cpphdl_n2669, cpphdl_n493) <+ cpphdl_channel(V(cpphdl_n490, cpphdl_n493), V(cpphdl_n2669, cpphdl_n493), 0.01, 0.69999999999999996, 1.0);
        // device 135, IC IC24, analog/basic/cmos_logic.hpp:21
        I(cpphdl_n493, Vss) <+ cpphdl_channel(V(cpphdl_n498, Vss), V(cpphdl_n493, Vss), 0.01, 0.69999999999999996, 1.0);
        // device 136, IC IC24, analog/basic/cmos_logic.hpp:23
        I(cpphdl_n2669, Vss) <+ V(cpphdl_n2669, Vss) / 1000000000.0;
        // device 137, IC IC24, analog/basic/cmos_logic.hpp:24
        I(cpphdl_n493, Vss) <+ V(cpphdl_n493, Vss) / 1000000000.0;
        // device 138, IC IC25, analog/basic/cmos_logic.hpp:17
        I(cpphdl_n498, Vss) <+ 5.0000000000000002e-14 * ddt(V(cpphdl_n498, Vss)); // Bench initial voltage = 0.0 V.
        // device 139, IC IC25, analog/basic/cmos_logic.hpp:18
        I(cpphdl_n498, Vdd) <+ cpphdl_channel(V(cpphdl_n496, Vdd), V(cpphdl_n498, Vdd), 0.01, 0.69999999999999996, -1.0);
        // device 140, IC IC25, analog/basic/cmos_logic.hpp:19
        I(cpphdl_n498, Vdd) <+ cpphdl_channel(V(cpphdl_n2669, Vdd), V(cpphdl_n498, Vdd), 0.01, 0.69999999999999996, -1.0);
        // device 141, IC IC25, analog/basic/cmos_logic.hpp:20
        I(cpphdl_n498, cpphdl_n499) <+ cpphdl_channel(V(cpphdl_n496, cpphdl_n499), V(cpphdl_n498, cpphdl_n499), 0.01, 0.69999999999999996, 1.0);
        // device 142, IC IC25, analog/basic/cmos_logic.hpp:21
        I(cpphdl_n499, Vss) <+ cpphdl_channel(V(cpphdl_n2669, Vss), V(cpphdl_n499, Vss), 0.01, 0.69999999999999996, 1.0);
        // device 143, IC IC25, analog/basic/cmos_logic.hpp:23
        I(cpphdl_n498, Vss) <+ V(cpphdl_n498, Vss) / 1000000000.0;
        // device 144, IC IC25, analog/basic/cmos_logic.hpp:24
        I(cpphdl_n499, Vss) <+ V(cpphdl_n499, Vss) / 1000000000.0;
        // device 145, IC IC23, analog/basic/nand_latch.hpp:36
        I(cpphdl_n490, Vss) <+ 2.9999999999999998e-15 * ddt(V(cpphdl_n490, Vss)); // Bench initial voltage = 0.0 V.
        // device 146, IC IC23, analog/basic/nand_latch.hpp:37
        I(cpphdl_n496, Vss) <+ 2.9999999999999998e-15 * ddt(V(cpphdl_n496, Vss)); // Bench initial voltage = 0.0 V.
        // device 147, IC IC26, analog/basic/inverter.hpp:11
        I(cpphdl_n504, Vdd) <+ cpphdl_channel(V(CLEAR, Vdd), V(cpphdl_n504, Vdd), 0.01, 0.69999999999999996, -1.0);
        // device 148, IC IC26, analog/basic/inverter.hpp:12
        I(cpphdl_n504, Vss) <+ cpphdl_channel(V(CLEAR, Vss), V(cpphdl_n504, Vss), 0.01, 0.69999999999999996, 1.0);
        // device 149, IC IC23, analog/basic/nand_latch.hpp:58
        I(cpphdl_n504, Vss) <+ 2.9999999999999998e-15 * ddt(V(cpphdl_n504, Vss)); // Bench initial voltage = 0.0 V.
        // device 150, IC IC23, analog/basic/nand_latch.hpp:59
        I(cpphdl_n2669, Vss) <+ cpphdl_channel(V(CLEAR, Vss), V(cpphdl_n2669, Vss), 0.050000000000000003, 0.69999999999999996, 1.0);
        // device 151, IC IC23, analog/basic/nand_latch.hpp:60
        I(cpphdl_n498, Vdd) <+ cpphdl_channel(V(cpphdl_n504, Vdd), V(cpphdl_n498, Vdd), 0.050000000000000003, 0.69999999999999996, -1.0);
        // device 152, IC IC29, analog/basic/inverter.hpp:11
        I(cpphdl_n528, Vdd) <+ cpphdl_channel(V(TRACK1, Vdd), V(cpphdl_n528, Vdd), 0.0040000000000000001, 0.69999999999999996, -1.0);
        // device 153, IC IC29, analog/basic/inverter.hpp:12
        I(cpphdl_n528, Vss) <+ cpphdl_channel(V(TRACK1, Vss), V(cpphdl_n528, Vss), 0.0040000000000000001, 0.69999999999999996, 1.0);
        // device 154, IC IC28, analog/basic/mos_track_hold.hpp:31
        I(cpphdl_n528, Vss) <+ 2e-14 * ddt(V(cpphdl_n528, Vss)); // Bench initial voltage = 3.2999999999999998 V.
        // device 155, IC IC28, analog/basic/mos_track_hold.hpp:32
        I(cpphdl_n2759, cpphdl_n582) <+ cpphdl_channel(V(TRACK1, cpphdl_n582), V(cpphdl_n2759, cpphdl_n582), 0.080000000000000002, 0.69999999999999996, 1.0);
        // device 156, IC IC28, analog/basic/mos_track_hold.hpp:33
        I(cpphdl_n582, cpphdl_n2759) <+ cpphdl_channel(V(cpphdl_n528, cpphdl_n2759), V(cpphdl_n582, cpphdl_n2759), 0.040000000000000001, 0.69999999999999996, -1.0);
        // device 157, IC IC28, analog/basic/mos_track_hold.hpp:37
        I(cpphdl_n582, cpphdl_n582) <+ cpphdl_channel(V(cpphdl_n528, cpphdl_n582), V(cpphdl_n582, cpphdl_n582), 0.040000000000000001, 0.69999999999999996, 1.0);
        // device 158, IC IC28, analog/basic/mos_track_hold.hpp:38
        I(cpphdl_n582, cpphdl_n582) <+ cpphdl_channel(V(TRACK1, cpphdl_n582), V(cpphdl_n582, cpphdl_n582), 0.02, 0.69999999999999996, -1.0);
        // device 159, IC IC28, analog/basic/mos_track_hold.hpp:39
        I(cpphdl_n582, Vss) <+ 3.0000000000000001e-12 * ddt(V(cpphdl_n582, Vss)); // Bench initial voltage = 1.6499999999999999 V.
        // device 160, IC IC28, analog/basic/mos_track_hold.hpp:41
        I(Vss, cpphdl_n582) <+ V(Vss, cpphdl_n582) / 1000000000.0;
        // device 161, IC IC28, analog/basic/mos_track_hold.hpp:42
        I(TRACK1, cpphdl_n582) <+ 8.0000000000000006e-15 * ddt(V(TRACK1, cpphdl_n582)); // Bench initial voltage = -1.6499999999999999 V.
        // device 162, IC IC28, analog/basic/mos_track_hold.hpp:43
        I(cpphdl_n528, cpphdl_n582) <+ 8.0000000000000006e-15 * ddt(V(cpphdl_n528, cpphdl_n582)); // Bench initial voltage = 1.6499999999999999 V.
        // device 163, IC IC28, analog/basic/mos_track_hold.hpp:44
        I(cpphdl_n2759, cpphdl_n582) <+ 4.0000000000000003e-15 * ddt(V(cpphdl_n2759, cpphdl_n582)); // Bench initial voltage = 0.0 V.
        // device 164, IC IC31, analog/basic/inverter.hpp:11
        I(cpphdl_n543, Vdd) <+ cpphdl_channel(V(BIT_N1_0, Vdd), V(cpphdl_n543, Vdd), 0.080000000000000002, 0.69999999999999996, -1.0);
        // device 165, IC IC31, analog/basic/inverter.hpp:12
        I(cpphdl_n543, Vss) <+ cpphdl_channel(V(BIT_N1_0, Vss), V(cpphdl_n543, Vss), 0.080000000000000002, 0.69999999999999996, 1.0);
        // device 166, IC IC30, analog/basic/mos_r2r_dac.hpp:27
        I(cpphdl_n543, Vss) <+ 2.9999999999999998e-15 * ddt(V(cpphdl_n543, Vss)); // Bench initial voltage = 0.0 V.
        // device 167, IC IC30, analog/basic/mos_r2r_dac.hpp:28
        I(cpphdl_n543, cpphdl_n572) <+ V(cpphdl_n543, cpphdl_n572) / 2000.0;
        // device 168, IC IC30, analog/basic/mos_r2r_dac.hpp:29
        I(cpphdl_n572, Vss) <+ 2.9999999999999998e-15 * ddt(V(cpphdl_n572, Vss)); // Bench initial voltage = 0.0 V.
        // device 169, IC IC32, analog/basic/inverter.hpp:11
        I(cpphdl_n547, Vdd) <+ cpphdl_channel(V(BIT_N1_1, Vdd), V(cpphdl_n547, Vdd), 0.080000000000000002, 0.69999999999999996, -1.0);
        // device 170, IC IC32, analog/basic/inverter.hpp:12
        I(cpphdl_n547, Vss) <+ cpphdl_channel(V(BIT_N1_1, Vss), V(cpphdl_n547, Vss), 0.080000000000000002, 0.69999999999999996, 1.0);
        // device 171, IC IC30, analog/basic/mos_r2r_dac.hpp:27
        I(cpphdl_n547, Vss) <+ 2.9999999999999998e-15 * ddt(V(cpphdl_n547, Vss)); // Bench initial voltage = 0.0 V.
        // device 172, IC IC30, analog/basic/mos_r2r_dac.hpp:28
        I(cpphdl_n547, cpphdl_n573) <+ V(cpphdl_n547, cpphdl_n573) / 2000.0;
        // device 173, IC IC30, analog/basic/mos_r2r_dac.hpp:29
        I(cpphdl_n573, Vss) <+ 2.9999999999999998e-15 * ddt(V(cpphdl_n573, Vss)); // Bench initial voltage = 0.0 V.
        // device 174, IC IC30, analog/basic/mos_r2r_dac.hpp:31
        I(cpphdl_n572, cpphdl_n573) <+ V(cpphdl_n572, cpphdl_n573) / 1000.0;
        // device 175, IC IC33, analog/basic/inverter.hpp:11
        I(cpphdl_n551, Vdd) <+ cpphdl_channel(V(BIT_N1_2, Vdd), V(cpphdl_n551, Vdd), 0.080000000000000002, 0.69999999999999996, -1.0);
        // device 176, IC IC33, analog/basic/inverter.hpp:12
        I(cpphdl_n551, Vss) <+ cpphdl_channel(V(BIT_N1_2, Vss), V(cpphdl_n551, Vss), 0.080000000000000002, 0.69999999999999996, 1.0);
        // device 177, IC IC30, analog/basic/mos_r2r_dac.hpp:27
        I(cpphdl_n551, Vss) <+ 2.9999999999999998e-15 * ddt(V(cpphdl_n551, Vss)); // Bench initial voltage = 0.0 V.
        // device 178, IC IC30, analog/basic/mos_r2r_dac.hpp:28
        I(cpphdl_n551, cpphdl_n574) <+ V(cpphdl_n551, cpphdl_n574) / 2000.0;
        // device 179, IC IC30, analog/basic/mos_r2r_dac.hpp:29
        I(cpphdl_n574, Vss) <+ 2.9999999999999998e-15 * ddt(V(cpphdl_n574, Vss)); // Bench initial voltage = 0.0 V.
        // device 180, IC IC30, analog/basic/mos_r2r_dac.hpp:31
        I(cpphdl_n573, cpphdl_n574) <+ V(cpphdl_n573, cpphdl_n574) / 1000.0;
        // device 181, IC IC34, analog/basic/inverter.hpp:11
        I(cpphdl_n555, Vdd) <+ cpphdl_channel(V(BIT_N1_3, Vdd), V(cpphdl_n555, Vdd), 0.080000000000000002, 0.69999999999999996, -1.0);
        // device 182, IC IC34, analog/basic/inverter.hpp:12
        I(cpphdl_n555, Vss) <+ cpphdl_channel(V(BIT_N1_3, Vss), V(cpphdl_n555, Vss), 0.080000000000000002, 0.69999999999999996, 1.0);
        // device 183, IC IC30, analog/basic/mos_r2r_dac.hpp:27
        I(cpphdl_n555, Vss) <+ 2.9999999999999998e-15 * ddt(V(cpphdl_n555, Vss)); // Bench initial voltage = 0.0 V.
        // device 184, IC IC30, analog/basic/mos_r2r_dac.hpp:28
        I(cpphdl_n555, cpphdl_n575) <+ V(cpphdl_n555, cpphdl_n575) / 2000.0;
        // device 185, IC IC30, analog/basic/mos_r2r_dac.hpp:29
        I(cpphdl_n575, Vss) <+ 2.9999999999999998e-15 * ddt(V(cpphdl_n575, Vss)); // Bench initial voltage = 0.0 V.
        // device 186, IC IC30, analog/basic/mos_r2r_dac.hpp:31
        I(cpphdl_n574, cpphdl_n575) <+ V(cpphdl_n574, cpphdl_n575) / 1000.0;
        // device 187, IC IC35, analog/basic/inverter.hpp:11
        I(cpphdl_n559, Vdd) <+ cpphdl_channel(V(BIT_N1_4, Vdd), V(cpphdl_n559, Vdd), 0.080000000000000002, 0.69999999999999996, -1.0);
        // device 188, IC IC35, analog/basic/inverter.hpp:12
        I(cpphdl_n559, Vss) <+ cpphdl_channel(V(BIT_N1_4, Vss), V(cpphdl_n559, Vss), 0.080000000000000002, 0.69999999999999996, 1.0);
        // device 189, IC IC30, analog/basic/mos_r2r_dac.hpp:27
        I(cpphdl_n559, Vss) <+ 2.9999999999999998e-15 * ddt(V(cpphdl_n559, Vss)); // Bench initial voltage = 0.0 V.
        // device 190, IC IC30, analog/basic/mos_r2r_dac.hpp:28
        I(cpphdl_n559, cpphdl_n576) <+ V(cpphdl_n559, cpphdl_n576) / 2000.0;
        // device 191, IC IC30, analog/basic/mos_r2r_dac.hpp:29
        I(cpphdl_n576, Vss) <+ 2.9999999999999998e-15 * ddt(V(cpphdl_n576, Vss)); // Bench initial voltage = 0.0 V.
        // device 192, IC IC30, analog/basic/mos_r2r_dac.hpp:31
        I(cpphdl_n575, cpphdl_n576) <+ V(cpphdl_n575, cpphdl_n576) / 1000.0;
        // device 193, IC IC36, analog/basic/inverter.hpp:11
        I(cpphdl_n563, Vdd) <+ cpphdl_channel(V(BIT_N1_5, Vdd), V(cpphdl_n563, Vdd), 0.080000000000000002, 0.69999999999999996, -1.0);
        // device 194, IC IC36, analog/basic/inverter.hpp:12
        I(cpphdl_n563, Vss) <+ cpphdl_channel(V(BIT_N1_5, Vss), V(cpphdl_n563, Vss), 0.080000000000000002, 0.69999999999999996, 1.0);
        // device 195, IC IC30, analog/basic/mos_r2r_dac.hpp:27
        I(cpphdl_n563, Vss) <+ 2.9999999999999998e-15 * ddt(V(cpphdl_n563, Vss)); // Bench initial voltage = 0.0 V.
        // device 196, IC IC30, analog/basic/mos_r2r_dac.hpp:28
        I(cpphdl_n563, cpphdl_n577) <+ V(cpphdl_n563, cpphdl_n577) / 2000.0;
        // device 197, IC IC30, analog/basic/mos_r2r_dac.hpp:29
        I(cpphdl_n577, Vss) <+ 2.9999999999999998e-15 * ddt(V(cpphdl_n577, Vss)); // Bench initial voltage = 0.0 V.
        // device 198, IC IC30, analog/basic/mos_r2r_dac.hpp:31
        I(cpphdl_n576, cpphdl_n577) <+ V(cpphdl_n576, cpphdl_n577) / 1000.0;
        // device 199, IC IC37, analog/basic/inverter.hpp:11
        I(cpphdl_n567, Vdd) <+ cpphdl_channel(V(BIT_N1_6, Vdd), V(cpphdl_n567, Vdd), 0.080000000000000002, 0.69999999999999996, -1.0);
        // device 200, IC IC37, analog/basic/inverter.hpp:12
        I(cpphdl_n567, Vss) <+ cpphdl_channel(V(BIT_N1_6, Vss), V(cpphdl_n567, Vss), 0.080000000000000002, 0.69999999999999996, 1.0);
        // device 201, IC IC30, analog/basic/mos_r2r_dac.hpp:27
        I(cpphdl_n567, Vss) <+ 2.9999999999999998e-15 * ddt(V(cpphdl_n567, Vss)); // Bench initial voltage = 0.0 V.
        // device 202, IC IC30, analog/basic/mos_r2r_dac.hpp:28
        I(cpphdl_n567, cpphdl_n578) <+ V(cpphdl_n567, cpphdl_n578) / 2000.0;
        // device 203, IC IC30, analog/basic/mos_r2r_dac.hpp:29
        I(cpphdl_n578, Vss) <+ 2.9999999999999998e-15 * ddt(V(cpphdl_n578, Vss)); // Bench initial voltage = 0.0 V.
        // device 204, IC IC30, analog/basic/mos_r2r_dac.hpp:31
        I(cpphdl_n577, cpphdl_n578) <+ V(cpphdl_n577, cpphdl_n578) / 1000.0;
        // device 205, IC IC38, analog/basic/inverter.hpp:11
        I(cpphdl_n571, Vdd) <+ cpphdl_channel(V(BIT_N1_7, Vdd), V(cpphdl_n571, Vdd), 0.080000000000000002, 0.69999999999999996, -1.0);
        // device 206, IC IC38, analog/basic/inverter.hpp:12
        I(cpphdl_n571, Vss) <+ cpphdl_channel(V(BIT_N1_7, Vss), V(cpphdl_n571, Vss), 0.080000000000000002, 0.69999999999999996, 1.0);
        // device 207, IC IC30, analog/basic/mos_r2r_dac.hpp:27
        I(cpphdl_n571, Vss) <+ 2.9999999999999998e-15 * ddt(V(cpphdl_n571, Vss)); // Bench initial voltage = 0.0 V.
        // device 208, IC IC30, analog/basic/mos_r2r_dac.hpp:28
        I(cpphdl_n571, cpphdl_n583) <+ V(cpphdl_n571, cpphdl_n583) / 2000.0;
        // device 209, IC IC30, analog/basic/mos_r2r_dac.hpp:29
        I(cpphdl_n583, Vss) <+ 2.9999999999999998e-15 * ddt(V(cpphdl_n583, Vss)); // Bench initial voltage = 0.0 V.
        // device 210, IC IC30, analog/basic/mos_r2r_dac.hpp:31
        I(cpphdl_n578, cpphdl_n583) <+ V(cpphdl_n578, cpphdl_n583) / 1000.0;
        // device 211, IC IC30, analog/basic/mos_r2r_dac.hpp:33
        I(Vss, cpphdl_n572) <+ V(Vss, cpphdl_n572) / 2000.0;
        // device 212, IC IC39, analog/basic/nmos_resistor_amplifier.hpp:23
        I(Vdd, cpphdl_n592) <+ V(Vdd, cpphdl_n592) / 500.0;
        // device 213, IC IC39, analog/basic/nmos_resistor_amplifier.hpp:24
        I(Vdd, cpphdl_n591) <+ V(Vdd, cpphdl_n591) / 500.0;
        // device 214, IC IC39, analog/basic/nmos_resistor_amplifier.hpp:25
        I(cpphdl_n592, cpphdl_n586) <+ cpphdl_channel(V(cpphdl_n582, cpphdl_n586), V(cpphdl_n592, cpphdl_n586), 0.014999999999999999, 0.69999999999999996, 1.0);
        // device 215, IC IC39, analog/basic/nmos_resistor_amplifier.hpp:26
        I(cpphdl_n591, cpphdl_n587) <+ cpphdl_channel(V(cpphdl_n583, cpphdl_n587), V(cpphdl_n591, cpphdl_n587), 0.014999999999999999, 0.69999999999999996, 1.0);
        // device 216, IC IC39, analog/basic/nmos_resistor_amplifier.hpp:27
        I(cpphdl_n588, cpphdl_n586) <+ V(cpphdl_n588, cpphdl_n586) / 50.0;
        // device 217, IC IC39, analog/basic/nmos_resistor_amplifier.hpp:28
        I(cpphdl_n588, cpphdl_n587) <+ V(cpphdl_n588, cpphdl_n587) / 50.0;
        // device 218, IC IC39, analog/basic/nmos_resistor_amplifier.hpp:29
        I(Vss, cpphdl_n588) <+ V(Vss, cpphdl_n588) / 150.0;
        // device 219, IC IC39, analog/basic/nmos_resistor_amplifier.hpp:30
        I(cpphdl_n592, Vdd) <+ 2.9999999999999998e-13 * ddt(V(cpphdl_n592, Vdd)); // Bench initial voltage = 0.0 V.
        // device 220, IC IC39, analog/basic/nmos_resistor_amplifier.hpp:31
        I(cpphdl_n591, Vdd) <+ 2.9999999999999998e-13 * ddt(V(cpphdl_n591, Vdd)); // Bench initial voltage = 0.0 V.
        // device 221, IC IC39, analog/basic/nmos_resistor_amplifier.hpp:32
        I(cpphdl_n588, Vss) <+ 4e-14 * ddt(V(cpphdl_n588, Vss)); // Bench initial voltage = 0.0 V.
        // device 222, IC IC39, analog/basic/nmos_resistor_amplifier.hpp:34
        I(cpphdl_n582, cpphdl_n586) <+ 2e-14 * ddt(V(cpphdl_n582, cpphdl_n586)); // Bench initial voltage = 1.6499999999999999 V.
        // device 223, IC IC39, analog/basic/nmos_resistor_amplifier.hpp:35
        I(cpphdl_n583, cpphdl_n587) <+ 2e-14 * ddt(V(cpphdl_n583, cpphdl_n587)); // Bench initial voltage = 0.0 V.
        // device 224, IC IC39, analog/basic/nmos_resistor_amplifier.hpp:36
        I(cpphdl_n582, cpphdl_n592) <+ 2.9999999999999998e-15 * ddt(V(cpphdl_n582, cpphdl_n592)); // Bench initial voltage = -1.6499999999999999 V.
        // device 225, IC IC39, analog/basic/nmos_resistor_amplifier.hpp:37
        I(cpphdl_n583, cpphdl_n591) <+ 2.9999999999999998e-15 * ddt(V(cpphdl_n583, cpphdl_n591)); // Bench initial voltage = -3.2999999999999998 V.
        // device 226, IC IC40, analog/basic/strongarm_comparator.hpp:28
        I(cpphdl_n596, cpphdl_n598) <+ cpphdl_channel(V(cpphdl_n591, cpphdl_n598), V(cpphdl_n596, cpphdl_n598), 0.0080000000000000002, 0.69999999999999996, 1.0);
        // device 227, IC IC40, analog/basic/strongarm_comparator.hpp:29
        I(cpphdl_n597, cpphdl_n598) <+ cpphdl_channel(V(cpphdl_n592, cpphdl_n598), V(cpphdl_n597, cpphdl_n598), 0.0080000000000000002, 0.69999999999999996, 1.0);
        // device 228, IC IC40, analog/basic/strongarm_comparator.hpp:30
        I(cpphdl_n598, Vss) <+ cpphdl_channel(V(EVALUATE, Vss), V(cpphdl_n598, Vss), 0.0080000000000000002, 0.69999999999999996, 1.0);
        // device 229, IC IC40, analog/basic/strongarm_comparator.hpp:33
        I(cpphdl_n611, cpphdl_n596) <+ cpphdl_channel(V(cpphdl_n615, cpphdl_n596), V(cpphdl_n611, cpphdl_n596), 0.0040000000000000001, 0.69999999999999996, 1.0);
        // device 230, IC IC40, analog/basic/strongarm_comparator.hpp:34
        I(cpphdl_n615, cpphdl_n597) <+ cpphdl_channel(V(cpphdl_n611, cpphdl_n597), V(cpphdl_n615, cpphdl_n597), 0.0040000000000000001, 0.69999999999999996, 1.0);
        // device 231, IC IC40, analog/basic/strongarm_comparator.hpp:35
        I(cpphdl_n615, Vdd) <+ cpphdl_channel(V(cpphdl_n611, Vdd), V(cpphdl_n615, Vdd), 0.002, 0.69999999999999996, -1.0);
        // device 232, IC IC40, analog/basic/strongarm_comparator.hpp:36
        I(cpphdl_n611, Vdd) <+ cpphdl_channel(V(cpphdl_n615, Vdd), V(cpphdl_n611, Vdd), 0.002, 0.69999999999999996, -1.0);
        // device 233, IC IC40, analog/basic/strongarm_comparator.hpp:38
        I(cpphdl_n596, Vdd) <+ cpphdl_channel(V(EVALUATE, Vdd), V(cpphdl_n596, Vdd), 0.002, 0.69999999999999996, -1.0);
        // device 234, IC IC40, analog/basic/strongarm_comparator.hpp:39
        I(cpphdl_n597, Vdd) <+ cpphdl_channel(V(EVALUATE, Vdd), V(cpphdl_n597, Vdd), 0.002, 0.69999999999999996, -1.0);
        // device 235, IC IC40, analog/basic/strongarm_comparator.hpp:40
        I(cpphdl_n615, Vdd) <+ cpphdl_channel(V(EVALUATE, Vdd), V(cpphdl_n615, Vdd), 0.002, 0.69999999999999996, -1.0);
        // device 236, IC IC40, analog/basic/strongarm_comparator.hpp:41
        I(cpphdl_n611, Vdd) <+ cpphdl_channel(V(EVALUATE, Vdd), V(cpphdl_n611, Vdd), 0.002, 0.69999999999999996, -1.0);
        // device 237, IC IC40, analog/basic/strongarm_comparator.hpp:42
        I(cpphdl_n596, Vss) <+ 2.9999999999999998e-14 * ddt(V(cpphdl_n596, Vss)); // Bench initial voltage = 0.0 V.
        // device 238, IC IC40, analog/basic/strongarm_comparator.hpp:43
        I(cpphdl_n597, Vss) <+ 2.9999999999999998e-14 * ddt(V(cpphdl_n597, Vss)); // Bench initial voltage = 0.0 V.
        // device 239, IC IC40, analog/basic/strongarm_comparator.hpp:44
        I(cpphdl_n598, Vss) <+ 2.9999999999999998e-14 * ddt(V(cpphdl_n598, Vss)); // Bench initial voltage = 0.0 V.
        // device 240, IC IC40, analog/basic/strongarm_comparator.hpp:45
        I(cpphdl_n615, Vss) <+ 5.0000000000000002e-14 * ddt(V(cpphdl_n615, Vss)); // Bench initial voltage = 0.0 V.
        // device 241, IC IC40, analog/basic/strongarm_comparator.hpp:46
        I(cpphdl_n611, Vss) <+ 5.0000000000000002e-14 * ddt(V(cpphdl_n611, Vss)); // Bench initial voltage = 0.0 V.
        // device 242, IC IC40, analog/basic/strongarm_comparator.hpp:47
        I(cpphdl_n591, cpphdl_n598) <+ 2e-14 * ddt(V(cpphdl_n591, cpphdl_n598)); // Bench initial voltage = 3.2999999999999998 V.
        // device 243, IC IC40, analog/basic/strongarm_comparator.hpp:48
        I(cpphdl_n592, cpphdl_n598) <+ 2e-14 * ddt(V(cpphdl_n592, cpphdl_n598)); // Bench initial voltage = 3.2999999999999998 V.
        // device 244, IC IC40, analog/basic/strongarm_comparator.hpp:49
        I(cpphdl_n591, cpphdl_n596) <+ 2.9999999999999998e-15 * ddt(V(cpphdl_n591, cpphdl_n596)); // Bench initial voltage = 3.2999999999999998 V.
        // device 245, IC IC40, analog/basic/strongarm_comparator.hpp:50
        I(cpphdl_n592, cpphdl_n597) <+ 2.9999999999999998e-15 * ddt(V(cpphdl_n592, cpphdl_n597)); // Bench initial voltage = 3.2999999999999998 V.
        // device 246, IC IC42, analog/basic/inverter.hpp:11
        I(cpphdl_n619, Vdd) <+ cpphdl_channel(V(cpphdl_n611, Vdd), V(cpphdl_n619, Vdd), 0.001, 0.69999999999999996, -1.0);
        // device 247, IC IC42, analog/basic/inverter.hpp:12
        I(cpphdl_n619, Vss) <+ cpphdl_channel(V(cpphdl_n611, Vss), V(cpphdl_n619, Vss), 0.001, 0.69999999999999996, 1.0);
        // device 248, IC IC44, analog/basic/inverter.hpp:11
        I(cpphdl_n633, Vdd) <+ cpphdl_channel(V(cpphdl_n619, Vdd), V(cpphdl_n633, Vdd), 0.0040000000000000001, 0.69999999999999996, -1.0);
        // device 249, IC IC44, analog/basic/inverter.hpp:12
        I(cpphdl_n633, Vss) <+ cpphdl_channel(V(cpphdl_n619, Vss), V(cpphdl_n633, Vss), 0.0040000000000000001, 0.69999999999999996, 1.0);
        // device 250, IC IC41, analog/basic/buffered_nand_latch.hpp:34
        I(cpphdl_n611, Vss) <+ 2.0000000000000002e-15 * ddt(V(cpphdl_n611, Vss)); // Bench initial voltage = 0.0 V.
        // device 251, IC IC41, analog/basic/buffered_nand_latch.hpp:35
        I(cpphdl_n611, cpphdl_n619) <+ 1.0000000000000001e-15 * ddt(V(cpphdl_n611, cpphdl_n619)); // Bench initial voltage = 0.0 V.
        // device 252, IC IC41, analog/basic/buffered_nand_latch.hpp:36
        I(cpphdl_n619, Vss) <+ 5e-15 * ddt(V(cpphdl_n619, Vss)); // Bench initial voltage = 0.0 V.
        // device 253, IC IC41, analog/basic/buffered_nand_latch.hpp:37
        I(cpphdl_n619, Vss) <+ 8.0000000000000006e-15 * ddt(V(cpphdl_n619, Vss)); // Bench initial voltage = 0.0 V.
        // device 254, IC IC41, analog/basic/buffered_nand_latch.hpp:38
        I(cpphdl_n633, Vss) <+ 1e-14 * ddt(V(cpphdl_n633, Vss)); // Bench initial voltage = 0.0 V.
        // device 255, IC IC43, analog/basic/inverter.hpp:11
        I(cpphdl_n623, Vdd) <+ cpphdl_channel(V(cpphdl_n615, Vdd), V(cpphdl_n623, Vdd), 0.001, 0.69999999999999996, -1.0);
        // device 256, IC IC43, analog/basic/inverter.hpp:12
        I(cpphdl_n623, Vss) <+ cpphdl_channel(V(cpphdl_n615, Vss), V(cpphdl_n623, Vss), 0.001, 0.69999999999999996, 1.0);
        // device 257, IC IC45, analog/basic/inverter.hpp:11
        I(cpphdl_n639, Vdd) <+ cpphdl_channel(V(cpphdl_n623, Vdd), V(cpphdl_n639, Vdd), 0.0040000000000000001, 0.69999999999999996, -1.0);
        // device 258, IC IC45, analog/basic/inverter.hpp:12
        I(cpphdl_n639, Vss) <+ cpphdl_channel(V(cpphdl_n623, Vss), V(cpphdl_n639, Vss), 0.0040000000000000001, 0.69999999999999996, 1.0);
        // device 259, IC IC41, analog/basic/buffered_nand_latch.hpp:34
        I(cpphdl_n615, Vss) <+ 2.0000000000000002e-15 * ddt(V(cpphdl_n615, Vss)); // Bench initial voltage = 0.0 V.
        // device 260, IC IC41, analog/basic/buffered_nand_latch.hpp:35
        I(cpphdl_n615, cpphdl_n623) <+ 1.0000000000000001e-15 * ddt(V(cpphdl_n615, cpphdl_n623)); // Bench initial voltage = 0.0 V.
        // device 261, IC IC41, analog/basic/buffered_nand_latch.hpp:36
        I(cpphdl_n623, Vss) <+ 5e-15 * ddt(V(cpphdl_n623, Vss)); // Bench initial voltage = 0.0 V.
        // device 262, IC IC41, analog/basic/buffered_nand_latch.hpp:37
        I(cpphdl_n623, Vss) <+ 8.0000000000000006e-15 * ddt(V(cpphdl_n623, Vss)); // Bench initial voltage = 0.0 V.
        // device 263, IC IC41, analog/basic/buffered_nand_latch.hpp:38
        I(cpphdl_n639, Vss) <+ 1e-14 * ddt(V(cpphdl_n639, Vss)); // Bench initial voltage = 0.0 V.
        // device 264, IC IC47, analog/basic/cmos_logic.hpp:17
        I(cpphdl_n2674, Vss) <+ 5.0000000000000002e-14 * ddt(V(cpphdl_n2674, Vss)); // Bench initial voltage = 0.0 V.
        // device 265, IC IC47, analog/basic/cmos_logic.hpp:18
        I(cpphdl_n2674, Vdd) <+ cpphdl_channel(V(cpphdl_n633, Vdd), V(cpphdl_n2674, Vdd), 0.01, 0.69999999999999996, -1.0);
        // device 266, IC IC47, analog/basic/cmos_logic.hpp:19
        I(cpphdl_n2674, Vdd) <+ cpphdl_channel(V(cpphdl_n641, Vdd), V(cpphdl_n2674, Vdd), 0.01, 0.69999999999999996, -1.0);
        // device 267, IC IC47, analog/basic/cmos_logic.hpp:20
        I(cpphdl_n2674, cpphdl_n636) <+ cpphdl_channel(V(cpphdl_n633, cpphdl_n636), V(cpphdl_n2674, cpphdl_n636), 0.01, 0.69999999999999996, 1.0);
        // device 268, IC IC47, analog/basic/cmos_logic.hpp:21
        I(cpphdl_n636, Vss) <+ cpphdl_channel(V(cpphdl_n641, Vss), V(cpphdl_n636, Vss), 0.01, 0.69999999999999996, 1.0);
        // device 269, IC IC47, analog/basic/cmos_logic.hpp:23
        I(cpphdl_n2674, Vss) <+ V(cpphdl_n2674, Vss) / 1000000000.0;
        // device 270, IC IC47, analog/basic/cmos_logic.hpp:24
        I(cpphdl_n636, Vss) <+ V(cpphdl_n636, Vss) / 1000000000.0;
        // device 271, IC IC48, analog/basic/cmos_logic.hpp:17
        I(cpphdl_n641, Vss) <+ 5.0000000000000002e-14 * ddt(V(cpphdl_n641, Vss)); // Bench initial voltage = 0.0 V.
        // device 272, IC IC48, analog/basic/cmos_logic.hpp:18
        I(cpphdl_n641, Vdd) <+ cpphdl_channel(V(cpphdl_n639, Vdd), V(cpphdl_n641, Vdd), 0.01, 0.69999999999999996, -1.0);
        // device 273, IC IC48, analog/basic/cmos_logic.hpp:19
        I(cpphdl_n641, Vdd) <+ cpphdl_channel(V(cpphdl_n2674, Vdd), V(cpphdl_n641, Vdd), 0.01, 0.69999999999999996, -1.0);
        // device 274, IC IC48, analog/basic/cmos_logic.hpp:20
        I(cpphdl_n641, cpphdl_n642) <+ cpphdl_channel(V(cpphdl_n639, cpphdl_n642), V(cpphdl_n641, cpphdl_n642), 0.01, 0.69999999999999996, 1.0);
        // device 275, IC IC48, analog/basic/cmos_logic.hpp:21
        I(cpphdl_n642, Vss) <+ cpphdl_channel(V(cpphdl_n2674, Vss), V(cpphdl_n642, Vss), 0.01, 0.69999999999999996, 1.0);
        // device 276, IC IC48, analog/basic/cmos_logic.hpp:23
        I(cpphdl_n641, Vss) <+ V(cpphdl_n641, Vss) / 1000000000.0;
        // device 277, IC IC48, analog/basic/cmos_logic.hpp:24
        I(cpphdl_n642, Vss) <+ V(cpphdl_n642, Vss) / 1000000000.0;
        // device 278, IC IC46, analog/basic/nand_latch.hpp:36
        I(cpphdl_n633, Vss) <+ 2.9999999999999998e-15 * ddt(V(cpphdl_n633, Vss)); // Bench initial voltage = 0.0 V.
        // device 279, IC IC46, analog/basic/nand_latch.hpp:37
        I(cpphdl_n639, Vss) <+ 2.9999999999999998e-15 * ddt(V(cpphdl_n639, Vss)); // Bench initial voltage = 0.0 V.
        // device 280, IC IC49, analog/basic/inverter.hpp:11
        I(cpphdl_n647, Vdd) <+ cpphdl_channel(V(CLEAR, Vdd), V(cpphdl_n647, Vdd), 0.01, 0.69999999999999996, -1.0);
        // device 281, IC IC49, analog/basic/inverter.hpp:12
        I(cpphdl_n647, Vss) <+ cpphdl_channel(V(CLEAR, Vss), V(cpphdl_n647, Vss), 0.01, 0.69999999999999996, 1.0);
        // device 282, IC IC46, analog/basic/nand_latch.hpp:58
        I(cpphdl_n647, Vss) <+ 2.9999999999999998e-15 * ddt(V(cpphdl_n647, Vss)); // Bench initial voltage = 0.0 V.
        // device 283, IC IC46, analog/basic/nand_latch.hpp:59
        I(cpphdl_n2674, Vss) <+ cpphdl_channel(V(CLEAR, Vss), V(cpphdl_n2674, Vss), 0.050000000000000003, 0.69999999999999996, 1.0);
        // device 284, IC IC46, analog/basic/nand_latch.hpp:60
        I(cpphdl_n641, Vdd) <+ cpphdl_channel(V(cpphdl_n647, Vdd), V(cpphdl_n641, Vdd), 0.050000000000000003, 0.69999999999999996, -1.0);
        // device 285, IC IC52, analog/basic/inverter.hpp:11
        I(cpphdl_n671, Vdd) <+ cpphdl_channel(V(TRACK2, Vdd), V(cpphdl_n671, Vdd), 0.0040000000000000001, 0.69999999999999996, -1.0);
        // device 286, IC IC52, analog/basic/inverter.hpp:12
        I(cpphdl_n671, Vss) <+ cpphdl_channel(V(TRACK2, Vss), V(cpphdl_n671, Vss), 0.0040000000000000001, 0.69999999999999996, 1.0);
        // device 287, IC IC51, analog/basic/mos_track_hold.hpp:31
        I(cpphdl_n671, Vss) <+ 2e-14 * ddt(V(cpphdl_n671, Vss)); // Bench initial voltage = 3.2999999999999998 V.
        // device 288, IC IC51, analog/basic/mos_track_hold.hpp:32
        I(cpphdl_n2759, cpphdl_n725) <+ cpphdl_channel(V(TRACK2, cpphdl_n725), V(cpphdl_n2759, cpphdl_n725), 0.080000000000000002, 0.69999999999999996, 1.0);
        // device 289, IC IC51, analog/basic/mos_track_hold.hpp:33
        I(cpphdl_n725, cpphdl_n2759) <+ cpphdl_channel(V(cpphdl_n671, cpphdl_n2759), V(cpphdl_n725, cpphdl_n2759), 0.040000000000000001, 0.69999999999999996, -1.0);
        // device 290, IC IC51, analog/basic/mos_track_hold.hpp:37
        I(cpphdl_n725, cpphdl_n725) <+ cpphdl_channel(V(cpphdl_n671, cpphdl_n725), V(cpphdl_n725, cpphdl_n725), 0.040000000000000001, 0.69999999999999996, 1.0);
        // device 291, IC IC51, analog/basic/mos_track_hold.hpp:38
        I(cpphdl_n725, cpphdl_n725) <+ cpphdl_channel(V(TRACK2, cpphdl_n725), V(cpphdl_n725, cpphdl_n725), 0.02, 0.69999999999999996, -1.0);
        // device 292, IC IC51, analog/basic/mos_track_hold.hpp:39
        I(cpphdl_n725, Vss) <+ 3.0000000000000001e-12 * ddt(V(cpphdl_n725, Vss)); // Bench initial voltage = 1.6499999999999999 V.
        // device 293, IC IC51, analog/basic/mos_track_hold.hpp:41
        I(Vss, cpphdl_n725) <+ V(Vss, cpphdl_n725) / 1000000000.0;
        // device 294, IC IC51, analog/basic/mos_track_hold.hpp:42
        I(TRACK2, cpphdl_n725) <+ 8.0000000000000006e-15 * ddt(V(TRACK2, cpphdl_n725)); // Bench initial voltage = -1.6499999999999999 V.
        // device 295, IC IC51, analog/basic/mos_track_hold.hpp:43
        I(cpphdl_n671, cpphdl_n725) <+ 8.0000000000000006e-15 * ddt(V(cpphdl_n671, cpphdl_n725)); // Bench initial voltage = 1.6499999999999999 V.
        // device 296, IC IC51, analog/basic/mos_track_hold.hpp:44
        I(cpphdl_n2759, cpphdl_n725) <+ 4.0000000000000003e-15 * ddt(V(cpphdl_n2759, cpphdl_n725)); // Bench initial voltage = 0.0 V.
        // device 297, IC IC54, analog/basic/inverter.hpp:11
        I(cpphdl_n686, Vdd) <+ cpphdl_channel(V(BIT_N2_0, Vdd), V(cpphdl_n686, Vdd), 0.080000000000000002, 0.69999999999999996, -1.0);
        // device 298, IC IC54, analog/basic/inverter.hpp:12
        I(cpphdl_n686, Vss) <+ cpphdl_channel(V(BIT_N2_0, Vss), V(cpphdl_n686, Vss), 0.080000000000000002, 0.69999999999999996, 1.0);
        // device 299, IC IC53, analog/basic/mos_r2r_dac.hpp:27
        I(cpphdl_n686, Vss) <+ 2.9999999999999998e-15 * ddt(V(cpphdl_n686, Vss)); // Bench initial voltage = 0.0 V.
        // device 300, IC IC53, analog/basic/mos_r2r_dac.hpp:28
        I(cpphdl_n686, cpphdl_n715) <+ V(cpphdl_n686, cpphdl_n715) / 2000.0;
        // device 301, IC IC53, analog/basic/mos_r2r_dac.hpp:29
        I(cpphdl_n715, Vss) <+ 2.9999999999999998e-15 * ddt(V(cpphdl_n715, Vss)); // Bench initial voltage = 0.0 V.
        // device 302, IC IC55, analog/basic/inverter.hpp:11
        I(cpphdl_n690, Vdd) <+ cpphdl_channel(V(BIT_N2_1, Vdd), V(cpphdl_n690, Vdd), 0.080000000000000002, 0.69999999999999996, -1.0);
        // device 303, IC IC55, analog/basic/inverter.hpp:12
        I(cpphdl_n690, Vss) <+ cpphdl_channel(V(BIT_N2_1, Vss), V(cpphdl_n690, Vss), 0.080000000000000002, 0.69999999999999996, 1.0);
        // device 304, IC IC53, analog/basic/mos_r2r_dac.hpp:27
        I(cpphdl_n690, Vss) <+ 2.9999999999999998e-15 * ddt(V(cpphdl_n690, Vss)); // Bench initial voltage = 0.0 V.
        // device 305, IC IC53, analog/basic/mos_r2r_dac.hpp:28
        I(cpphdl_n690, cpphdl_n716) <+ V(cpphdl_n690, cpphdl_n716) / 2000.0;
        // device 306, IC IC53, analog/basic/mos_r2r_dac.hpp:29
        I(cpphdl_n716, Vss) <+ 2.9999999999999998e-15 * ddt(V(cpphdl_n716, Vss)); // Bench initial voltage = 0.0 V.
        // device 307, IC IC53, analog/basic/mos_r2r_dac.hpp:31
        I(cpphdl_n715, cpphdl_n716) <+ V(cpphdl_n715, cpphdl_n716) / 1000.0;
        // device 308, IC IC56, analog/basic/inverter.hpp:11
        I(cpphdl_n694, Vdd) <+ cpphdl_channel(V(BIT_N2_2, Vdd), V(cpphdl_n694, Vdd), 0.080000000000000002, 0.69999999999999996, -1.0);
        // device 309, IC IC56, analog/basic/inverter.hpp:12
        I(cpphdl_n694, Vss) <+ cpphdl_channel(V(BIT_N2_2, Vss), V(cpphdl_n694, Vss), 0.080000000000000002, 0.69999999999999996, 1.0);
        // device 310, IC IC53, analog/basic/mos_r2r_dac.hpp:27
        I(cpphdl_n694, Vss) <+ 2.9999999999999998e-15 * ddt(V(cpphdl_n694, Vss)); // Bench initial voltage = 0.0 V.
        // device 311, IC IC53, analog/basic/mos_r2r_dac.hpp:28
        I(cpphdl_n694, cpphdl_n717) <+ V(cpphdl_n694, cpphdl_n717) / 2000.0;
        // device 312, IC IC53, analog/basic/mos_r2r_dac.hpp:29
        I(cpphdl_n717, Vss) <+ 2.9999999999999998e-15 * ddt(V(cpphdl_n717, Vss)); // Bench initial voltage = 0.0 V.
        // device 313, IC IC53, analog/basic/mos_r2r_dac.hpp:31
        I(cpphdl_n716, cpphdl_n717) <+ V(cpphdl_n716, cpphdl_n717) / 1000.0;
        // device 314, IC IC57, analog/basic/inverter.hpp:11
        I(cpphdl_n698, Vdd) <+ cpphdl_channel(V(BIT_N2_3, Vdd), V(cpphdl_n698, Vdd), 0.080000000000000002, 0.69999999999999996, -1.0);
        // device 315, IC IC57, analog/basic/inverter.hpp:12
        I(cpphdl_n698, Vss) <+ cpphdl_channel(V(BIT_N2_3, Vss), V(cpphdl_n698, Vss), 0.080000000000000002, 0.69999999999999996, 1.0);
        // device 316, IC IC53, analog/basic/mos_r2r_dac.hpp:27
        I(cpphdl_n698, Vss) <+ 2.9999999999999998e-15 * ddt(V(cpphdl_n698, Vss)); // Bench initial voltage = 0.0 V.
        // device 317, IC IC53, analog/basic/mos_r2r_dac.hpp:28
        I(cpphdl_n698, cpphdl_n718) <+ V(cpphdl_n698, cpphdl_n718) / 2000.0;
        // device 318, IC IC53, analog/basic/mos_r2r_dac.hpp:29
        I(cpphdl_n718, Vss) <+ 2.9999999999999998e-15 * ddt(V(cpphdl_n718, Vss)); // Bench initial voltage = 0.0 V.
        // device 319, IC IC53, analog/basic/mos_r2r_dac.hpp:31
        I(cpphdl_n717, cpphdl_n718) <+ V(cpphdl_n717, cpphdl_n718) / 1000.0;
        // device 320, IC IC58, analog/basic/inverter.hpp:11
        I(cpphdl_n702, Vdd) <+ cpphdl_channel(V(BIT_N2_4, Vdd), V(cpphdl_n702, Vdd), 0.080000000000000002, 0.69999999999999996, -1.0);
        // device 321, IC IC58, analog/basic/inverter.hpp:12
        I(cpphdl_n702, Vss) <+ cpphdl_channel(V(BIT_N2_4, Vss), V(cpphdl_n702, Vss), 0.080000000000000002, 0.69999999999999996, 1.0);
        // device 322, IC IC53, analog/basic/mos_r2r_dac.hpp:27
        I(cpphdl_n702, Vss) <+ 2.9999999999999998e-15 * ddt(V(cpphdl_n702, Vss)); // Bench initial voltage = 0.0 V.
        // device 323, IC IC53, analog/basic/mos_r2r_dac.hpp:28
        I(cpphdl_n702, cpphdl_n719) <+ V(cpphdl_n702, cpphdl_n719) / 2000.0;
        // device 324, IC IC53, analog/basic/mos_r2r_dac.hpp:29
        I(cpphdl_n719, Vss) <+ 2.9999999999999998e-15 * ddt(V(cpphdl_n719, Vss)); // Bench initial voltage = 0.0 V.
        // device 325, IC IC53, analog/basic/mos_r2r_dac.hpp:31
        I(cpphdl_n718, cpphdl_n719) <+ V(cpphdl_n718, cpphdl_n719) / 1000.0;
        // device 326, IC IC59, analog/basic/inverter.hpp:11
        I(cpphdl_n706, Vdd) <+ cpphdl_channel(V(BIT_N2_5, Vdd), V(cpphdl_n706, Vdd), 0.080000000000000002, 0.69999999999999996, -1.0);
        // device 327, IC IC59, analog/basic/inverter.hpp:12
        I(cpphdl_n706, Vss) <+ cpphdl_channel(V(BIT_N2_5, Vss), V(cpphdl_n706, Vss), 0.080000000000000002, 0.69999999999999996, 1.0);
        // device 328, IC IC53, analog/basic/mos_r2r_dac.hpp:27
        I(cpphdl_n706, Vss) <+ 2.9999999999999998e-15 * ddt(V(cpphdl_n706, Vss)); // Bench initial voltage = 0.0 V.
        // device 329, IC IC53, analog/basic/mos_r2r_dac.hpp:28
        I(cpphdl_n706, cpphdl_n720) <+ V(cpphdl_n706, cpphdl_n720) / 2000.0;
        // device 330, IC IC53, analog/basic/mos_r2r_dac.hpp:29
        I(cpphdl_n720, Vss) <+ 2.9999999999999998e-15 * ddt(V(cpphdl_n720, Vss)); // Bench initial voltage = 0.0 V.
        // device 331, IC IC53, analog/basic/mos_r2r_dac.hpp:31
        I(cpphdl_n719, cpphdl_n720) <+ V(cpphdl_n719, cpphdl_n720) / 1000.0;
        // device 332, IC IC60, analog/basic/inverter.hpp:11
        I(cpphdl_n710, Vdd) <+ cpphdl_channel(V(BIT_N2_6, Vdd), V(cpphdl_n710, Vdd), 0.080000000000000002, 0.69999999999999996, -1.0);
        // device 333, IC IC60, analog/basic/inverter.hpp:12
        I(cpphdl_n710, Vss) <+ cpphdl_channel(V(BIT_N2_6, Vss), V(cpphdl_n710, Vss), 0.080000000000000002, 0.69999999999999996, 1.0);
        // device 334, IC IC53, analog/basic/mos_r2r_dac.hpp:27
        I(cpphdl_n710, Vss) <+ 2.9999999999999998e-15 * ddt(V(cpphdl_n710, Vss)); // Bench initial voltage = 0.0 V.
        // device 335, IC IC53, analog/basic/mos_r2r_dac.hpp:28
        I(cpphdl_n710, cpphdl_n721) <+ V(cpphdl_n710, cpphdl_n721) / 2000.0;
        // device 336, IC IC53, analog/basic/mos_r2r_dac.hpp:29
        I(cpphdl_n721, Vss) <+ 2.9999999999999998e-15 * ddt(V(cpphdl_n721, Vss)); // Bench initial voltage = 0.0 V.
        // device 337, IC IC53, analog/basic/mos_r2r_dac.hpp:31
        I(cpphdl_n720, cpphdl_n721) <+ V(cpphdl_n720, cpphdl_n721) / 1000.0;
        // device 338, IC IC61, analog/basic/inverter.hpp:11
        I(cpphdl_n714, Vdd) <+ cpphdl_channel(V(BIT_N2_7, Vdd), V(cpphdl_n714, Vdd), 0.080000000000000002, 0.69999999999999996, -1.0);
        // device 339, IC IC61, analog/basic/inverter.hpp:12
        I(cpphdl_n714, Vss) <+ cpphdl_channel(V(BIT_N2_7, Vss), V(cpphdl_n714, Vss), 0.080000000000000002, 0.69999999999999996, 1.0);
        // device 340, IC IC53, analog/basic/mos_r2r_dac.hpp:27
        I(cpphdl_n714, Vss) <+ 2.9999999999999998e-15 * ddt(V(cpphdl_n714, Vss)); // Bench initial voltage = 0.0 V.
        // device 341, IC IC53, analog/basic/mos_r2r_dac.hpp:28
        I(cpphdl_n714, cpphdl_n726) <+ V(cpphdl_n714, cpphdl_n726) / 2000.0;
        // device 342, IC IC53, analog/basic/mos_r2r_dac.hpp:29
        I(cpphdl_n726, Vss) <+ 2.9999999999999998e-15 * ddt(V(cpphdl_n726, Vss)); // Bench initial voltage = 0.0 V.
        // device 343, IC IC53, analog/basic/mos_r2r_dac.hpp:31
        I(cpphdl_n721, cpphdl_n726) <+ V(cpphdl_n721, cpphdl_n726) / 1000.0;
        // device 344, IC IC53, analog/basic/mos_r2r_dac.hpp:33
        I(Vss, cpphdl_n715) <+ V(Vss, cpphdl_n715) / 2000.0;
        // device 345, IC IC62, analog/basic/nmos_resistor_amplifier.hpp:23
        I(Vdd, cpphdl_n735) <+ V(Vdd, cpphdl_n735) / 500.0;
        // device 346, IC IC62, analog/basic/nmos_resistor_amplifier.hpp:24
        I(Vdd, cpphdl_n734) <+ V(Vdd, cpphdl_n734) / 500.0;
        // device 347, IC IC62, analog/basic/nmos_resistor_amplifier.hpp:25
        I(cpphdl_n735, cpphdl_n729) <+ cpphdl_channel(V(cpphdl_n725, cpphdl_n729), V(cpphdl_n735, cpphdl_n729), 0.014999999999999999, 0.69999999999999996, 1.0);
        // device 348, IC IC62, analog/basic/nmos_resistor_amplifier.hpp:26
        I(cpphdl_n734, cpphdl_n730) <+ cpphdl_channel(V(cpphdl_n726, cpphdl_n730), V(cpphdl_n734, cpphdl_n730), 0.014999999999999999, 0.69999999999999996, 1.0);
        // device 349, IC IC62, analog/basic/nmos_resistor_amplifier.hpp:27
        I(cpphdl_n731, cpphdl_n729) <+ V(cpphdl_n731, cpphdl_n729) / 50.0;
        // device 350, IC IC62, analog/basic/nmos_resistor_amplifier.hpp:28
        I(cpphdl_n731, cpphdl_n730) <+ V(cpphdl_n731, cpphdl_n730) / 50.0;
        // device 351, IC IC62, analog/basic/nmos_resistor_amplifier.hpp:29
        I(Vss, cpphdl_n731) <+ V(Vss, cpphdl_n731) / 150.0;
        // device 352, IC IC62, analog/basic/nmos_resistor_amplifier.hpp:30
        I(cpphdl_n735, Vdd) <+ 2.9999999999999998e-13 * ddt(V(cpphdl_n735, Vdd)); // Bench initial voltage = 0.0 V.
        // device 353, IC IC62, analog/basic/nmos_resistor_amplifier.hpp:31
        I(cpphdl_n734, Vdd) <+ 2.9999999999999998e-13 * ddt(V(cpphdl_n734, Vdd)); // Bench initial voltage = 0.0 V.
        // device 354, IC IC62, analog/basic/nmos_resistor_amplifier.hpp:32
        I(cpphdl_n731, Vss) <+ 4e-14 * ddt(V(cpphdl_n731, Vss)); // Bench initial voltage = 0.0 V.
        // device 355, IC IC62, analog/basic/nmos_resistor_amplifier.hpp:34
        I(cpphdl_n725, cpphdl_n729) <+ 2e-14 * ddt(V(cpphdl_n725, cpphdl_n729)); // Bench initial voltage = 1.6499999999999999 V.
        // device 356, IC IC62, analog/basic/nmos_resistor_amplifier.hpp:35
        I(cpphdl_n726, cpphdl_n730) <+ 2e-14 * ddt(V(cpphdl_n726, cpphdl_n730)); // Bench initial voltage = 0.0 V.
        // device 357, IC IC62, analog/basic/nmos_resistor_amplifier.hpp:36
        I(cpphdl_n725, cpphdl_n735) <+ 2.9999999999999998e-15 * ddt(V(cpphdl_n725, cpphdl_n735)); // Bench initial voltage = -1.6499999999999999 V.
        // device 358, IC IC62, analog/basic/nmos_resistor_amplifier.hpp:37
        I(cpphdl_n726, cpphdl_n734) <+ 2.9999999999999998e-15 * ddt(V(cpphdl_n726, cpphdl_n734)); // Bench initial voltage = -3.2999999999999998 V.
        // device 359, IC IC63, analog/basic/strongarm_comparator.hpp:28
        I(cpphdl_n739, cpphdl_n741) <+ cpphdl_channel(V(cpphdl_n734, cpphdl_n741), V(cpphdl_n739, cpphdl_n741), 0.0080000000000000002, 0.69999999999999996, 1.0);
        // device 360, IC IC63, analog/basic/strongarm_comparator.hpp:29
        I(cpphdl_n740, cpphdl_n741) <+ cpphdl_channel(V(cpphdl_n735, cpphdl_n741), V(cpphdl_n740, cpphdl_n741), 0.0080000000000000002, 0.69999999999999996, 1.0);
        // device 361, IC IC63, analog/basic/strongarm_comparator.hpp:30
        I(cpphdl_n741, Vss) <+ cpphdl_channel(V(EVALUATE, Vss), V(cpphdl_n741, Vss), 0.0080000000000000002, 0.69999999999999996, 1.0);
        // device 362, IC IC63, analog/basic/strongarm_comparator.hpp:33
        I(cpphdl_n754, cpphdl_n739) <+ cpphdl_channel(V(cpphdl_n758, cpphdl_n739), V(cpphdl_n754, cpphdl_n739), 0.0040000000000000001, 0.69999999999999996, 1.0);
        // device 363, IC IC63, analog/basic/strongarm_comparator.hpp:34
        I(cpphdl_n758, cpphdl_n740) <+ cpphdl_channel(V(cpphdl_n754, cpphdl_n740), V(cpphdl_n758, cpphdl_n740), 0.0040000000000000001, 0.69999999999999996, 1.0);
        // device 364, IC IC63, analog/basic/strongarm_comparator.hpp:35
        I(cpphdl_n758, Vdd) <+ cpphdl_channel(V(cpphdl_n754, Vdd), V(cpphdl_n758, Vdd), 0.002, 0.69999999999999996, -1.0);
        // device 365, IC IC63, analog/basic/strongarm_comparator.hpp:36
        I(cpphdl_n754, Vdd) <+ cpphdl_channel(V(cpphdl_n758, Vdd), V(cpphdl_n754, Vdd), 0.002, 0.69999999999999996, -1.0);
        // device 366, IC IC63, analog/basic/strongarm_comparator.hpp:38
        I(cpphdl_n739, Vdd) <+ cpphdl_channel(V(EVALUATE, Vdd), V(cpphdl_n739, Vdd), 0.002, 0.69999999999999996, -1.0);
        // device 367, IC IC63, analog/basic/strongarm_comparator.hpp:39
        I(cpphdl_n740, Vdd) <+ cpphdl_channel(V(EVALUATE, Vdd), V(cpphdl_n740, Vdd), 0.002, 0.69999999999999996, -1.0);
        // device 368, IC IC63, analog/basic/strongarm_comparator.hpp:40
        I(cpphdl_n758, Vdd) <+ cpphdl_channel(V(EVALUATE, Vdd), V(cpphdl_n758, Vdd), 0.002, 0.69999999999999996, -1.0);
        // device 369, IC IC63, analog/basic/strongarm_comparator.hpp:41
        I(cpphdl_n754, Vdd) <+ cpphdl_channel(V(EVALUATE, Vdd), V(cpphdl_n754, Vdd), 0.002, 0.69999999999999996, -1.0);
        // device 370, IC IC63, analog/basic/strongarm_comparator.hpp:42
        I(cpphdl_n739, Vss) <+ 2.9999999999999998e-14 * ddt(V(cpphdl_n739, Vss)); // Bench initial voltage = 0.0 V.
        // device 371, IC IC63, analog/basic/strongarm_comparator.hpp:43
        I(cpphdl_n740, Vss) <+ 2.9999999999999998e-14 * ddt(V(cpphdl_n740, Vss)); // Bench initial voltage = 0.0 V.
        // device 372, IC IC63, analog/basic/strongarm_comparator.hpp:44
        I(cpphdl_n741, Vss) <+ 2.9999999999999998e-14 * ddt(V(cpphdl_n741, Vss)); // Bench initial voltage = 0.0 V.
        // device 373, IC IC63, analog/basic/strongarm_comparator.hpp:45
        I(cpphdl_n758, Vss) <+ 5.0000000000000002e-14 * ddt(V(cpphdl_n758, Vss)); // Bench initial voltage = 0.0 V.
        // device 374, IC IC63, analog/basic/strongarm_comparator.hpp:46
        I(cpphdl_n754, Vss) <+ 5.0000000000000002e-14 * ddt(V(cpphdl_n754, Vss)); // Bench initial voltage = 0.0 V.
        // device 375, IC IC63, analog/basic/strongarm_comparator.hpp:47
        I(cpphdl_n734, cpphdl_n741) <+ 2e-14 * ddt(V(cpphdl_n734, cpphdl_n741)); // Bench initial voltage = 3.2999999999999998 V.
        // device 376, IC IC63, analog/basic/strongarm_comparator.hpp:48
        I(cpphdl_n735, cpphdl_n741) <+ 2e-14 * ddt(V(cpphdl_n735, cpphdl_n741)); // Bench initial voltage = 3.2999999999999998 V.
        // device 377, IC IC63, analog/basic/strongarm_comparator.hpp:49
        I(cpphdl_n734, cpphdl_n739) <+ 2.9999999999999998e-15 * ddt(V(cpphdl_n734, cpphdl_n739)); // Bench initial voltage = 3.2999999999999998 V.
        // device 378, IC IC63, analog/basic/strongarm_comparator.hpp:50
        I(cpphdl_n735, cpphdl_n740) <+ 2.9999999999999998e-15 * ddt(V(cpphdl_n735, cpphdl_n740)); // Bench initial voltage = 3.2999999999999998 V.
        // device 379, IC IC65, analog/basic/inverter.hpp:11
        I(cpphdl_n762, Vdd) <+ cpphdl_channel(V(cpphdl_n754, Vdd), V(cpphdl_n762, Vdd), 0.001, 0.69999999999999996, -1.0);
        // device 380, IC IC65, analog/basic/inverter.hpp:12
        I(cpphdl_n762, Vss) <+ cpphdl_channel(V(cpphdl_n754, Vss), V(cpphdl_n762, Vss), 0.001, 0.69999999999999996, 1.0);
        // device 381, IC IC67, analog/basic/inverter.hpp:11
        I(cpphdl_n776, Vdd) <+ cpphdl_channel(V(cpphdl_n762, Vdd), V(cpphdl_n776, Vdd), 0.0040000000000000001, 0.69999999999999996, -1.0);
        // device 382, IC IC67, analog/basic/inverter.hpp:12
        I(cpphdl_n776, Vss) <+ cpphdl_channel(V(cpphdl_n762, Vss), V(cpphdl_n776, Vss), 0.0040000000000000001, 0.69999999999999996, 1.0);
        // device 383, IC IC64, analog/basic/buffered_nand_latch.hpp:34
        I(cpphdl_n754, Vss) <+ 2.0000000000000002e-15 * ddt(V(cpphdl_n754, Vss)); // Bench initial voltage = 0.0 V.
        // device 384, IC IC64, analog/basic/buffered_nand_latch.hpp:35
        I(cpphdl_n754, cpphdl_n762) <+ 1.0000000000000001e-15 * ddt(V(cpphdl_n754, cpphdl_n762)); // Bench initial voltage = 0.0 V.
        // device 385, IC IC64, analog/basic/buffered_nand_latch.hpp:36
        I(cpphdl_n762, Vss) <+ 5e-15 * ddt(V(cpphdl_n762, Vss)); // Bench initial voltage = 0.0 V.
        // device 386, IC IC64, analog/basic/buffered_nand_latch.hpp:37
        I(cpphdl_n762, Vss) <+ 8.0000000000000006e-15 * ddt(V(cpphdl_n762, Vss)); // Bench initial voltage = 0.0 V.
        // device 387, IC IC64, analog/basic/buffered_nand_latch.hpp:38
        I(cpphdl_n776, Vss) <+ 1e-14 * ddt(V(cpphdl_n776, Vss)); // Bench initial voltage = 0.0 V.
        // device 388, IC IC66, analog/basic/inverter.hpp:11
        I(cpphdl_n766, Vdd) <+ cpphdl_channel(V(cpphdl_n758, Vdd), V(cpphdl_n766, Vdd), 0.001, 0.69999999999999996, -1.0);
        // device 389, IC IC66, analog/basic/inverter.hpp:12
        I(cpphdl_n766, Vss) <+ cpphdl_channel(V(cpphdl_n758, Vss), V(cpphdl_n766, Vss), 0.001, 0.69999999999999996, 1.0);
        // device 390, IC IC68, analog/basic/inverter.hpp:11
        I(cpphdl_n782, Vdd) <+ cpphdl_channel(V(cpphdl_n766, Vdd), V(cpphdl_n782, Vdd), 0.0040000000000000001, 0.69999999999999996, -1.0);
        // device 391, IC IC68, analog/basic/inverter.hpp:12
        I(cpphdl_n782, Vss) <+ cpphdl_channel(V(cpphdl_n766, Vss), V(cpphdl_n782, Vss), 0.0040000000000000001, 0.69999999999999996, 1.0);
        // device 392, IC IC64, analog/basic/buffered_nand_latch.hpp:34
        I(cpphdl_n758, Vss) <+ 2.0000000000000002e-15 * ddt(V(cpphdl_n758, Vss)); // Bench initial voltage = 0.0 V.
        // device 393, IC IC64, analog/basic/buffered_nand_latch.hpp:35
        I(cpphdl_n758, cpphdl_n766) <+ 1.0000000000000001e-15 * ddt(V(cpphdl_n758, cpphdl_n766)); // Bench initial voltage = 0.0 V.
        // device 394, IC IC64, analog/basic/buffered_nand_latch.hpp:36
        I(cpphdl_n766, Vss) <+ 5e-15 * ddt(V(cpphdl_n766, Vss)); // Bench initial voltage = 0.0 V.
        // device 395, IC IC64, analog/basic/buffered_nand_latch.hpp:37
        I(cpphdl_n766, Vss) <+ 8.0000000000000006e-15 * ddt(V(cpphdl_n766, Vss)); // Bench initial voltage = 0.0 V.
        // device 396, IC IC64, analog/basic/buffered_nand_latch.hpp:38
        I(cpphdl_n782, Vss) <+ 1e-14 * ddt(V(cpphdl_n782, Vss)); // Bench initial voltage = 0.0 V.
        // device 397, IC IC70, analog/basic/cmos_logic.hpp:17
        I(cpphdl_n2679, Vss) <+ 5.0000000000000002e-14 * ddt(V(cpphdl_n2679, Vss)); // Bench initial voltage = 0.0 V.
        // device 398, IC IC70, analog/basic/cmos_logic.hpp:18
        I(cpphdl_n2679, Vdd) <+ cpphdl_channel(V(cpphdl_n776, Vdd), V(cpphdl_n2679, Vdd), 0.01, 0.69999999999999996, -1.0);
        // device 399, IC IC70, analog/basic/cmos_logic.hpp:19
        I(cpphdl_n2679, Vdd) <+ cpphdl_channel(V(cpphdl_n784, Vdd), V(cpphdl_n2679, Vdd), 0.01, 0.69999999999999996, -1.0);
        // device 400, IC IC70, analog/basic/cmos_logic.hpp:20
        I(cpphdl_n2679, cpphdl_n779) <+ cpphdl_channel(V(cpphdl_n776, cpphdl_n779), V(cpphdl_n2679, cpphdl_n779), 0.01, 0.69999999999999996, 1.0);
        // device 401, IC IC70, analog/basic/cmos_logic.hpp:21
        I(cpphdl_n779, Vss) <+ cpphdl_channel(V(cpphdl_n784, Vss), V(cpphdl_n779, Vss), 0.01, 0.69999999999999996, 1.0);
        // device 402, IC IC70, analog/basic/cmos_logic.hpp:23
        I(cpphdl_n2679, Vss) <+ V(cpphdl_n2679, Vss) / 1000000000.0;
        // device 403, IC IC70, analog/basic/cmos_logic.hpp:24
        I(cpphdl_n779, Vss) <+ V(cpphdl_n779, Vss) / 1000000000.0;
        // device 404, IC IC71, analog/basic/cmos_logic.hpp:17
        I(cpphdl_n784, Vss) <+ 5.0000000000000002e-14 * ddt(V(cpphdl_n784, Vss)); // Bench initial voltage = 0.0 V.
        // device 405, IC IC71, analog/basic/cmos_logic.hpp:18
        I(cpphdl_n784, Vdd) <+ cpphdl_channel(V(cpphdl_n782, Vdd), V(cpphdl_n784, Vdd), 0.01, 0.69999999999999996, -1.0);
        // device 406, IC IC71, analog/basic/cmos_logic.hpp:19
        I(cpphdl_n784, Vdd) <+ cpphdl_channel(V(cpphdl_n2679, Vdd), V(cpphdl_n784, Vdd), 0.01, 0.69999999999999996, -1.0);
        // device 407, IC IC71, analog/basic/cmos_logic.hpp:20
        I(cpphdl_n784, cpphdl_n785) <+ cpphdl_channel(V(cpphdl_n782, cpphdl_n785), V(cpphdl_n784, cpphdl_n785), 0.01, 0.69999999999999996, 1.0);
        // device 408, IC IC71, analog/basic/cmos_logic.hpp:21
        I(cpphdl_n785, Vss) <+ cpphdl_channel(V(cpphdl_n2679, Vss), V(cpphdl_n785, Vss), 0.01, 0.69999999999999996, 1.0);
        // device 409, IC IC71, analog/basic/cmos_logic.hpp:23
        I(cpphdl_n784, Vss) <+ V(cpphdl_n784, Vss) / 1000000000.0;
        // device 410, IC IC71, analog/basic/cmos_logic.hpp:24
        I(cpphdl_n785, Vss) <+ V(cpphdl_n785, Vss) / 1000000000.0;
        // device 411, IC IC69, analog/basic/nand_latch.hpp:36
        I(cpphdl_n776, Vss) <+ 2.9999999999999998e-15 * ddt(V(cpphdl_n776, Vss)); // Bench initial voltage = 0.0 V.
        // device 412, IC IC69, analog/basic/nand_latch.hpp:37
        I(cpphdl_n782, Vss) <+ 2.9999999999999998e-15 * ddt(V(cpphdl_n782, Vss)); // Bench initial voltage = 0.0 V.
        // device 413, IC IC72, analog/basic/inverter.hpp:11
        I(cpphdl_n790, Vdd) <+ cpphdl_channel(V(CLEAR, Vdd), V(cpphdl_n790, Vdd), 0.01, 0.69999999999999996, -1.0);
        // device 414, IC IC72, analog/basic/inverter.hpp:12
        I(cpphdl_n790, Vss) <+ cpphdl_channel(V(CLEAR, Vss), V(cpphdl_n790, Vss), 0.01, 0.69999999999999996, 1.0);
        // device 415, IC IC69, analog/basic/nand_latch.hpp:58
        I(cpphdl_n790, Vss) <+ 2.9999999999999998e-15 * ddt(V(cpphdl_n790, Vss)); // Bench initial voltage = 0.0 V.
        // device 416, IC IC69, analog/basic/nand_latch.hpp:59
        I(cpphdl_n2679, Vss) <+ cpphdl_channel(V(CLEAR, Vss), V(cpphdl_n2679, Vss), 0.050000000000000003, 0.69999999999999996, 1.0);
        // device 417, IC IC69, analog/basic/nand_latch.hpp:60
        I(cpphdl_n784, Vdd) <+ cpphdl_channel(V(cpphdl_n790, Vdd), V(cpphdl_n784, Vdd), 0.050000000000000003, 0.69999999999999996, -1.0);
        // device 418, IC IC75, analog/basic/inverter.hpp:11
        I(cpphdl_n814, Vdd) <+ cpphdl_channel(V(TRACK3, Vdd), V(cpphdl_n814, Vdd), 0.0040000000000000001, 0.69999999999999996, -1.0);
        // device 419, IC IC75, analog/basic/inverter.hpp:12
        I(cpphdl_n814, Vss) <+ cpphdl_channel(V(TRACK3, Vss), V(cpphdl_n814, Vss), 0.0040000000000000001, 0.69999999999999996, 1.0);
        // device 420, IC IC74, analog/basic/mos_track_hold.hpp:31
        I(cpphdl_n814, Vss) <+ 2e-14 * ddt(V(cpphdl_n814, Vss)); // Bench initial voltage = 3.2999999999999998 V.
        // device 421, IC IC74, analog/basic/mos_track_hold.hpp:32
        I(cpphdl_n2759, cpphdl_n868) <+ cpphdl_channel(V(TRACK3, cpphdl_n868), V(cpphdl_n2759, cpphdl_n868), 0.080000000000000002, 0.69999999999999996, 1.0);
        // device 422, IC IC74, analog/basic/mos_track_hold.hpp:33
        I(cpphdl_n868, cpphdl_n2759) <+ cpphdl_channel(V(cpphdl_n814, cpphdl_n2759), V(cpphdl_n868, cpphdl_n2759), 0.040000000000000001, 0.69999999999999996, -1.0);
        // device 423, IC IC74, analog/basic/mos_track_hold.hpp:37
        I(cpphdl_n868, cpphdl_n868) <+ cpphdl_channel(V(cpphdl_n814, cpphdl_n868), V(cpphdl_n868, cpphdl_n868), 0.040000000000000001, 0.69999999999999996, 1.0);
        // device 424, IC IC74, analog/basic/mos_track_hold.hpp:38
        I(cpphdl_n868, cpphdl_n868) <+ cpphdl_channel(V(TRACK3, cpphdl_n868), V(cpphdl_n868, cpphdl_n868), 0.02, 0.69999999999999996, -1.0);
        // device 425, IC IC74, analog/basic/mos_track_hold.hpp:39
        I(cpphdl_n868, Vss) <+ 3.0000000000000001e-12 * ddt(V(cpphdl_n868, Vss)); // Bench initial voltage = 1.6499999999999999 V.
        // device 426, IC IC74, analog/basic/mos_track_hold.hpp:41
        I(Vss, cpphdl_n868) <+ V(Vss, cpphdl_n868) / 1000000000.0;
        // device 427, IC IC74, analog/basic/mos_track_hold.hpp:42
        I(TRACK3, cpphdl_n868) <+ 8.0000000000000006e-15 * ddt(V(TRACK3, cpphdl_n868)); // Bench initial voltage = -1.6499999999999999 V.
        // device 428, IC IC74, analog/basic/mos_track_hold.hpp:43
        I(cpphdl_n814, cpphdl_n868) <+ 8.0000000000000006e-15 * ddt(V(cpphdl_n814, cpphdl_n868)); // Bench initial voltage = 1.6499999999999999 V.
        // device 429, IC IC74, analog/basic/mos_track_hold.hpp:44
        I(cpphdl_n2759, cpphdl_n868) <+ 4.0000000000000003e-15 * ddt(V(cpphdl_n2759, cpphdl_n868)); // Bench initial voltage = 0.0 V.
        // device 430, IC IC77, analog/basic/inverter.hpp:11
        I(cpphdl_n829, Vdd) <+ cpphdl_channel(V(BIT_N3_0, Vdd), V(cpphdl_n829, Vdd), 0.080000000000000002, 0.69999999999999996, -1.0);
        // device 431, IC IC77, analog/basic/inverter.hpp:12
        I(cpphdl_n829, Vss) <+ cpphdl_channel(V(BIT_N3_0, Vss), V(cpphdl_n829, Vss), 0.080000000000000002, 0.69999999999999996, 1.0);
        // device 432, IC IC76, analog/basic/mos_r2r_dac.hpp:27
        I(cpphdl_n829, Vss) <+ 2.9999999999999998e-15 * ddt(V(cpphdl_n829, Vss)); // Bench initial voltage = 0.0 V.
        // device 433, IC IC76, analog/basic/mos_r2r_dac.hpp:28
        I(cpphdl_n829, cpphdl_n858) <+ V(cpphdl_n829, cpphdl_n858) / 2000.0;
        // device 434, IC IC76, analog/basic/mos_r2r_dac.hpp:29
        I(cpphdl_n858, Vss) <+ 2.9999999999999998e-15 * ddt(V(cpphdl_n858, Vss)); // Bench initial voltage = 0.0 V.
        // device 435, IC IC78, analog/basic/inverter.hpp:11
        I(cpphdl_n833, Vdd) <+ cpphdl_channel(V(BIT_N3_1, Vdd), V(cpphdl_n833, Vdd), 0.080000000000000002, 0.69999999999999996, -1.0);
        // device 436, IC IC78, analog/basic/inverter.hpp:12
        I(cpphdl_n833, Vss) <+ cpphdl_channel(V(BIT_N3_1, Vss), V(cpphdl_n833, Vss), 0.080000000000000002, 0.69999999999999996, 1.0);
        // device 437, IC IC76, analog/basic/mos_r2r_dac.hpp:27
        I(cpphdl_n833, Vss) <+ 2.9999999999999998e-15 * ddt(V(cpphdl_n833, Vss)); // Bench initial voltage = 0.0 V.
        // device 438, IC IC76, analog/basic/mos_r2r_dac.hpp:28
        I(cpphdl_n833, cpphdl_n859) <+ V(cpphdl_n833, cpphdl_n859) / 2000.0;
        // device 439, IC IC76, analog/basic/mos_r2r_dac.hpp:29
        I(cpphdl_n859, Vss) <+ 2.9999999999999998e-15 * ddt(V(cpphdl_n859, Vss)); // Bench initial voltage = 0.0 V.
        // device 440, IC IC76, analog/basic/mos_r2r_dac.hpp:31
        I(cpphdl_n858, cpphdl_n859) <+ V(cpphdl_n858, cpphdl_n859) / 1000.0;
        // device 441, IC IC79, analog/basic/inverter.hpp:11
        I(cpphdl_n837, Vdd) <+ cpphdl_channel(V(BIT_N3_2, Vdd), V(cpphdl_n837, Vdd), 0.080000000000000002, 0.69999999999999996, -1.0);
        // device 442, IC IC79, analog/basic/inverter.hpp:12
        I(cpphdl_n837, Vss) <+ cpphdl_channel(V(BIT_N3_2, Vss), V(cpphdl_n837, Vss), 0.080000000000000002, 0.69999999999999996, 1.0);
        // device 443, IC IC76, analog/basic/mos_r2r_dac.hpp:27
        I(cpphdl_n837, Vss) <+ 2.9999999999999998e-15 * ddt(V(cpphdl_n837, Vss)); // Bench initial voltage = 0.0 V.
        // device 444, IC IC76, analog/basic/mos_r2r_dac.hpp:28
        I(cpphdl_n837, cpphdl_n860) <+ V(cpphdl_n837, cpphdl_n860) / 2000.0;
        // device 445, IC IC76, analog/basic/mos_r2r_dac.hpp:29
        I(cpphdl_n860, Vss) <+ 2.9999999999999998e-15 * ddt(V(cpphdl_n860, Vss)); // Bench initial voltage = 0.0 V.
        // device 446, IC IC76, analog/basic/mos_r2r_dac.hpp:31
        I(cpphdl_n859, cpphdl_n860) <+ V(cpphdl_n859, cpphdl_n860) / 1000.0;
        // device 447, IC IC80, analog/basic/inverter.hpp:11
        I(cpphdl_n841, Vdd) <+ cpphdl_channel(V(BIT_N3_3, Vdd), V(cpphdl_n841, Vdd), 0.080000000000000002, 0.69999999999999996, -1.0);
        // device 448, IC IC80, analog/basic/inverter.hpp:12
        I(cpphdl_n841, Vss) <+ cpphdl_channel(V(BIT_N3_3, Vss), V(cpphdl_n841, Vss), 0.080000000000000002, 0.69999999999999996, 1.0);
        // device 449, IC IC76, analog/basic/mos_r2r_dac.hpp:27
        I(cpphdl_n841, Vss) <+ 2.9999999999999998e-15 * ddt(V(cpphdl_n841, Vss)); // Bench initial voltage = 0.0 V.
        // device 450, IC IC76, analog/basic/mos_r2r_dac.hpp:28
        I(cpphdl_n841, cpphdl_n861) <+ V(cpphdl_n841, cpphdl_n861) / 2000.0;
        // device 451, IC IC76, analog/basic/mos_r2r_dac.hpp:29
        I(cpphdl_n861, Vss) <+ 2.9999999999999998e-15 * ddt(V(cpphdl_n861, Vss)); // Bench initial voltage = 0.0 V.
        // device 452, IC IC76, analog/basic/mos_r2r_dac.hpp:31
        I(cpphdl_n860, cpphdl_n861) <+ V(cpphdl_n860, cpphdl_n861) / 1000.0;
        // device 453, IC IC81, analog/basic/inverter.hpp:11
        I(cpphdl_n845, Vdd) <+ cpphdl_channel(V(BIT_N3_4, Vdd), V(cpphdl_n845, Vdd), 0.080000000000000002, 0.69999999999999996, -1.0);
        // device 454, IC IC81, analog/basic/inverter.hpp:12
        I(cpphdl_n845, Vss) <+ cpphdl_channel(V(BIT_N3_4, Vss), V(cpphdl_n845, Vss), 0.080000000000000002, 0.69999999999999996, 1.0);
        // device 455, IC IC76, analog/basic/mos_r2r_dac.hpp:27
        I(cpphdl_n845, Vss) <+ 2.9999999999999998e-15 * ddt(V(cpphdl_n845, Vss)); // Bench initial voltage = 0.0 V.
        // device 456, IC IC76, analog/basic/mos_r2r_dac.hpp:28
        I(cpphdl_n845, cpphdl_n862) <+ V(cpphdl_n845, cpphdl_n862) / 2000.0;
        // device 457, IC IC76, analog/basic/mos_r2r_dac.hpp:29
        I(cpphdl_n862, Vss) <+ 2.9999999999999998e-15 * ddt(V(cpphdl_n862, Vss)); // Bench initial voltage = 0.0 V.
        // device 458, IC IC76, analog/basic/mos_r2r_dac.hpp:31
        I(cpphdl_n861, cpphdl_n862) <+ V(cpphdl_n861, cpphdl_n862) / 1000.0;
        // device 459, IC IC82, analog/basic/inverter.hpp:11
        I(cpphdl_n849, Vdd) <+ cpphdl_channel(V(BIT_N3_5, Vdd), V(cpphdl_n849, Vdd), 0.080000000000000002, 0.69999999999999996, -1.0);
        // device 460, IC IC82, analog/basic/inverter.hpp:12
        I(cpphdl_n849, Vss) <+ cpphdl_channel(V(BIT_N3_5, Vss), V(cpphdl_n849, Vss), 0.080000000000000002, 0.69999999999999996, 1.0);
        // device 461, IC IC76, analog/basic/mos_r2r_dac.hpp:27
        I(cpphdl_n849, Vss) <+ 2.9999999999999998e-15 * ddt(V(cpphdl_n849, Vss)); // Bench initial voltage = 0.0 V.
        // device 462, IC IC76, analog/basic/mos_r2r_dac.hpp:28
        I(cpphdl_n849, cpphdl_n863) <+ V(cpphdl_n849, cpphdl_n863) / 2000.0;
        // device 463, IC IC76, analog/basic/mos_r2r_dac.hpp:29
        I(cpphdl_n863, Vss) <+ 2.9999999999999998e-15 * ddt(V(cpphdl_n863, Vss)); // Bench initial voltage = 0.0 V.
        // device 464, IC IC76, analog/basic/mos_r2r_dac.hpp:31
        I(cpphdl_n862, cpphdl_n863) <+ V(cpphdl_n862, cpphdl_n863) / 1000.0;
        // device 465, IC IC83, analog/basic/inverter.hpp:11
        I(cpphdl_n853, Vdd) <+ cpphdl_channel(V(BIT_N3_6, Vdd), V(cpphdl_n853, Vdd), 0.080000000000000002, 0.69999999999999996, -1.0);
        // device 466, IC IC83, analog/basic/inverter.hpp:12
        I(cpphdl_n853, Vss) <+ cpphdl_channel(V(BIT_N3_6, Vss), V(cpphdl_n853, Vss), 0.080000000000000002, 0.69999999999999996, 1.0);
        // device 467, IC IC76, analog/basic/mos_r2r_dac.hpp:27
        I(cpphdl_n853, Vss) <+ 2.9999999999999998e-15 * ddt(V(cpphdl_n853, Vss)); // Bench initial voltage = 0.0 V.
        // device 468, IC IC76, analog/basic/mos_r2r_dac.hpp:28
        I(cpphdl_n853, cpphdl_n864) <+ V(cpphdl_n853, cpphdl_n864) / 2000.0;
        // device 469, IC IC76, analog/basic/mos_r2r_dac.hpp:29
        I(cpphdl_n864, Vss) <+ 2.9999999999999998e-15 * ddt(V(cpphdl_n864, Vss)); // Bench initial voltage = 0.0 V.
        // device 470, IC IC76, analog/basic/mos_r2r_dac.hpp:31
        I(cpphdl_n863, cpphdl_n864) <+ V(cpphdl_n863, cpphdl_n864) / 1000.0;
        // device 471, IC IC84, analog/basic/inverter.hpp:11
        I(cpphdl_n857, Vdd) <+ cpphdl_channel(V(BIT_N3_7, Vdd), V(cpphdl_n857, Vdd), 0.080000000000000002, 0.69999999999999996, -1.0);
        // device 472, IC IC84, analog/basic/inverter.hpp:12
        I(cpphdl_n857, Vss) <+ cpphdl_channel(V(BIT_N3_7, Vss), V(cpphdl_n857, Vss), 0.080000000000000002, 0.69999999999999996, 1.0);
        // device 473, IC IC76, analog/basic/mos_r2r_dac.hpp:27
        I(cpphdl_n857, Vss) <+ 2.9999999999999998e-15 * ddt(V(cpphdl_n857, Vss)); // Bench initial voltage = 0.0 V.
        // device 474, IC IC76, analog/basic/mos_r2r_dac.hpp:28
        I(cpphdl_n857, cpphdl_n869) <+ V(cpphdl_n857, cpphdl_n869) / 2000.0;
        // device 475, IC IC76, analog/basic/mos_r2r_dac.hpp:29
        I(cpphdl_n869, Vss) <+ 2.9999999999999998e-15 * ddt(V(cpphdl_n869, Vss)); // Bench initial voltage = 0.0 V.
        // device 476, IC IC76, analog/basic/mos_r2r_dac.hpp:31
        I(cpphdl_n864, cpphdl_n869) <+ V(cpphdl_n864, cpphdl_n869) / 1000.0;
        // device 477, IC IC76, analog/basic/mos_r2r_dac.hpp:33
        I(Vss, cpphdl_n858) <+ V(Vss, cpphdl_n858) / 2000.0;
        // device 478, IC IC85, analog/basic/nmos_resistor_amplifier.hpp:23
        I(Vdd, cpphdl_n878) <+ V(Vdd, cpphdl_n878) / 500.0;
        // device 479, IC IC85, analog/basic/nmos_resistor_amplifier.hpp:24
        I(Vdd, cpphdl_n877) <+ V(Vdd, cpphdl_n877) / 500.0;
        // device 480, IC IC85, analog/basic/nmos_resistor_amplifier.hpp:25
        I(cpphdl_n878, cpphdl_n872) <+ cpphdl_channel(V(cpphdl_n868, cpphdl_n872), V(cpphdl_n878, cpphdl_n872), 0.014999999999999999, 0.69999999999999996, 1.0);
        // device 481, IC IC85, analog/basic/nmos_resistor_amplifier.hpp:26
        I(cpphdl_n877, cpphdl_n873) <+ cpphdl_channel(V(cpphdl_n869, cpphdl_n873), V(cpphdl_n877, cpphdl_n873), 0.014999999999999999, 0.69999999999999996, 1.0);
        // device 482, IC IC85, analog/basic/nmos_resistor_amplifier.hpp:27
        I(cpphdl_n874, cpphdl_n872) <+ V(cpphdl_n874, cpphdl_n872) / 50.0;
        // device 483, IC IC85, analog/basic/nmos_resistor_amplifier.hpp:28
        I(cpphdl_n874, cpphdl_n873) <+ V(cpphdl_n874, cpphdl_n873) / 50.0;
        // device 484, IC IC85, analog/basic/nmos_resistor_amplifier.hpp:29
        I(Vss, cpphdl_n874) <+ V(Vss, cpphdl_n874) / 150.0;
        // device 485, IC IC85, analog/basic/nmos_resistor_amplifier.hpp:30
        I(cpphdl_n878, Vdd) <+ 2.9999999999999998e-13 * ddt(V(cpphdl_n878, Vdd)); // Bench initial voltage = 0.0 V.
        // device 486, IC IC85, analog/basic/nmos_resistor_amplifier.hpp:31
        I(cpphdl_n877, Vdd) <+ 2.9999999999999998e-13 * ddt(V(cpphdl_n877, Vdd)); // Bench initial voltage = 0.0 V.
        // device 487, IC IC85, analog/basic/nmos_resistor_amplifier.hpp:32
        I(cpphdl_n874, Vss) <+ 4e-14 * ddt(V(cpphdl_n874, Vss)); // Bench initial voltage = 0.0 V.
        // device 488, IC IC85, analog/basic/nmos_resistor_amplifier.hpp:34
        I(cpphdl_n868, cpphdl_n872) <+ 2e-14 * ddt(V(cpphdl_n868, cpphdl_n872)); // Bench initial voltage = 1.6499999999999999 V.
        // device 489, IC IC85, analog/basic/nmos_resistor_amplifier.hpp:35
        I(cpphdl_n869, cpphdl_n873) <+ 2e-14 * ddt(V(cpphdl_n869, cpphdl_n873)); // Bench initial voltage = 0.0 V.
        // device 490, IC IC85, analog/basic/nmos_resistor_amplifier.hpp:36
        I(cpphdl_n868, cpphdl_n878) <+ 2.9999999999999998e-15 * ddt(V(cpphdl_n868, cpphdl_n878)); // Bench initial voltage = -1.6499999999999999 V.
        // device 491, IC IC85, analog/basic/nmos_resistor_amplifier.hpp:37
        I(cpphdl_n869, cpphdl_n877) <+ 2.9999999999999998e-15 * ddt(V(cpphdl_n869, cpphdl_n877)); // Bench initial voltage = -3.2999999999999998 V.
        // device 492, IC IC86, analog/basic/strongarm_comparator.hpp:28
        I(cpphdl_n882, cpphdl_n884) <+ cpphdl_channel(V(cpphdl_n877, cpphdl_n884), V(cpphdl_n882, cpphdl_n884), 0.0080000000000000002, 0.69999999999999996, 1.0);
        // device 493, IC IC86, analog/basic/strongarm_comparator.hpp:29
        I(cpphdl_n883, cpphdl_n884) <+ cpphdl_channel(V(cpphdl_n878, cpphdl_n884), V(cpphdl_n883, cpphdl_n884), 0.0080000000000000002, 0.69999999999999996, 1.0);
        // device 494, IC IC86, analog/basic/strongarm_comparator.hpp:30
        I(cpphdl_n884, Vss) <+ cpphdl_channel(V(EVALUATE, Vss), V(cpphdl_n884, Vss), 0.0080000000000000002, 0.69999999999999996, 1.0);
        // device 495, IC IC86, analog/basic/strongarm_comparator.hpp:33
        I(cpphdl_n897, cpphdl_n882) <+ cpphdl_channel(V(cpphdl_n901, cpphdl_n882), V(cpphdl_n897, cpphdl_n882), 0.0040000000000000001, 0.69999999999999996, 1.0);
        // device 496, IC IC86, analog/basic/strongarm_comparator.hpp:34
        I(cpphdl_n901, cpphdl_n883) <+ cpphdl_channel(V(cpphdl_n897, cpphdl_n883), V(cpphdl_n901, cpphdl_n883), 0.0040000000000000001, 0.69999999999999996, 1.0);
        // device 497, IC IC86, analog/basic/strongarm_comparator.hpp:35
        I(cpphdl_n901, Vdd) <+ cpphdl_channel(V(cpphdl_n897, Vdd), V(cpphdl_n901, Vdd), 0.002, 0.69999999999999996, -1.0);
        // device 498, IC IC86, analog/basic/strongarm_comparator.hpp:36
        I(cpphdl_n897, Vdd) <+ cpphdl_channel(V(cpphdl_n901, Vdd), V(cpphdl_n897, Vdd), 0.002, 0.69999999999999996, -1.0);
        // device 499, IC IC86, analog/basic/strongarm_comparator.hpp:38
        I(cpphdl_n882, Vdd) <+ cpphdl_channel(V(EVALUATE, Vdd), V(cpphdl_n882, Vdd), 0.002, 0.69999999999999996, -1.0);
        // device 500, IC IC86, analog/basic/strongarm_comparator.hpp:39
        I(cpphdl_n883, Vdd) <+ cpphdl_channel(V(EVALUATE, Vdd), V(cpphdl_n883, Vdd), 0.002, 0.69999999999999996, -1.0);
        // device 501, IC IC86, analog/basic/strongarm_comparator.hpp:40
        I(cpphdl_n901, Vdd) <+ cpphdl_channel(V(EVALUATE, Vdd), V(cpphdl_n901, Vdd), 0.002, 0.69999999999999996, -1.0);
        // device 502, IC IC86, analog/basic/strongarm_comparator.hpp:41
        I(cpphdl_n897, Vdd) <+ cpphdl_channel(V(EVALUATE, Vdd), V(cpphdl_n897, Vdd), 0.002, 0.69999999999999996, -1.0);
        // device 503, IC IC86, analog/basic/strongarm_comparator.hpp:42
        I(cpphdl_n882, Vss) <+ 2.9999999999999998e-14 * ddt(V(cpphdl_n882, Vss)); // Bench initial voltage = 0.0 V.
        // device 504, IC IC86, analog/basic/strongarm_comparator.hpp:43
        I(cpphdl_n883, Vss) <+ 2.9999999999999998e-14 * ddt(V(cpphdl_n883, Vss)); // Bench initial voltage = 0.0 V.
        // device 505, IC IC86, analog/basic/strongarm_comparator.hpp:44
        I(cpphdl_n884, Vss) <+ 2.9999999999999998e-14 * ddt(V(cpphdl_n884, Vss)); // Bench initial voltage = 0.0 V.
        // device 506, IC IC86, analog/basic/strongarm_comparator.hpp:45
        I(cpphdl_n901, Vss) <+ 5.0000000000000002e-14 * ddt(V(cpphdl_n901, Vss)); // Bench initial voltage = 0.0 V.
        // device 507, IC IC86, analog/basic/strongarm_comparator.hpp:46
        I(cpphdl_n897, Vss) <+ 5.0000000000000002e-14 * ddt(V(cpphdl_n897, Vss)); // Bench initial voltage = 0.0 V.
        // device 508, IC IC86, analog/basic/strongarm_comparator.hpp:47
        I(cpphdl_n877, cpphdl_n884) <+ 2e-14 * ddt(V(cpphdl_n877, cpphdl_n884)); // Bench initial voltage = 3.2999999999999998 V.
        // device 509, IC IC86, analog/basic/strongarm_comparator.hpp:48
        I(cpphdl_n878, cpphdl_n884) <+ 2e-14 * ddt(V(cpphdl_n878, cpphdl_n884)); // Bench initial voltage = 3.2999999999999998 V.
        // device 510, IC IC86, analog/basic/strongarm_comparator.hpp:49
        I(cpphdl_n877, cpphdl_n882) <+ 2.9999999999999998e-15 * ddt(V(cpphdl_n877, cpphdl_n882)); // Bench initial voltage = 3.2999999999999998 V.
        // device 511, IC IC86, analog/basic/strongarm_comparator.hpp:50
        I(cpphdl_n878, cpphdl_n883) <+ 2.9999999999999998e-15 * ddt(V(cpphdl_n878, cpphdl_n883)); // Bench initial voltage = 3.2999999999999998 V.
        // device 512, IC IC88, analog/basic/inverter.hpp:11
        I(cpphdl_n905, Vdd) <+ cpphdl_channel(V(cpphdl_n897, Vdd), V(cpphdl_n905, Vdd), 0.001, 0.69999999999999996, -1.0);
        // device 513, IC IC88, analog/basic/inverter.hpp:12
        I(cpphdl_n905, Vss) <+ cpphdl_channel(V(cpphdl_n897, Vss), V(cpphdl_n905, Vss), 0.001, 0.69999999999999996, 1.0);
        // device 514, IC IC90, analog/basic/inverter.hpp:11
        I(cpphdl_n919, Vdd) <+ cpphdl_channel(V(cpphdl_n905, Vdd), V(cpphdl_n919, Vdd), 0.0040000000000000001, 0.69999999999999996, -1.0);
        // device 515, IC IC90, analog/basic/inverter.hpp:12
        I(cpphdl_n919, Vss) <+ cpphdl_channel(V(cpphdl_n905, Vss), V(cpphdl_n919, Vss), 0.0040000000000000001, 0.69999999999999996, 1.0);
        // device 516, IC IC87, analog/basic/buffered_nand_latch.hpp:34
        I(cpphdl_n897, Vss) <+ 2.0000000000000002e-15 * ddt(V(cpphdl_n897, Vss)); // Bench initial voltage = 0.0 V.
        // device 517, IC IC87, analog/basic/buffered_nand_latch.hpp:35
        I(cpphdl_n897, cpphdl_n905) <+ 1.0000000000000001e-15 * ddt(V(cpphdl_n897, cpphdl_n905)); // Bench initial voltage = 0.0 V.
        // device 518, IC IC87, analog/basic/buffered_nand_latch.hpp:36
        I(cpphdl_n905, Vss) <+ 5e-15 * ddt(V(cpphdl_n905, Vss)); // Bench initial voltage = 0.0 V.
        // device 519, IC IC87, analog/basic/buffered_nand_latch.hpp:37
        I(cpphdl_n905, Vss) <+ 8.0000000000000006e-15 * ddt(V(cpphdl_n905, Vss)); // Bench initial voltage = 0.0 V.
        // device 520, IC IC87, analog/basic/buffered_nand_latch.hpp:38
        I(cpphdl_n919, Vss) <+ 1e-14 * ddt(V(cpphdl_n919, Vss)); // Bench initial voltage = 0.0 V.
        // device 521, IC IC89, analog/basic/inverter.hpp:11
        I(cpphdl_n909, Vdd) <+ cpphdl_channel(V(cpphdl_n901, Vdd), V(cpphdl_n909, Vdd), 0.001, 0.69999999999999996, -1.0);
        // device 522, IC IC89, analog/basic/inverter.hpp:12
        I(cpphdl_n909, Vss) <+ cpphdl_channel(V(cpphdl_n901, Vss), V(cpphdl_n909, Vss), 0.001, 0.69999999999999996, 1.0);
        // device 523, IC IC91, analog/basic/inverter.hpp:11
        I(cpphdl_n925, Vdd) <+ cpphdl_channel(V(cpphdl_n909, Vdd), V(cpphdl_n925, Vdd), 0.0040000000000000001, 0.69999999999999996, -1.0);
        // device 524, IC IC91, analog/basic/inverter.hpp:12
        I(cpphdl_n925, Vss) <+ cpphdl_channel(V(cpphdl_n909, Vss), V(cpphdl_n925, Vss), 0.0040000000000000001, 0.69999999999999996, 1.0);
        // device 525, IC IC87, analog/basic/buffered_nand_latch.hpp:34
        I(cpphdl_n901, Vss) <+ 2.0000000000000002e-15 * ddt(V(cpphdl_n901, Vss)); // Bench initial voltage = 0.0 V.
        // device 526, IC IC87, analog/basic/buffered_nand_latch.hpp:35
        I(cpphdl_n901, cpphdl_n909) <+ 1.0000000000000001e-15 * ddt(V(cpphdl_n901, cpphdl_n909)); // Bench initial voltage = 0.0 V.
        // device 527, IC IC87, analog/basic/buffered_nand_latch.hpp:36
        I(cpphdl_n909, Vss) <+ 5e-15 * ddt(V(cpphdl_n909, Vss)); // Bench initial voltage = 0.0 V.
        // device 528, IC IC87, analog/basic/buffered_nand_latch.hpp:37
        I(cpphdl_n909, Vss) <+ 8.0000000000000006e-15 * ddt(V(cpphdl_n909, Vss)); // Bench initial voltage = 0.0 V.
        // device 529, IC IC87, analog/basic/buffered_nand_latch.hpp:38
        I(cpphdl_n925, Vss) <+ 1e-14 * ddt(V(cpphdl_n925, Vss)); // Bench initial voltage = 0.0 V.
        // device 530, IC IC93, analog/basic/cmos_logic.hpp:17
        I(cpphdl_n2684, Vss) <+ 5.0000000000000002e-14 * ddt(V(cpphdl_n2684, Vss)); // Bench initial voltage = 0.0 V.
        // device 531, IC IC93, analog/basic/cmos_logic.hpp:18
        I(cpphdl_n2684, Vdd) <+ cpphdl_channel(V(cpphdl_n919, Vdd), V(cpphdl_n2684, Vdd), 0.01, 0.69999999999999996, -1.0);
        // device 532, IC IC93, analog/basic/cmos_logic.hpp:19
        I(cpphdl_n2684, Vdd) <+ cpphdl_channel(V(cpphdl_n927, Vdd), V(cpphdl_n2684, Vdd), 0.01, 0.69999999999999996, -1.0);
        // device 533, IC IC93, analog/basic/cmos_logic.hpp:20
        I(cpphdl_n2684, cpphdl_n922) <+ cpphdl_channel(V(cpphdl_n919, cpphdl_n922), V(cpphdl_n2684, cpphdl_n922), 0.01, 0.69999999999999996, 1.0);
        // device 534, IC IC93, analog/basic/cmos_logic.hpp:21
        I(cpphdl_n922, Vss) <+ cpphdl_channel(V(cpphdl_n927, Vss), V(cpphdl_n922, Vss), 0.01, 0.69999999999999996, 1.0);
        // device 535, IC IC93, analog/basic/cmos_logic.hpp:23
        I(cpphdl_n2684, Vss) <+ V(cpphdl_n2684, Vss) / 1000000000.0;
        // device 536, IC IC93, analog/basic/cmos_logic.hpp:24
        I(cpphdl_n922, Vss) <+ V(cpphdl_n922, Vss) / 1000000000.0;
        // device 537, IC IC94, analog/basic/cmos_logic.hpp:17
        I(cpphdl_n927, Vss) <+ 5.0000000000000002e-14 * ddt(V(cpphdl_n927, Vss)); // Bench initial voltage = 0.0 V.
        // device 538, IC IC94, analog/basic/cmos_logic.hpp:18
        I(cpphdl_n927, Vdd) <+ cpphdl_channel(V(cpphdl_n925, Vdd), V(cpphdl_n927, Vdd), 0.01, 0.69999999999999996, -1.0);
        // device 539, IC IC94, analog/basic/cmos_logic.hpp:19
        I(cpphdl_n927, Vdd) <+ cpphdl_channel(V(cpphdl_n2684, Vdd), V(cpphdl_n927, Vdd), 0.01, 0.69999999999999996, -1.0);
        // device 540, IC IC94, analog/basic/cmos_logic.hpp:20
        I(cpphdl_n927, cpphdl_n928) <+ cpphdl_channel(V(cpphdl_n925, cpphdl_n928), V(cpphdl_n927, cpphdl_n928), 0.01, 0.69999999999999996, 1.0);
        // device 541, IC IC94, analog/basic/cmos_logic.hpp:21
        I(cpphdl_n928, Vss) <+ cpphdl_channel(V(cpphdl_n2684, Vss), V(cpphdl_n928, Vss), 0.01, 0.69999999999999996, 1.0);
        // device 542, IC IC94, analog/basic/cmos_logic.hpp:23
        I(cpphdl_n927, Vss) <+ V(cpphdl_n927, Vss) / 1000000000.0;
        // device 543, IC IC94, analog/basic/cmos_logic.hpp:24
        I(cpphdl_n928, Vss) <+ V(cpphdl_n928, Vss) / 1000000000.0;
        // device 544, IC IC92, analog/basic/nand_latch.hpp:36
        I(cpphdl_n919, Vss) <+ 2.9999999999999998e-15 * ddt(V(cpphdl_n919, Vss)); // Bench initial voltage = 0.0 V.
        // device 545, IC IC92, analog/basic/nand_latch.hpp:37
        I(cpphdl_n925, Vss) <+ 2.9999999999999998e-15 * ddt(V(cpphdl_n925, Vss)); // Bench initial voltage = 0.0 V.
        // device 546, IC IC95, analog/basic/inverter.hpp:11
        I(cpphdl_n933, Vdd) <+ cpphdl_channel(V(CLEAR, Vdd), V(cpphdl_n933, Vdd), 0.01, 0.69999999999999996, -1.0);
        // device 547, IC IC95, analog/basic/inverter.hpp:12
        I(cpphdl_n933, Vss) <+ cpphdl_channel(V(CLEAR, Vss), V(cpphdl_n933, Vss), 0.01, 0.69999999999999996, 1.0);
        // device 548, IC IC92, analog/basic/nand_latch.hpp:58
        I(cpphdl_n933, Vss) <+ 2.9999999999999998e-15 * ddt(V(cpphdl_n933, Vss)); // Bench initial voltage = 0.0 V.
        // device 549, IC IC92, analog/basic/nand_latch.hpp:59
        I(cpphdl_n2684, Vss) <+ cpphdl_channel(V(CLEAR, Vss), V(cpphdl_n2684, Vss), 0.050000000000000003, 0.69999999999999996, 1.0);
        // device 550, IC IC92, analog/basic/nand_latch.hpp:60
        I(cpphdl_n927, Vdd) <+ cpphdl_channel(V(cpphdl_n933, Vdd), V(cpphdl_n927, Vdd), 0.050000000000000003, 0.69999999999999996, -1.0);
        // device 551, IC IC98, analog/basic/inverter.hpp:11
        I(cpphdl_n957, Vdd) <+ cpphdl_channel(V(TRACK4, Vdd), V(cpphdl_n957, Vdd), 0.0040000000000000001, 0.69999999999999996, -1.0);
        // device 552, IC IC98, analog/basic/inverter.hpp:12
        I(cpphdl_n957, Vss) <+ cpphdl_channel(V(TRACK4, Vss), V(cpphdl_n957, Vss), 0.0040000000000000001, 0.69999999999999996, 1.0);
        // device 553, IC IC97, analog/basic/mos_track_hold.hpp:31
        I(cpphdl_n957, Vss) <+ 2e-14 * ddt(V(cpphdl_n957, Vss)); // Bench initial voltage = 3.2999999999999998 V.
        // device 554, IC IC97, analog/basic/mos_track_hold.hpp:32
        I(cpphdl_n2759, cpphdl_n1011) <+ cpphdl_channel(V(TRACK4, cpphdl_n1011), V(cpphdl_n2759, cpphdl_n1011), 0.080000000000000002, 0.69999999999999996, 1.0);
        // device 555, IC IC97, analog/basic/mos_track_hold.hpp:33
        I(cpphdl_n1011, cpphdl_n2759) <+ cpphdl_channel(V(cpphdl_n957, cpphdl_n2759), V(cpphdl_n1011, cpphdl_n2759), 0.040000000000000001, 0.69999999999999996, -1.0);
        // device 556, IC IC97, analog/basic/mos_track_hold.hpp:37
        I(cpphdl_n1011, cpphdl_n1011) <+ cpphdl_channel(V(cpphdl_n957, cpphdl_n1011), V(cpphdl_n1011, cpphdl_n1011), 0.040000000000000001, 0.69999999999999996, 1.0);
        // device 557, IC IC97, analog/basic/mos_track_hold.hpp:38
        I(cpphdl_n1011, cpphdl_n1011) <+ cpphdl_channel(V(TRACK4, cpphdl_n1011), V(cpphdl_n1011, cpphdl_n1011), 0.02, 0.69999999999999996, -1.0);
        // device 558, IC IC97, analog/basic/mos_track_hold.hpp:39
        I(cpphdl_n1011, Vss) <+ 3.0000000000000001e-12 * ddt(V(cpphdl_n1011, Vss)); // Bench initial voltage = 1.6499999999999999 V.
        // device 559, IC IC97, analog/basic/mos_track_hold.hpp:41
        I(Vss, cpphdl_n1011) <+ V(Vss, cpphdl_n1011) / 1000000000.0;
        // device 560, IC IC97, analog/basic/mos_track_hold.hpp:42
        I(TRACK4, cpphdl_n1011) <+ 8.0000000000000006e-15 * ddt(V(TRACK4, cpphdl_n1011)); // Bench initial voltage = -1.6499999999999999 V.
        // device 561, IC IC97, analog/basic/mos_track_hold.hpp:43
        I(cpphdl_n957, cpphdl_n1011) <+ 8.0000000000000006e-15 * ddt(V(cpphdl_n957, cpphdl_n1011)); // Bench initial voltage = 1.6499999999999999 V.
        // device 562, IC IC97, analog/basic/mos_track_hold.hpp:44
        I(cpphdl_n2759, cpphdl_n1011) <+ 4.0000000000000003e-15 * ddt(V(cpphdl_n2759, cpphdl_n1011)); // Bench initial voltage = 0.0 V.
        // device 563, IC IC100, analog/basic/inverter.hpp:11
        I(cpphdl_n972, Vdd) <+ cpphdl_channel(V(BIT_N4_0, Vdd), V(cpphdl_n972, Vdd), 0.080000000000000002, 0.69999999999999996, -1.0);
        // device 564, IC IC100, analog/basic/inverter.hpp:12
        I(cpphdl_n972, Vss) <+ cpphdl_channel(V(BIT_N4_0, Vss), V(cpphdl_n972, Vss), 0.080000000000000002, 0.69999999999999996, 1.0);
        // device 565, IC IC99, analog/basic/mos_r2r_dac.hpp:27
        I(cpphdl_n972, Vss) <+ 2.9999999999999998e-15 * ddt(V(cpphdl_n972, Vss)); // Bench initial voltage = 0.0 V.
        // device 566, IC IC99, analog/basic/mos_r2r_dac.hpp:28
        I(cpphdl_n972, cpphdl_n1001) <+ V(cpphdl_n972, cpphdl_n1001) / 2000.0;
        // device 567, IC IC99, analog/basic/mos_r2r_dac.hpp:29
        I(cpphdl_n1001, Vss) <+ 2.9999999999999998e-15 * ddt(V(cpphdl_n1001, Vss)); // Bench initial voltage = 0.0 V.
        // device 568, IC IC101, analog/basic/inverter.hpp:11
        I(cpphdl_n976, Vdd) <+ cpphdl_channel(V(BIT_N4_1, Vdd), V(cpphdl_n976, Vdd), 0.080000000000000002, 0.69999999999999996, -1.0);
        // device 569, IC IC101, analog/basic/inverter.hpp:12
        I(cpphdl_n976, Vss) <+ cpphdl_channel(V(BIT_N4_1, Vss), V(cpphdl_n976, Vss), 0.080000000000000002, 0.69999999999999996, 1.0);
        // device 570, IC IC99, analog/basic/mos_r2r_dac.hpp:27
        I(cpphdl_n976, Vss) <+ 2.9999999999999998e-15 * ddt(V(cpphdl_n976, Vss)); // Bench initial voltage = 0.0 V.
        // device 571, IC IC99, analog/basic/mos_r2r_dac.hpp:28
        I(cpphdl_n976, cpphdl_n1002) <+ V(cpphdl_n976, cpphdl_n1002) / 2000.0;
        // device 572, IC IC99, analog/basic/mos_r2r_dac.hpp:29
        I(cpphdl_n1002, Vss) <+ 2.9999999999999998e-15 * ddt(V(cpphdl_n1002, Vss)); // Bench initial voltage = 0.0 V.
        // device 573, IC IC99, analog/basic/mos_r2r_dac.hpp:31
        I(cpphdl_n1001, cpphdl_n1002) <+ V(cpphdl_n1001, cpphdl_n1002) / 1000.0;
        // device 574, IC IC102, analog/basic/inverter.hpp:11
        I(cpphdl_n980, Vdd) <+ cpphdl_channel(V(BIT_N4_2, Vdd), V(cpphdl_n980, Vdd), 0.080000000000000002, 0.69999999999999996, -1.0);
        // device 575, IC IC102, analog/basic/inverter.hpp:12
        I(cpphdl_n980, Vss) <+ cpphdl_channel(V(BIT_N4_2, Vss), V(cpphdl_n980, Vss), 0.080000000000000002, 0.69999999999999996, 1.0);
        // device 576, IC IC99, analog/basic/mos_r2r_dac.hpp:27
        I(cpphdl_n980, Vss) <+ 2.9999999999999998e-15 * ddt(V(cpphdl_n980, Vss)); // Bench initial voltage = 0.0 V.
        // device 577, IC IC99, analog/basic/mos_r2r_dac.hpp:28
        I(cpphdl_n980, cpphdl_n1003) <+ V(cpphdl_n980, cpphdl_n1003) / 2000.0;
        // device 578, IC IC99, analog/basic/mos_r2r_dac.hpp:29
        I(cpphdl_n1003, Vss) <+ 2.9999999999999998e-15 * ddt(V(cpphdl_n1003, Vss)); // Bench initial voltage = 0.0 V.
        // device 579, IC IC99, analog/basic/mos_r2r_dac.hpp:31
        I(cpphdl_n1002, cpphdl_n1003) <+ V(cpphdl_n1002, cpphdl_n1003) / 1000.0;
        // device 580, IC IC103, analog/basic/inverter.hpp:11
        I(cpphdl_n984, Vdd) <+ cpphdl_channel(V(BIT_N4_3, Vdd), V(cpphdl_n984, Vdd), 0.080000000000000002, 0.69999999999999996, -1.0);
        // device 581, IC IC103, analog/basic/inverter.hpp:12
        I(cpphdl_n984, Vss) <+ cpphdl_channel(V(BIT_N4_3, Vss), V(cpphdl_n984, Vss), 0.080000000000000002, 0.69999999999999996, 1.0);
        // device 582, IC IC99, analog/basic/mos_r2r_dac.hpp:27
        I(cpphdl_n984, Vss) <+ 2.9999999999999998e-15 * ddt(V(cpphdl_n984, Vss)); // Bench initial voltage = 0.0 V.
        // device 583, IC IC99, analog/basic/mos_r2r_dac.hpp:28
        I(cpphdl_n984, cpphdl_n1004) <+ V(cpphdl_n984, cpphdl_n1004) / 2000.0;
        // device 584, IC IC99, analog/basic/mos_r2r_dac.hpp:29
        I(cpphdl_n1004, Vss) <+ 2.9999999999999998e-15 * ddt(V(cpphdl_n1004, Vss)); // Bench initial voltage = 0.0 V.
        // device 585, IC IC99, analog/basic/mos_r2r_dac.hpp:31
        I(cpphdl_n1003, cpphdl_n1004) <+ V(cpphdl_n1003, cpphdl_n1004) / 1000.0;
        // device 586, IC IC104, analog/basic/inverter.hpp:11
        I(cpphdl_n988, Vdd) <+ cpphdl_channel(V(BIT_N4_4, Vdd), V(cpphdl_n988, Vdd), 0.080000000000000002, 0.69999999999999996, -1.0);
        // device 587, IC IC104, analog/basic/inverter.hpp:12
        I(cpphdl_n988, Vss) <+ cpphdl_channel(V(BIT_N4_4, Vss), V(cpphdl_n988, Vss), 0.080000000000000002, 0.69999999999999996, 1.0);
        // device 588, IC IC99, analog/basic/mos_r2r_dac.hpp:27
        I(cpphdl_n988, Vss) <+ 2.9999999999999998e-15 * ddt(V(cpphdl_n988, Vss)); // Bench initial voltage = 0.0 V.
        // device 589, IC IC99, analog/basic/mos_r2r_dac.hpp:28
        I(cpphdl_n988, cpphdl_n1005) <+ V(cpphdl_n988, cpphdl_n1005) / 2000.0;
        // device 590, IC IC99, analog/basic/mos_r2r_dac.hpp:29
        I(cpphdl_n1005, Vss) <+ 2.9999999999999998e-15 * ddt(V(cpphdl_n1005, Vss)); // Bench initial voltage = 0.0 V.
        // device 591, IC IC99, analog/basic/mos_r2r_dac.hpp:31
        I(cpphdl_n1004, cpphdl_n1005) <+ V(cpphdl_n1004, cpphdl_n1005) / 1000.0;
        // device 592, IC IC105, analog/basic/inverter.hpp:11
        I(cpphdl_n992, Vdd) <+ cpphdl_channel(V(BIT_N4_5, Vdd), V(cpphdl_n992, Vdd), 0.080000000000000002, 0.69999999999999996, -1.0);
        // device 593, IC IC105, analog/basic/inverter.hpp:12
        I(cpphdl_n992, Vss) <+ cpphdl_channel(V(BIT_N4_5, Vss), V(cpphdl_n992, Vss), 0.080000000000000002, 0.69999999999999996, 1.0);
        // device 594, IC IC99, analog/basic/mos_r2r_dac.hpp:27
        I(cpphdl_n992, Vss) <+ 2.9999999999999998e-15 * ddt(V(cpphdl_n992, Vss)); // Bench initial voltage = 0.0 V.
        // device 595, IC IC99, analog/basic/mos_r2r_dac.hpp:28
        I(cpphdl_n992, cpphdl_n1006) <+ V(cpphdl_n992, cpphdl_n1006) / 2000.0;
        // device 596, IC IC99, analog/basic/mos_r2r_dac.hpp:29
        I(cpphdl_n1006, Vss) <+ 2.9999999999999998e-15 * ddt(V(cpphdl_n1006, Vss)); // Bench initial voltage = 0.0 V.
        // device 597, IC IC99, analog/basic/mos_r2r_dac.hpp:31
        I(cpphdl_n1005, cpphdl_n1006) <+ V(cpphdl_n1005, cpphdl_n1006) / 1000.0;
        // device 598, IC IC106, analog/basic/inverter.hpp:11
        I(cpphdl_n996, Vdd) <+ cpphdl_channel(V(BIT_N4_6, Vdd), V(cpphdl_n996, Vdd), 0.080000000000000002, 0.69999999999999996, -1.0);
        // device 599, IC IC106, analog/basic/inverter.hpp:12
        I(cpphdl_n996, Vss) <+ cpphdl_channel(V(BIT_N4_6, Vss), V(cpphdl_n996, Vss), 0.080000000000000002, 0.69999999999999996, 1.0);
        // device 600, IC IC99, analog/basic/mos_r2r_dac.hpp:27
        I(cpphdl_n996, Vss) <+ 2.9999999999999998e-15 * ddt(V(cpphdl_n996, Vss)); // Bench initial voltage = 0.0 V.
        // device 601, IC IC99, analog/basic/mos_r2r_dac.hpp:28
        I(cpphdl_n996, cpphdl_n1007) <+ V(cpphdl_n996, cpphdl_n1007) / 2000.0;
        // device 602, IC IC99, analog/basic/mos_r2r_dac.hpp:29
        I(cpphdl_n1007, Vss) <+ 2.9999999999999998e-15 * ddt(V(cpphdl_n1007, Vss)); // Bench initial voltage = 0.0 V.
        // device 603, IC IC99, analog/basic/mos_r2r_dac.hpp:31
        I(cpphdl_n1006, cpphdl_n1007) <+ V(cpphdl_n1006, cpphdl_n1007) / 1000.0;
        // device 604, IC IC107, analog/basic/inverter.hpp:11
        I(cpphdl_n1000, Vdd) <+ cpphdl_channel(V(BIT_N4_7, Vdd), V(cpphdl_n1000, Vdd), 0.080000000000000002, 0.69999999999999996, -1.0);
        // device 605, IC IC107, analog/basic/inverter.hpp:12
        I(cpphdl_n1000, Vss) <+ cpphdl_channel(V(BIT_N4_7, Vss), V(cpphdl_n1000, Vss), 0.080000000000000002, 0.69999999999999996, 1.0);
        // device 606, IC IC99, analog/basic/mos_r2r_dac.hpp:27
        I(cpphdl_n1000, Vss) <+ 2.9999999999999998e-15 * ddt(V(cpphdl_n1000, Vss)); // Bench initial voltage = 0.0 V.
        // device 607, IC IC99, analog/basic/mos_r2r_dac.hpp:28
        I(cpphdl_n1000, cpphdl_n1012) <+ V(cpphdl_n1000, cpphdl_n1012) / 2000.0;
        // device 608, IC IC99, analog/basic/mos_r2r_dac.hpp:29
        I(cpphdl_n1012, Vss) <+ 2.9999999999999998e-15 * ddt(V(cpphdl_n1012, Vss)); // Bench initial voltage = 0.0 V.
        // device 609, IC IC99, analog/basic/mos_r2r_dac.hpp:31
        I(cpphdl_n1007, cpphdl_n1012) <+ V(cpphdl_n1007, cpphdl_n1012) / 1000.0;
        // device 610, IC IC99, analog/basic/mos_r2r_dac.hpp:33
        I(Vss, cpphdl_n1001) <+ V(Vss, cpphdl_n1001) / 2000.0;
        // device 611, IC IC108, analog/basic/nmos_resistor_amplifier.hpp:23
        I(Vdd, cpphdl_n1021) <+ V(Vdd, cpphdl_n1021) / 500.0;
        // device 612, IC IC108, analog/basic/nmos_resistor_amplifier.hpp:24
        I(Vdd, cpphdl_n1020) <+ V(Vdd, cpphdl_n1020) / 500.0;
        // device 613, IC IC108, analog/basic/nmos_resistor_amplifier.hpp:25
        I(cpphdl_n1021, cpphdl_n1015) <+ cpphdl_channel(V(cpphdl_n1011, cpphdl_n1015), V(cpphdl_n1021, cpphdl_n1015), 0.014999999999999999, 0.69999999999999996, 1.0);
        // device 614, IC IC108, analog/basic/nmos_resistor_amplifier.hpp:26
        I(cpphdl_n1020, cpphdl_n1016) <+ cpphdl_channel(V(cpphdl_n1012, cpphdl_n1016), V(cpphdl_n1020, cpphdl_n1016), 0.014999999999999999, 0.69999999999999996, 1.0);
        // device 615, IC IC108, analog/basic/nmos_resistor_amplifier.hpp:27
        I(cpphdl_n1017, cpphdl_n1015) <+ V(cpphdl_n1017, cpphdl_n1015) / 50.0;
        // device 616, IC IC108, analog/basic/nmos_resistor_amplifier.hpp:28
        I(cpphdl_n1017, cpphdl_n1016) <+ V(cpphdl_n1017, cpphdl_n1016) / 50.0;
        // device 617, IC IC108, analog/basic/nmos_resistor_amplifier.hpp:29
        I(Vss, cpphdl_n1017) <+ V(Vss, cpphdl_n1017) / 150.0;
        // device 618, IC IC108, analog/basic/nmos_resistor_amplifier.hpp:30
        I(cpphdl_n1021, Vdd) <+ 2.9999999999999998e-13 * ddt(V(cpphdl_n1021, Vdd)); // Bench initial voltage = 0.0 V.
        // device 619, IC IC108, analog/basic/nmos_resistor_amplifier.hpp:31
        I(cpphdl_n1020, Vdd) <+ 2.9999999999999998e-13 * ddt(V(cpphdl_n1020, Vdd)); // Bench initial voltage = 0.0 V.
        // device 620, IC IC108, analog/basic/nmos_resistor_amplifier.hpp:32
        I(cpphdl_n1017, Vss) <+ 4e-14 * ddt(V(cpphdl_n1017, Vss)); // Bench initial voltage = 0.0 V.
        // device 621, IC IC108, analog/basic/nmos_resistor_amplifier.hpp:34
        I(cpphdl_n1011, cpphdl_n1015) <+ 2e-14 * ddt(V(cpphdl_n1011, cpphdl_n1015)); // Bench initial voltage = 1.6499999999999999 V.
        // device 622, IC IC108, analog/basic/nmos_resistor_amplifier.hpp:35
        I(cpphdl_n1012, cpphdl_n1016) <+ 2e-14 * ddt(V(cpphdl_n1012, cpphdl_n1016)); // Bench initial voltage = 0.0 V.
        // device 623, IC IC108, analog/basic/nmos_resistor_amplifier.hpp:36
        I(cpphdl_n1011, cpphdl_n1021) <+ 2.9999999999999998e-15 * ddt(V(cpphdl_n1011, cpphdl_n1021)); // Bench initial voltage = -1.6499999999999999 V.
        // device 624, IC IC108, analog/basic/nmos_resistor_amplifier.hpp:37
        I(cpphdl_n1012, cpphdl_n1020) <+ 2.9999999999999998e-15 * ddt(V(cpphdl_n1012, cpphdl_n1020)); // Bench initial voltage = -3.2999999999999998 V.
        // device 625, IC IC109, analog/basic/strongarm_comparator.hpp:28
        I(cpphdl_n1025, cpphdl_n1027) <+ cpphdl_channel(V(cpphdl_n1020, cpphdl_n1027), V(cpphdl_n1025, cpphdl_n1027), 0.0080000000000000002, 0.69999999999999996, 1.0);
        // device 626, IC IC109, analog/basic/strongarm_comparator.hpp:29
        I(cpphdl_n1026, cpphdl_n1027) <+ cpphdl_channel(V(cpphdl_n1021, cpphdl_n1027), V(cpphdl_n1026, cpphdl_n1027), 0.0080000000000000002, 0.69999999999999996, 1.0);
        // device 627, IC IC109, analog/basic/strongarm_comparator.hpp:30
        I(cpphdl_n1027, Vss) <+ cpphdl_channel(V(EVALUATE, Vss), V(cpphdl_n1027, Vss), 0.0080000000000000002, 0.69999999999999996, 1.0);
        // device 628, IC IC109, analog/basic/strongarm_comparator.hpp:33
        I(cpphdl_n1040, cpphdl_n1025) <+ cpphdl_channel(V(cpphdl_n1044, cpphdl_n1025), V(cpphdl_n1040, cpphdl_n1025), 0.0040000000000000001, 0.69999999999999996, 1.0);
        // device 629, IC IC109, analog/basic/strongarm_comparator.hpp:34
        I(cpphdl_n1044, cpphdl_n1026) <+ cpphdl_channel(V(cpphdl_n1040, cpphdl_n1026), V(cpphdl_n1044, cpphdl_n1026), 0.0040000000000000001, 0.69999999999999996, 1.0);
        // device 630, IC IC109, analog/basic/strongarm_comparator.hpp:35
        I(cpphdl_n1044, Vdd) <+ cpphdl_channel(V(cpphdl_n1040, Vdd), V(cpphdl_n1044, Vdd), 0.002, 0.69999999999999996, -1.0);
        // device 631, IC IC109, analog/basic/strongarm_comparator.hpp:36
        I(cpphdl_n1040, Vdd) <+ cpphdl_channel(V(cpphdl_n1044, Vdd), V(cpphdl_n1040, Vdd), 0.002, 0.69999999999999996, -1.0);
        // device 632, IC IC109, analog/basic/strongarm_comparator.hpp:38
        I(cpphdl_n1025, Vdd) <+ cpphdl_channel(V(EVALUATE, Vdd), V(cpphdl_n1025, Vdd), 0.002, 0.69999999999999996, -1.0);
        // device 633, IC IC109, analog/basic/strongarm_comparator.hpp:39
        I(cpphdl_n1026, Vdd) <+ cpphdl_channel(V(EVALUATE, Vdd), V(cpphdl_n1026, Vdd), 0.002, 0.69999999999999996, -1.0);
        // device 634, IC IC109, analog/basic/strongarm_comparator.hpp:40
        I(cpphdl_n1044, Vdd) <+ cpphdl_channel(V(EVALUATE, Vdd), V(cpphdl_n1044, Vdd), 0.002, 0.69999999999999996, -1.0);
        // device 635, IC IC109, analog/basic/strongarm_comparator.hpp:41
        I(cpphdl_n1040, Vdd) <+ cpphdl_channel(V(EVALUATE, Vdd), V(cpphdl_n1040, Vdd), 0.002, 0.69999999999999996, -1.0);
        // device 636, IC IC109, analog/basic/strongarm_comparator.hpp:42
        I(cpphdl_n1025, Vss) <+ 2.9999999999999998e-14 * ddt(V(cpphdl_n1025, Vss)); // Bench initial voltage = 0.0 V.
        // device 637, IC IC109, analog/basic/strongarm_comparator.hpp:43
        I(cpphdl_n1026, Vss) <+ 2.9999999999999998e-14 * ddt(V(cpphdl_n1026, Vss)); // Bench initial voltage = 0.0 V.
        // device 638, IC IC109, analog/basic/strongarm_comparator.hpp:44
        I(cpphdl_n1027, Vss) <+ 2.9999999999999998e-14 * ddt(V(cpphdl_n1027, Vss)); // Bench initial voltage = 0.0 V.
        // device 639, IC IC109, analog/basic/strongarm_comparator.hpp:45
        I(cpphdl_n1044, Vss) <+ 5.0000000000000002e-14 * ddt(V(cpphdl_n1044, Vss)); // Bench initial voltage = 0.0 V.
        // device 640, IC IC109, analog/basic/strongarm_comparator.hpp:46
        I(cpphdl_n1040, Vss) <+ 5.0000000000000002e-14 * ddt(V(cpphdl_n1040, Vss)); // Bench initial voltage = 0.0 V.
        // device 641, IC IC109, analog/basic/strongarm_comparator.hpp:47
        I(cpphdl_n1020, cpphdl_n1027) <+ 2e-14 * ddt(V(cpphdl_n1020, cpphdl_n1027)); // Bench initial voltage = 3.2999999999999998 V.
        // device 642, IC IC109, analog/basic/strongarm_comparator.hpp:48
        I(cpphdl_n1021, cpphdl_n1027) <+ 2e-14 * ddt(V(cpphdl_n1021, cpphdl_n1027)); // Bench initial voltage = 3.2999999999999998 V.
        // device 643, IC IC109, analog/basic/strongarm_comparator.hpp:49
        I(cpphdl_n1020, cpphdl_n1025) <+ 2.9999999999999998e-15 * ddt(V(cpphdl_n1020, cpphdl_n1025)); // Bench initial voltage = 3.2999999999999998 V.
        // device 644, IC IC109, analog/basic/strongarm_comparator.hpp:50
        I(cpphdl_n1021, cpphdl_n1026) <+ 2.9999999999999998e-15 * ddt(V(cpphdl_n1021, cpphdl_n1026)); // Bench initial voltage = 3.2999999999999998 V.
        // device 645, IC IC111, analog/basic/inverter.hpp:11
        I(cpphdl_n1048, Vdd) <+ cpphdl_channel(V(cpphdl_n1040, Vdd), V(cpphdl_n1048, Vdd), 0.001, 0.69999999999999996, -1.0);
        // device 646, IC IC111, analog/basic/inverter.hpp:12
        I(cpphdl_n1048, Vss) <+ cpphdl_channel(V(cpphdl_n1040, Vss), V(cpphdl_n1048, Vss), 0.001, 0.69999999999999996, 1.0);
        // device 647, IC IC113, analog/basic/inverter.hpp:11
        I(cpphdl_n1062, Vdd) <+ cpphdl_channel(V(cpphdl_n1048, Vdd), V(cpphdl_n1062, Vdd), 0.0040000000000000001, 0.69999999999999996, -1.0);
        // device 648, IC IC113, analog/basic/inverter.hpp:12
        I(cpphdl_n1062, Vss) <+ cpphdl_channel(V(cpphdl_n1048, Vss), V(cpphdl_n1062, Vss), 0.0040000000000000001, 0.69999999999999996, 1.0);
        // device 649, IC IC110, analog/basic/buffered_nand_latch.hpp:34
        I(cpphdl_n1040, Vss) <+ 2.0000000000000002e-15 * ddt(V(cpphdl_n1040, Vss)); // Bench initial voltage = 0.0 V.
        // device 650, IC IC110, analog/basic/buffered_nand_latch.hpp:35
        I(cpphdl_n1040, cpphdl_n1048) <+ 1.0000000000000001e-15 * ddt(V(cpphdl_n1040, cpphdl_n1048)); // Bench initial voltage = 0.0 V.
        // device 651, IC IC110, analog/basic/buffered_nand_latch.hpp:36
        I(cpphdl_n1048, Vss) <+ 5e-15 * ddt(V(cpphdl_n1048, Vss)); // Bench initial voltage = 0.0 V.
        // device 652, IC IC110, analog/basic/buffered_nand_latch.hpp:37
        I(cpphdl_n1048, Vss) <+ 8.0000000000000006e-15 * ddt(V(cpphdl_n1048, Vss)); // Bench initial voltage = 0.0 V.
        // device 653, IC IC110, analog/basic/buffered_nand_latch.hpp:38
        I(cpphdl_n1062, Vss) <+ 1e-14 * ddt(V(cpphdl_n1062, Vss)); // Bench initial voltage = 0.0 V.
        // device 654, IC IC112, analog/basic/inverter.hpp:11
        I(cpphdl_n1052, Vdd) <+ cpphdl_channel(V(cpphdl_n1044, Vdd), V(cpphdl_n1052, Vdd), 0.001, 0.69999999999999996, -1.0);
        // device 655, IC IC112, analog/basic/inverter.hpp:12
        I(cpphdl_n1052, Vss) <+ cpphdl_channel(V(cpphdl_n1044, Vss), V(cpphdl_n1052, Vss), 0.001, 0.69999999999999996, 1.0);
        // device 656, IC IC114, analog/basic/inverter.hpp:11
        I(cpphdl_n1068, Vdd) <+ cpphdl_channel(V(cpphdl_n1052, Vdd), V(cpphdl_n1068, Vdd), 0.0040000000000000001, 0.69999999999999996, -1.0);
        // device 657, IC IC114, analog/basic/inverter.hpp:12
        I(cpphdl_n1068, Vss) <+ cpphdl_channel(V(cpphdl_n1052, Vss), V(cpphdl_n1068, Vss), 0.0040000000000000001, 0.69999999999999996, 1.0);
        // device 658, IC IC110, analog/basic/buffered_nand_latch.hpp:34
        I(cpphdl_n1044, Vss) <+ 2.0000000000000002e-15 * ddt(V(cpphdl_n1044, Vss)); // Bench initial voltage = 0.0 V.
        // device 659, IC IC110, analog/basic/buffered_nand_latch.hpp:35
        I(cpphdl_n1044, cpphdl_n1052) <+ 1.0000000000000001e-15 * ddt(V(cpphdl_n1044, cpphdl_n1052)); // Bench initial voltage = 0.0 V.
        // device 660, IC IC110, analog/basic/buffered_nand_latch.hpp:36
        I(cpphdl_n1052, Vss) <+ 5e-15 * ddt(V(cpphdl_n1052, Vss)); // Bench initial voltage = 0.0 V.
        // device 661, IC IC110, analog/basic/buffered_nand_latch.hpp:37
        I(cpphdl_n1052, Vss) <+ 8.0000000000000006e-15 * ddt(V(cpphdl_n1052, Vss)); // Bench initial voltage = 0.0 V.
        // device 662, IC IC110, analog/basic/buffered_nand_latch.hpp:38
        I(cpphdl_n1068, Vss) <+ 1e-14 * ddt(V(cpphdl_n1068, Vss)); // Bench initial voltage = 0.0 V.
        // device 663, IC IC116, analog/basic/cmos_logic.hpp:17
        I(cpphdl_n2689, Vss) <+ 5.0000000000000002e-14 * ddt(V(cpphdl_n2689, Vss)); // Bench initial voltage = 0.0 V.
        // device 664, IC IC116, analog/basic/cmos_logic.hpp:18
        I(cpphdl_n2689, Vdd) <+ cpphdl_channel(V(cpphdl_n1062, Vdd), V(cpphdl_n2689, Vdd), 0.01, 0.69999999999999996, -1.0);
        // device 665, IC IC116, analog/basic/cmos_logic.hpp:19
        I(cpphdl_n2689, Vdd) <+ cpphdl_channel(V(cpphdl_n1070, Vdd), V(cpphdl_n2689, Vdd), 0.01, 0.69999999999999996, -1.0);
        // device 666, IC IC116, analog/basic/cmos_logic.hpp:20
        I(cpphdl_n2689, cpphdl_n1065) <+ cpphdl_channel(V(cpphdl_n1062, cpphdl_n1065), V(cpphdl_n2689, cpphdl_n1065), 0.01, 0.69999999999999996, 1.0);
        // device 667, IC IC116, analog/basic/cmos_logic.hpp:21
        I(cpphdl_n1065, Vss) <+ cpphdl_channel(V(cpphdl_n1070, Vss), V(cpphdl_n1065, Vss), 0.01, 0.69999999999999996, 1.0);
        // device 668, IC IC116, analog/basic/cmos_logic.hpp:23
        I(cpphdl_n2689, Vss) <+ V(cpphdl_n2689, Vss) / 1000000000.0;
        // device 669, IC IC116, analog/basic/cmos_logic.hpp:24
        I(cpphdl_n1065, Vss) <+ V(cpphdl_n1065, Vss) / 1000000000.0;
        // device 670, IC IC117, analog/basic/cmos_logic.hpp:17
        I(cpphdl_n1070, Vss) <+ 5.0000000000000002e-14 * ddt(V(cpphdl_n1070, Vss)); // Bench initial voltage = 0.0 V.
        // device 671, IC IC117, analog/basic/cmos_logic.hpp:18
        I(cpphdl_n1070, Vdd) <+ cpphdl_channel(V(cpphdl_n1068, Vdd), V(cpphdl_n1070, Vdd), 0.01, 0.69999999999999996, -1.0);
        // device 672, IC IC117, analog/basic/cmos_logic.hpp:19
        I(cpphdl_n1070, Vdd) <+ cpphdl_channel(V(cpphdl_n2689, Vdd), V(cpphdl_n1070, Vdd), 0.01, 0.69999999999999996, -1.0);
        // device 673, IC IC117, analog/basic/cmos_logic.hpp:20
        I(cpphdl_n1070, cpphdl_n1071) <+ cpphdl_channel(V(cpphdl_n1068, cpphdl_n1071), V(cpphdl_n1070, cpphdl_n1071), 0.01, 0.69999999999999996, 1.0);
        // device 674, IC IC117, analog/basic/cmos_logic.hpp:21
        I(cpphdl_n1071, Vss) <+ cpphdl_channel(V(cpphdl_n2689, Vss), V(cpphdl_n1071, Vss), 0.01, 0.69999999999999996, 1.0);
        // device 675, IC IC117, analog/basic/cmos_logic.hpp:23
        I(cpphdl_n1070, Vss) <+ V(cpphdl_n1070, Vss) / 1000000000.0;
        // device 676, IC IC117, analog/basic/cmos_logic.hpp:24
        I(cpphdl_n1071, Vss) <+ V(cpphdl_n1071, Vss) / 1000000000.0;
        // device 677, IC IC115, analog/basic/nand_latch.hpp:36
        I(cpphdl_n1062, Vss) <+ 2.9999999999999998e-15 * ddt(V(cpphdl_n1062, Vss)); // Bench initial voltage = 0.0 V.
        // device 678, IC IC115, analog/basic/nand_latch.hpp:37
        I(cpphdl_n1068, Vss) <+ 2.9999999999999998e-15 * ddt(V(cpphdl_n1068, Vss)); // Bench initial voltage = 0.0 V.
        // device 679, IC IC118, analog/basic/inverter.hpp:11
        I(cpphdl_n1076, Vdd) <+ cpphdl_channel(V(CLEAR, Vdd), V(cpphdl_n1076, Vdd), 0.01, 0.69999999999999996, -1.0);
        // device 680, IC IC118, analog/basic/inverter.hpp:12
        I(cpphdl_n1076, Vss) <+ cpphdl_channel(V(CLEAR, Vss), V(cpphdl_n1076, Vss), 0.01, 0.69999999999999996, 1.0);
        // device 681, IC IC115, analog/basic/nand_latch.hpp:58
        I(cpphdl_n1076, Vss) <+ 2.9999999999999998e-15 * ddt(V(cpphdl_n1076, Vss)); // Bench initial voltage = 0.0 V.
        // device 682, IC IC115, analog/basic/nand_latch.hpp:59
        I(cpphdl_n2689, Vss) <+ cpphdl_channel(V(CLEAR, Vss), V(cpphdl_n2689, Vss), 0.050000000000000003, 0.69999999999999996, 1.0);
        // device 683, IC IC115, analog/basic/nand_latch.hpp:60
        I(cpphdl_n1070, Vdd) <+ cpphdl_channel(V(cpphdl_n1076, Vdd), V(cpphdl_n1070, Vdd), 0.050000000000000003, 0.69999999999999996, -1.0);
        // device 684, IC IC121, analog/basic/inverter.hpp:11
        I(cpphdl_n1100, Vdd) <+ cpphdl_channel(V(TRACK5, Vdd), V(cpphdl_n1100, Vdd), 0.0040000000000000001, 0.69999999999999996, -1.0);
        // device 685, IC IC121, analog/basic/inverter.hpp:12
        I(cpphdl_n1100, Vss) <+ cpphdl_channel(V(TRACK5, Vss), V(cpphdl_n1100, Vss), 0.0040000000000000001, 0.69999999999999996, 1.0);
        // device 686, IC IC120, analog/basic/mos_track_hold.hpp:31
        I(cpphdl_n1100, Vss) <+ 2e-14 * ddt(V(cpphdl_n1100, Vss)); // Bench initial voltage = 3.2999999999999998 V.
        // device 687, IC IC120, analog/basic/mos_track_hold.hpp:32
        I(cpphdl_n2759, cpphdl_n1154) <+ cpphdl_channel(V(TRACK5, cpphdl_n1154), V(cpphdl_n2759, cpphdl_n1154), 0.080000000000000002, 0.69999999999999996, 1.0);
        // device 688, IC IC120, analog/basic/mos_track_hold.hpp:33
        I(cpphdl_n1154, cpphdl_n2759) <+ cpphdl_channel(V(cpphdl_n1100, cpphdl_n2759), V(cpphdl_n1154, cpphdl_n2759), 0.040000000000000001, 0.69999999999999996, -1.0);
        // device 689, IC IC120, analog/basic/mos_track_hold.hpp:37
        I(cpphdl_n1154, cpphdl_n1154) <+ cpphdl_channel(V(cpphdl_n1100, cpphdl_n1154), V(cpphdl_n1154, cpphdl_n1154), 0.040000000000000001, 0.69999999999999996, 1.0);
        // device 690, IC IC120, analog/basic/mos_track_hold.hpp:38
        I(cpphdl_n1154, cpphdl_n1154) <+ cpphdl_channel(V(TRACK5, cpphdl_n1154), V(cpphdl_n1154, cpphdl_n1154), 0.02, 0.69999999999999996, -1.0);
        // device 691, IC IC120, analog/basic/mos_track_hold.hpp:39
        I(cpphdl_n1154, Vss) <+ 3.0000000000000001e-12 * ddt(V(cpphdl_n1154, Vss)); // Bench initial voltage = 1.6499999999999999 V.
        // device 692, IC IC120, analog/basic/mos_track_hold.hpp:41
        I(Vss, cpphdl_n1154) <+ V(Vss, cpphdl_n1154) / 1000000000.0;
        // device 693, IC IC120, analog/basic/mos_track_hold.hpp:42
        I(TRACK5, cpphdl_n1154) <+ 8.0000000000000006e-15 * ddt(V(TRACK5, cpphdl_n1154)); // Bench initial voltage = -1.6499999999999999 V.
        // device 694, IC IC120, analog/basic/mos_track_hold.hpp:43
        I(cpphdl_n1100, cpphdl_n1154) <+ 8.0000000000000006e-15 * ddt(V(cpphdl_n1100, cpphdl_n1154)); // Bench initial voltage = 1.6499999999999999 V.
        // device 695, IC IC120, analog/basic/mos_track_hold.hpp:44
        I(cpphdl_n2759, cpphdl_n1154) <+ 4.0000000000000003e-15 * ddt(V(cpphdl_n2759, cpphdl_n1154)); // Bench initial voltage = 0.0 V.
        // device 696, IC IC123, analog/basic/inverter.hpp:11
        I(cpphdl_n1115, Vdd) <+ cpphdl_channel(V(BIT_N5_0, Vdd), V(cpphdl_n1115, Vdd), 0.080000000000000002, 0.69999999999999996, -1.0);
        // device 697, IC IC123, analog/basic/inverter.hpp:12
        I(cpphdl_n1115, Vss) <+ cpphdl_channel(V(BIT_N5_0, Vss), V(cpphdl_n1115, Vss), 0.080000000000000002, 0.69999999999999996, 1.0);
        // device 698, IC IC122, analog/basic/mos_r2r_dac.hpp:27
        I(cpphdl_n1115, Vss) <+ 2.9999999999999998e-15 * ddt(V(cpphdl_n1115, Vss)); // Bench initial voltage = 0.0 V.
        // device 699, IC IC122, analog/basic/mos_r2r_dac.hpp:28
        I(cpphdl_n1115, cpphdl_n1144) <+ V(cpphdl_n1115, cpphdl_n1144) / 2000.0;
        // device 700, IC IC122, analog/basic/mos_r2r_dac.hpp:29
        I(cpphdl_n1144, Vss) <+ 2.9999999999999998e-15 * ddt(V(cpphdl_n1144, Vss)); // Bench initial voltage = 0.0 V.
        // device 701, IC IC124, analog/basic/inverter.hpp:11
        I(cpphdl_n1119, Vdd) <+ cpphdl_channel(V(BIT_N5_1, Vdd), V(cpphdl_n1119, Vdd), 0.080000000000000002, 0.69999999999999996, -1.0);
        // device 702, IC IC124, analog/basic/inverter.hpp:12
        I(cpphdl_n1119, Vss) <+ cpphdl_channel(V(BIT_N5_1, Vss), V(cpphdl_n1119, Vss), 0.080000000000000002, 0.69999999999999996, 1.0);
        // device 703, IC IC122, analog/basic/mos_r2r_dac.hpp:27
        I(cpphdl_n1119, Vss) <+ 2.9999999999999998e-15 * ddt(V(cpphdl_n1119, Vss)); // Bench initial voltage = 0.0 V.
        // device 704, IC IC122, analog/basic/mos_r2r_dac.hpp:28
        I(cpphdl_n1119, cpphdl_n1145) <+ V(cpphdl_n1119, cpphdl_n1145) / 2000.0;
        // device 705, IC IC122, analog/basic/mos_r2r_dac.hpp:29
        I(cpphdl_n1145, Vss) <+ 2.9999999999999998e-15 * ddt(V(cpphdl_n1145, Vss)); // Bench initial voltage = 0.0 V.
        // device 706, IC IC122, analog/basic/mos_r2r_dac.hpp:31
        I(cpphdl_n1144, cpphdl_n1145) <+ V(cpphdl_n1144, cpphdl_n1145) / 1000.0;
        // device 707, IC IC125, analog/basic/inverter.hpp:11
        I(cpphdl_n1123, Vdd) <+ cpphdl_channel(V(BIT_N5_2, Vdd), V(cpphdl_n1123, Vdd), 0.080000000000000002, 0.69999999999999996, -1.0);
        // device 708, IC IC125, analog/basic/inverter.hpp:12
        I(cpphdl_n1123, Vss) <+ cpphdl_channel(V(BIT_N5_2, Vss), V(cpphdl_n1123, Vss), 0.080000000000000002, 0.69999999999999996, 1.0);
        // device 709, IC IC122, analog/basic/mos_r2r_dac.hpp:27
        I(cpphdl_n1123, Vss) <+ 2.9999999999999998e-15 * ddt(V(cpphdl_n1123, Vss)); // Bench initial voltage = 0.0 V.
        // device 710, IC IC122, analog/basic/mos_r2r_dac.hpp:28
        I(cpphdl_n1123, cpphdl_n1146) <+ V(cpphdl_n1123, cpphdl_n1146) / 2000.0;
        // device 711, IC IC122, analog/basic/mos_r2r_dac.hpp:29
        I(cpphdl_n1146, Vss) <+ 2.9999999999999998e-15 * ddt(V(cpphdl_n1146, Vss)); // Bench initial voltage = 0.0 V.
        // device 712, IC IC122, analog/basic/mos_r2r_dac.hpp:31
        I(cpphdl_n1145, cpphdl_n1146) <+ V(cpphdl_n1145, cpphdl_n1146) / 1000.0;
        // device 713, IC IC126, analog/basic/inverter.hpp:11
        I(cpphdl_n1127, Vdd) <+ cpphdl_channel(V(BIT_N5_3, Vdd), V(cpphdl_n1127, Vdd), 0.080000000000000002, 0.69999999999999996, -1.0);
        // device 714, IC IC126, analog/basic/inverter.hpp:12
        I(cpphdl_n1127, Vss) <+ cpphdl_channel(V(BIT_N5_3, Vss), V(cpphdl_n1127, Vss), 0.080000000000000002, 0.69999999999999996, 1.0);
        // device 715, IC IC122, analog/basic/mos_r2r_dac.hpp:27
        I(cpphdl_n1127, Vss) <+ 2.9999999999999998e-15 * ddt(V(cpphdl_n1127, Vss)); // Bench initial voltage = 0.0 V.
        // device 716, IC IC122, analog/basic/mos_r2r_dac.hpp:28
        I(cpphdl_n1127, cpphdl_n1147) <+ V(cpphdl_n1127, cpphdl_n1147) / 2000.0;
        // device 717, IC IC122, analog/basic/mos_r2r_dac.hpp:29
        I(cpphdl_n1147, Vss) <+ 2.9999999999999998e-15 * ddt(V(cpphdl_n1147, Vss)); // Bench initial voltage = 0.0 V.
        // device 718, IC IC122, analog/basic/mos_r2r_dac.hpp:31
        I(cpphdl_n1146, cpphdl_n1147) <+ V(cpphdl_n1146, cpphdl_n1147) / 1000.0;
        // device 719, IC IC127, analog/basic/inverter.hpp:11
        I(cpphdl_n1131, Vdd) <+ cpphdl_channel(V(BIT_N5_4, Vdd), V(cpphdl_n1131, Vdd), 0.080000000000000002, 0.69999999999999996, -1.0);
        // device 720, IC IC127, analog/basic/inverter.hpp:12
        I(cpphdl_n1131, Vss) <+ cpphdl_channel(V(BIT_N5_4, Vss), V(cpphdl_n1131, Vss), 0.080000000000000002, 0.69999999999999996, 1.0);
        // device 721, IC IC122, analog/basic/mos_r2r_dac.hpp:27
        I(cpphdl_n1131, Vss) <+ 2.9999999999999998e-15 * ddt(V(cpphdl_n1131, Vss)); // Bench initial voltage = 0.0 V.
        // device 722, IC IC122, analog/basic/mos_r2r_dac.hpp:28
        I(cpphdl_n1131, cpphdl_n1148) <+ V(cpphdl_n1131, cpphdl_n1148) / 2000.0;
        // device 723, IC IC122, analog/basic/mos_r2r_dac.hpp:29
        I(cpphdl_n1148, Vss) <+ 2.9999999999999998e-15 * ddt(V(cpphdl_n1148, Vss)); // Bench initial voltage = 0.0 V.
        // device 724, IC IC122, analog/basic/mos_r2r_dac.hpp:31
        I(cpphdl_n1147, cpphdl_n1148) <+ V(cpphdl_n1147, cpphdl_n1148) / 1000.0;
        // device 725, IC IC128, analog/basic/inverter.hpp:11
        I(cpphdl_n1135, Vdd) <+ cpphdl_channel(V(BIT_N5_5, Vdd), V(cpphdl_n1135, Vdd), 0.080000000000000002, 0.69999999999999996, -1.0);
        // device 726, IC IC128, analog/basic/inverter.hpp:12
        I(cpphdl_n1135, Vss) <+ cpphdl_channel(V(BIT_N5_5, Vss), V(cpphdl_n1135, Vss), 0.080000000000000002, 0.69999999999999996, 1.0);
        // device 727, IC IC122, analog/basic/mos_r2r_dac.hpp:27
        I(cpphdl_n1135, Vss) <+ 2.9999999999999998e-15 * ddt(V(cpphdl_n1135, Vss)); // Bench initial voltage = 0.0 V.
        // device 728, IC IC122, analog/basic/mos_r2r_dac.hpp:28
        I(cpphdl_n1135, cpphdl_n1149) <+ V(cpphdl_n1135, cpphdl_n1149) / 2000.0;
        // device 729, IC IC122, analog/basic/mos_r2r_dac.hpp:29
        I(cpphdl_n1149, Vss) <+ 2.9999999999999998e-15 * ddt(V(cpphdl_n1149, Vss)); // Bench initial voltage = 0.0 V.
        // device 730, IC IC122, analog/basic/mos_r2r_dac.hpp:31
        I(cpphdl_n1148, cpphdl_n1149) <+ V(cpphdl_n1148, cpphdl_n1149) / 1000.0;
        // device 731, IC IC129, analog/basic/inverter.hpp:11
        I(cpphdl_n1139, Vdd) <+ cpphdl_channel(V(BIT_N5_6, Vdd), V(cpphdl_n1139, Vdd), 0.080000000000000002, 0.69999999999999996, -1.0);
        // device 732, IC IC129, analog/basic/inverter.hpp:12
        I(cpphdl_n1139, Vss) <+ cpphdl_channel(V(BIT_N5_6, Vss), V(cpphdl_n1139, Vss), 0.080000000000000002, 0.69999999999999996, 1.0);
        // device 733, IC IC122, analog/basic/mos_r2r_dac.hpp:27
        I(cpphdl_n1139, Vss) <+ 2.9999999999999998e-15 * ddt(V(cpphdl_n1139, Vss)); // Bench initial voltage = 0.0 V.
        // device 734, IC IC122, analog/basic/mos_r2r_dac.hpp:28
        I(cpphdl_n1139, cpphdl_n1150) <+ V(cpphdl_n1139, cpphdl_n1150) / 2000.0;
        // device 735, IC IC122, analog/basic/mos_r2r_dac.hpp:29
        I(cpphdl_n1150, Vss) <+ 2.9999999999999998e-15 * ddt(V(cpphdl_n1150, Vss)); // Bench initial voltage = 0.0 V.
        // device 736, IC IC122, analog/basic/mos_r2r_dac.hpp:31
        I(cpphdl_n1149, cpphdl_n1150) <+ V(cpphdl_n1149, cpphdl_n1150) / 1000.0;
        // device 737, IC IC130, analog/basic/inverter.hpp:11
        I(cpphdl_n1143, Vdd) <+ cpphdl_channel(V(BIT_N5_7, Vdd), V(cpphdl_n1143, Vdd), 0.080000000000000002, 0.69999999999999996, -1.0);
        // device 738, IC IC130, analog/basic/inverter.hpp:12
        I(cpphdl_n1143, Vss) <+ cpphdl_channel(V(BIT_N5_7, Vss), V(cpphdl_n1143, Vss), 0.080000000000000002, 0.69999999999999996, 1.0);
        // device 739, IC IC122, analog/basic/mos_r2r_dac.hpp:27
        I(cpphdl_n1143, Vss) <+ 2.9999999999999998e-15 * ddt(V(cpphdl_n1143, Vss)); // Bench initial voltage = 0.0 V.
        // device 740, IC IC122, analog/basic/mos_r2r_dac.hpp:28
        I(cpphdl_n1143, cpphdl_n1155) <+ V(cpphdl_n1143, cpphdl_n1155) / 2000.0;
        // device 741, IC IC122, analog/basic/mos_r2r_dac.hpp:29
        I(cpphdl_n1155, Vss) <+ 2.9999999999999998e-15 * ddt(V(cpphdl_n1155, Vss)); // Bench initial voltage = 0.0 V.
        // device 742, IC IC122, analog/basic/mos_r2r_dac.hpp:31
        I(cpphdl_n1150, cpphdl_n1155) <+ V(cpphdl_n1150, cpphdl_n1155) / 1000.0;
        // device 743, IC IC122, analog/basic/mos_r2r_dac.hpp:33
        I(Vss, cpphdl_n1144) <+ V(Vss, cpphdl_n1144) / 2000.0;
        // device 744, IC IC131, analog/basic/nmos_resistor_amplifier.hpp:23
        I(Vdd, cpphdl_n1164) <+ V(Vdd, cpphdl_n1164) / 500.0;
        // device 745, IC IC131, analog/basic/nmos_resistor_amplifier.hpp:24
        I(Vdd, cpphdl_n1163) <+ V(Vdd, cpphdl_n1163) / 500.0;
        // device 746, IC IC131, analog/basic/nmos_resistor_amplifier.hpp:25
        I(cpphdl_n1164, cpphdl_n1158) <+ cpphdl_channel(V(cpphdl_n1154, cpphdl_n1158), V(cpphdl_n1164, cpphdl_n1158), 0.014999999999999999, 0.69999999999999996, 1.0);
        // device 747, IC IC131, analog/basic/nmos_resistor_amplifier.hpp:26
        I(cpphdl_n1163, cpphdl_n1159) <+ cpphdl_channel(V(cpphdl_n1155, cpphdl_n1159), V(cpphdl_n1163, cpphdl_n1159), 0.014999999999999999, 0.69999999999999996, 1.0);
        // device 748, IC IC131, analog/basic/nmos_resistor_amplifier.hpp:27
        I(cpphdl_n1160, cpphdl_n1158) <+ V(cpphdl_n1160, cpphdl_n1158) / 50.0;
        // device 749, IC IC131, analog/basic/nmos_resistor_amplifier.hpp:28
        I(cpphdl_n1160, cpphdl_n1159) <+ V(cpphdl_n1160, cpphdl_n1159) / 50.0;
        // device 750, IC IC131, analog/basic/nmos_resistor_amplifier.hpp:29
        I(Vss, cpphdl_n1160) <+ V(Vss, cpphdl_n1160) / 150.0;
        // device 751, IC IC131, analog/basic/nmos_resistor_amplifier.hpp:30
        I(cpphdl_n1164, Vdd) <+ 2.9999999999999998e-13 * ddt(V(cpphdl_n1164, Vdd)); // Bench initial voltage = 0.0 V.
        // device 752, IC IC131, analog/basic/nmos_resistor_amplifier.hpp:31
        I(cpphdl_n1163, Vdd) <+ 2.9999999999999998e-13 * ddt(V(cpphdl_n1163, Vdd)); // Bench initial voltage = 0.0 V.
        // device 753, IC IC131, analog/basic/nmos_resistor_amplifier.hpp:32
        I(cpphdl_n1160, Vss) <+ 4e-14 * ddt(V(cpphdl_n1160, Vss)); // Bench initial voltage = 0.0 V.
        // device 754, IC IC131, analog/basic/nmos_resistor_amplifier.hpp:34
        I(cpphdl_n1154, cpphdl_n1158) <+ 2e-14 * ddt(V(cpphdl_n1154, cpphdl_n1158)); // Bench initial voltage = 1.6499999999999999 V.
        // device 755, IC IC131, analog/basic/nmos_resistor_amplifier.hpp:35
        I(cpphdl_n1155, cpphdl_n1159) <+ 2e-14 * ddt(V(cpphdl_n1155, cpphdl_n1159)); // Bench initial voltage = 0.0 V.
        // device 756, IC IC131, analog/basic/nmos_resistor_amplifier.hpp:36
        I(cpphdl_n1154, cpphdl_n1164) <+ 2.9999999999999998e-15 * ddt(V(cpphdl_n1154, cpphdl_n1164)); // Bench initial voltage = -1.6499999999999999 V.
        // device 757, IC IC131, analog/basic/nmos_resistor_amplifier.hpp:37
        I(cpphdl_n1155, cpphdl_n1163) <+ 2.9999999999999998e-15 * ddt(V(cpphdl_n1155, cpphdl_n1163)); // Bench initial voltage = -3.2999999999999998 V.
        // device 758, IC IC132, analog/basic/strongarm_comparator.hpp:28
        I(cpphdl_n1168, cpphdl_n1170) <+ cpphdl_channel(V(cpphdl_n1163, cpphdl_n1170), V(cpphdl_n1168, cpphdl_n1170), 0.0080000000000000002, 0.69999999999999996, 1.0);
        // device 759, IC IC132, analog/basic/strongarm_comparator.hpp:29
        I(cpphdl_n1169, cpphdl_n1170) <+ cpphdl_channel(V(cpphdl_n1164, cpphdl_n1170), V(cpphdl_n1169, cpphdl_n1170), 0.0080000000000000002, 0.69999999999999996, 1.0);
        // device 760, IC IC132, analog/basic/strongarm_comparator.hpp:30
        I(cpphdl_n1170, Vss) <+ cpphdl_channel(V(EVALUATE, Vss), V(cpphdl_n1170, Vss), 0.0080000000000000002, 0.69999999999999996, 1.0);
        // device 761, IC IC132, analog/basic/strongarm_comparator.hpp:33
        I(cpphdl_n1183, cpphdl_n1168) <+ cpphdl_channel(V(cpphdl_n1187, cpphdl_n1168), V(cpphdl_n1183, cpphdl_n1168), 0.0040000000000000001, 0.69999999999999996, 1.0);
        // device 762, IC IC132, analog/basic/strongarm_comparator.hpp:34
        I(cpphdl_n1187, cpphdl_n1169) <+ cpphdl_channel(V(cpphdl_n1183, cpphdl_n1169), V(cpphdl_n1187, cpphdl_n1169), 0.0040000000000000001, 0.69999999999999996, 1.0);
        // device 763, IC IC132, analog/basic/strongarm_comparator.hpp:35
        I(cpphdl_n1187, Vdd) <+ cpphdl_channel(V(cpphdl_n1183, Vdd), V(cpphdl_n1187, Vdd), 0.002, 0.69999999999999996, -1.0);
        // device 764, IC IC132, analog/basic/strongarm_comparator.hpp:36
        I(cpphdl_n1183, Vdd) <+ cpphdl_channel(V(cpphdl_n1187, Vdd), V(cpphdl_n1183, Vdd), 0.002, 0.69999999999999996, -1.0);
        // device 765, IC IC132, analog/basic/strongarm_comparator.hpp:38
        I(cpphdl_n1168, Vdd) <+ cpphdl_channel(V(EVALUATE, Vdd), V(cpphdl_n1168, Vdd), 0.002, 0.69999999999999996, -1.0);
        // device 766, IC IC132, analog/basic/strongarm_comparator.hpp:39
        I(cpphdl_n1169, Vdd) <+ cpphdl_channel(V(EVALUATE, Vdd), V(cpphdl_n1169, Vdd), 0.002, 0.69999999999999996, -1.0);
        // device 767, IC IC132, analog/basic/strongarm_comparator.hpp:40
        I(cpphdl_n1187, Vdd) <+ cpphdl_channel(V(EVALUATE, Vdd), V(cpphdl_n1187, Vdd), 0.002, 0.69999999999999996, -1.0);
        // device 768, IC IC132, analog/basic/strongarm_comparator.hpp:41
        I(cpphdl_n1183, Vdd) <+ cpphdl_channel(V(EVALUATE, Vdd), V(cpphdl_n1183, Vdd), 0.002, 0.69999999999999996, -1.0);
        // device 769, IC IC132, analog/basic/strongarm_comparator.hpp:42
        I(cpphdl_n1168, Vss) <+ 2.9999999999999998e-14 * ddt(V(cpphdl_n1168, Vss)); // Bench initial voltage = 0.0 V.
        // device 770, IC IC132, analog/basic/strongarm_comparator.hpp:43
        I(cpphdl_n1169, Vss) <+ 2.9999999999999998e-14 * ddt(V(cpphdl_n1169, Vss)); // Bench initial voltage = 0.0 V.
        // device 771, IC IC132, analog/basic/strongarm_comparator.hpp:44
        I(cpphdl_n1170, Vss) <+ 2.9999999999999998e-14 * ddt(V(cpphdl_n1170, Vss)); // Bench initial voltage = 0.0 V.
        // device 772, IC IC132, analog/basic/strongarm_comparator.hpp:45
        I(cpphdl_n1187, Vss) <+ 5.0000000000000002e-14 * ddt(V(cpphdl_n1187, Vss)); // Bench initial voltage = 0.0 V.
        // device 773, IC IC132, analog/basic/strongarm_comparator.hpp:46
        I(cpphdl_n1183, Vss) <+ 5.0000000000000002e-14 * ddt(V(cpphdl_n1183, Vss)); // Bench initial voltage = 0.0 V.
        // device 774, IC IC132, analog/basic/strongarm_comparator.hpp:47
        I(cpphdl_n1163, cpphdl_n1170) <+ 2e-14 * ddt(V(cpphdl_n1163, cpphdl_n1170)); // Bench initial voltage = 3.2999999999999998 V.
        // device 775, IC IC132, analog/basic/strongarm_comparator.hpp:48
        I(cpphdl_n1164, cpphdl_n1170) <+ 2e-14 * ddt(V(cpphdl_n1164, cpphdl_n1170)); // Bench initial voltage = 3.2999999999999998 V.
        // device 776, IC IC132, analog/basic/strongarm_comparator.hpp:49
        I(cpphdl_n1163, cpphdl_n1168) <+ 2.9999999999999998e-15 * ddt(V(cpphdl_n1163, cpphdl_n1168)); // Bench initial voltage = 3.2999999999999998 V.
        // device 777, IC IC132, analog/basic/strongarm_comparator.hpp:50
        I(cpphdl_n1164, cpphdl_n1169) <+ 2.9999999999999998e-15 * ddt(V(cpphdl_n1164, cpphdl_n1169)); // Bench initial voltage = 3.2999999999999998 V.
        // device 778, IC IC134, analog/basic/inverter.hpp:11
        I(cpphdl_n1191, Vdd) <+ cpphdl_channel(V(cpphdl_n1183, Vdd), V(cpphdl_n1191, Vdd), 0.001, 0.69999999999999996, -1.0);
        // device 779, IC IC134, analog/basic/inverter.hpp:12
        I(cpphdl_n1191, Vss) <+ cpphdl_channel(V(cpphdl_n1183, Vss), V(cpphdl_n1191, Vss), 0.001, 0.69999999999999996, 1.0);
        // device 780, IC IC136, analog/basic/inverter.hpp:11
        I(cpphdl_n1205, Vdd) <+ cpphdl_channel(V(cpphdl_n1191, Vdd), V(cpphdl_n1205, Vdd), 0.0040000000000000001, 0.69999999999999996, -1.0);
        // device 781, IC IC136, analog/basic/inverter.hpp:12
        I(cpphdl_n1205, Vss) <+ cpphdl_channel(V(cpphdl_n1191, Vss), V(cpphdl_n1205, Vss), 0.0040000000000000001, 0.69999999999999996, 1.0);
        // device 782, IC IC133, analog/basic/buffered_nand_latch.hpp:34
        I(cpphdl_n1183, Vss) <+ 2.0000000000000002e-15 * ddt(V(cpphdl_n1183, Vss)); // Bench initial voltage = 0.0 V.
        // device 783, IC IC133, analog/basic/buffered_nand_latch.hpp:35
        I(cpphdl_n1183, cpphdl_n1191) <+ 1.0000000000000001e-15 * ddt(V(cpphdl_n1183, cpphdl_n1191)); // Bench initial voltage = 0.0 V.
        // device 784, IC IC133, analog/basic/buffered_nand_latch.hpp:36
        I(cpphdl_n1191, Vss) <+ 5e-15 * ddt(V(cpphdl_n1191, Vss)); // Bench initial voltage = 0.0 V.
        // device 785, IC IC133, analog/basic/buffered_nand_latch.hpp:37
        I(cpphdl_n1191, Vss) <+ 8.0000000000000006e-15 * ddt(V(cpphdl_n1191, Vss)); // Bench initial voltage = 0.0 V.
        // device 786, IC IC133, analog/basic/buffered_nand_latch.hpp:38
        I(cpphdl_n1205, Vss) <+ 1e-14 * ddt(V(cpphdl_n1205, Vss)); // Bench initial voltage = 0.0 V.
        // device 787, IC IC135, analog/basic/inverter.hpp:11
        I(cpphdl_n1195, Vdd) <+ cpphdl_channel(V(cpphdl_n1187, Vdd), V(cpphdl_n1195, Vdd), 0.001, 0.69999999999999996, -1.0);
        // device 788, IC IC135, analog/basic/inverter.hpp:12
        I(cpphdl_n1195, Vss) <+ cpphdl_channel(V(cpphdl_n1187, Vss), V(cpphdl_n1195, Vss), 0.001, 0.69999999999999996, 1.0);
        // device 789, IC IC137, analog/basic/inverter.hpp:11
        I(cpphdl_n1211, Vdd) <+ cpphdl_channel(V(cpphdl_n1195, Vdd), V(cpphdl_n1211, Vdd), 0.0040000000000000001, 0.69999999999999996, -1.0);
        // device 790, IC IC137, analog/basic/inverter.hpp:12
        I(cpphdl_n1211, Vss) <+ cpphdl_channel(V(cpphdl_n1195, Vss), V(cpphdl_n1211, Vss), 0.0040000000000000001, 0.69999999999999996, 1.0);
        // device 791, IC IC133, analog/basic/buffered_nand_latch.hpp:34
        I(cpphdl_n1187, Vss) <+ 2.0000000000000002e-15 * ddt(V(cpphdl_n1187, Vss)); // Bench initial voltage = 0.0 V.
        // device 792, IC IC133, analog/basic/buffered_nand_latch.hpp:35
        I(cpphdl_n1187, cpphdl_n1195) <+ 1.0000000000000001e-15 * ddt(V(cpphdl_n1187, cpphdl_n1195)); // Bench initial voltage = 0.0 V.
        // device 793, IC IC133, analog/basic/buffered_nand_latch.hpp:36
        I(cpphdl_n1195, Vss) <+ 5e-15 * ddt(V(cpphdl_n1195, Vss)); // Bench initial voltage = 0.0 V.
        // device 794, IC IC133, analog/basic/buffered_nand_latch.hpp:37
        I(cpphdl_n1195, Vss) <+ 8.0000000000000006e-15 * ddt(V(cpphdl_n1195, Vss)); // Bench initial voltage = 0.0 V.
        // device 795, IC IC133, analog/basic/buffered_nand_latch.hpp:38
        I(cpphdl_n1211, Vss) <+ 1e-14 * ddt(V(cpphdl_n1211, Vss)); // Bench initial voltage = 0.0 V.
        // device 796, IC IC139, analog/basic/cmos_logic.hpp:17
        I(cpphdl_n2694, Vss) <+ 5.0000000000000002e-14 * ddt(V(cpphdl_n2694, Vss)); // Bench initial voltage = 0.0 V.
        // device 797, IC IC139, analog/basic/cmos_logic.hpp:18
        I(cpphdl_n2694, Vdd) <+ cpphdl_channel(V(cpphdl_n1205, Vdd), V(cpphdl_n2694, Vdd), 0.01, 0.69999999999999996, -1.0);
        // device 798, IC IC139, analog/basic/cmos_logic.hpp:19
        I(cpphdl_n2694, Vdd) <+ cpphdl_channel(V(cpphdl_n1213, Vdd), V(cpphdl_n2694, Vdd), 0.01, 0.69999999999999996, -1.0);
        // device 799, IC IC139, analog/basic/cmos_logic.hpp:20
        I(cpphdl_n2694, cpphdl_n1208) <+ cpphdl_channel(V(cpphdl_n1205, cpphdl_n1208), V(cpphdl_n2694, cpphdl_n1208), 0.01, 0.69999999999999996, 1.0);
        // device 800, IC IC139, analog/basic/cmos_logic.hpp:21
        I(cpphdl_n1208, Vss) <+ cpphdl_channel(V(cpphdl_n1213, Vss), V(cpphdl_n1208, Vss), 0.01, 0.69999999999999996, 1.0);
        // device 801, IC IC139, analog/basic/cmos_logic.hpp:23
        I(cpphdl_n2694, Vss) <+ V(cpphdl_n2694, Vss) / 1000000000.0;
        // device 802, IC IC139, analog/basic/cmos_logic.hpp:24
        I(cpphdl_n1208, Vss) <+ V(cpphdl_n1208, Vss) / 1000000000.0;
        // device 803, IC IC140, analog/basic/cmos_logic.hpp:17
        I(cpphdl_n1213, Vss) <+ 5.0000000000000002e-14 * ddt(V(cpphdl_n1213, Vss)); // Bench initial voltage = 0.0 V.
        // device 804, IC IC140, analog/basic/cmos_logic.hpp:18
        I(cpphdl_n1213, Vdd) <+ cpphdl_channel(V(cpphdl_n1211, Vdd), V(cpphdl_n1213, Vdd), 0.01, 0.69999999999999996, -1.0);
        // device 805, IC IC140, analog/basic/cmos_logic.hpp:19
        I(cpphdl_n1213, Vdd) <+ cpphdl_channel(V(cpphdl_n2694, Vdd), V(cpphdl_n1213, Vdd), 0.01, 0.69999999999999996, -1.0);
        // device 806, IC IC140, analog/basic/cmos_logic.hpp:20
        I(cpphdl_n1213, cpphdl_n1214) <+ cpphdl_channel(V(cpphdl_n1211, cpphdl_n1214), V(cpphdl_n1213, cpphdl_n1214), 0.01, 0.69999999999999996, 1.0);
        // device 807, IC IC140, analog/basic/cmos_logic.hpp:21
        I(cpphdl_n1214, Vss) <+ cpphdl_channel(V(cpphdl_n2694, Vss), V(cpphdl_n1214, Vss), 0.01, 0.69999999999999996, 1.0);
        // device 808, IC IC140, analog/basic/cmos_logic.hpp:23
        I(cpphdl_n1213, Vss) <+ V(cpphdl_n1213, Vss) / 1000000000.0;
        // device 809, IC IC140, analog/basic/cmos_logic.hpp:24
        I(cpphdl_n1214, Vss) <+ V(cpphdl_n1214, Vss) / 1000000000.0;
        // device 810, IC IC138, analog/basic/nand_latch.hpp:36
        I(cpphdl_n1205, Vss) <+ 2.9999999999999998e-15 * ddt(V(cpphdl_n1205, Vss)); // Bench initial voltage = 0.0 V.
        // device 811, IC IC138, analog/basic/nand_latch.hpp:37
        I(cpphdl_n1211, Vss) <+ 2.9999999999999998e-15 * ddt(V(cpphdl_n1211, Vss)); // Bench initial voltage = 0.0 V.
        // device 812, IC IC141, analog/basic/inverter.hpp:11
        I(cpphdl_n1219, Vdd) <+ cpphdl_channel(V(CLEAR, Vdd), V(cpphdl_n1219, Vdd), 0.01, 0.69999999999999996, -1.0);
        // device 813, IC IC141, analog/basic/inverter.hpp:12
        I(cpphdl_n1219, Vss) <+ cpphdl_channel(V(CLEAR, Vss), V(cpphdl_n1219, Vss), 0.01, 0.69999999999999996, 1.0);
        // device 814, IC IC138, analog/basic/nand_latch.hpp:58
        I(cpphdl_n1219, Vss) <+ 2.9999999999999998e-15 * ddt(V(cpphdl_n1219, Vss)); // Bench initial voltage = 0.0 V.
        // device 815, IC IC138, analog/basic/nand_latch.hpp:59
        I(cpphdl_n2694, Vss) <+ cpphdl_channel(V(CLEAR, Vss), V(cpphdl_n2694, Vss), 0.050000000000000003, 0.69999999999999996, 1.0);
        // device 816, IC IC138, analog/basic/nand_latch.hpp:60
        I(cpphdl_n1213, Vdd) <+ cpphdl_channel(V(cpphdl_n1219, Vdd), V(cpphdl_n1213, Vdd), 0.050000000000000003, 0.69999999999999996, -1.0);
        // device 817, IC IC144, analog/basic/inverter.hpp:11
        I(cpphdl_n1243, Vdd) <+ cpphdl_channel(V(TRACK6, Vdd), V(cpphdl_n1243, Vdd), 0.0040000000000000001, 0.69999999999999996, -1.0);
        // device 818, IC IC144, analog/basic/inverter.hpp:12
        I(cpphdl_n1243, Vss) <+ cpphdl_channel(V(TRACK6, Vss), V(cpphdl_n1243, Vss), 0.0040000000000000001, 0.69999999999999996, 1.0);
        // device 819, IC IC143, analog/basic/mos_track_hold.hpp:31
        I(cpphdl_n1243, Vss) <+ 2e-14 * ddt(V(cpphdl_n1243, Vss)); // Bench initial voltage = 3.2999999999999998 V.
        // device 820, IC IC143, analog/basic/mos_track_hold.hpp:32
        I(cpphdl_n2759, cpphdl_n1297) <+ cpphdl_channel(V(TRACK6, cpphdl_n1297), V(cpphdl_n2759, cpphdl_n1297), 0.080000000000000002, 0.69999999999999996, 1.0);
        // device 821, IC IC143, analog/basic/mos_track_hold.hpp:33
        I(cpphdl_n1297, cpphdl_n2759) <+ cpphdl_channel(V(cpphdl_n1243, cpphdl_n2759), V(cpphdl_n1297, cpphdl_n2759), 0.040000000000000001, 0.69999999999999996, -1.0);
        // device 822, IC IC143, analog/basic/mos_track_hold.hpp:37
        I(cpphdl_n1297, cpphdl_n1297) <+ cpphdl_channel(V(cpphdl_n1243, cpphdl_n1297), V(cpphdl_n1297, cpphdl_n1297), 0.040000000000000001, 0.69999999999999996, 1.0);
        // device 823, IC IC143, analog/basic/mos_track_hold.hpp:38
        I(cpphdl_n1297, cpphdl_n1297) <+ cpphdl_channel(V(TRACK6, cpphdl_n1297), V(cpphdl_n1297, cpphdl_n1297), 0.02, 0.69999999999999996, -1.0);
        // device 824, IC IC143, analog/basic/mos_track_hold.hpp:39
        I(cpphdl_n1297, Vss) <+ 3.0000000000000001e-12 * ddt(V(cpphdl_n1297, Vss)); // Bench initial voltage = 1.6499999999999999 V.
        // device 825, IC IC143, analog/basic/mos_track_hold.hpp:41
        I(Vss, cpphdl_n1297) <+ V(Vss, cpphdl_n1297) / 1000000000.0;
        // device 826, IC IC143, analog/basic/mos_track_hold.hpp:42
        I(TRACK6, cpphdl_n1297) <+ 8.0000000000000006e-15 * ddt(V(TRACK6, cpphdl_n1297)); // Bench initial voltage = -1.6499999999999999 V.
        // device 827, IC IC143, analog/basic/mos_track_hold.hpp:43
        I(cpphdl_n1243, cpphdl_n1297) <+ 8.0000000000000006e-15 * ddt(V(cpphdl_n1243, cpphdl_n1297)); // Bench initial voltage = 1.6499999999999999 V.
        // device 828, IC IC143, analog/basic/mos_track_hold.hpp:44
        I(cpphdl_n2759, cpphdl_n1297) <+ 4.0000000000000003e-15 * ddt(V(cpphdl_n2759, cpphdl_n1297)); // Bench initial voltage = 0.0 V.
        // device 829, IC IC146, analog/basic/inverter.hpp:11
        I(cpphdl_n1258, Vdd) <+ cpphdl_channel(V(BIT_N6_0, Vdd), V(cpphdl_n1258, Vdd), 0.080000000000000002, 0.69999999999999996, -1.0);
        // device 830, IC IC146, analog/basic/inverter.hpp:12
        I(cpphdl_n1258, Vss) <+ cpphdl_channel(V(BIT_N6_0, Vss), V(cpphdl_n1258, Vss), 0.080000000000000002, 0.69999999999999996, 1.0);
        // device 831, IC IC145, analog/basic/mos_r2r_dac.hpp:27
        I(cpphdl_n1258, Vss) <+ 2.9999999999999998e-15 * ddt(V(cpphdl_n1258, Vss)); // Bench initial voltage = 0.0 V.
        // device 832, IC IC145, analog/basic/mos_r2r_dac.hpp:28
        I(cpphdl_n1258, cpphdl_n1287) <+ V(cpphdl_n1258, cpphdl_n1287) / 2000.0;
        // device 833, IC IC145, analog/basic/mos_r2r_dac.hpp:29
        I(cpphdl_n1287, Vss) <+ 2.9999999999999998e-15 * ddt(V(cpphdl_n1287, Vss)); // Bench initial voltage = 0.0 V.
        // device 834, IC IC147, analog/basic/inverter.hpp:11
        I(cpphdl_n1262, Vdd) <+ cpphdl_channel(V(BIT_N6_1, Vdd), V(cpphdl_n1262, Vdd), 0.080000000000000002, 0.69999999999999996, -1.0);
        // device 835, IC IC147, analog/basic/inverter.hpp:12
        I(cpphdl_n1262, Vss) <+ cpphdl_channel(V(BIT_N6_1, Vss), V(cpphdl_n1262, Vss), 0.080000000000000002, 0.69999999999999996, 1.0);
        // device 836, IC IC145, analog/basic/mos_r2r_dac.hpp:27
        I(cpphdl_n1262, Vss) <+ 2.9999999999999998e-15 * ddt(V(cpphdl_n1262, Vss)); // Bench initial voltage = 0.0 V.
        // device 837, IC IC145, analog/basic/mos_r2r_dac.hpp:28
        I(cpphdl_n1262, cpphdl_n1288) <+ V(cpphdl_n1262, cpphdl_n1288) / 2000.0;
        // device 838, IC IC145, analog/basic/mos_r2r_dac.hpp:29
        I(cpphdl_n1288, Vss) <+ 2.9999999999999998e-15 * ddt(V(cpphdl_n1288, Vss)); // Bench initial voltage = 0.0 V.
        // device 839, IC IC145, analog/basic/mos_r2r_dac.hpp:31
        I(cpphdl_n1287, cpphdl_n1288) <+ V(cpphdl_n1287, cpphdl_n1288) / 1000.0;
        // device 840, IC IC148, analog/basic/inverter.hpp:11
        I(cpphdl_n1266, Vdd) <+ cpphdl_channel(V(BIT_N6_2, Vdd), V(cpphdl_n1266, Vdd), 0.080000000000000002, 0.69999999999999996, -1.0);
        // device 841, IC IC148, analog/basic/inverter.hpp:12
        I(cpphdl_n1266, Vss) <+ cpphdl_channel(V(BIT_N6_2, Vss), V(cpphdl_n1266, Vss), 0.080000000000000002, 0.69999999999999996, 1.0);
        // device 842, IC IC145, analog/basic/mos_r2r_dac.hpp:27
        I(cpphdl_n1266, Vss) <+ 2.9999999999999998e-15 * ddt(V(cpphdl_n1266, Vss)); // Bench initial voltage = 0.0 V.
        // device 843, IC IC145, analog/basic/mos_r2r_dac.hpp:28
        I(cpphdl_n1266, cpphdl_n1289) <+ V(cpphdl_n1266, cpphdl_n1289) / 2000.0;
        // device 844, IC IC145, analog/basic/mos_r2r_dac.hpp:29
        I(cpphdl_n1289, Vss) <+ 2.9999999999999998e-15 * ddt(V(cpphdl_n1289, Vss)); // Bench initial voltage = 0.0 V.
        // device 845, IC IC145, analog/basic/mos_r2r_dac.hpp:31
        I(cpphdl_n1288, cpphdl_n1289) <+ V(cpphdl_n1288, cpphdl_n1289) / 1000.0;
        // device 846, IC IC149, analog/basic/inverter.hpp:11
        I(cpphdl_n1270, Vdd) <+ cpphdl_channel(V(BIT_N6_3, Vdd), V(cpphdl_n1270, Vdd), 0.080000000000000002, 0.69999999999999996, -1.0);
        // device 847, IC IC149, analog/basic/inverter.hpp:12
        I(cpphdl_n1270, Vss) <+ cpphdl_channel(V(BIT_N6_3, Vss), V(cpphdl_n1270, Vss), 0.080000000000000002, 0.69999999999999996, 1.0);
        // device 848, IC IC145, analog/basic/mos_r2r_dac.hpp:27
        I(cpphdl_n1270, Vss) <+ 2.9999999999999998e-15 * ddt(V(cpphdl_n1270, Vss)); // Bench initial voltage = 0.0 V.
        // device 849, IC IC145, analog/basic/mos_r2r_dac.hpp:28
        I(cpphdl_n1270, cpphdl_n1290) <+ V(cpphdl_n1270, cpphdl_n1290) / 2000.0;
        // device 850, IC IC145, analog/basic/mos_r2r_dac.hpp:29
        I(cpphdl_n1290, Vss) <+ 2.9999999999999998e-15 * ddt(V(cpphdl_n1290, Vss)); // Bench initial voltage = 0.0 V.
        // device 851, IC IC145, analog/basic/mos_r2r_dac.hpp:31
        I(cpphdl_n1289, cpphdl_n1290) <+ V(cpphdl_n1289, cpphdl_n1290) / 1000.0;
        // device 852, IC IC150, analog/basic/inverter.hpp:11
        I(cpphdl_n1274, Vdd) <+ cpphdl_channel(V(BIT_N6_4, Vdd), V(cpphdl_n1274, Vdd), 0.080000000000000002, 0.69999999999999996, -1.0);
        // device 853, IC IC150, analog/basic/inverter.hpp:12
        I(cpphdl_n1274, Vss) <+ cpphdl_channel(V(BIT_N6_4, Vss), V(cpphdl_n1274, Vss), 0.080000000000000002, 0.69999999999999996, 1.0);
        // device 854, IC IC145, analog/basic/mos_r2r_dac.hpp:27
        I(cpphdl_n1274, Vss) <+ 2.9999999999999998e-15 * ddt(V(cpphdl_n1274, Vss)); // Bench initial voltage = 0.0 V.
        // device 855, IC IC145, analog/basic/mos_r2r_dac.hpp:28
        I(cpphdl_n1274, cpphdl_n1291) <+ V(cpphdl_n1274, cpphdl_n1291) / 2000.0;
        // device 856, IC IC145, analog/basic/mos_r2r_dac.hpp:29
        I(cpphdl_n1291, Vss) <+ 2.9999999999999998e-15 * ddt(V(cpphdl_n1291, Vss)); // Bench initial voltage = 0.0 V.
        // device 857, IC IC145, analog/basic/mos_r2r_dac.hpp:31
        I(cpphdl_n1290, cpphdl_n1291) <+ V(cpphdl_n1290, cpphdl_n1291) / 1000.0;
        // device 858, IC IC151, analog/basic/inverter.hpp:11
        I(cpphdl_n1278, Vdd) <+ cpphdl_channel(V(BIT_N6_5, Vdd), V(cpphdl_n1278, Vdd), 0.080000000000000002, 0.69999999999999996, -1.0);
        // device 859, IC IC151, analog/basic/inverter.hpp:12
        I(cpphdl_n1278, Vss) <+ cpphdl_channel(V(BIT_N6_5, Vss), V(cpphdl_n1278, Vss), 0.080000000000000002, 0.69999999999999996, 1.0);
        // device 860, IC IC145, analog/basic/mos_r2r_dac.hpp:27
        I(cpphdl_n1278, Vss) <+ 2.9999999999999998e-15 * ddt(V(cpphdl_n1278, Vss)); // Bench initial voltage = 0.0 V.
        // device 861, IC IC145, analog/basic/mos_r2r_dac.hpp:28
        I(cpphdl_n1278, cpphdl_n1292) <+ V(cpphdl_n1278, cpphdl_n1292) / 2000.0;
        // device 862, IC IC145, analog/basic/mos_r2r_dac.hpp:29
        I(cpphdl_n1292, Vss) <+ 2.9999999999999998e-15 * ddt(V(cpphdl_n1292, Vss)); // Bench initial voltage = 0.0 V.
        // device 863, IC IC145, analog/basic/mos_r2r_dac.hpp:31
        I(cpphdl_n1291, cpphdl_n1292) <+ V(cpphdl_n1291, cpphdl_n1292) / 1000.0;
        // device 864, IC IC152, analog/basic/inverter.hpp:11
        I(cpphdl_n1282, Vdd) <+ cpphdl_channel(V(BIT_N6_6, Vdd), V(cpphdl_n1282, Vdd), 0.080000000000000002, 0.69999999999999996, -1.0);
        // device 865, IC IC152, analog/basic/inverter.hpp:12
        I(cpphdl_n1282, Vss) <+ cpphdl_channel(V(BIT_N6_6, Vss), V(cpphdl_n1282, Vss), 0.080000000000000002, 0.69999999999999996, 1.0);
        // device 866, IC IC145, analog/basic/mos_r2r_dac.hpp:27
        I(cpphdl_n1282, Vss) <+ 2.9999999999999998e-15 * ddt(V(cpphdl_n1282, Vss)); // Bench initial voltage = 0.0 V.
        // device 867, IC IC145, analog/basic/mos_r2r_dac.hpp:28
        I(cpphdl_n1282, cpphdl_n1293) <+ V(cpphdl_n1282, cpphdl_n1293) / 2000.0;
        // device 868, IC IC145, analog/basic/mos_r2r_dac.hpp:29
        I(cpphdl_n1293, Vss) <+ 2.9999999999999998e-15 * ddt(V(cpphdl_n1293, Vss)); // Bench initial voltage = 0.0 V.
        // device 869, IC IC145, analog/basic/mos_r2r_dac.hpp:31
        I(cpphdl_n1292, cpphdl_n1293) <+ V(cpphdl_n1292, cpphdl_n1293) / 1000.0;
        // device 870, IC IC153, analog/basic/inverter.hpp:11
        I(cpphdl_n1286, Vdd) <+ cpphdl_channel(V(BIT_N6_7, Vdd), V(cpphdl_n1286, Vdd), 0.080000000000000002, 0.69999999999999996, -1.0);
        // device 871, IC IC153, analog/basic/inverter.hpp:12
        I(cpphdl_n1286, Vss) <+ cpphdl_channel(V(BIT_N6_7, Vss), V(cpphdl_n1286, Vss), 0.080000000000000002, 0.69999999999999996, 1.0);
        // device 872, IC IC145, analog/basic/mos_r2r_dac.hpp:27
        I(cpphdl_n1286, Vss) <+ 2.9999999999999998e-15 * ddt(V(cpphdl_n1286, Vss)); // Bench initial voltage = 0.0 V.
        // device 873, IC IC145, analog/basic/mos_r2r_dac.hpp:28
        I(cpphdl_n1286, cpphdl_n1298) <+ V(cpphdl_n1286, cpphdl_n1298) / 2000.0;
        // device 874, IC IC145, analog/basic/mos_r2r_dac.hpp:29
        I(cpphdl_n1298, Vss) <+ 2.9999999999999998e-15 * ddt(V(cpphdl_n1298, Vss)); // Bench initial voltage = 0.0 V.
        // device 875, IC IC145, analog/basic/mos_r2r_dac.hpp:31
        I(cpphdl_n1293, cpphdl_n1298) <+ V(cpphdl_n1293, cpphdl_n1298) / 1000.0;
        // device 876, IC IC145, analog/basic/mos_r2r_dac.hpp:33
        I(Vss, cpphdl_n1287) <+ V(Vss, cpphdl_n1287) / 2000.0;
        // device 877, IC IC154, analog/basic/nmos_resistor_amplifier.hpp:23
        I(Vdd, cpphdl_n1307) <+ V(Vdd, cpphdl_n1307) / 500.0;
        // device 878, IC IC154, analog/basic/nmos_resistor_amplifier.hpp:24
        I(Vdd, cpphdl_n1306) <+ V(Vdd, cpphdl_n1306) / 500.0;
        // device 879, IC IC154, analog/basic/nmos_resistor_amplifier.hpp:25
        I(cpphdl_n1307, cpphdl_n1301) <+ cpphdl_channel(V(cpphdl_n1297, cpphdl_n1301), V(cpphdl_n1307, cpphdl_n1301), 0.014999999999999999, 0.69999999999999996, 1.0);
        // device 880, IC IC154, analog/basic/nmos_resistor_amplifier.hpp:26
        I(cpphdl_n1306, cpphdl_n1302) <+ cpphdl_channel(V(cpphdl_n1298, cpphdl_n1302), V(cpphdl_n1306, cpphdl_n1302), 0.014999999999999999, 0.69999999999999996, 1.0);
        // device 881, IC IC154, analog/basic/nmos_resistor_amplifier.hpp:27
        I(cpphdl_n1303, cpphdl_n1301) <+ V(cpphdl_n1303, cpphdl_n1301) / 50.0;
        // device 882, IC IC154, analog/basic/nmos_resistor_amplifier.hpp:28
        I(cpphdl_n1303, cpphdl_n1302) <+ V(cpphdl_n1303, cpphdl_n1302) / 50.0;
        // device 883, IC IC154, analog/basic/nmos_resistor_amplifier.hpp:29
        I(Vss, cpphdl_n1303) <+ V(Vss, cpphdl_n1303) / 150.0;
        // device 884, IC IC154, analog/basic/nmos_resistor_amplifier.hpp:30
        I(cpphdl_n1307, Vdd) <+ 2.9999999999999998e-13 * ddt(V(cpphdl_n1307, Vdd)); // Bench initial voltage = 0.0 V.
        // device 885, IC IC154, analog/basic/nmos_resistor_amplifier.hpp:31
        I(cpphdl_n1306, Vdd) <+ 2.9999999999999998e-13 * ddt(V(cpphdl_n1306, Vdd)); // Bench initial voltage = 0.0 V.
        // device 886, IC IC154, analog/basic/nmos_resistor_amplifier.hpp:32
        I(cpphdl_n1303, Vss) <+ 4e-14 * ddt(V(cpphdl_n1303, Vss)); // Bench initial voltage = 0.0 V.
        // device 887, IC IC154, analog/basic/nmos_resistor_amplifier.hpp:34
        I(cpphdl_n1297, cpphdl_n1301) <+ 2e-14 * ddt(V(cpphdl_n1297, cpphdl_n1301)); // Bench initial voltage = 1.6499999999999999 V.
        // device 888, IC IC154, analog/basic/nmos_resistor_amplifier.hpp:35
        I(cpphdl_n1298, cpphdl_n1302) <+ 2e-14 * ddt(V(cpphdl_n1298, cpphdl_n1302)); // Bench initial voltage = 0.0 V.
        // device 889, IC IC154, analog/basic/nmos_resistor_amplifier.hpp:36
        I(cpphdl_n1297, cpphdl_n1307) <+ 2.9999999999999998e-15 * ddt(V(cpphdl_n1297, cpphdl_n1307)); // Bench initial voltage = -1.6499999999999999 V.
        // device 890, IC IC154, analog/basic/nmos_resistor_amplifier.hpp:37
        I(cpphdl_n1298, cpphdl_n1306) <+ 2.9999999999999998e-15 * ddt(V(cpphdl_n1298, cpphdl_n1306)); // Bench initial voltage = -3.2999999999999998 V.
        // device 891, IC IC155, analog/basic/strongarm_comparator.hpp:28
        I(cpphdl_n1311, cpphdl_n1313) <+ cpphdl_channel(V(cpphdl_n1306, cpphdl_n1313), V(cpphdl_n1311, cpphdl_n1313), 0.0080000000000000002, 0.69999999999999996, 1.0);
        // device 892, IC IC155, analog/basic/strongarm_comparator.hpp:29
        I(cpphdl_n1312, cpphdl_n1313) <+ cpphdl_channel(V(cpphdl_n1307, cpphdl_n1313), V(cpphdl_n1312, cpphdl_n1313), 0.0080000000000000002, 0.69999999999999996, 1.0);
        // device 893, IC IC155, analog/basic/strongarm_comparator.hpp:30
        I(cpphdl_n1313, Vss) <+ cpphdl_channel(V(EVALUATE, Vss), V(cpphdl_n1313, Vss), 0.0080000000000000002, 0.69999999999999996, 1.0);
        // device 894, IC IC155, analog/basic/strongarm_comparator.hpp:33
        I(cpphdl_n1326, cpphdl_n1311) <+ cpphdl_channel(V(cpphdl_n1330, cpphdl_n1311), V(cpphdl_n1326, cpphdl_n1311), 0.0040000000000000001, 0.69999999999999996, 1.0);
        // device 895, IC IC155, analog/basic/strongarm_comparator.hpp:34
        I(cpphdl_n1330, cpphdl_n1312) <+ cpphdl_channel(V(cpphdl_n1326, cpphdl_n1312), V(cpphdl_n1330, cpphdl_n1312), 0.0040000000000000001, 0.69999999999999996, 1.0);
        // device 896, IC IC155, analog/basic/strongarm_comparator.hpp:35
        I(cpphdl_n1330, Vdd) <+ cpphdl_channel(V(cpphdl_n1326, Vdd), V(cpphdl_n1330, Vdd), 0.002, 0.69999999999999996, -1.0);
        // device 897, IC IC155, analog/basic/strongarm_comparator.hpp:36
        I(cpphdl_n1326, Vdd) <+ cpphdl_channel(V(cpphdl_n1330, Vdd), V(cpphdl_n1326, Vdd), 0.002, 0.69999999999999996, -1.0);
        // device 898, IC IC155, analog/basic/strongarm_comparator.hpp:38
        I(cpphdl_n1311, Vdd) <+ cpphdl_channel(V(EVALUATE, Vdd), V(cpphdl_n1311, Vdd), 0.002, 0.69999999999999996, -1.0);
        // device 899, IC IC155, analog/basic/strongarm_comparator.hpp:39
        I(cpphdl_n1312, Vdd) <+ cpphdl_channel(V(EVALUATE, Vdd), V(cpphdl_n1312, Vdd), 0.002, 0.69999999999999996, -1.0);
        // device 900, IC IC155, analog/basic/strongarm_comparator.hpp:40
        I(cpphdl_n1330, Vdd) <+ cpphdl_channel(V(EVALUATE, Vdd), V(cpphdl_n1330, Vdd), 0.002, 0.69999999999999996, -1.0);
        // device 901, IC IC155, analog/basic/strongarm_comparator.hpp:41
        I(cpphdl_n1326, Vdd) <+ cpphdl_channel(V(EVALUATE, Vdd), V(cpphdl_n1326, Vdd), 0.002, 0.69999999999999996, -1.0);
        // device 902, IC IC155, analog/basic/strongarm_comparator.hpp:42
        I(cpphdl_n1311, Vss) <+ 2.9999999999999998e-14 * ddt(V(cpphdl_n1311, Vss)); // Bench initial voltage = 0.0 V.
        // device 903, IC IC155, analog/basic/strongarm_comparator.hpp:43
        I(cpphdl_n1312, Vss) <+ 2.9999999999999998e-14 * ddt(V(cpphdl_n1312, Vss)); // Bench initial voltage = 0.0 V.
        // device 904, IC IC155, analog/basic/strongarm_comparator.hpp:44
        I(cpphdl_n1313, Vss) <+ 2.9999999999999998e-14 * ddt(V(cpphdl_n1313, Vss)); // Bench initial voltage = 0.0 V.
        // device 905, IC IC155, analog/basic/strongarm_comparator.hpp:45
        I(cpphdl_n1330, Vss) <+ 5.0000000000000002e-14 * ddt(V(cpphdl_n1330, Vss)); // Bench initial voltage = 0.0 V.
        // device 906, IC IC155, analog/basic/strongarm_comparator.hpp:46
        I(cpphdl_n1326, Vss) <+ 5.0000000000000002e-14 * ddt(V(cpphdl_n1326, Vss)); // Bench initial voltage = 0.0 V.
        // device 907, IC IC155, analog/basic/strongarm_comparator.hpp:47
        I(cpphdl_n1306, cpphdl_n1313) <+ 2e-14 * ddt(V(cpphdl_n1306, cpphdl_n1313)); // Bench initial voltage = 3.2999999999999998 V.
        // device 908, IC IC155, analog/basic/strongarm_comparator.hpp:48
        I(cpphdl_n1307, cpphdl_n1313) <+ 2e-14 * ddt(V(cpphdl_n1307, cpphdl_n1313)); // Bench initial voltage = 3.2999999999999998 V.
        // device 909, IC IC155, analog/basic/strongarm_comparator.hpp:49
        I(cpphdl_n1306, cpphdl_n1311) <+ 2.9999999999999998e-15 * ddt(V(cpphdl_n1306, cpphdl_n1311)); // Bench initial voltage = 3.2999999999999998 V.
        // device 910, IC IC155, analog/basic/strongarm_comparator.hpp:50
        I(cpphdl_n1307, cpphdl_n1312) <+ 2.9999999999999998e-15 * ddt(V(cpphdl_n1307, cpphdl_n1312)); // Bench initial voltage = 3.2999999999999998 V.
        // device 911, IC IC157, analog/basic/inverter.hpp:11
        I(cpphdl_n1334, Vdd) <+ cpphdl_channel(V(cpphdl_n1326, Vdd), V(cpphdl_n1334, Vdd), 0.001, 0.69999999999999996, -1.0);
        // device 912, IC IC157, analog/basic/inverter.hpp:12
        I(cpphdl_n1334, Vss) <+ cpphdl_channel(V(cpphdl_n1326, Vss), V(cpphdl_n1334, Vss), 0.001, 0.69999999999999996, 1.0);
        // device 913, IC IC159, analog/basic/inverter.hpp:11
        I(cpphdl_n1348, Vdd) <+ cpphdl_channel(V(cpphdl_n1334, Vdd), V(cpphdl_n1348, Vdd), 0.0040000000000000001, 0.69999999999999996, -1.0);
        // device 914, IC IC159, analog/basic/inverter.hpp:12
        I(cpphdl_n1348, Vss) <+ cpphdl_channel(V(cpphdl_n1334, Vss), V(cpphdl_n1348, Vss), 0.0040000000000000001, 0.69999999999999996, 1.0);
        // device 915, IC IC156, analog/basic/buffered_nand_latch.hpp:34
        I(cpphdl_n1326, Vss) <+ 2.0000000000000002e-15 * ddt(V(cpphdl_n1326, Vss)); // Bench initial voltage = 0.0 V.
        // device 916, IC IC156, analog/basic/buffered_nand_latch.hpp:35
        I(cpphdl_n1326, cpphdl_n1334) <+ 1.0000000000000001e-15 * ddt(V(cpphdl_n1326, cpphdl_n1334)); // Bench initial voltage = 0.0 V.
        // device 917, IC IC156, analog/basic/buffered_nand_latch.hpp:36
        I(cpphdl_n1334, Vss) <+ 5e-15 * ddt(V(cpphdl_n1334, Vss)); // Bench initial voltage = 0.0 V.
        // device 918, IC IC156, analog/basic/buffered_nand_latch.hpp:37
        I(cpphdl_n1334, Vss) <+ 8.0000000000000006e-15 * ddt(V(cpphdl_n1334, Vss)); // Bench initial voltage = 0.0 V.
        // device 919, IC IC156, analog/basic/buffered_nand_latch.hpp:38
        I(cpphdl_n1348, Vss) <+ 1e-14 * ddt(V(cpphdl_n1348, Vss)); // Bench initial voltage = 0.0 V.
        // device 920, IC IC158, analog/basic/inverter.hpp:11
        I(cpphdl_n1338, Vdd) <+ cpphdl_channel(V(cpphdl_n1330, Vdd), V(cpphdl_n1338, Vdd), 0.001, 0.69999999999999996, -1.0);
        // device 921, IC IC158, analog/basic/inverter.hpp:12
        I(cpphdl_n1338, Vss) <+ cpphdl_channel(V(cpphdl_n1330, Vss), V(cpphdl_n1338, Vss), 0.001, 0.69999999999999996, 1.0);
        // device 922, IC IC160, analog/basic/inverter.hpp:11
        I(cpphdl_n1354, Vdd) <+ cpphdl_channel(V(cpphdl_n1338, Vdd), V(cpphdl_n1354, Vdd), 0.0040000000000000001, 0.69999999999999996, -1.0);
        // device 923, IC IC160, analog/basic/inverter.hpp:12
        I(cpphdl_n1354, Vss) <+ cpphdl_channel(V(cpphdl_n1338, Vss), V(cpphdl_n1354, Vss), 0.0040000000000000001, 0.69999999999999996, 1.0);
        // device 924, IC IC156, analog/basic/buffered_nand_latch.hpp:34
        I(cpphdl_n1330, Vss) <+ 2.0000000000000002e-15 * ddt(V(cpphdl_n1330, Vss)); // Bench initial voltage = 0.0 V.
        // device 925, IC IC156, analog/basic/buffered_nand_latch.hpp:35
        I(cpphdl_n1330, cpphdl_n1338) <+ 1.0000000000000001e-15 * ddt(V(cpphdl_n1330, cpphdl_n1338)); // Bench initial voltage = 0.0 V.
        // device 926, IC IC156, analog/basic/buffered_nand_latch.hpp:36
        I(cpphdl_n1338, Vss) <+ 5e-15 * ddt(V(cpphdl_n1338, Vss)); // Bench initial voltage = 0.0 V.
        // device 927, IC IC156, analog/basic/buffered_nand_latch.hpp:37
        I(cpphdl_n1338, Vss) <+ 8.0000000000000006e-15 * ddt(V(cpphdl_n1338, Vss)); // Bench initial voltage = 0.0 V.
        // device 928, IC IC156, analog/basic/buffered_nand_latch.hpp:38
        I(cpphdl_n1354, Vss) <+ 1e-14 * ddt(V(cpphdl_n1354, Vss)); // Bench initial voltage = 0.0 V.
        // device 929, IC IC162, analog/basic/cmos_logic.hpp:17
        I(cpphdl_n2699, Vss) <+ 5.0000000000000002e-14 * ddt(V(cpphdl_n2699, Vss)); // Bench initial voltage = 0.0 V.
        // device 930, IC IC162, analog/basic/cmos_logic.hpp:18
        I(cpphdl_n2699, Vdd) <+ cpphdl_channel(V(cpphdl_n1348, Vdd), V(cpphdl_n2699, Vdd), 0.01, 0.69999999999999996, -1.0);
        // device 931, IC IC162, analog/basic/cmos_logic.hpp:19
        I(cpphdl_n2699, Vdd) <+ cpphdl_channel(V(cpphdl_n1356, Vdd), V(cpphdl_n2699, Vdd), 0.01, 0.69999999999999996, -1.0);
        // device 932, IC IC162, analog/basic/cmos_logic.hpp:20
        I(cpphdl_n2699, cpphdl_n1351) <+ cpphdl_channel(V(cpphdl_n1348, cpphdl_n1351), V(cpphdl_n2699, cpphdl_n1351), 0.01, 0.69999999999999996, 1.0);
        // device 933, IC IC162, analog/basic/cmos_logic.hpp:21
        I(cpphdl_n1351, Vss) <+ cpphdl_channel(V(cpphdl_n1356, Vss), V(cpphdl_n1351, Vss), 0.01, 0.69999999999999996, 1.0);
        // device 934, IC IC162, analog/basic/cmos_logic.hpp:23
        I(cpphdl_n2699, Vss) <+ V(cpphdl_n2699, Vss) / 1000000000.0;
        // device 935, IC IC162, analog/basic/cmos_logic.hpp:24
        I(cpphdl_n1351, Vss) <+ V(cpphdl_n1351, Vss) / 1000000000.0;
        // device 936, IC IC163, analog/basic/cmos_logic.hpp:17
        I(cpphdl_n1356, Vss) <+ 5.0000000000000002e-14 * ddt(V(cpphdl_n1356, Vss)); // Bench initial voltage = 0.0 V.
        // device 937, IC IC163, analog/basic/cmos_logic.hpp:18
        I(cpphdl_n1356, Vdd) <+ cpphdl_channel(V(cpphdl_n1354, Vdd), V(cpphdl_n1356, Vdd), 0.01, 0.69999999999999996, -1.0);
        // device 938, IC IC163, analog/basic/cmos_logic.hpp:19
        I(cpphdl_n1356, Vdd) <+ cpphdl_channel(V(cpphdl_n2699, Vdd), V(cpphdl_n1356, Vdd), 0.01, 0.69999999999999996, -1.0);
        // device 939, IC IC163, analog/basic/cmos_logic.hpp:20
        I(cpphdl_n1356, cpphdl_n1357) <+ cpphdl_channel(V(cpphdl_n1354, cpphdl_n1357), V(cpphdl_n1356, cpphdl_n1357), 0.01, 0.69999999999999996, 1.0);
        // device 940, IC IC163, analog/basic/cmos_logic.hpp:21
        I(cpphdl_n1357, Vss) <+ cpphdl_channel(V(cpphdl_n2699, Vss), V(cpphdl_n1357, Vss), 0.01, 0.69999999999999996, 1.0);
        // device 941, IC IC163, analog/basic/cmos_logic.hpp:23
        I(cpphdl_n1356, Vss) <+ V(cpphdl_n1356, Vss) / 1000000000.0;
        // device 942, IC IC163, analog/basic/cmos_logic.hpp:24
        I(cpphdl_n1357, Vss) <+ V(cpphdl_n1357, Vss) / 1000000000.0;
        // device 943, IC IC161, analog/basic/nand_latch.hpp:36
        I(cpphdl_n1348, Vss) <+ 2.9999999999999998e-15 * ddt(V(cpphdl_n1348, Vss)); // Bench initial voltage = 0.0 V.
        // device 944, IC IC161, analog/basic/nand_latch.hpp:37
        I(cpphdl_n1354, Vss) <+ 2.9999999999999998e-15 * ddt(V(cpphdl_n1354, Vss)); // Bench initial voltage = 0.0 V.
        // device 945, IC IC164, analog/basic/inverter.hpp:11
        I(cpphdl_n1362, Vdd) <+ cpphdl_channel(V(CLEAR, Vdd), V(cpphdl_n1362, Vdd), 0.01, 0.69999999999999996, -1.0);
        // device 946, IC IC164, analog/basic/inverter.hpp:12
        I(cpphdl_n1362, Vss) <+ cpphdl_channel(V(CLEAR, Vss), V(cpphdl_n1362, Vss), 0.01, 0.69999999999999996, 1.0);
        // device 947, IC IC161, analog/basic/nand_latch.hpp:58
        I(cpphdl_n1362, Vss) <+ 2.9999999999999998e-15 * ddt(V(cpphdl_n1362, Vss)); // Bench initial voltage = 0.0 V.
        // device 948, IC IC161, analog/basic/nand_latch.hpp:59
        I(cpphdl_n2699, Vss) <+ cpphdl_channel(V(CLEAR, Vss), V(cpphdl_n2699, Vss), 0.050000000000000003, 0.69999999999999996, 1.0);
        // device 949, IC IC161, analog/basic/nand_latch.hpp:60
        I(cpphdl_n1356, Vdd) <+ cpphdl_channel(V(cpphdl_n1362, Vdd), V(cpphdl_n1356, Vdd), 0.050000000000000003, 0.69999999999999996, -1.0);
        // device 950, IC IC167, analog/basic/inverter.hpp:11
        I(cpphdl_n1386, Vdd) <+ cpphdl_channel(V(TRACK7, Vdd), V(cpphdl_n1386, Vdd), 0.0040000000000000001, 0.69999999999999996, -1.0);
        // device 951, IC IC167, analog/basic/inverter.hpp:12
        I(cpphdl_n1386, Vss) <+ cpphdl_channel(V(TRACK7, Vss), V(cpphdl_n1386, Vss), 0.0040000000000000001, 0.69999999999999996, 1.0);
        // device 952, IC IC166, analog/basic/mos_track_hold.hpp:31
        I(cpphdl_n1386, Vss) <+ 2e-14 * ddt(V(cpphdl_n1386, Vss)); // Bench initial voltage = 3.2999999999999998 V.
        // device 953, IC IC166, analog/basic/mos_track_hold.hpp:32
        I(cpphdl_n2759, cpphdl_n1440) <+ cpphdl_channel(V(TRACK7, cpphdl_n1440), V(cpphdl_n2759, cpphdl_n1440), 0.080000000000000002, 0.69999999999999996, 1.0);
        // device 954, IC IC166, analog/basic/mos_track_hold.hpp:33
        I(cpphdl_n1440, cpphdl_n2759) <+ cpphdl_channel(V(cpphdl_n1386, cpphdl_n2759), V(cpphdl_n1440, cpphdl_n2759), 0.040000000000000001, 0.69999999999999996, -1.0);
        // device 955, IC IC166, analog/basic/mos_track_hold.hpp:37
        I(cpphdl_n1440, cpphdl_n1440) <+ cpphdl_channel(V(cpphdl_n1386, cpphdl_n1440), V(cpphdl_n1440, cpphdl_n1440), 0.040000000000000001, 0.69999999999999996, 1.0);
        // device 956, IC IC166, analog/basic/mos_track_hold.hpp:38
        I(cpphdl_n1440, cpphdl_n1440) <+ cpphdl_channel(V(TRACK7, cpphdl_n1440), V(cpphdl_n1440, cpphdl_n1440), 0.02, 0.69999999999999996, -1.0);
        // device 957, IC IC166, analog/basic/mos_track_hold.hpp:39
        I(cpphdl_n1440, Vss) <+ 3.0000000000000001e-12 * ddt(V(cpphdl_n1440, Vss)); // Bench initial voltage = 1.6499999999999999 V.
        // device 958, IC IC166, analog/basic/mos_track_hold.hpp:41
        I(Vss, cpphdl_n1440) <+ V(Vss, cpphdl_n1440) / 1000000000.0;
        // device 959, IC IC166, analog/basic/mos_track_hold.hpp:42
        I(TRACK7, cpphdl_n1440) <+ 8.0000000000000006e-15 * ddt(V(TRACK7, cpphdl_n1440)); // Bench initial voltage = -1.6499999999999999 V.
        // device 960, IC IC166, analog/basic/mos_track_hold.hpp:43
        I(cpphdl_n1386, cpphdl_n1440) <+ 8.0000000000000006e-15 * ddt(V(cpphdl_n1386, cpphdl_n1440)); // Bench initial voltage = 1.6499999999999999 V.
        // device 961, IC IC166, analog/basic/mos_track_hold.hpp:44
        I(cpphdl_n2759, cpphdl_n1440) <+ 4.0000000000000003e-15 * ddt(V(cpphdl_n2759, cpphdl_n1440)); // Bench initial voltage = 0.0 V.
        // device 962, IC IC169, analog/basic/inverter.hpp:11
        I(cpphdl_n1401, Vdd) <+ cpphdl_channel(V(BIT_N7_0, Vdd), V(cpphdl_n1401, Vdd), 0.080000000000000002, 0.69999999999999996, -1.0);
        // device 963, IC IC169, analog/basic/inverter.hpp:12
        I(cpphdl_n1401, Vss) <+ cpphdl_channel(V(BIT_N7_0, Vss), V(cpphdl_n1401, Vss), 0.080000000000000002, 0.69999999999999996, 1.0);
        // device 964, IC IC168, analog/basic/mos_r2r_dac.hpp:27
        I(cpphdl_n1401, Vss) <+ 2.9999999999999998e-15 * ddt(V(cpphdl_n1401, Vss)); // Bench initial voltage = 0.0 V.
        // device 965, IC IC168, analog/basic/mos_r2r_dac.hpp:28
        I(cpphdl_n1401, cpphdl_n1430) <+ V(cpphdl_n1401, cpphdl_n1430) / 2000.0;
        // device 966, IC IC168, analog/basic/mos_r2r_dac.hpp:29
        I(cpphdl_n1430, Vss) <+ 2.9999999999999998e-15 * ddt(V(cpphdl_n1430, Vss)); // Bench initial voltage = 0.0 V.
        // device 967, IC IC170, analog/basic/inverter.hpp:11
        I(cpphdl_n1405, Vdd) <+ cpphdl_channel(V(BIT_N7_1, Vdd), V(cpphdl_n1405, Vdd), 0.080000000000000002, 0.69999999999999996, -1.0);
        // device 968, IC IC170, analog/basic/inverter.hpp:12
        I(cpphdl_n1405, Vss) <+ cpphdl_channel(V(BIT_N7_1, Vss), V(cpphdl_n1405, Vss), 0.080000000000000002, 0.69999999999999996, 1.0);
        // device 969, IC IC168, analog/basic/mos_r2r_dac.hpp:27
        I(cpphdl_n1405, Vss) <+ 2.9999999999999998e-15 * ddt(V(cpphdl_n1405, Vss)); // Bench initial voltage = 0.0 V.
        // device 970, IC IC168, analog/basic/mos_r2r_dac.hpp:28
        I(cpphdl_n1405, cpphdl_n1431) <+ V(cpphdl_n1405, cpphdl_n1431) / 2000.0;
        // device 971, IC IC168, analog/basic/mos_r2r_dac.hpp:29
        I(cpphdl_n1431, Vss) <+ 2.9999999999999998e-15 * ddt(V(cpphdl_n1431, Vss)); // Bench initial voltage = 0.0 V.
        // device 972, IC IC168, analog/basic/mos_r2r_dac.hpp:31
        I(cpphdl_n1430, cpphdl_n1431) <+ V(cpphdl_n1430, cpphdl_n1431) / 1000.0;
        // device 973, IC IC171, analog/basic/inverter.hpp:11
        I(cpphdl_n1409, Vdd) <+ cpphdl_channel(V(BIT_N7_2, Vdd), V(cpphdl_n1409, Vdd), 0.080000000000000002, 0.69999999999999996, -1.0);
        // device 974, IC IC171, analog/basic/inverter.hpp:12
        I(cpphdl_n1409, Vss) <+ cpphdl_channel(V(BIT_N7_2, Vss), V(cpphdl_n1409, Vss), 0.080000000000000002, 0.69999999999999996, 1.0);
        // device 975, IC IC168, analog/basic/mos_r2r_dac.hpp:27
        I(cpphdl_n1409, Vss) <+ 2.9999999999999998e-15 * ddt(V(cpphdl_n1409, Vss)); // Bench initial voltage = 0.0 V.
        // device 976, IC IC168, analog/basic/mos_r2r_dac.hpp:28
        I(cpphdl_n1409, cpphdl_n1432) <+ V(cpphdl_n1409, cpphdl_n1432) / 2000.0;
        // device 977, IC IC168, analog/basic/mos_r2r_dac.hpp:29
        I(cpphdl_n1432, Vss) <+ 2.9999999999999998e-15 * ddt(V(cpphdl_n1432, Vss)); // Bench initial voltage = 0.0 V.
        // device 978, IC IC168, analog/basic/mos_r2r_dac.hpp:31
        I(cpphdl_n1431, cpphdl_n1432) <+ V(cpphdl_n1431, cpphdl_n1432) / 1000.0;
        // device 979, IC IC172, analog/basic/inverter.hpp:11
        I(cpphdl_n1413, Vdd) <+ cpphdl_channel(V(BIT_N7_3, Vdd), V(cpphdl_n1413, Vdd), 0.080000000000000002, 0.69999999999999996, -1.0);
        // device 980, IC IC172, analog/basic/inverter.hpp:12
        I(cpphdl_n1413, Vss) <+ cpphdl_channel(V(BIT_N7_3, Vss), V(cpphdl_n1413, Vss), 0.080000000000000002, 0.69999999999999996, 1.0);
        // device 981, IC IC168, analog/basic/mos_r2r_dac.hpp:27
        I(cpphdl_n1413, Vss) <+ 2.9999999999999998e-15 * ddt(V(cpphdl_n1413, Vss)); // Bench initial voltage = 0.0 V.
        // device 982, IC IC168, analog/basic/mos_r2r_dac.hpp:28
        I(cpphdl_n1413, cpphdl_n1433) <+ V(cpphdl_n1413, cpphdl_n1433) / 2000.0;
        // device 983, IC IC168, analog/basic/mos_r2r_dac.hpp:29
        I(cpphdl_n1433, Vss) <+ 2.9999999999999998e-15 * ddt(V(cpphdl_n1433, Vss)); // Bench initial voltage = 0.0 V.
        // device 984, IC IC168, analog/basic/mos_r2r_dac.hpp:31
        I(cpphdl_n1432, cpphdl_n1433) <+ V(cpphdl_n1432, cpphdl_n1433) / 1000.0;
        // device 985, IC IC173, analog/basic/inverter.hpp:11
        I(cpphdl_n1417, Vdd) <+ cpphdl_channel(V(BIT_N7_4, Vdd), V(cpphdl_n1417, Vdd), 0.080000000000000002, 0.69999999999999996, -1.0);
        // device 986, IC IC173, analog/basic/inverter.hpp:12
        I(cpphdl_n1417, Vss) <+ cpphdl_channel(V(BIT_N7_4, Vss), V(cpphdl_n1417, Vss), 0.080000000000000002, 0.69999999999999996, 1.0);
        // device 987, IC IC168, analog/basic/mos_r2r_dac.hpp:27
        I(cpphdl_n1417, Vss) <+ 2.9999999999999998e-15 * ddt(V(cpphdl_n1417, Vss)); // Bench initial voltage = 0.0 V.
        // device 988, IC IC168, analog/basic/mos_r2r_dac.hpp:28
        I(cpphdl_n1417, cpphdl_n1434) <+ V(cpphdl_n1417, cpphdl_n1434) / 2000.0;
        // device 989, IC IC168, analog/basic/mos_r2r_dac.hpp:29
        I(cpphdl_n1434, Vss) <+ 2.9999999999999998e-15 * ddt(V(cpphdl_n1434, Vss)); // Bench initial voltage = 0.0 V.
        // device 990, IC IC168, analog/basic/mos_r2r_dac.hpp:31
        I(cpphdl_n1433, cpphdl_n1434) <+ V(cpphdl_n1433, cpphdl_n1434) / 1000.0;
        // device 991, IC IC174, analog/basic/inverter.hpp:11
        I(cpphdl_n1421, Vdd) <+ cpphdl_channel(V(BIT_N7_5, Vdd), V(cpphdl_n1421, Vdd), 0.080000000000000002, 0.69999999999999996, -1.0);
        // device 992, IC IC174, analog/basic/inverter.hpp:12
        I(cpphdl_n1421, Vss) <+ cpphdl_channel(V(BIT_N7_5, Vss), V(cpphdl_n1421, Vss), 0.080000000000000002, 0.69999999999999996, 1.0);
        // device 993, IC IC168, analog/basic/mos_r2r_dac.hpp:27
        I(cpphdl_n1421, Vss) <+ 2.9999999999999998e-15 * ddt(V(cpphdl_n1421, Vss)); // Bench initial voltage = 0.0 V.
        // device 994, IC IC168, analog/basic/mos_r2r_dac.hpp:28
        I(cpphdl_n1421, cpphdl_n1435) <+ V(cpphdl_n1421, cpphdl_n1435) / 2000.0;
        // device 995, IC IC168, analog/basic/mos_r2r_dac.hpp:29
        I(cpphdl_n1435, Vss) <+ 2.9999999999999998e-15 * ddt(V(cpphdl_n1435, Vss)); // Bench initial voltage = 0.0 V.
        // device 996, IC IC168, analog/basic/mos_r2r_dac.hpp:31
        I(cpphdl_n1434, cpphdl_n1435) <+ V(cpphdl_n1434, cpphdl_n1435) / 1000.0;
        // device 997, IC IC175, analog/basic/inverter.hpp:11
        I(cpphdl_n1425, Vdd) <+ cpphdl_channel(V(BIT_N7_6, Vdd), V(cpphdl_n1425, Vdd), 0.080000000000000002, 0.69999999999999996, -1.0);
        // device 998, IC IC175, analog/basic/inverter.hpp:12
        I(cpphdl_n1425, Vss) <+ cpphdl_channel(V(BIT_N7_6, Vss), V(cpphdl_n1425, Vss), 0.080000000000000002, 0.69999999999999996, 1.0);
        // device 999, IC IC168, analog/basic/mos_r2r_dac.hpp:27
        I(cpphdl_n1425, Vss) <+ 2.9999999999999998e-15 * ddt(V(cpphdl_n1425, Vss)); // Bench initial voltage = 0.0 V.
        // device 1000, IC IC168, analog/basic/mos_r2r_dac.hpp:28
        I(cpphdl_n1425, cpphdl_n1436) <+ V(cpphdl_n1425, cpphdl_n1436) / 2000.0;
        // device 1001, IC IC168, analog/basic/mos_r2r_dac.hpp:29
        I(cpphdl_n1436, Vss) <+ 2.9999999999999998e-15 * ddt(V(cpphdl_n1436, Vss)); // Bench initial voltage = 0.0 V.
        // device 1002, IC IC168, analog/basic/mos_r2r_dac.hpp:31
        I(cpphdl_n1435, cpphdl_n1436) <+ V(cpphdl_n1435, cpphdl_n1436) / 1000.0;
        // device 1003, IC IC176, analog/basic/inverter.hpp:11
        I(cpphdl_n1429, Vdd) <+ cpphdl_channel(V(BIT_N7_7, Vdd), V(cpphdl_n1429, Vdd), 0.080000000000000002, 0.69999999999999996, -1.0);
        // device 1004, IC IC176, analog/basic/inverter.hpp:12
        I(cpphdl_n1429, Vss) <+ cpphdl_channel(V(BIT_N7_7, Vss), V(cpphdl_n1429, Vss), 0.080000000000000002, 0.69999999999999996, 1.0);
        // device 1005, IC IC168, analog/basic/mos_r2r_dac.hpp:27
        I(cpphdl_n1429, Vss) <+ 2.9999999999999998e-15 * ddt(V(cpphdl_n1429, Vss)); // Bench initial voltage = 0.0 V.
        // device 1006, IC IC168, analog/basic/mos_r2r_dac.hpp:28
        I(cpphdl_n1429, cpphdl_n1441) <+ V(cpphdl_n1429, cpphdl_n1441) / 2000.0;
        // device 1007, IC IC168, analog/basic/mos_r2r_dac.hpp:29
        I(cpphdl_n1441, Vss) <+ 2.9999999999999998e-15 * ddt(V(cpphdl_n1441, Vss)); // Bench initial voltage = 0.0 V.
        // device 1008, IC IC168, analog/basic/mos_r2r_dac.hpp:31
        I(cpphdl_n1436, cpphdl_n1441) <+ V(cpphdl_n1436, cpphdl_n1441) / 1000.0;
        // device 1009, IC IC168, analog/basic/mos_r2r_dac.hpp:33
        I(Vss, cpphdl_n1430) <+ V(Vss, cpphdl_n1430) / 2000.0;
        // device 1010, IC IC177, analog/basic/nmos_resistor_amplifier.hpp:23
        I(Vdd, cpphdl_n1450) <+ V(Vdd, cpphdl_n1450) / 500.0;
        // device 1011, IC IC177, analog/basic/nmos_resistor_amplifier.hpp:24
        I(Vdd, cpphdl_n1449) <+ V(Vdd, cpphdl_n1449) / 500.0;
        // device 1012, IC IC177, analog/basic/nmos_resistor_amplifier.hpp:25
        I(cpphdl_n1450, cpphdl_n1444) <+ cpphdl_channel(V(cpphdl_n1440, cpphdl_n1444), V(cpphdl_n1450, cpphdl_n1444), 0.014999999999999999, 0.69999999999999996, 1.0);
        // device 1013, IC IC177, analog/basic/nmos_resistor_amplifier.hpp:26
        I(cpphdl_n1449, cpphdl_n1445) <+ cpphdl_channel(V(cpphdl_n1441, cpphdl_n1445), V(cpphdl_n1449, cpphdl_n1445), 0.014999999999999999, 0.69999999999999996, 1.0);
        // device 1014, IC IC177, analog/basic/nmos_resistor_amplifier.hpp:27
        I(cpphdl_n1446, cpphdl_n1444) <+ V(cpphdl_n1446, cpphdl_n1444) / 50.0;
        // device 1015, IC IC177, analog/basic/nmos_resistor_amplifier.hpp:28
        I(cpphdl_n1446, cpphdl_n1445) <+ V(cpphdl_n1446, cpphdl_n1445) / 50.0;
        // device 1016, IC IC177, analog/basic/nmos_resistor_amplifier.hpp:29
        I(Vss, cpphdl_n1446) <+ V(Vss, cpphdl_n1446) / 150.0;
        // device 1017, IC IC177, analog/basic/nmos_resistor_amplifier.hpp:30
        I(cpphdl_n1450, Vdd) <+ 2.9999999999999998e-13 * ddt(V(cpphdl_n1450, Vdd)); // Bench initial voltage = 0.0 V.
        // device 1018, IC IC177, analog/basic/nmos_resistor_amplifier.hpp:31
        I(cpphdl_n1449, Vdd) <+ 2.9999999999999998e-13 * ddt(V(cpphdl_n1449, Vdd)); // Bench initial voltage = 0.0 V.
        // device 1019, IC IC177, analog/basic/nmos_resistor_amplifier.hpp:32
        I(cpphdl_n1446, Vss) <+ 4e-14 * ddt(V(cpphdl_n1446, Vss)); // Bench initial voltage = 0.0 V.
        // device 1020, IC IC177, analog/basic/nmos_resistor_amplifier.hpp:34
        I(cpphdl_n1440, cpphdl_n1444) <+ 2e-14 * ddt(V(cpphdl_n1440, cpphdl_n1444)); // Bench initial voltage = 1.6499999999999999 V.
        // device 1021, IC IC177, analog/basic/nmos_resistor_amplifier.hpp:35
        I(cpphdl_n1441, cpphdl_n1445) <+ 2e-14 * ddt(V(cpphdl_n1441, cpphdl_n1445)); // Bench initial voltage = 0.0 V.
        // device 1022, IC IC177, analog/basic/nmos_resistor_amplifier.hpp:36
        I(cpphdl_n1440, cpphdl_n1450) <+ 2.9999999999999998e-15 * ddt(V(cpphdl_n1440, cpphdl_n1450)); // Bench initial voltage = -1.6499999999999999 V.
        // device 1023, IC IC177, analog/basic/nmos_resistor_amplifier.hpp:37
        I(cpphdl_n1441, cpphdl_n1449) <+ 2.9999999999999998e-15 * ddt(V(cpphdl_n1441, cpphdl_n1449)); // Bench initial voltage = -3.2999999999999998 V.
        // device 1024, IC IC178, analog/basic/strongarm_comparator.hpp:28
        I(cpphdl_n1454, cpphdl_n1456) <+ cpphdl_channel(V(cpphdl_n1449, cpphdl_n1456), V(cpphdl_n1454, cpphdl_n1456), 0.0080000000000000002, 0.69999999999999996, 1.0);
        // device 1025, IC IC178, analog/basic/strongarm_comparator.hpp:29
        I(cpphdl_n1455, cpphdl_n1456) <+ cpphdl_channel(V(cpphdl_n1450, cpphdl_n1456), V(cpphdl_n1455, cpphdl_n1456), 0.0080000000000000002, 0.69999999999999996, 1.0);
        // device 1026, IC IC178, analog/basic/strongarm_comparator.hpp:30
        I(cpphdl_n1456, Vss) <+ cpphdl_channel(V(EVALUATE, Vss), V(cpphdl_n1456, Vss), 0.0080000000000000002, 0.69999999999999996, 1.0);
        // device 1027, IC IC178, analog/basic/strongarm_comparator.hpp:33
        I(cpphdl_n1469, cpphdl_n1454) <+ cpphdl_channel(V(cpphdl_n1473, cpphdl_n1454), V(cpphdl_n1469, cpphdl_n1454), 0.0040000000000000001, 0.69999999999999996, 1.0);
        // device 1028, IC IC178, analog/basic/strongarm_comparator.hpp:34
        I(cpphdl_n1473, cpphdl_n1455) <+ cpphdl_channel(V(cpphdl_n1469, cpphdl_n1455), V(cpphdl_n1473, cpphdl_n1455), 0.0040000000000000001, 0.69999999999999996, 1.0);
        // device 1029, IC IC178, analog/basic/strongarm_comparator.hpp:35
        I(cpphdl_n1473, Vdd) <+ cpphdl_channel(V(cpphdl_n1469, Vdd), V(cpphdl_n1473, Vdd), 0.002, 0.69999999999999996, -1.0);
        // device 1030, IC IC178, analog/basic/strongarm_comparator.hpp:36
        I(cpphdl_n1469, Vdd) <+ cpphdl_channel(V(cpphdl_n1473, Vdd), V(cpphdl_n1469, Vdd), 0.002, 0.69999999999999996, -1.0);
        // device 1031, IC IC178, analog/basic/strongarm_comparator.hpp:38
        I(cpphdl_n1454, Vdd) <+ cpphdl_channel(V(EVALUATE, Vdd), V(cpphdl_n1454, Vdd), 0.002, 0.69999999999999996, -1.0);
        // device 1032, IC IC178, analog/basic/strongarm_comparator.hpp:39
        I(cpphdl_n1455, Vdd) <+ cpphdl_channel(V(EVALUATE, Vdd), V(cpphdl_n1455, Vdd), 0.002, 0.69999999999999996, -1.0);
        // device 1033, IC IC178, analog/basic/strongarm_comparator.hpp:40
        I(cpphdl_n1473, Vdd) <+ cpphdl_channel(V(EVALUATE, Vdd), V(cpphdl_n1473, Vdd), 0.002, 0.69999999999999996, -1.0);
        // device 1034, IC IC178, analog/basic/strongarm_comparator.hpp:41
        I(cpphdl_n1469, Vdd) <+ cpphdl_channel(V(EVALUATE, Vdd), V(cpphdl_n1469, Vdd), 0.002, 0.69999999999999996, -1.0);
        // device 1035, IC IC178, analog/basic/strongarm_comparator.hpp:42
        I(cpphdl_n1454, Vss) <+ 2.9999999999999998e-14 * ddt(V(cpphdl_n1454, Vss)); // Bench initial voltage = 0.0 V.
        // device 1036, IC IC178, analog/basic/strongarm_comparator.hpp:43
        I(cpphdl_n1455, Vss) <+ 2.9999999999999998e-14 * ddt(V(cpphdl_n1455, Vss)); // Bench initial voltage = 0.0 V.
        // device 1037, IC IC178, analog/basic/strongarm_comparator.hpp:44
        I(cpphdl_n1456, Vss) <+ 2.9999999999999998e-14 * ddt(V(cpphdl_n1456, Vss)); // Bench initial voltage = 0.0 V.
        // device 1038, IC IC178, analog/basic/strongarm_comparator.hpp:45
        I(cpphdl_n1473, Vss) <+ 5.0000000000000002e-14 * ddt(V(cpphdl_n1473, Vss)); // Bench initial voltage = 0.0 V.
        // device 1039, IC IC178, analog/basic/strongarm_comparator.hpp:46
        I(cpphdl_n1469, Vss) <+ 5.0000000000000002e-14 * ddt(V(cpphdl_n1469, Vss)); // Bench initial voltage = 0.0 V.
        // device 1040, IC IC178, analog/basic/strongarm_comparator.hpp:47
        I(cpphdl_n1449, cpphdl_n1456) <+ 2e-14 * ddt(V(cpphdl_n1449, cpphdl_n1456)); // Bench initial voltage = 3.2999999999999998 V.
        // device 1041, IC IC178, analog/basic/strongarm_comparator.hpp:48
        I(cpphdl_n1450, cpphdl_n1456) <+ 2e-14 * ddt(V(cpphdl_n1450, cpphdl_n1456)); // Bench initial voltage = 3.2999999999999998 V.
        // device 1042, IC IC178, analog/basic/strongarm_comparator.hpp:49
        I(cpphdl_n1449, cpphdl_n1454) <+ 2.9999999999999998e-15 * ddt(V(cpphdl_n1449, cpphdl_n1454)); // Bench initial voltage = 3.2999999999999998 V.
        // device 1043, IC IC178, analog/basic/strongarm_comparator.hpp:50
        I(cpphdl_n1450, cpphdl_n1455) <+ 2.9999999999999998e-15 * ddt(V(cpphdl_n1450, cpphdl_n1455)); // Bench initial voltage = 3.2999999999999998 V.
        // device 1044, IC IC180, analog/basic/inverter.hpp:11
        I(cpphdl_n1477, Vdd) <+ cpphdl_channel(V(cpphdl_n1469, Vdd), V(cpphdl_n1477, Vdd), 0.001, 0.69999999999999996, -1.0);
        // device 1045, IC IC180, analog/basic/inverter.hpp:12
        I(cpphdl_n1477, Vss) <+ cpphdl_channel(V(cpphdl_n1469, Vss), V(cpphdl_n1477, Vss), 0.001, 0.69999999999999996, 1.0);
        // device 1046, IC IC182, analog/basic/inverter.hpp:11
        I(cpphdl_n1491, Vdd) <+ cpphdl_channel(V(cpphdl_n1477, Vdd), V(cpphdl_n1491, Vdd), 0.0040000000000000001, 0.69999999999999996, -1.0);
        // device 1047, IC IC182, analog/basic/inverter.hpp:12
        I(cpphdl_n1491, Vss) <+ cpphdl_channel(V(cpphdl_n1477, Vss), V(cpphdl_n1491, Vss), 0.0040000000000000001, 0.69999999999999996, 1.0);
        // device 1048, IC IC179, analog/basic/buffered_nand_latch.hpp:34
        I(cpphdl_n1469, Vss) <+ 2.0000000000000002e-15 * ddt(V(cpphdl_n1469, Vss)); // Bench initial voltage = 0.0 V.
        // device 1049, IC IC179, analog/basic/buffered_nand_latch.hpp:35
        I(cpphdl_n1469, cpphdl_n1477) <+ 1.0000000000000001e-15 * ddt(V(cpphdl_n1469, cpphdl_n1477)); // Bench initial voltage = 0.0 V.
        // device 1050, IC IC179, analog/basic/buffered_nand_latch.hpp:36
        I(cpphdl_n1477, Vss) <+ 5e-15 * ddt(V(cpphdl_n1477, Vss)); // Bench initial voltage = 0.0 V.
        // device 1051, IC IC179, analog/basic/buffered_nand_latch.hpp:37
        I(cpphdl_n1477, Vss) <+ 8.0000000000000006e-15 * ddt(V(cpphdl_n1477, Vss)); // Bench initial voltage = 0.0 V.
        // device 1052, IC IC179, analog/basic/buffered_nand_latch.hpp:38
        I(cpphdl_n1491, Vss) <+ 1e-14 * ddt(V(cpphdl_n1491, Vss)); // Bench initial voltage = 0.0 V.
        // device 1053, IC IC181, analog/basic/inverter.hpp:11
        I(cpphdl_n1481, Vdd) <+ cpphdl_channel(V(cpphdl_n1473, Vdd), V(cpphdl_n1481, Vdd), 0.001, 0.69999999999999996, -1.0);
        // device 1054, IC IC181, analog/basic/inverter.hpp:12
        I(cpphdl_n1481, Vss) <+ cpphdl_channel(V(cpphdl_n1473, Vss), V(cpphdl_n1481, Vss), 0.001, 0.69999999999999996, 1.0);
        // device 1055, IC IC183, analog/basic/inverter.hpp:11
        I(cpphdl_n1497, Vdd) <+ cpphdl_channel(V(cpphdl_n1481, Vdd), V(cpphdl_n1497, Vdd), 0.0040000000000000001, 0.69999999999999996, -1.0);
        // device 1056, IC IC183, analog/basic/inverter.hpp:12
        I(cpphdl_n1497, Vss) <+ cpphdl_channel(V(cpphdl_n1481, Vss), V(cpphdl_n1497, Vss), 0.0040000000000000001, 0.69999999999999996, 1.0);
        // device 1057, IC IC179, analog/basic/buffered_nand_latch.hpp:34
        I(cpphdl_n1473, Vss) <+ 2.0000000000000002e-15 * ddt(V(cpphdl_n1473, Vss)); // Bench initial voltage = 0.0 V.
        // device 1058, IC IC179, analog/basic/buffered_nand_latch.hpp:35
        I(cpphdl_n1473, cpphdl_n1481) <+ 1.0000000000000001e-15 * ddt(V(cpphdl_n1473, cpphdl_n1481)); // Bench initial voltage = 0.0 V.
        // device 1059, IC IC179, analog/basic/buffered_nand_latch.hpp:36
        I(cpphdl_n1481, Vss) <+ 5e-15 * ddt(V(cpphdl_n1481, Vss)); // Bench initial voltage = 0.0 V.
        // device 1060, IC IC179, analog/basic/buffered_nand_latch.hpp:37
        I(cpphdl_n1481, Vss) <+ 8.0000000000000006e-15 * ddt(V(cpphdl_n1481, Vss)); // Bench initial voltage = 0.0 V.
        // device 1061, IC IC179, analog/basic/buffered_nand_latch.hpp:38
        I(cpphdl_n1497, Vss) <+ 1e-14 * ddt(V(cpphdl_n1497, Vss)); // Bench initial voltage = 0.0 V.
        // device 1062, IC IC185, analog/basic/cmos_logic.hpp:17
        I(cpphdl_n2704, Vss) <+ 5.0000000000000002e-14 * ddt(V(cpphdl_n2704, Vss)); // Bench initial voltage = 0.0 V.
        // device 1063, IC IC185, analog/basic/cmos_logic.hpp:18
        I(cpphdl_n2704, Vdd) <+ cpphdl_channel(V(cpphdl_n1491, Vdd), V(cpphdl_n2704, Vdd), 0.01, 0.69999999999999996, -1.0);
        // device 1064, IC IC185, analog/basic/cmos_logic.hpp:19
        I(cpphdl_n2704, Vdd) <+ cpphdl_channel(V(cpphdl_n1499, Vdd), V(cpphdl_n2704, Vdd), 0.01, 0.69999999999999996, -1.0);
        // device 1065, IC IC185, analog/basic/cmos_logic.hpp:20
        I(cpphdl_n2704, cpphdl_n1494) <+ cpphdl_channel(V(cpphdl_n1491, cpphdl_n1494), V(cpphdl_n2704, cpphdl_n1494), 0.01, 0.69999999999999996, 1.0);
        // device 1066, IC IC185, analog/basic/cmos_logic.hpp:21
        I(cpphdl_n1494, Vss) <+ cpphdl_channel(V(cpphdl_n1499, Vss), V(cpphdl_n1494, Vss), 0.01, 0.69999999999999996, 1.0);
        // device 1067, IC IC185, analog/basic/cmos_logic.hpp:23
        I(cpphdl_n2704, Vss) <+ V(cpphdl_n2704, Vss) / 1000000000.0;
        // device 1068, IC IC185, analog/basic/cmos_logic.hpp:24
        I(cpphdl_n1494, Vss) <+ V(cpphdl_n1494, Vss) / 1000000000.0;
        // device 1069, IC IC186, analog/basic/cmos_logic.hpp:17
        I(cpphdl_n1499, Vss) <+ 5.0000000000000002e-14 * ddt(V(cpphdl_n1499, Vss)); // Bench initial voltage = 0.0 V.
        // device 1070, IC IC186, analog/basic/cmos_logic.hpp:18
        I(cpphdl_n1499, Vdd) <+ cpphdl_channel(V(cpphdl_n1497, Vdd), V(cpphdl_n1499, Vdd), 0.01, 0.69999999999999996, -1.0);
        // device 1071, IC IC186, analog/basic/cmos_logic.hpp:19
        I(cpphdl_n1499, Vdd) <+ cpphdl_channel(V(cpphdl_n2704, Vdd), V(cpphdl_n1499, Vdd), 0.01, 0.69999999999999996, -1.0);
        // device 1072, IC IC186, analog/basic/cmos_logic.hpp:20
        I(cpphdl_n1499, cpphdl_n1500) <+ cpphdl_channel(V(cpphdl_n1497, cpphdl_n1500), V(cpphdl_n1499, cpphdl_n1500), 0.01, 0.69999999999999996, 1.0);
        // device 1073, IC IC186, analog/basic/cmos_logic.hpp:21
        I(cpphdl_n1500, Vss) <+ cpphdl_channel(V(cpphdl_n2704, Vss), V(cpphdl_n1500, Vss), 0.01, 0.69999999999999996, 1.0);
        // device 1074, IC IC186, analog/basic/cmos_logic.hpp:23
        I(cpphdl_n1499, Vss) <+ V(cpphdl_n1499, Vss) / 1000000000.0;
        // device 1075, IC IC186, analog/basic/cmos_logic.hpp:24
        I(cpphdl_n1500, Vss) <+ V(cpphdl_n1500, Vss) / 1000000000.0;
        // device 1076, IC IC184, analog/basic/nand_latch.hpp:36
        I(cpphdl_n1491, Vss) <+ 2.9999999999999998e-15 * ddt(V(cpphdl_n1491, Vss)); // Bench initial voltage = 0.0 V.
        // device 1077, IC IC184, analog/basic/nand_latch.hpp:37
        I(cpphdl_n1497, Vss) <+ 2.9999999999999998e-15 * ddt(V(cpphdl_n1497, Vss)); // Bench initial voltage = 0.0 V.
        // device 1078, IC IC187, analog/basic/inverter.hpp:11
        I(cpphdl_n1505, Vdd) <+ cpphdl_channel(V(CLEAR, Vdd), V(cpphdl_n1505, Vdd), 0.01, 0.69999999999999996, -1.0);
        // device 1079, IC IC187, analog/basic/inverter.hpp:12
        I(cpphdl_n1505, Vss) <+ cpphdl_channel(V(CLEAR, Vss), V(cpphdl_n1505, Vss), 0.01, 0.69999999999999996, 1.0);
        // device 1080, IC IC184, analog/basic/nand_latch.hpp:58
        I(cpphdl_n1505, Vss) <+ 2.9999999999999998e-15 * ddt(V(cpphdl_n1505, Vss)); // Bench initial voltage = 0.0 V.
        // device 1081, IC IC184, analog/basic/nand_latch.hpp:59
        I(cpphdl_n2704, Vss) <+ cpphdl_channel(V(CLEAR, Vss), V(cpphdl_n2704, Vss), 0.050000000000000003, 0.69999999999999996, 1.0);
        // device 1082, IC IC184, analog/basic/nand_latch.hpp:60
        I(cpphdl_n1499, Vdd) <+ cpphdl_channel(V(cpphdl_n1505, Vdd), V(cpphdl_n1499, Vdd), 0.050000000000000003, 0.69999999999999996, -1.0);
        // device 1083, IC IC190, analog/basic/inverter.hpp:11
        I(cpphdl_n1529, Vdd) <+ cpphdl_channel(V(TRACK8, Vdd), V(cpphdl_n1529, Vdd), 0.0040000000000000001, 0.69999999999999996, -1.0);
        // device 1084, IC IC190, analog/basic/inverter.hpp:12
        I(cpphdl_n1529, Vss) <+ cpphdl_channel(V(TRACK8, Vss), V(cpphdl_n1529, Vss), 0.0040000000000000001, 0.69999999999999996, 1.0);
        // device 1085, IC IC189, analog/basic/mos_track_hold.hpp:31
        I(cpphdl_n1529, Vss) <+ 2e-14 * ddt(V(cpphdl_n1529, Vss)); // Bench initial voltage = 3.2999999999999998 V.
        // device 1086, IC IC189, analog/basic/mos_track_hold.hpp:32
        I(cpphdl_n2759, cpphdl_n1583) <+ cpphdl_channel(V(TRACK8, cpphdl_n1583), V(cpphdl_n2759, cpphdl_n1583), 0.080000000000000002, 0.69999999999999996, 1.0);
        // device 1087, IC IC189, analog/basic/mos_track_hold.hpp:33
        I(cpphdl_n1583, cpphdl_n2759) <+ cpphdl_channel(V(cpphdl_n1529, cpphdl_n2759), V(cpphdl_n1583, cpphdl_n2759), 0.040000000000000001, 0.69999999999999996, -1.0);
        // device 1088, IC IC189, analog/basic/mos_track_hold.hpp:37
        I(cpphdl_n1583, cpphdl_n1583) <+ cpphdl_channel(V(cpphdl_n1529, cpphdl_n1583), V(cpphdl_n1583, cpphdl_n1583), 0.040000000000000001, 0.69999999999999996, 1.0);
        // device 1089, IC IC189, analog/basic/mos_track_hold.hpp:38
        I(cpphdl_n1583, cpphdl_n1583) <+ cpphdl_channel(V(TRACK8, cpphdl_n1583), V(cpphdl_n1583, cpphdl_n1583), 0.02, 0.69999999999999996, -1.0);
        // device 1090, IC IC189, analog/basic/mos_track_hold.hpp:39
        I(cpphdl_n1583, Vss) <+ 3.0000000000000001e-12 * ddt(V(cpphdl_n1583, Vss)); // Bench initial voltage = 1.6499999999999999 V.
        // device 1091, IC IC189, analog/basic/mos_track_hold.hpp:41
        I(Vss, cpphdl_n1583) <+ V(Vss, cpphdl_n1583) / 1000000000.0;
        // device 1092, IC IC189, analog/basic/mos_track_hold.hpp:42
        I(TRACK8, cpphdl_n1583) <+ 8.0000000000000006e-15 * ddt(V(TRACK8, cpphdl_n1583)); // Bench initial voltage = -1.6499999999999999 V.
        // device 1093, IC IC189, analog/basic/mos_track_hold.hpp:43
        I(cpphdl_n1529, cpphdl_n1583) <+ 8.0000000000000006e-15 * ddt(V(cpphdl_n1529, cpphdl_n1583)); // Bench initial voltage = 1.6499999999999999 V.
        // device 1094, IC IC189, analog/basic/mos_track_hold.hpp:44
        I(cpphdl_n2759, cpphdl_n1583) <+ 4.0000000000000003e-15 * ddt(V(cpphdl_n2759, cpphdl_n1583)); // Bench initial voltage = 0.0 V.
        // device 1095, IC IC192, analog/basic/inverter.hpp:11
        I(cpphdl_n1544, Vdd) <+ cpphdl_channel(V(BIT_N8_0, Vdd), V(cpphdl_n1544, Vdd), 0.080000000000000002, 0.69999999999999996, -1.0);
        // device 1096, IC IC192, analog/basic/inverter.hpp:12
        I(cpphdl_n1544, Vss) <+ cpphdl_channel(V(BIT_N8_0, Vss), V(cpphdl_n1544, Vss), 0.080000000000000002, 0.69999999999999996, 1.0);
        // device 1097, IC IC191, analog/basic/mos_r2r_dac.hpp:27
        I(cpphdl_n1544, Vss) <+ 2.9999999999999998e-15 * ddt(V(cpphdl_n1544, Vss)); // Bench initial voltage = 0.0 V.
        // device 1098, IC IC191, analog/basic/mos_r2r_dac.hpp:28
        I(cpphdl_n1544, cpphdl_n1573) <+ V(cpphdl_n1544, cpphdl_n1573) / 2000.0;
        // device 1099, IC IC191, analog/basic/mos_r2r_dac.hpp:29
        I(cpphdl_n1573, Vss) <+ 2.9999999999999998e-15 * ddt(V(cpphdl_n1573, Vss)); // Bench initial voltage = 0.0 V.
        // device 1100, IC IC193, analog/basic/inverter.hpp:11
        I(cpphdl_n1548, Vdd) <+ cpphdl_channel(V(BIT_N8_1, Vdd), V(cpphdl_n1548, Vdd), 0.080000000000000002, 0.69999999999999996, -1.0);
        // device 1101, IC IC193, analog/basic/inverter.hpp:12
        I(cpphdl_n1548, Vss) <+ cpphdl_channel(V(BIT_N8_1, Vss), V(cpphdl_n1548, Vss), 0.080000000000000002, 0.69999999999999996, 1.0);
        // device 1102, IC IC191, analog/basic/mos_r2r_dac.hpp:27
        I(cpphdl_n1548, Vss) <+ 2.9999999999999998e-15 * ddt(V(cpphdl_n1548, Vss)); // Bench initial voltage = 0.0 V.
        // device 1103, IC IC191, analog/basic/mos_r2r_dac.hpp:28
        I(cpphdl_n1548, cpphdl_n1574) <+ V(cpphdl_n1548, cpphdl_n1574) / 2000.0;
        // device 1104, IC IC191, analog/basic/mos_r2r_dac.hpp:29
        I(cpphdl_n1574, Vss) <+ 2.9999999999999998e-15 * ddt(V(cpphdl_n1574, Vss)); // Bench initial voltage = 0.0 V.
        // device 1105, IC IC191, analog/basic/mos_r2r_dac.hpp:31
        I(cpphdl_n1573, cpphdl_n1574) <+ V(cpphdl_n1573, cpphdl_n1574) / 1000.0;
        // device 1106, IC IC194, analog/basic/inverter.hpp:11
        I(cpphdl_n1552, Vdd) <+ cpphdl_channel(V(BIT_N8_2, Vdd), V(cpphdl_n1552, Vdd), 0.080000000000000002, 0.69999999999999996, -1.0);
        // device 1107, IC IC194, analog/basic/inverter.hpp:12
        I(cpphdl_n1552, Vss) <+ cpphdl_channel(V(BIT_N8_2, Vss), V(cpphdl_n1552, Vss), 0.080000000000000002, 0.69999999999999996, 1.0);
        // device 1108, IC IC191, analog/basic/mos_r2r_dac.hpp:27
        I(cpphdl_n1552, Vss) <+ 2.9999999999999998e-15 * ddt(V(cpphdl_n1552, Vss)); // Bench initial voltage = 0.0 V.
        // device 1109, IC IC191, analog/basic/mos_r2r_dac.hpp:28
        I(cpphdl_n1552, cpphdl_n1575) <+ V(cpphdl_n1552, cpphdl_n1575) / 2000.0;
        // device 1110, IC IC191, analog/basic/mos_r2r_dac.hpp:29
        I(cpphdl_n1575, Vss) <+ 2.9999999999999998e-15 * ddt(V(cpphdl_n1575, Vss)); // Bench initial voltage = 0.0 V.
        // device 1111, IC IC191, analog/basic/mos_r2r_dac.hpp:31
        I(cpphdl_n1574, cpphdl_n1575) <+ V(cpphdl_n1574, cpphdl_n1575) / 1000.0;
        // device 1112, IC IC195, analog/basic/inverter.hpp:11
        I(cpphdl_n1556, Vdd) <+ cpphdl_channel(V(BIT_N8_3, Vdd), V(cpphdl_n1556, Vdd), 0.080000000000000002, 0.69999999999999996, -1.0);
        // device 1113, IC IC195, analog/basic/inverter.hpp:12
        I(cpphdl_n1556, Vss) <+ cpphdl_channel(V(BIT_N8_3, Vss), V(cpphdl_n1556, Vss), 0.080000000000000002, 0.69999999999999996, 1.0);
        // device 1114, IC IC191, analog/basic/mos_r2r_dac.hpp:27
        I(cpphdl_n1556, Vss) <+ 2.9999999999999998e-15 * ddt(V(cpphdl_n1556, Vss)); // Bench initial voltage = 0.0 V.
        // device 1115, IC IC191, analog/basic/mos_r2r_dac.hpp:28
        I(cpphdl_n1556, cpphdl_n1576) <+ V(cpphdl_n1556, cpphdl_n1576) / 2000.0;
        // device 1116, IC IC191, analog/basic/mos_r2r_dac.hpp:29
        I(cpphdl_n1576, Vss) <+ 2.9999999999999998e-15 * ddt(V(cpphdl_n1576, Vss)); // Bench initial voltage = 0.0 V.
        // device 1117, IC IC191, analog/basic/mos_r2r_dac.hpp:31
        I(cpphdl_n1575, cpphdl_n1576) <+ V(cpphdl_n1575, cpphdl_n1576) / 1000.0;
        // device 1118, IC IC196, analog/basic/inverter.hpp:11
        I(cpphdl_n1560, Vdd) <+ cpphdl_channel(V(BIT_N8_4, Vdd), V(cpphdl_n1560, Vdd), 0.080000000000000002, 0.69999999999999996, -1.0);
        // device 1119, IC IC196, analog/basic/inverter.hpp:12
        I(cpphdl_n1560, Vss) <+ cpphdl_channel(V(BIT_N8_4, Vss), V(cpphdl_n1560, Vss), 0.080000000000000002, 0.69999999999999996, 1.0);
        // device 1120, IC IC191, analog/basic/mos_r2r_dac.hpp:27
        I(cpphdl_n1560, Vss) <+ 2.9999999999999998e-15 * ddt(V(cpphdl_n1560, Vss)); // Bench initial voltage = 0.0 V.
        // device 1121, IC IC191, analog/basic/mos_r2r_dac.hpp:28
        I(cpphdl_n1560, cpphdl_n1577) <+ V(cpphdl_n1560, cpphdl_n1577) / 2000.0;
        // device 1122, IC IC191, analog/basic/mos_r2r_dac.hpp:29
        I(cpphdl_n1577, Vss) <+ 2.9999999999999998e-15 * ddt(V(cpphdl_n1577, Vss)); // Bench initial voltage = 0.0 V.
        // device 1123, IC IC191, analog/basic/mos_r2r_dac.hpp:31
        I(cpphdl_n1576, cpphdl_n1577) <+ V(cpphdl_n1576, cpphdl_n1577) / 1000.0;
        // device 1124, IC IC197, analog/basic/inverter.hpp:11
        I(cpphdl_n1564, Vdd) <+ cpphdl_channel(V(BIT_N8_5, Vdd), V(cpphdl_n1564, Vdd), 0.080000000000000002, 0.69999999999999996, -1.0);
        // device 1125, IC IC197, analog/basic/inverter.hpp:12
        I(cpphdl_n1564, Vss) <+ cpphdl_channel(V(BIT_N8_5, Vss), V(cpphdl_n1564, Vss), 0.080000000000000002, 0.69999999999999996, 1.0);
        // device 1126, IC IC191, analog/basic/mos_r2r_dac.hpp:27
        I(cpphdl_n1564, Vss) <+ 2.9999999999999998e-15 * ddt(V(cpphdl_n1564, Vss)); // Bench initial voltage = 0.0 V.
        // device 1127, IC IC191, analog/basic/mos_r2r_dac.hpp:28
        I(cpphdl_n1564, cpphdl_n1578) <+ V(cpphdl_n1564, cpphdl_n1578) / 2000.0;
        // device 1128, IC IC191, analog/basic/mos_r2r_dac.hpp:29
        I(cpphdl_n1578, Vss) <+ 2.9999999999999998e-15 * ddt(V(cpphdl_n1578, Vss)); // Bench initial voltage = 0.0 V.
        // device 1129, IC IC191, analog/basic/mos_r2r_dac.hpp:31
        I(cpphdl_n1577, cpphdl_n1578) <+ V(cpphdl_n1577, cpphdl_n1578) / 1000.0;
        // device 1130, IC IC198, analog/basic/inverter.hpp:11
        I(cpphdl_n1568, Vdd) <+ cpphdl_channel(V(BIT_N8_6, Vdd), V(cpphdl_n1568, Vdd), 0.080000000000000002, 0.69999999999999996, -1.0);
        // device 1131, IC IC198, analog/basic/inverter.hpp:12
        I(cpphdl_n1568, Vss) <+ cpphdl_channel(V(BIT_N8_6, Vss), V(cpphdl_n1568, Vss), 0.080000000000000002, 0.69999999999999996, 1.0);
        // device 1132, IC IC191, analog/basic/mos_r2r_dac.hpp:27
        I(cpphdl_n1568, Vss) <+ 2.9999999999999998e-15 * ddt(V(cpphdl_n1568, Vss)); // Bench initial voltage = 0.0 V.
        // device 1133, IC IC191, analog/basic/mos_r2r_dac.hpp:28
        I(cpphdl_n1568, cpphdl_n1579) <+ V(cpphdl_n1568, cpphdl_n1579) / 2000.0;
        // device 1134, IC IC191, analog/basic/mos_r2r_dac.hpp:29
        I(cpphdl_n1579, Vss) <+ 2.9999999999999998e-15 * ddt(V(cpphdl_n1579, Vss)); // Bench initial voltage = 0.0 V.
        // device 1135, IC IC191, analog/basic/mos_r2r_dac.hpp:31
        I(cpphdl_n1578, cpphdl_n1579) <+ V(cpphdl_n1578, cpphdl_n1579) / 1000.0;
        // device 1136, IC IC199, analog/basic/inverter.hpp:11
        I(cpphdl_n1572, Vdd) <+ cpphdl_channel(V(BIT_N8_7, Vdd), V(cpphdl_n1572, Vdd), 0.080000000000000002, 0.69999999999999996, -1.0);
        // device 1137, IC IC199, analog/basic/inverter.hpp:12
        I(cpphdl_n1572, Vss) <+ cpphdl_channel(V(BIT_N8_7, Vss), V(cpphdl_n1572, Vss), 0.080000000000000002, 0.69999999999999996, 1.0);
        // device 1138, IC IC191, analog/basic/mos_r2r_dac.hpp:27
        I(cpphdl_n1572, Vss) <+ 2.9999999999999998e-15 * ddt(V(cpphdl_n1572, Vss)); // Bench initial voltage = 0.0 V.
        // device 1139, IC IC191, analog/basic/mos_r2r_dac.hpp:28
        I(cpphdl_n1572, cpphdl_n1584) <+ V(cpphdl_n1572, cpphdl_n1584) / 2000.0;
        // device 1140, IC IC191, analog/basic/mos_r2r_dac.hpp:29
        I(cpphdl_n1584, Vss) <+ 2.9999999999999998e-15 * ddt(V(cpphdl_n1584, Vss)); // Bench initial voltage = 0.0 V.
        // device 1141, IC IC191, analog/basic/mos_r2r_dac.hpp:31
        I(cpphdl_n1579, cpphdl_n1584) <+ V(cpphdl_n1579, cpphdl_n1584) / 1000.0;
        // device 1142, IC IC191, analog/basic/mos_r2r_dac.hpp:33
        I(Vss, cpphdl_n1573) <+ V(Vss, cpphdl_n1573) / 2000.0;
        // device 1143, IC IC200, analog/basic/nmos_resistor_amplifier.hpp:23
        I(Vdd, cpphdl_n1593) <+ V(Vdd, cpphdl_n1593) / 500.0;
        // device 1144, IC IC200, analog/basic/nmos_resistor_amplifier.hpp:24
        I(Vdd, cpphdl_n1592) <+ V(Vdd, cpphdl_n1592) / 500.0;
        // device 1145, IC IC200, analog/basic/nmos_resistor_amplifier.hpp:25
        I(cpphdl_n1593, cpphdl_n1587) <+ cpphdl_channel(V(cpphdl_n1583, cpphdl_n1587), V(cpphdl_n1593, cpphdl_n1587), 0.014999999999999999, 0.69999999999999996, 1.0);
        // device 1146, IC IC200, analog/basic/nmos_resistor_amplifier.hpp:26
        I(cpphdl_n1592, cpphdl_n1588) <+ cpphdl_channel(V(cpphdl_n1584, cpphdl_n1588), V(cpphdl_n1592, cpphdl_n1588), 0.014999999999999999, 0.69999999999999996, 1.0);
        // device 1147, IC IC200, analog/basic/nmos_resistor_amplifier.hpp:27
        I(cpphdl_n1589, cpphdl_n1587) <+ V(cpphdl_n1589, cpphdl_n1587) / 50.0;
        // device 1148, IC IC200, analog/basic/nmos_resistor_amplifier.hpp:28
        I(cpphdl_n1589, cpphdl_n1588) <+ V(cpphdl_n1589, cpphdl_n1588) / 50.0;
        // device 1149, IC IC200, analog/basic/nmos_resistor_amplifier.hpp:29
        I(Vss, cpphdl_n1589) <+ V(Vss, cpphdl_n1589) / 150.0;
        // device 1150, IC IC200, analog/basic/nmos_resistor_amplifier.hpp:30
        I(cpphdl_n1593, Vdd) <+ 2.9999999999999998e-13 * ddt(V(cpphdl_n1593, Vdd)); // Bench initial voltage = 0.0 V.
        // device 1151, IC IC200, analog/basic/nmos_resistor_amplifier.hpp:31
        I(cpphdl_n1592, Vdd) <+ 2.9999999999999998e-13 * ddt(V(cpphdl_n1592, Vdd)); // Bench initial voltage = 0.0 V.
        // device 1152, IC IC200, analog/basic/nmos_resistor_amplifier.hpp:32
        I(cpphdl_n1589, Vss) <+ 4e-14 * ddt(V(cpphdl_n1589, Vss)); // Bench initial voltage = 0.0 V.
        // device 1153, IC IC200, analog/basic/nmos_resistor_amplifier.hpp:34
        I(cpphdl_n1583, cpphdl_n1587) <+ 2e-14 * ddt(V(cpphdl_n1583, cpphdl_n1587)); // Bench initial voltage = 1.6499999999999999 V.
        // device 1154, IC IC200, analog/basic/nmos_resistor_amplifier.hpp:35
        I(cpphdl_n1584, cpphdl_n1588) <+ 2e-14 * ddt(V(cpphdl_n1584, cpphdl_n1588)); // Bench initial voltage = 0.0 V.
        // device 1155, IC IC200, analog/basic/nmos_resistor_amplifier.hpp:36
        I(cpphdl_n1583, cpphdl_n1593) <+ 2.9999999999999998e-15 * ddt(V(cpphdl_n1583, cpphdl_n1593)); // Bench initial voltage = -1.6499999999999999 V.
        // device 1156, IC IC200, analog/basic/nmos_resistor_amplifier.hpp:37
        I(cpphdl_n1584, cpphdl_n1592) <+ 2.9999999999999998e-15 * ddt(V(cpphdl_n1584, cpphdl_n1592)); // Bench initial voltage = -3.2999999999999998 V.
        // device 1157, IC IC201, analog/basic/strongarm_comparator.hpp:28
        I(cpphdl_n1597, cpphdl_n1599) <+ cpphdl_channel(V(cpphdl_n1592, cpphdl_n1599), V(cpphdl_n1597, cpphdl_n1599), 0.0080000000000000002, 0.69999999999999996, 1.0);
        // device 1158, IC IC201, analog/basic/strongarm_comparator.hpp:29
        I(cpphdl_n1598, cpphdl_n1599) <+ cpphdl_channel(V(cpphdl_n1593, cpphdl_n1599), V(cpphdl_n1598, cpphdl_n1599), 0.0080000000000000002, 0.69999999999999996, 1.0);
        // device 1159, IC IC201, analog/basic/strongarm_comparator.hpp:30
        I(cpphdl_n1599, Vss) <+ cpphdl_channel(V(EVALUATE, Vss), V(cpphdl_n1599, Vss), 0.0080000000000000002, 0.69999999999999996, 1.0);
        // device 1160, IC IC201, analog/basic/strongarm_comparator.hpp:33
        I(cpphdl_n1612, cpphdl_n1597) <+ cpphdl_channel(V(cpphdl_n1616, cpphdl_n1597), V(cpphdl_n1612, cpphdl_n1597), 0.0040000000000000001, 0.69999999999999996, 1.0);
        // device 1161, IC IC201, analog/basic/strongarm_comparator.hpp:34
        I(cpphdl_n1616, cpphdl_n1598) <+ cpphdl_channel(V(cpphdl_n1612, cpphdl_n1598), V(cpphdl_n1616, cpphdl_n1598), 0.0040000000000000001, 0.69999999999999996, 1.0);
        // device 1162, IC IC201, analog/basic/strongarm_comparator.hpp:35
        I(cpphdl_n1616, Vdd) <+ cpphdl_channel(V(cpphdl_n1612, Vdd), V(cpphdl_n1616, Vdd), 0.002, 0.69999999999999996, -1.0);
        // device 1163, IC IC201, analog/basic/strongarm_comparator.hpp:36
        I(cpphdl_n1612, Vdd) <+ cpphdl_channel(V(cpphdl_n1616, Vdd), V(cpphdl_n1612, Vdd), 0.002, 0.69999999999999996, -1.0);
        // device 1164, IC IC201, analog/basic/strongarm_comparator.hpp:38
        I(cpphdl_n1597, Vdd) <+ cpphdl_channel(V(EVALUATE, Vdd), V(cpphdl_n1597, Vdd), 0.002, 0.69999999999999996, -1.0);
        // device 1165, IC IC201, analog/basic/strongarm_comparator.hpp:39
        I(cpphdl_n1598, Vdd) <+ cpphdl_channel(V(EVALUATE, Vdd), V(cpphdl_n1598, Vdd), 0.002, 0.69999999999999996, -1.0);
        // device 1166, IC IC201, analog/basic/strongarm_comparator.hpp:40
        I(cpphdl_n1616, Vdd) <+ cpphdl_channel(V(EVALUATE, Vdd), V(cpphdl_n1616, Vdd), 0.002, 0.69999999999999996, -1.0);
        // device 1167, IC IC201, analog/basic/strongarm_comparator.hpp:41
        I(cpphdl_n1612, Vdd) <+ cpphdl_channel(V(EVALUATE, Vdd), V(cpphdl_n1612, Vdd), 0.002, 0.69999999999999996, -1.0);
        // device 1168, IC IC201, analog/basic/strongarm_comparator.hpp:42
        I(cpphdl_n1597, Vss) <+ 2.9999999999999998e-14 * ddt(V(cpphdl_n1597, Vss)); // Bench initial voltage = 0.0 V.
        // device 1169, IC IC201, analog/basic/strongarm_comparator.hpp:43
        I(cpphdl_n1598, Vss) <+ 2.9999999999999998e-14 * ddt(V(cpphdl_n1598, Vss)); // Bench initial voltage = 0.0 V.
        // device 1170, IC IC201, analog/basic/strongarm_comparator.hpp:44
        I(cpphdl_n1599, Vss) <+ 2.9999999999999998e-14 * ddt(V(cpphdl_n1599, Vss)); // Bench initial voltage = 0.0 V.
        // device 1171, IC IC201, analog/basic/strongarm_comparator.hpp:45
        I(cpphdl_n1616, Vss) <+ 5.0000000000000002e-14 * ddt(V(cpphdl_n1616, Vss)); // Bench initial voltage = 0.0 V.
        // device 1172, IC IC201, analog/basic/strongarm_comparator.hpp:46
        I(cpphdl_n1612, Vss) <+ 5.0000000000000002e-14 * ddt(V(cpphdl_n1612, Vss)); // Bench initial voltage = 0.0 V.
        // device 1173, IC IC201, analog/basic/strongarm_comparator.hpp:47
        I(cpphdl_n1592, cpphdl_n1599) <+ 2e-14 * ddt(V(cpphdl_n1592, cpphdl_n1599)); // Bench initial voltage = 3.2999999999999998 V.
        // device 1174, IC IC201, analog/basic/strongarm_comparator.hpp:48
        I(cpphdl_n1593, cpphdl_n1599) <+ 2e-14 * ddt(V(cpphdl_n1593, cpphdl_n1599)); // Bench initial voltage = 3.2999999999999998 V.
        // device 1175, IC IC201, analog/basic/strongarm_comparator.hpp:49
        I(cpphdl_n1592, cpphdl_n1597) <+ 2.9999999999999998e-15 * ddt(V(cpphdl_n1592, cpphdl_n1597)); // Bench initial voltage = 3.2999999999999998 V.
        // device 1176, IC IC201, analog/basic/strongarm_comparator.hpp:50
        I(cpphdl_n1593, cpphdl_n1598) <+ 2.9999999999999998e-15 * ddt(V(cpphdl_n1593, cpphdl_n1598)); // Bench initial voltage = 3.2999999999999998 V.
        // device 1177, IC IC203, analog/basic/inverter.hpp:11
        I(cpphdl_n1620, Vdd) <+ cpphdl_channel(V(cpphdl_n1612, Vdd), V(cpphdl_n1620, Vdd), 0.001, 0.69999999999999996, -1.0);
        // device 1178, IC IC203, analog/basic/inverter.hpp:12
        I(cpphdl_n1620, Vss) <+ cpphdl_channel(V(cpphdl_n1612, Vss), V(cpphdl_n1620, Vss), 0.001, 0.69999999999999996, 1.0);
        // device 1179, IC IC205, analog/basic/inverter.hpp:11
        I(cpphdl_n1634, Vdd) <+ cpphdl_channel(V(cpphdl_n1620, Vdd), V(cpphdl_n1634, Vdd), 0.0040000000000000001, 0.69999999999999996, -1.0);
        // device 1180, IC IC205, analog/basic/inverter.hpp:12
        I(cpphdl_n1634, Vss) <+ cpphdl_channel(V(cpphdl_n1620, Vss), V(cpphdl_n1634, Vss), 0.0040000000000000001, 0.69999999999999996, 1.0);
        // device 1181, IC IC202, analog/basic/buffered_nand_latch.hpp:34
        I(cpphdl_n1612, Vss) <+ 2.0000000000000002e-15 * ddt(V(cpphdl_n1612, Vss)); // Bench initial voltage = 0.0 V.
        // device 1182, IC IC202, analog/basic/buffered_nand_latch.hpp:35
        I(cpphdl_n1612, cpphdl_n1620) <+ 1.0000000000000001e-15 * ddt(V(cpphdl_n1612, cpphdl_n1620)); // Bench initial voltage = 0.0 V.
        // device 1183, IC IC202, analog/basic/buffered_nand_latch.hpp:36
        I(cpphdl_n1620, Vss) <+ 5e-15 * ddt(V(cpphdl_n1620, Vss)); // Bench initial voltage = 0.0 V.
        // device 1184, IC IC202, analog/basic/buffered_nand_latch.hpp:37
        I(cpphdl_n1620, Vss) <+ 8.0000000000000006e-15 * ddt(V(cpphdl_n1620, Vss)); // Bench initial voltage = 0.0 V.
        // device 1185, IC IC202, analog/basic/buffered_nand_latch.hpp:38
        I(cpphdl_n1634, Vss) <+ 1e-14 * ddt(V(cpphdl_n1634, Vss)); // Bench initial voltage = 0.0 V.
        // device 1186, IC IC204, analog/basic/inverter.hpp:11
        I(cpphdl_n1624, Vdd) <+ cpphdl_channel(V(cpphdl_n1616, Vdd), V(cpphdl_n1624, Vdd), 0.001, 0.69999999999999996, -1.0);
        // device 1187, IC IC204, analog/basic/inverter.hpp:12
        I(cpphdl_n1624, Vss) <+ cpphdl_channel(V(cpphdl_n1616, Vss), V(cpphdl_n1624, Vss), 0.001, 0.69999999999999996, 1.0);
        // device 1188, IC IC206, analog/basic/inverter.hpp:11
        I(cpphdl_n1640, Vdd) <+ cpphdl_channel(V(cpphdl_n1624, Vdd), V(cpphdl_n1640, Vdd), 0.0040000000000000001, 0.69999999999999996, -1.0);
        // device 1189, IC IC206, analog/basic/inverter.hpp:12
        I(cpphdl_n1640, Vss) <+ cpphdl_channel(V(cpphdl_n1624, Vss), V(cpphdl_n1640, Vss), 0.0040000000000000001, 0.69999999999999996, 1.0);
        // device 1190, IC IC202, analog/basic/buffered_nand_latch.hpp:34
        I(cpphdl_n1616, Vss) <+ 2.0000000000000002e-15 * ddt(V(cpphdl_n1616, Vss)); // Bench initial voltage = 0.0 V.
        // device 1191, IC IC202, analog/basic/buffered_nand_latch.hpp:35
        I(cpphdl_n1616, cpphdl_n1624) <+ 1.0000000000000001e-15 * ddt(V(cpphdl_n1616, cpphdl_n1624)); // Bench initial voltage = 0.0 V.
        // device 1192, IC IC202, analog/basic/buffered_nand_latch.hpp:36
        I(cpphdl_n1624, Vss) <+ 5e-15 * ddt(V(cpphdl_n1624, Vss)); // Bench initial voltage = 0.0 V.
        // device 1193, IC IC202, analog/basic/buffered_nand_latch.hpp:37
        I(cpphdl_n1624, Vss) <+ 8.0000000000000006e-15 * ddt(V(cpphdl_n1624, Vss)); // Bench initial voltage = 0.0 V.
        // device 1194, IC IC202, analog/basic/buffered_nand_latch.hpp:38
        I(cpphdl_n1640, Vss) <+ 1e-14 * ddt(V(cpphdl_n1640, Vss)); // Bench initial voltage = 0.0 V.
        // device 1195, IC IC208, analog/basic/cmos_logic.hpp:17
        I(cpphdl_n2709, Vss) <+ 5.0000000000000002e-14 * ddt(V(cpphdl_n2709, Vss)); // Bench initial voltage = 0.0 V.
        // device 1196, IC IC208, analog/basic/cmos_logic.hpp:18
        I(cpphdl_n2709, Vdd) <+ cpphdl_channel(V(cpphdl_n1634, Vdd), V(cpphdl_n2709, Vdd), 0.01, 0.69999999999999996, -1.0);
        // device 1197, IC IC208, analog/basic/cmos_logic.hpp:19
        I(cpphdl_n2709, Vdd) <+ cpphdl_channel(V(cpphdl_n1642, Vdd), V(cpphdl_n2709, Vdd), 0.01, 0.69999999999999996, -1.0);
        // device 1198, IC IC208, analog/basic/cmos_logic.hpp:20
        I(cpphdl_n2709, cpphdl_n1637) <+ cpphdl_channel(V(cpphdl_n1634, cpphdl_n1637), V(cpphdl_n2709, cpphdl_n1637), 0.01, 0.69999999999999996, 1.0);
        // device 1199, IC IC208, analog/basic/cmos_logic.hpp:21
        I(cpphdl_n1637, Vss) <+ cpphdl_channel(V(cpphdl_n1642, Vss), V(cpphdl_n1637, Vss), 0.01, 0.69999999999999996, 1.0);
        // device 1200, IC IC208, analog/basic/cmos_logic.hpp:23
        I(cpphdl_n2709, Vss) <+ V(cpphdl_n2709, Vss) / 1000000000.0;
        // device 1201, IC IC208, analog/basic/cmos_logic.hpp:24
        I(cpphdl_n1637, Vss) <+ V(cpphdl_n1637, Vss) / 1000000000.0;
        // device 1202, IC IC209, analog/basic/cmos_logic.hpp:17
        I(cpphdl_n1642, Vss) <+ 5.0000000000000002e-14 * ddt(V(cpphdl_n1642, Vss)); // Bench initial voltage = 0.0 V.
        // device 1203, IC IC209, analog/basic/cmos_logic.hpp:18
        I(cpphdl_n1642, Vdd) <+ cpphdl_channel(V(cpphdl_n1640, Vdd), V(cpphdl_n1642, Vdd), 0.01, 0.69999999999999996, -1.0);
        // device 1204, IC IC209, analog/basic/cmos_logic.hpp:19
        I(cpphdl_n1642, Vdd) <+ cpphdl_channel(V(cpphdl_n2709, Vdd), V(cpphdl_n1642, Vdd), 0.01, 0.69999999999999996, -1.0);
        // device 1205, IC IC209, analog/basic/cmos_logic.hpp:20
        I(cpphdl_n1642, cpphdl_n1643) <+ cpphdl_channel(V(cpphdl_n1640, cpphdl_n1643), V(cpphdl_n1642, cpphdl_n1643), 0.01, 0.69999999999999996, 1.0);
        // device 1206, IC IC209, analog/basic/cmos_logic.hpp:21
        I(cpphdl_n1643, Vss) <+ cpphdl_channel(V(cpphdl_n2709, Vss), V(cpphdl_n1643, Vss), 0.01, 0.69999999999999996, 1.0);
        // device 1207, IC IC209, analog/basic/cmos_logic.hpp:23
        I(cpphdl_n1642, Vss) <+ V(cpphdl_n1642, Vss) / 1000000000.0;
        // device 1208, IC IC209, analog/basic/cmos_logic.hpp:24
        I(cpphdl_n1643, Vss) <+ V(cpphdl_n1643, Vss) / 1000000000.0;
        // device 1209, IC IC207, analog/basic/nand_latch.hpp:36
        I(cpphdl_n1634, Vss) <+ 2.9999999999999998e-15 * ddt(V(cpphdl_n1634, Vss)); // Bench initial voltage = 0.0 V.
        // device 1210, IC IC207, analog/basic/nand_latch.hpp:37
        I(cpphdl_n1640, Vss) <+ 2.9999999999999998e-15 * ddt(V(cpphdl_n1640, Vss)); // Bench initial voltage = 0.0 V.
        // device 1211, IC IC210, analog/basic/inverter.hpp:11
        I(cpphdl_n1648, Vdd) <+ cpphdl_channel(V(CLEAR, Vdd), V(cpphdl_n1648, Vdd), 0.01, 0.69999999999999996, -1.0);
        // device 1212, IC IC210, analog/basic/inverter.hpp:12
        I(cpphdl_n1648, Vss) <+ cpphdl_channel(V(CLEAR, Vss), V(cpphdl_n1648, Vss), 0.01, 0.69999999999999996, 1.0);
        // device 1213, IC IC207, analog/basic/nand_latch.hpp:58
        I(cpphdl_n1648, Vss) <+ 2.9999999999999998e-15 * ddt(V(cpphdl_n1648, Vss)); // Bench initial voltage = 0.0 V.
        // device 1214, IC IC207, analog/basic/nand_latch.hpp:59
        I(cpphdl_n2709, Vss) <+ cpphdl_channel(V(CLEAR, Vss), V(cpphdl_n2709, Vss), 0.050000000000000003, 0.69999999999999996, 1.0);
        // device 1215, IC IC207, analog/basic/nand_latch.hpp:60
        I(cpphdl_n1642, Vdd) <+ cpphdl_channel(V(cpphdl_n1648, Vdd), V(cpphdl_n1642, Vdd), 0.050000000000000003, 0.69999999999999996, -1.0);
        // device 1216, IC IC213, analog/basic/inverter.hpp:11
        I(cpphdl_n1672, Vdd) <+ cpphdl_channel(V(TRACK9, Vdd), V(cpphdl_n1672, Vdd), 0.0040000000000000001, 0.69999999999999996, -1.0);
        // device 1217, IC IC213, analog/basic/inverter.hpp:12
        I(cpphdl_n1672, Vss) <+ cpphdl_channel(V(TRACK9, Vss), V(cpphdl_n1672, Vss), 0.0040000000000000001, 0.69999999999999996, 1.0);
        // device 1218, IC IC212, analog/basic/mos_track_hold.hpp:31
        I(cpphdl_n1672, Vss) <+ 2e-14 * ddt(V(cpphdl_n1672, Vss)); // Bench initial voltage = 3.2999999999999998 V.
        // device 1219, IC IC212, analog/basic/mos_track_hold.hpp:32
        I(cpphdl_n2759, cpphdl_n1726) <+ cpphdl_channel(V(TRACK9, cpphdl_n1726), V(cpphdl_n2759, cpphdl_n1726), 0.080000000000000002, 0.69999999999999996, 1.0);
        // device 1220, IC IC212, analog/basic/mos_track_hold.hpp:33
        I(cpphdl_n1726, cpphdl_n2759) <+ cpphdl_channel(V(cpphdl_n1672, cpphdl_n2759), V(cpphdl_n1726, cpphdl_n2759), 0.040000000000000001, 0.69999999999999996, -1.0);
        // device 1221, IC IC212, analog/basic/mos_track_hold.hpp:37
        I(cpphdl_n1726, cpphdl_n1726) <+ cpphdl_channel(V(cpphdl_n1672, cpphdl_n1726), V(cpphdl_n1726, cpphdl_n1726), 0.040000000000000001, 0.69999999999999996, 1.0);
        // device 1222, IC IC212, analog/basic/mos_track_hold.hpp:38
        I(cpphdl_n1726, cpphdl_n1726) <+ cpphdl_channel(V(TRACK9, cpphdl_n1726), V(cpphdl_n1726, cpphdl_n1726), 0.02, 0.69999999999999996, -1.0);
        // device 1223, IC IC212, analog/basic/mos_track_hold.hpp:39
        I(cpphdl_n1726, Vss) <+ 3.0000000000000001e-12 * ddt(V(cpphdl_n1726, Vss)); // Bench initial voltage = 1.6499999999999999 V.
        // device 1224, IC IC212, analog/basic/mos_track_hold.hpp:41
        I(Vss, cpphdl_n1726) <+ V(Vss, cpphdl_n1726) / 1000000000.0;
        // device 1225, IC IC212, analog/basic/mos_track_hold.hpp:42
        I(TRACK9, cpphdl_n1726) <+ 8.0000000000000006e-15 * ddt(V(TRACK9, cpphdl_n1726)); // Bench initial voltage = -1.6499999999999999 V.
        // device 1226, IC IC212, analog/basic/mos_track_hold.hpp:43
        I(cpphdl_n1672, cpphdl_n1726) <+ 8.0000000000000006e-15 * ddt(V(cpphdl_n1672, cpphdl_n1726)); // Bench initial voltage = 1.6499999999999999 V.
        // device 1227, IC IC212, analog/basic/mos_track_hold.hpp:44
        I(cpphdl_n2759, cpphdl_n1726) <+ 4.0000000000000003e-15 * ddt(V(cpphdl_n2759, cpphdl_n1726)); // Bench initial voltage = 0.0 V.
        // device 1228, IC IC215, analog/basic/inverter.hpp:11
        I(cpphdl_n1687, Vdd) <+ cpphdl_channel(V(BIT_N9_0, Vdd), V(cpphdl_n1687, Vdd), 0.080000000000000002, 0.69999999999999996, -1.0);
        // device 1229, IC IC215, analog/basic/inverter.hpp:12
        I(cpphdl_n1687, Vss) <+ cpphdl_channel(V(BIT_N9_0, Vss), V(cpphdl_n1687, Vss), 0.080000000000000002, 0.69999999999999996, 1.0);
        // device 1230, IC IC214, analog/basic/mos_r2r_dac.hpp:27
        I(cpphdl_n1687, Vss) <+ 2.9999999999999998e-15 * ddt(V(cpphdl_n1687, Vss)); // Bench initial voltage = 0.0 V.
        // device 1231, IC IC214, analog/basic/mos_r2r_dac.hpp:28
        I(cpphdl_n1687, cpphdl_n1716) <+ V(cpphdl_n1687, cpphdl_n1716) / 2000.0;
        // device 1232, IC IC214, analog/basic/mos_r2r_dac.hpp:29
        I(cpphdl_n1716, Vss) <+ 2.9999999999999998e-15 * ddt(V(cpphdl_n1716, Vss)); // Bench initial voltage = 0.0 V.
        // device 1233, IC IC216, analog/basic/inverter.hpp:11
        I(cpphdl_n1691, Vdd) <+ cpphdl_channel(V(BIT_N9_1, Vdd), V(cpphdl_n1691, Vdd), 0.080000000000000002, 0.69999999999999996, -1.0);
        // device 1234, IC IC216, analog/basic/inverter.hpp:12
        I(cpphdl_n1691, Vss) <+ cpphdl_channel(V(BIT_N9_1, Vss), V(cpphdl_n1691, Vss), 0.080000000000000002, 0.69999999999999996, 1.0);
        // device 1235, IC IC214, analog/basic/mos_r2r_dac.hpp:27
        I(cpphdl_n1691, Vss) <+ 2.9999999999999998e-15 * ddt(V(cpphdl_n1691, Vss)); // Bench initial voltage = 0.0 V.
        // device 1236, IC IC214, analog/basic/mos_r2r_dac.hpp:28
        I(cpphdl_n1691, cpphdl_n1717) <+ V(cpphdl_n1691, cpphdl_n1717) / 2000.0;
        // device 1237, IC IC214, analog/basic/mos_r2r_dac.hpp:29
        I(cpphdl_n1717, Vss) <+ 2.9999999999999998e-15 * ddt(V(cpphdl_n1717, Vss)); // Bench initial voltage = 0.0 V.
        // device 1238, IC IC214, analog/basic/mos_r2r_dac.hpp:31
        I(cpphdl_n1716, cpphdl_n1717) <+ V(cpphdl_n1716, cpphdl_n1717) / 1000.0;
        // device 1239, IC IC217, analog/basic/inverter.hpp:11
        I(cpphdl_n1695, Vdd) <+ cpphdl_channel(V(BIT_N9_2, Vdd), V(cpphdl_n1695, Vdd), 0.080000000000000002, 0.69999999999999996, -1.0);
        // device 1240, IC IC217, analog/basic/inverter.hpp:12
        I(cpphdl_n1695, Vss) <+ cpphdl_channel(V(BIT_N9_2, Vss), V(cpphdl_n1695, Vss), 0.080000000000000002, 0.69999999999999996, 1.0);
        // device 1241, IC IC214, analog/basic/mos_r2r_dac.hpp:27
        I(cpphdl_n1695, Vss) <+ 2.9999999999999998e-15 * ddt(V(cpphdl_n1695, Vss)); // Bench initial voltage = 0.0 V.
        // device 1242, IC IC214, analog/basic/mos_r2r_dac.hpp:28
        I(cpphdl_n1695, cpphdl_n1718) <+ V(cpphdl_n1695, cpphdl_n1718) / 2000.0;
        // device 1243, IC IC214, analog/basic/mos_r2r_dac.hpp:29
        I(cpphdl_n1718, Vss) <+ 2.9999999999999998e-15 * ddt(V(cpphdl_n1718, Vss)); // Bench initial voltage = 0.0 V.
        // device 1244, IC IC214, analog/basic/mos_r2r_dac.hpp:31
        I(cpphdl_n1717, cpphdl_n1718) <+ V(cpphdl_n1717, cpphdl_n1718) / 1000.0;
        // device 1245, IC IC218, analog/basic/inverter.hpp:11
        I(cpphdl_n1699, Vdd) <+ cpphdl_channel(V(BIT_N9_3, Vdd), V(cpphdl_n1699, Vdd), 0.080000000000000002, 0.69999999999999996, -1.0);
        // device 1246, IC IC218, analog/basic/inverter.hpp:12
        I(cpphdl_n1699, Vss) <+ cpphdl_channel(V(BIT_N9_3, Vss), V(cpphdl_n1699, Vss), 0.080000000000000002, 0.69999999999999996, 1.0);
        // device 1247, IC IC214, analog/basic/mos_r2r_dac.hpp:27
        I(cpphdl_n1699, Vss) <+ 2.9999999999999998e-15 * ddt(V(cpphdl_n1699, Vss)); // Bench initial voltage = 0.0 V.
        // device 1248, IC IC214, analog/basic/mos_r2r_dac.hpp:28
        I(cpphdl_n1699, cpphdl_n1719) <+ V(cpphdl_n1699, cpphdl_n1719) / 2000.0;
        // device 1249, IC IC214, analog/basic/mos_r2r_dac.hpp:29
        I(cpphdl_n1719, Vss) <+ 2.9999999999999998e-15 * ddt(V(cpphdl_n1719, Vss)); // Bench initial voltage = 0.0 V.
        // device 1250, IC IC214, analog/basic/mos_r2r_dac.hpp:31
        I(cpphdl_n1718, cpphdl_n1719) <+ V(cpphdl_n1718, cpphdl_n1719) / 1000.0;
        // device 1251, IC IC219, analog/basic/inverter.hpp:11
        I(cpphdl_n1703, Vdd) <+ cpphdl_channel(V(BIT_N9_4, Vdd), V(cpphdl_n1703, Vdd), 0.080000000000000002, 0.69999999999999996, -1.0);
        // device 1252, IC IC219, analog/basic/inverter.hpp:12
        I(cpphdl_n1703, Vss) <+ cpphdl_channel(V(BIT_N9_4, Vss), V(cpphdl_n1703, Vss), 0.080000000000000002, 0.69999999999999996, 1.0);
        // device 1253, IC IC214, analog/basic/mos_r2r_dac.hpp:27
        I(cpphdl_n1703, Vss) <+ 2.9999999999999998e-15 * ddt(V(cpphdl_n1703, Vss)); // Bench initial voltage = 0.0 V.
        // device 1254, IC IC214, analog/basic/mos_r2r_dac.hpp:28
        I(cpphdl_n1703, cpphdl_n1720) <+ V(cpphdl_n1703, cpphdl_n1720) / 2000.0;
        // device 1255, IC IC214, analog/basic/mos_r2r_dac.hpp:29
        I(cpphdl_n1720, Vss) <+ 2.9999999999999998e-15 * ddt(V(cpphdl_n1720, Vss)); // Bench initial voltage = 0.0 V.
        // device 1256, IC IC214, analog/basic/mos_r2r_dac.hpp:31
        I(cpphdl_n1719, cpphdl_n1720) <+ V(cpphdl_n1719, cpphdl_n1720) / 1000.0;
        // device 1257, IC IC220, analog/basic/inverter.hpp:11
        I(cpphdl_n1707, Vdd) <+ cpphdl_channel(V(BIT_N9_5, Vdd), V(cpphdl_n1707, Vdd), 0.080000000000000002, 0.69999999999999996, -1.0);
        // device 1258, IC IC220, analog/basic/inverter.hpp:12
        I(cpphdl_n1707, Vss) <+ cpphdl_channel(V(BIT_N9_5, Vss), V(cpphdl_n1707, Vss), 0.080000000000000002, 0.69999999999999996, 1.0);
        // device 1259, IC IC214, analog/basic/mos_r2r_dac.hpp:27
        I(cpphdl_n1707, Vss) <+ 2.9999999999999998e-15 * ddt(V(cpphdl_n1707, Vss)); // Bench initial voltage = 0.0 V.
        // device 1260, IC IC214, analog/basic/mos_r2r_dac.hpp:28
        I(cpphdl_n1707, cpphdl_n1721) <+ V(cpphdl_n1707, cpphdl_n1721) / 2000.0;
        // device 1261, IC IC214, analog/basic/mos_r2r_dac.hpp:29
        I(cpphdl_n1721, Vss) <+ 2.9999999999999998e-15 * ddt(V(cpphdl_n1721, Vss)); // Bench initial voltage = 0.0 V.
        // device 1262, IC IC214, analog/basic/mos_r2r_dac.hpp:31
        I(cpphdl_n1720, cpphdl_n1721) <+ V(cpphdl_n1720, cpphdl_n1721) / 1000.0;
        // device 1263, IC IC221, analog/basic/inverter.hpp:11
        I(cpphdl_n1711, Vdd) <+ cpphdl_channel(V(BIT_N9_6, Vdd), V(cpphdl_n1711, Vdd), 0.080000000000000002, 0.69999999999999996, -1.0);
        // device 1264, IC IC221, analog/basic/inverter.hpp:12
        I(cpphdl_n1711, Vss) <+ cpphdl_channel(V(BIT_N9_6, Vss), V(cpphdl_n1711, Vss), 0.080000000000000002, 0.69999999999999996, 1.0);
        // device 1265, IC IC214, analog/basic/mos_r2r_dac.hpp:27
        I(cpphdl_n1711, Vss) <+ 2.9999999999999998e-15 * ddt(V(cpphdl_n1711, Vss)); // Bench initial voltage = 0.0 V.
        // device 1266, IC IC214, analog/basic/mos_r2r_dac.hpp:28
        I(cpphdl_n1711, cpphdl_n1722) <+ V(cpphdl_n1711, cpphdl_n1722) / 2000.0;
        // device 1267, IC IC214, analog/basic/mos_r2r_dac.hpp:29
        I(cpphdl_n1722, Vss) <+ 2.9999999999999998e-15 * ddt(V(cpphdl_n1722, Vss)); // Bench initial voltage = 0.0 V.
        // device 1268, IC IC214, analog/basic/mos_r2r_dac.hpp:31
        I(cpphdl_n1721, cpphdl_n1722) <+ V(cpphdl_n1721, cpphdl_n1722) / 1000.0;
        // device 1269, IC IC222, analog/basic/inverter.hpp:11
        I(cpphdl_n1715, Vdd) <+ cpphdl_channel(V(BIT_N9_7, Vdd), V(cpphdl_n1715, Vdd), 0.080000000000000002, 0.69999999999999996, -1.0);
        // device 1270, IC IC222, analog/basic/inverter.hpp:12
        I(cpphdl_n1715, Vss) <+ cpphdl_channel(V(BIT_N9_7, Vss), V(cpphdl_n1715, Vss), 0.080000000000000002, 0.69999999999999996, 1.0);
        // device 1271, IC IC214, analog/basic/mos_r2r_dac.hpp:27
        I(cpphdl_n1715, Vss) <+ 2.9999999999999998e-15 * ddt(V(cpphdl_n1715, Vss)); // Bench initial voltage = 0.0 V.
        // device 1272, IC IC214, analog/basic/mos_r2r_dac.hpp:28
        I(cpphdl_n1715, cpphdl_n1727) <+ V(cpphdl_n1715, cpphdl_n1727) / 2000.0;
        // device 1273, IC IC214, analog/basic/mos_r2r_dac.hpp:29
        I(cpphdl_n1727, Vss) <+ 2.9999999999999998e-15 * ddt(V(cpphdl_n1727, Vss)); // Bench initial voltage = 0.0 V.
        // device 1274, IC IC214, analog/basic/mos_r2r_dac.hpp:31
        I(cpphdl_n1722, cpphdl_n1727) <+ V(cpphdl_n1722, cpphdl_n1727) / 1000.0;
        // device 1275, IC IC214, analog/basic/mos_r2r_dac.hpp:33
        I(Vss, cpphdl_n1716) <+ V(Vss, cpphdl_n1716) / 2000.0;
        // device 1276, IC IC223, analog/basic/nmos_resistor_amplifier.hpp:23
        I(Vdd, cpphdl_n1736) <+ V(Vdd, cpphdl_n1736) / 500.0;
        // device 1277, IC IC223, analog/basic/nmos_resistor_amplifier.hpp:24
        I(Vdd, cpphdl_n1735) <+ V(Vdd, cpphdl_n1735) / 500.0;
        // device 1278, IC IC223, analog/basic/nmos_resistor_amplifier.hpp:25
        I(cpphdl_n1736, cpphdl_n1730) <+ cpphdl_channel(V(cpphdl_n1726, cpphdl_n1730), V(cpphdl_n1736, cpphdl_n1730), 0.014999999999999999, 0.69999999999999996, 1.0);
        // device 1279, IC IC223, analog/basic/nmos_resistor_amplifier.hpp:26
        I(cpphdl_n1735, cpphdl_n1731) <+ cpphdl_channel(V(cpphdl_n1727, cpphdl_n1731), V(cpphdl_n1735, cpphdl_n1731), 0.014999999999999999, 0.69999999999999996, 1.0);
        // device 1280, IC IC223, analog/basic/nmos_resistor_amplifier.hpp:27
        I(cpphdl_n1732, cpphdl_n1730) <+ V(cpphdl_n1732, cpphdl_n1730) / 50.0;
        // device 1281, IC IC223, analog/basic/nmos_resistor_amplifier.hpp:28
        I(cpphdl_n1732, cpphdl_n1731) <+ V(cpphdl_n1732, cpphdl_n1731) / 50.0;
        // device 1282, IC IC223, analog/basic/nmos_resistor_amplifier.hpp:29
        I(Vss, cpphdl_n1732) <+ V(Vss, cpphdl_n1732) / 150.0;
        // device 1283, IC IC223, analog/basic/nmos_resistor_amplifier.hpp:30
        I(cpphdl_n1736, Vdd) <+ 2.9999999999999998e-13 * ddt(V(cpphdl_n1736, Vdd)); // Bench initial voltage = 0.0 V.
        // device 1284, IC IC223, analog/basic/nmos_resistor_amplifier.hpp:31
        I(cpphdl_n1735, Vdd) <+ 2.9999999999999998e-13 * ddt(V(cpphdl_n1735, Vdd)); // Bench initial voltage = 0.0 V.
        // device 1285, IC IC223, analog/basic/nmos_resistor_amplifier.hpp:32
        I(cpphdl_n1732, Vss) <+ 4e-14 * ddt(V(cpphdl_n1732, Vss)); // Bench initial voltage = 0.0 V.
        // device 1286, IC IC223, analog/basic/nmos_resistor_amplifier.hpp:34
        I(cpphdl_n1726, cpphdl_n1730) <+ 2e-14 * ddt(V(cpphdl_n1726, cpphdl_n1730)); // Bench initial voltage = 1.6499999999999999 V.
        // device 1287, IC IC223, analog/basic/nmos_resistor_amplifier.hpp:35
        I(cpphdl_n1727, cpphdl_n1731) <+ 2e-14 * ddt(V(cpphdl_n1727, cpphdl_n1731)); // Bench initial voltage = 0.0 V.
        // device 1288, IC IC223, analog/basic/nmos_resistor_amplifier.hpp:36
        I(cpphdl_n1726, cpphdl_n1736) <+ 2.9999999999999998e-15 * ddt(V(cpphdl_n1726, cpphdl_n1736)); // Bench initial voltage = -1.6499999999999999 V.
        // device 1289, IC IC223, analog/basic/nmos_resistor_amplifier.hpp:37
        I(cpphdl_n1727, cpphdl_n1735) <+ 2.9999999999999998e-15 * ddt(V(cpphdl_n1727, cpphdl_n1735)); // Bench initial voltage = -3.2999999999999998 V.
        // device 1290, IC IC224, analog/basic/strongarm_comparator.hpp:28
        I(cpphdl_n1740, cpphdl_n1742) <+ cpphdl_channel(V(cpphdl_n1735, cpphdl_n1742), V(cpphdl_n1740, cpphdl_n1742), 0.0080000000000000002, 0.69999999999999996, 1.0);
        // device 1291, IC IC224, analog/basic/strongarm_comparator.hpp:29
        I(cpphdl_n1741, cpphdl_n1742) <+ cpphdl_channel(V(cpphdl_n1736, cpphdl_n1742), V(cpphdl_n1741, cpphdl_n1742), 0.0080000000000000002, 0.69999999999999996, 1.0);
        // device 1292, IC IC224, analog/basic/strongarm_comparator.hpp:30
        I(cpphdl_n1742, Vss) <+ cpphdl_channel(V(EVALUATE, Vss), V(cpphdl_n1742, Vss), 0.0080000000000000002, 0.69999999999999996, 1.0);
        // device 1293, IC IC224, analog/basic/strongarm_comparator.hpp:33
        I(cpphdl_n1755, cpphdl_n1740) <+ cpphdl_channel(V(cpphdl_n1759, cpphdl_n1740), V(cpphdl_n1755, cpphdl_n1740), 0.0040000000000000001, 0.69999999999999996, 1.0);
        // device 1294, IC IC224, analog/basic/strongarm_comparator.hpp:34
        I(cpphdl_n1759, cpphdl_n1741) <+ cpphdl_channel(V(cpphdl_n1755, cpphdl_n1741), V(cpphdl_n1759, cpphdl_n1741), 0.0040000000000000001, 0.69999999999999996, 1.0);
        // device 1295, IC IC224, analog/basic/strongarm_comparator.hpp:35
        I(cpphdl_n1759, Vdd) <+ cpphdl_channel(V(cpphdl_n1755, Vdd), V(cpphdl_n1759, Vdd), 0.002, 0.69999999999999996, -1.0);
        // device 1296, IC IC224, analog/basic/strongarm_comparator.hpp:36
        I(cpphdl_n1755, Vdd) <+ cpphdl_channel(V(cpphdl_n1759, Vdd), V(cpphdl_n1755, Vdd), 0.002, 0.69999999999999996, -1.0);
        // device 1297, IC IC224, analog/basic/strongarm_comparator.hpp:38
        I(cpphdl_n1740, Vdd) <+ cpphdl_channel(V(EVALUATE, Vdd), V(cpphdl_n1740, Vdd), 0.002, 0.69999999999999996, -1.0);
        // device 1298, IC IC224, analog/basic/strongarm_comparator.hpp:39
        I(cpphdl_n1741, Vdd) <+ cpphdl_channel(V(EVALUATE, Vdd), V(cpphdl_n1741, Vdd), 0.002, 0.69999999999999996, -1.0);
        // device 1299, IC IC224, analog/basic/strongarm_comparator.hpp:40
        I(cpphdl_n1759, Vdd) <+ cpphdl_channel(V(EVALUATE, Vdd), V(cpphdl_n1759, Vdd), 0.002, 0.69999999999999996, -1.0);
        // device 1300, IC IC224, analog/basic/strongarm_comparator.hpp:41
        I(cpphdl_n1755, Vdd) <+ cpphdl_channel(V(EVALUATE, Vdd), V(cpphdl_n1755, Vdd), 0.002, 0.69999999999999996, -1.0);
        // device 1301, IC IC224, analog/basic/strongarm_comparator.hpp:42
        I(cpphdl_n1740, Vss) <+ 2.9999999999999998e-14 * ddt(V(cpphdl_n1740, Vss)); // Bench initial voltage = 0.0 V.
        // device 1302, IC IC224, analog/basic/strongarm_comparator.hpp:43
        I(cpphdl_n1741, Vss) <+ 2.9999999999999998e-14 * ddt(V(cpphdl_n1741, Vss)); // Bench initial voltage = 0.0 V.
        // device 1303, IC IC224, analog/basic/strongarm_comparator.hpp:44
        I(cpphdl_n1742, Vss) <+ 2.9999999999999998e-14 * ddt(V(cpphdl_n1742, Vss)); // Bench initial voltage = 0.0 V.
        // device 1304, IC IC224, analog/basic/strongarm_comparator.hpp:45
        I(cpphdl_n1759, Vss) <+ 5.0000000000000002e-14 * ddt(V(cpphdl_n1759, Vss)); // Bench initial voltage = 0.0 V.
        // device 1305, IC IC224, analog/basic/strongarm_comparator.hpp:46
        I(cpphdl_n1755, Vss) <+ 5.0000000000000002e-14 * ddt(V(cpphdl_n1755, Vss)); // Bench initial voltage = 0.0 V.
        // device 1306, IC IC224, analog/basic/strongarm_comparator.hpp:47
        I(cpphdl_n1735, cpphdl_n1742) <+ 2e-14 * ddt(V(cpphdl_n1735, cpphdl_n1742)); // Bench initial voltage = 3.2999999999999998 V.
        // device 1307, IC IC224, analog/basic/strongarm_comparator.hpp:48
        I(cpphdl_n1736, cpphdl_n1742) <+ 2e-14 * ddt(V(cpphdl_n1736, cpphdl_n1742)); // Bench initial voltage = 3.2999999999999998 V.
        // device 1308, IC IC224, analog/basic/strongarm_comparator.hpp:49
        I(cpphdl_n1735, cpphdl_n1740) <+ 2.9999999999999998e-15 * ddt(V(cpphdl_n1735, cpphdl_n1740)); // Bench initial voltage = 3.2999999999999998 V.
        // device 1309, IC IC224, analog/basic/strongarm_comparator.hpp:50
        I(cpphdl_n1736, cpphdl_n1741) <+ 2.9999999999999998e-15 * ddt(V(cpphdl_n1736, cpphdl_n1741)); // Bench initial voltage = 3.2999999999999998 V.
        // device 1310, IC IC226, analog/basic/inverter.hpp:11
        I(cpphdl_n1763, Vdd) <+ cpphdl_channel(V(cpphdl_n1755, Vdd), V(cpphdl_n1763, Vdd), 0.001, 0.69999999999999996, -1.0);
        // device 1311, IC IC226, analog/basic/inverter.hpp:12
        I(cpphdl_n1763, Vss) <+ cpphdl_channel(V(cpphdl_n1755, Vss), V(cpphdl_n1763, Vss), 0.001, 0.69999999999999996, 1.0);
        // device 1312, IC IC228, analog/basic/inverter.hpp:11
        I(cpphdl_n1777, Vdd) <+ cpphdl_channel(V(cpphdl_n1763, Vdd), V(cpphdl_n1777, Vdd), 0.0040000000000000001, 0.69999999999999996, -1.0);
        // device 1313, IC IC228, analog/basic/inverter.hpp:12
        I(cpphdl_n1777, Vss) <+ cpphdl_channel(V(cpphdl_n1763, Vss), V(cpphdl_n1777, Vss), 0.0040000000000000001, 0.69999999999999996, 1.0);
        // device 1314, IC IC225, analog/basic/buffered_nand_latch.hpp:34
        I(cpphdl_n1755, Vss) <+ 2.0000000000000002e-15 * ddt(V(cpphdl_n1755, Vss)); // Bench initial voltage = 0.0 V.
        // device 1315, IC IC225, analog/basic/buffered_nand_latch.hpp:35
        I(cpphdl_n1755, cpphdl_n1763) <+ 1.0000000000000001e-15 * ddt(V(cpphdl_n1755, cpphdl_n1763)); // Bench initial voltage = 0.0 V.
        // device 1316, IC IC225, analog/basic/buffered_nand_latch.hpp:36
        I(cpphdl_n1763, Vss) <+ 5e-15 * ddt(V(cpphdl_n1763, Vss)); // Bench initial voltage = 0.0 V.
        // device 1317, IC IC225, analog/basic/buffered_nand_latch.hpp:37
        I(cpphdl_n1763, Vss) <+ 8.0000000000000006e-15 * ddt(V(cpphdl_n1763, Vss)); // Bench initial voltage = 0.0 V.
        // device 1318, IC IC225, analog/basic/buffered_nand_latch.hpp:38
        I(cpphdl_n1777, Vss) <+ 1e-14 * ddt(V(cpphdl_n1777, Vss)); // Bench initial voltage = 0.0 V.
        // device 1319, IC IC227, analog/basic/inverter.hpp:11
        I(cpphdl_n1767, Vdd) <+ cpphdl_channel(V(cpphdl_n1759, Vdd), V(cpphdl_n1767, Vdd), 0.001, 0.69999999999999996, -1.0);
        // device 1320, IC IC227, analog/basic/inverter.hpp:12
        I(cpphdl_n1767, Vss) <+ cpphdl_channel(V(cpphdl_n1759, Vss), V(cpphdl_n1767, Vss), 0.001, 0.69999999999999996, 1.0);
        // device 1321, IC IC229, analog/basic/inverter.hpp:11
        I(cpphdl_n1783, Vdd) <+ cpphdl_channel(V(cpphdl_n1767, Vdd), V(cpphdl_n1783, Vdd), 0.0040000000000000001, 0.69999999999999996, -1.0);
        // device 1322, IC IC229, analog/basic/inverter.hpp:12
        I(cpphdl_n1783, Vss) <+ cpphdl_channel(V(cpphdl_n1767, Vss), V(cpphdl_n1783, Vss), 0.0040000000000000001, 0.69999999999999996, 1.0);
        // device 1323, IC IC225, analog/basic/buffered_nand_latch.hpp:34
        I(cpphdl_n1759, Vss) <+ 2.0000000000000002e-15 * ddt(V(cpphdl_n1759, Vss)); // Bench initial voltage = 0.0 V.
        // device 1324, IC IC225, analog/basic/buffered_nand_latch.hpp:35
        I(cpphdl_n1759, cpphdl_n1767) <+ 1.0000000000000001e-15 * ddt(V(cpphdl_n1759, cpphdl_n1767)); // Bench initial voltage = 0.0 V.
        // device 1325, IC IC225, analog/basic/buffered_nand_latch.hpp:36
        I(cpphdl_n1767, Vss) <+ 5e-15 * ddt(V(cpphdl_n1767, Vss)); // Bench initial voltage = 0.0 V.
        // device 1326, IC IC225, analog/basic/buffered_nand_latch.hpp:37
        I(cpphdl_n1767, Vss) <+ 8.0000000000000006e-15 * ddt(V(cpphdl_n1767, Vss)); // Bench initial voltage = 0.0 V.
        // device 1327, IC IC225, analog/basic/buffered_nand_latch.hpp:38
        I(cpphdl_n1783, Vss) <+ 1e-14 * ddt(V(cpphdl_n1783, Vss)); // Bench initial voltage = 0.0 V.
        // device 1328, IC IC231, analog/basic/cmos_logic.hpp:17
        I(cpphdl_n2714, Vss) <+ 5.0000000000000002e-14 * ddt(V(cpphdl_n2714, Vss)); // Bench initial voltage = 0.0 V.
        // device 1329, IC IC231, analog/basic/cmos_logic.hpp:18
        I(cpphdl_n2714, Vdd) <+ cpphdl_channel(V(cpphdl_n1777, Vdd), V(cpphdl_n2714, Vdd), 0.01, 0.69999999999999996, -1.0);
        // device 1330, IC IC231, analog/basic/cmos_logic.hpp:19
        I(cpphdl_n2714, Vdd) <+ cpphdl_channel(V(cpphdl_n1785, Vdd), V(cpphdl_n2714, Vdd), 0.01, 0.69999999999999996, -1.0);
        // device 1331, IC IC231, analog/basic/cmos_logic.hpp:20
        I(cpphdl_n2714, cpphdl_n1780) <+ cpphdl_channel(V(cpphdl_n1777, cpphdl_n1780), V(cpphdl_n2714, cpphdl_n1780), 0.01, 0.69999999999999996, 1.0);
        // device 1332, IC IC231, analog/basic/cmos_logic.hpp:21
        I(cpphdl_n1780, Vss) <+ cpphdl_channel(V(cpphdl_n1785, Vss), V(cpphdl_n1780, Vss), 0.01, 0.69999999999999996, 1.0);
        // device 1333, IC IC231, analog/basic/cmos_logic.hpp:23
        I(cpphdl_n2714, Vss) <+ V(cpphdl_n2714, Vss) / 1000000000.0;
        // device 1334, IC IC231, analog/basic/cmos_logic.hpp:24
        I(cpphdl_n1780, Vss) <+ V(cpphdl_n1780, Vss) / 1000000000.0;
        // device 1335, IC IC232, analog/basic/cmos_logic.hpp:17
        I(cpphdl_n1785, Vss) <+ 5.0000000000000002e-14 * ddt(V(cpphdl_n1785, Vss)); // Bench initial voltage = 0.0 V.
        // device 1336, IC IC232, analog/basic/cmos_logic.hpp:18
        I(cpphdl_n1785, Vdd) <+ cpphdl_channel(V(cpphdl_n1783, Vdd), V(cpphdl_n1785, Vdd), 0.01, 0.69999999999999996, -1.0);
        // device 1337, IC IC232, analog/basic/cmos_logic.hpp:19
        I(cpphdl_n1785, Vdd) <+ cpphdl_channel(V(cpphdl_n2714, Vdd), V(cpphdl_n1785, Vdd), 0.01, 0.69999999999999996, -1.0);
        // device 1338, IC IC232, analog/basic/cmos_logic.hpp:20
        I(cpphdl_n1785, cpphdl_n1786) <+ cpphdl_channel(V(cpphdl_n1783, cpphdl_n1786), V(cpphdl_n1785, cpphdl_n1786), 0.01, 0.69999999999999996, 1.0);
        // device 1339, IC IC232, analog/basic/cmos_logic.hpp:21
        I(cpphdl_n1786, Vss) <+ cpphdl_channel(V(cpphdl_n2714, Vss), V(cpphdl_n1786, Vss), 0.01, 0.69999999999999996, 1.0);
        // device 1340, IC IC232, analog/basic/cmos_logic.hpp:23
        I(cpphdl_n1785, Vss) <+ V(cpphdl_n1785, Vss) / 1000000000.0;
        // device 1341, IC IC232, analog/basic/cmos_logic.hpp:24
        I(cpphdl_n1786, Vss) <+ V(cpphdl_n1786, Vss) / 1000000000.0;
        // device 1342, IC IC230, analog/basic/nand_latch.hpp:36
        I(cpphdl_n1777, Vss) <+ 2.9999999999999998e-15 * ddt(V(cpphdl_n1777, Vss)); // Bench initial voltage = 0.0 V.
        // device 1343, IC IC230, analog/basic/nand_latch.hpp:37
        I(cpphdl_n1783, Vss) <+ 2.9999999999999998e-15 * ddt(V(cpphdl_n1783, Vss)); // Bench initial voltage = 0.0 V.
        // device 1344, IC IC233, analog/basic/inverter.hpp:11
        I(cpphdl_n1791, Vdd) <+ cpphdl_channel(V(CLEAR, Vdd), V(cpphdl_n1791, Vdd), 0.01, 0.69999999999999996, -1.0);
        // device 1345, IC IC233, analog/basic/inverter.hpp:12
        I(cpphdl_n1791, Vss) <+ cpphdl_channel(V(CLEAR, Vss), V(cpphdl_n1791, Vss), 0.01, 0.69999999999999996, 1.0);
        // device 1346, IC IC230, analog/basic/nand_latch.hpp:58
        I(cpphdl_n1791, Vss) <+ 2.9999999999999998e-15 * ddt(V(cpphdl_n1791, Vss)); // Bench initial voltage = 0.0 V.
        // device 1347, IC IC230, analog/basic/nand_latch.hpp:59
        I(cpphdl_n2714, Vss) <+ cpphdl_channel(V(CLEAR, Vss), V(cpphdl_n2714, Vss), 0.050000000000000003, 0.69999999999999996, 1.0);
        // device 1348, IC IC230, analog/basic/nand_latch.hpp:60
        I(cpphdl_n1785, Vdd) <+ cpphdl_channel(V(cpphdl_n1791, Vdd), V(cpphdl_n1785, Vdd), 0.050000000000000003, 0.69999999999999996, -1.0);
        // device 1349, IC IC236, analog/basic/inverter.hpp:11
        I(cpphdl_n1815, Vdd) <+ cpphdl_channel(V(TRACK10, Vdd), V(cpphdl_n1815, Vdd), 0.0040000000000000001, 0.69999999999999996, -1.0);
        // device 1350, IC IC236, analog/basic/inverter.hpp:12
        I(cpphdl_n1815, Vss) <+ cpphdl_channel(V(TRACK10, Vss), V(cpphdl_n1815, Vss), 0.0040000000000000001, 0.69999999999999996, 1.0);
        // device 1351, IC IC235, analog/basic/mos_track_hold.hpp:31
        I(cpphdl_n1815, Vss) <+ 2e-14 * ddt(V(cpphdl_n1815, Vss)); // Bench initial voltage = 3.2999999999999998 V.
        // device 1352, IC IC235, analog/basic/mos_track_hold.hpp:32
        I(cpphdl_n2759, cpphdl_n1869) <+ cpphdl_channel(V(TRACK10, cpphdl_n1869), V(cpphdl_n2759, cpphdl_n1869), 0.080000000000000002, 0.69999999999999996, 1.0);
        // device 1353, IC IC235, analog/basic/mos_track_hold.hpp:33
        I(cpphdl_n1869, cpphdl_n2759) <+ cpphdl_channel(V(cpphdl_n1815, cpphdl_n2759), V(cpphdl_n1869, cpphdl_n2759), 0.040000000000000001, 0.69999999999999996, -1.0);
        // device 1354, IC IC235, analog/basic/mos_track_hold.hpp:37
        I(cpphdl_n1869, cpphdl_n1869) <+ cpphdl_channel(V(cpphdl_n1815, cpphdl_n1869), V(cpphdl_n1869, cpphdl_n1869), 0.040000000000000001, 0.69999999999999996, 1.0);
        // device 1355, IC IC235, analog/basic/mos_track_hold.hpp:38
        I(cpphdl_n1869, cpphdl_n1869) <+ cpphdl_channel(V(TRACK10, cpphdl_n1869), V(cpphdl_n1869, cpphdl_n1869), 0.02, 0.69999999999999996, -1.0);
        // device 1356, IC IC235, analog/basic/mos_track_hold.hpp:39
        I(cpphdl_n1869, Vss) <+ 3.0000000000000001e-12 * ddt(V(cpphdl_n1869, Vss)); // Bench initial voltage = 1.6499999999999999 V.
        // device 1357, IC IC235, analog/basic/mos_track_hold.hpp:41
        I(Vss, cpphdl_n1869) <+ V(Vss, cpphdl_n1869) / 1000000000.0;
        // device 1358, IC IC235, analog/basic/mos_track_hold.hpp:42
        I(TRACK10, cpphdl_n1869) <+ 8.0000000000000006e-15 * ddt(V(TRACK10, cpphdl_n1869)); // Bench initial voltage = -1.6499999999999999 V.
        // device 1359, IC IC235, analog/basic/mos_track_hold.hpp:43
        I(cpphdl_n1815, cpphdl_n1869) <+ 8.0000000000000006e-15 * ddt(V(cpphdl_n1815, cpphdl_n1869)); // Bench initial voltage = 1.6499999999999999 V.
        // device 1360, IC IC235, analog/basic/mos_track_hold.hpp:44
        I(cpphdl_n2759, cpphdl_n1869) <+ 4.0000000000000003e-15 * ddt(V(cpphdl_n2759, cpphdl_n1869)); // Bench initial voltage = 0.0 V.
        // device 1361, IC IC238, analog/basic/inverter.hpp:11
        I(cpphdl_n1830, Vdd) <+ cpphdl_channel(V(BIT_N10_0, Vdd), V(cpphdl_n1830, Vdd), 0.080000000000000002, 0.69999999999999996, -1.0);
        // device 1362, IC IC238, analog/basic/inverter.hpp:12
        I(cpphdl_n1830, Vss) <+ cpphdl_channel(V(BIT_N10_0, Vss), V(cpphdl_n1830, Vss), 0.080000000000000002, 0.69999999999999996, 1.0);
        // device 1363, IC IC237, analog/basic/mos_r2r_dac.hpp:27
        I(cpphdl_n1830, Vss) <+ 2.9999999999999998e-15 * ddt(V(cpphdl_n1830, Vss)); // Bench initial voltage = 0.0 V.
        // device 1364, IC IC237, analog/basic/mos_r2r_dac.hpp:28
        I(cpphdl_n1830, cpphdl_n1859) <+ V(cpphdl_n1830, cpphdl_n1859) / 2000.0;
        // device 1365, IC IC237, analog/basic/mos_r2r_dac.hpp:29
        I(cpphdl_n1859, Vss) <+ 2.9999999999999998e-15 * ddt(V(cpphdl_n1859, Vss)); // Bench initial voltage = 0.0 V.
        // device 1366, IC IC239, analog/basic/inverter.hpp:11
        I(cpphdl_n1834, Vdd) <+ cpphdl_channel(V(BIT_N10_1, Vdd), V(cpphdl_n1834, Vdd), 0.080000000000000002, 0.69999999999999996, -1.0);
        // device 1367, IC IC239, analog/basic/inverter.hpp:12
        I(cpphdl_n1834, Vss) <+ cpphdl_channel(V(BIT_N10_1, Vss), V(cpphdl_n1834, Vss), 0.080000000000000002, 0.69999999999999996, 1.0);
        // device 1368, IC IC237, analog/basic/mos_r2r_dac.hpp:27
        I(cpphdl_n1834, Vss) <+ 2.9999999999999998e-15 * ddt(V(cpphdl_n1834, Vss)); // Bench initial voltage = 0.0 V.
        // device 1369, IC IC237, analog/basic/mos_r2r_dac.hpp:28
        I(cpphdl_n1834, cpphdl_n1860) <+ V(cpphdl_n1834, cpphdl_n1860) / 2000.0;
        // device 1370, IC IC237, analog/basic/mos_r2r_dac.hpp:29
        I(cpphdl_n1860, Vss) <+ 2.9999999999999998e-15 * ddt(V(cpphdl_n1860, Vss)); // Bench initial voltage = 0.0 V.
        // device 1371, IC IC237, analog/basic/mos_r2r_dac.hpp:31
        I(cpphdl_n1859, cpphdl_n1860) <+ V(cpphdl_n1859, cpphdl_n1860) / 1000.0;
        // device 1372, IC IC240, analog/basic/inverter.hpp:11
        I(cpphdl_n1838, Vdd) <+ cpphdl_channel(V(BIT_N10_2, Vdd), V(cpphdl_n1838, Vdd), 0.080000000000000002, 0.69999999999999996, -1.0);
        // device 1373, IC IC240, analog/basic/inverter.hpp:12
        I(cpphdl_n1838, Vss) <+ cpphdl_channel(V(BIT_N10_2, Vss), V(cpphdl_n1838, Vss), 0.080000000000000002, 0.69999999999999996, 1.0);
        // device 1374, IC IC237, analog/basic/mos_r2r_dac.hpp:27
        I(cpphdl_n1838, Vss) <+ 2.9999999999999998e-15 * ddt(V(cpphdl_n1838, Vss)); // Bench initial voltage = 0.0 V.
        // device 1375, IC IC237, analog/basic/mos_r2r_dac.hpp:28
        I(cpphdl_n1838, cpphdl_n1861) <+ V(cpphdl_n1838, cpphdl_n1861) / 2000.0;
        // device 1376, IC IC237, analog/basic/mos_r2r_dac.hpp:29
        I(cpphdl_n1861, Vss) <+ 2.9999999999999998e-15 * ddt(V(cpphdl_n1861, Vss)); // Bench initial voltage = 0.0 V.
        // device 1377, IC IC237, analog/basic/mos_r2r_dac.hpp:31
        I(cpphdl_n1860, cpphdl_n1861) <+ V(cpphdl_n1860, cpphdl_n1861) / 1000.0;
        // device 1378, IC IC241, analog/basic/inverter.hpp:11
        I(cpphdl_n1842, Vdd) <+ cpphdl_channel(V(BIT_N10_3, Vdd), V(cpphdl_n1842, Vdd), 0.080000000000000002, 0.69999999999999996, -1.0);
        // device 1379, IC IC241, analog/basic/inverter.hpp:12
        I(cpphdl_n1842, Vss) <+ cpphdl_channel(V(BIT_N10_3, Vss), V(cpphdl_n1842, Vss), 0.080000000000000002, 0.69999999999999996, 1.0);
        // device 1380, IC IC237, analog/basic/mos_r2r_dac.hpp:27
        I(cpphdl_n1842, Vss) <+ 2.9999999999999998e-15 * ddt(V(cpphdl_n1842, Vss)); // Bench initial voltage = 0.0 V.
        // device 1381, IC IC237, analog/basic/mos_r2r_dac.hpp:28
        I(cpphdl_n1842, cpphdl_n1862) <+ V(cpphdl_n1842, cpphdl_n1862) / 2000.0;
        // device 1382, IC IC237, analog/basic/mos_r2r_dac.hpp:29
        I(cpphdl_n1862, Vss) <+ 2.9999999999999998e-15 * ddt(V(cpphdl_n1862, Vss)); // Bench initial voltage = 0.0 V.
        // device 1383, IC IC237, analog/basic/mos_r2r_dac.hpp:31
        I(cpphdl_n1861, cpphdl_n1862) <+ V(cpphdl_n1861, cpphdl_n1862) / 1000.0;
        // device 1384, IC IC242, analog/basic/inverter.hpp:11
        I(cpphdl_n1846, Vdd) <+ cpphdl_channel(V(BIT_N10_4, Vdd), V(cpphdl_n1846, Vdd), 0.080000000000000002, 0.69999999999999996, -1.0);
        // device 1385, IC IC242, analog/basic/inverter.hpp:12
        I(cpphdl_n1846, Vss) <+ cpphdl_channel(V(BIT_N10_4, Vss), V(cpphdl_n1846, Vss), 0.080000000000000002, 0.69999999999999996, 1.0);
        // device 1386, IC IC237, analog/basic/mos_r2r_dac.hpp:27
        I(cpphdl_n1846, Vss) <+ 2.9999999999999998e-15 * ddt(V(cpphdl_n1846, Vss)); // Bench initial voltage = 0.0 V.
        // device 1387, IC IC237, analog/basic/mos_r2r_dac.hpp:28
        I(cpphdl_n1846, cpphdl_n1863) <+ V(cpphdl_n1846, cpphdl_n1863) / 2000.0;
        // device 1388, IC IC237, analog/basic/mos_r2r_dac.hpp:29
        I(cpphdl_n1863, Vss) <+ 2.9999999999999998e-15 * ddt(V(cpphdl_n1863, Vss)); // Bench initial voltage = 0.0 V.
        // device 1389, IC IC237, analog/basic/mos_r2r_dac.hpp:31
        I(cpphdl_n1862, cpphdl_n1863) <+ V(cpphdl_n1862, cpphdl_n1863) / 1000.0;
        // device 1390, IC IC243, analog/basic/inverter.hpp:11
        I(cpphdl_n1850, Vdd) <+ cpphdl_channel(V(BIT_N10_5, Vdd), V(cpphdl_n1850, Vdd), 0.080000000000000002, 0.69999999999999996, -1.0);
        // device 1391, IC IC243, analog/basic/inverter.hpp:12
        I(cpphdl_n1850, Vss) <+ cpphdl_channel(V(BIT_N10_5, Vss), V(cpphdl_n1850, Vss), 0.080000000000000002, 0.69999999999999996, 1.0);
        // device 1392, IC IC237, analog/basic/mos_r2r_dac.hpp:27
        I(cpphdl_n1850, Vss) <+ 2.9999999999999998e-15 * ddt(V(cpphdl_n1850, Vss)); // Bench initial voltage = 0.0 V.
        // device 1393, IC IC237, analog/basic/mos_r2r_dac.hpp:28
        I(cpphdl_n1850, cpphdl_n1864) <+ V(cpphdl_n1850, cpphdl_n1864) / 2000.0;
        // device 1394, IC IC237, analog/basic/mos_r2r_dac.hpp:29
        I(cpphdl_n1864, Vss) <+ 2.9999999999999998e-15 * ddt(V(cpphdl_n1864, Vss)); // Bench initial voltage = 0.0 V.
        // device 1395, IC IC237, analog/basic/mos_r2r_dac.hpp:31
        I(cpphdl_n1863, cpphdl_n1864) <+ V(cpphdl_n1863, cpphdl_n1864) / 1000.0;
        // device 1396, IC IC244, analog/basic/inverter.hpp:11
        I(cpphdl_n1854, Vdd) <+ cpphdl_channel(V(BIT_N10_6, Vdd), V(cpphdl_n1854, Vdd), 0.080000000000000002, 0.69999999999999996, -1.0);
        // device 1397, IC IC244, analog/basic/inverter.hpp:12
        I(cpphdl_n1854, Vss) <+ cpphdl_channel(V(BIT_N10_6, Vss), V(cpphdl_n1854, Vss), 0.080000000000000002, 0.69999999999999996, 1.0);
        // device 1398, IC IC237, analog/basic/mos_r2r_dac.hpp:27
        I(cpphdl_n1854, Vss) <+ 2.9999999999999998e-15 * ddt(V(cpphdl_n1854, Vss)); // Bench initial voltage = 0.0 V.
        // device 1399, IC IC237, analog/basic/mos_r2r_dac.hpp:28
        I(cpphdl_n1854, cpphdl_n1865) <+ V(cpphdl_n1854, cpphdl_n1865) / 2000.0;
        // device 1400, IC IC237, analog/basic/mos_r2r_dac.hpp:29
        I(cpphdl_n1865, Vss) <+ 2.9999999999999998e-15 * ddt(V(cpphdl_n1865, Vss)); // Bench initial voltage = 0.0 V.
        // device 1401, IC IC237, analog/basic/mos_r2r_dac.hpp:31
        I(cpphdl_n1864, cpphdl_n1865) <+ V(cpphdl_n1864, cpphdl_n1865) / 1000.0;
        // device 1402, IC IC245, analog/basic/inverter.hpp:11
        I(cpphdl_n1858, Vdd) <+ cpphdl_channel(V(BIT_N10_7, Vdd), V(cpphdl_n1858, Vdd), 0.080000000000000002, 0.69999999999999996, -1.0);
        // device 1403, IC IC245, analog/basic/inverter.hpp:12
        I(cpphdl_n1858, Vss) <+ cpphdl_channel(V(BIT_N10_7, Vss), V(cpphdl_n1858, Vss), 0.080000000000000002, 0.69999999999999996, 1.0);
        // device 1404, IC IC237, analog/basic/mos_r2r_dac.hpp:27
        I(cpphdl_n1858, Vss) <+ 2.9999999999999998e-15 * ddt(V(cpphdl_n1858, Vss)); // Bench initial voltage = 0.0 V.
        // device 1405, IC IC237, analog/basic/mos_r2r_dac.hpp:28
        I(cpphdl_n1858, cpphdl_n1870) <+ V(cpphdl_n1858, cpphdl_n1870) / 2000.0;
        // device 1406, IC IC237, analog/basic/mos_r2r_dac.hpp:29
        I(cpphdl_n1870, Vss) <+ 2.9999999999999998e-15 * ddt(V(cpphdl_n1870, Vss)); // Bench initial voltage = 0.0 V.
        // device 1407, IC IC237, analog/basic/mos_r2r_dac.hpp:31
        I(cpphdl_n1865, cpphdl_n1870) <+ V(cpphdl_n1865, cpphdl_n1870) / 1000.0;
        // device 1408, IC IC237, analog/basic/mos_r2r_dac.hpp:33
        I(Vss, cpphdl_n1859) <+ V(Vss, cpphdl_n1859) / 2000.0;
        // device 1409, IC IC246, analog/basic/nmos_resistor_amplifier.hpp:23
        I(Vdd, cpphdl_n1879) <+ V(Vdd, cpphdl_n1879) / 500.0;
        // device 1410, IC IC246, analog/basic/nmos_resistor_amplifier.hpp:24
        I(Vdd, cpphdl_n1878) <+ V(Vdd, cpphdl_n1878) / 500.0;
        // device 1411, IC IC246, analog/basic/nmos_resistor_amplifier.hpp:25
        I(cpphdl_n1879, cpphdl_n1873) <+ cpphdl_channel(V(cpphdl_n1869, cpphdl_n1873), V(cpphdl_n1879, cpphdl_n1873), 0.014999999999999999, 0.69999999999999996, 1.0);
        // device 1412, IC IC246, analog/basic/nmos_resistor_amplifier.hpp:26
        I(cpphdl_n1878, cpphdl_n1874) <+ cpphdl_channel(V(cpphdl_n1870, cpphdl_n1874), V(cpphdl_n1878, cpphdl_n1874), 0.014999999999999999, 0.69999999999999996, 1.0);
        // device 1413, IC IC246, analog/basic/nmos_resistor_amplifier.hpp:27
        I(cpphdl_n1875, cpphdl_n1873) <+ V(cpphdl_n1875, cpphdl_n1873) / 50.0;
        // device 1414, IC IC246, analog/basic/nmos_resistor_amplifier.hpp:28
        I(cpphdl_n1875, cpphdl_n1874) <+ V(cpphdl_n1875, cpphdl_n1874) / 50.0;
        // device 1415, IC IC246, analog/basic/nmos_resistor_amplifier.hpp:29
        I(Vss, cpphdl_n1875) <+ V(Vss, cpphdl_n1875) / 150.0;
        // device 1416, IC IC246, analog/basic/nmos_resistor_amplifier.hpp:30
        I(cpphdl_n1879, Vdd) <+ 2.9999999999999998e-13 * ddt(V(cpphdl_n1879, Vdd)); // Bench initial voltage = 0.0 V.
        // device 1417, IC IC246, analog/basic/nmos_resistor_amplifier.hpp:31
        I(cpphdl_n1878, Vdd) <+ 2.9999999999999998e-13 * ddt(V(cpphdl_n1878, Vdd)); // Bench initial voltage = 0.0 V.
        // device 1418, IC IC246, analog/basic/nmos_resistor_amplifier.hpp:32
        I(cpphdl_n1875, Vss) <+ 4e-14 * ddt(V(cpphdl_n1875, Vss)); // Bench initial voltage = 0.0 V.
        // device 1419, IC IC246, analog/basic/nmos_resistor_amplifier.hpp:34
        I(cpphdl_n1869, cpphdl_n1873) <+ 2e-14 * ddt(V(cpphdl_n1869, cpphdl_n1873)); // Bench initial voltage = 1.6499999999999999 V.
        // device 1420, IC IC246, analog/basic/nmos_resistor_amplifier.hpp:35
        I(cpphdl_n1870, cpphdl_n1874) <+ 2e-14 * ddt(V(cpphdl_n1870, cpphdl_n1874)); // Bench initial voltage = 0.0 V.
        // device 1421, IC IC246, analog/basic/nmos_resistor_amplifier.hpp:36
        I(cpphdl_n1869, cpphdl_n1879) <+ 2.9999999999999998e-15 * ddt(V(cpphdl_n1869, cpphdl_n1879)); // Bench initial voltage = -1.6499999999999999 V.
        // device 1422, IC IC246, analog/basic/nmos_resistor_amplifier.hpp:37
        I(cpphdl_n1870, cpphdl_n1878) <+ 2.9999999999999998e-15 * ddt(V(cpphdl_n1870, cpphdl_n1878)); // Bench initial voltage = -3.2999999999999998 V.
        // device 1423, IC IC247, analog/basic/strongarm_comparator.hpp:28
        I(cpphdl_n1883, cpphdl_n1885) <+ cpphdl_channel(V(cpphdl_n1878, cpphdl_n1885), V(cpphdl_n1883, cpphdl_n1885), 0.0080000000000000002, 0.69999999999999996, 1.0);
        // device 1424, IC IC247, analog/basic/strongarm_comparator.hpp:29
        I(cpphdl_n1884, cpphdl_n1885) <+ cpphdl_channel(V(cpphdl_n1879, cpphdl_n1885), V(cpphdl_n1884, cpphdl_n1885), 0.0080000000000000002, 0.69999999999999996, 1.0);
        // device 1425, IC IC247, analog/basic/strongarm_comparator.hpp:30
        I(cpphdl_n1885, Vss) <+ cpphdl_channel(V(EVALUATE, Vss), V(cpphdl_n1885, Vss), 0.0080000000000000002, 0.69999999999999996, 1.0);
        // device 1426, IC IC247, analog/basic/strongarm_comparator.hpp:33
        I(cpphdl_n1898, cpphdl_n1883) <+ cpphdl_channel(V(cpphdl_n1902, cpphdl_n1883), V(cpphdl_n1898, cpphdl_n1883), 0.0040000000000000001, 0.69999999999999996, 1.0);
        // device 1427, IC IC247, analog/basic/strongarm_comparator.hpp:34
        I(cpphdl_n1902, cpphdl_n1884) <+ cpphdl_channel(V(cpphdl_n1898, cpphdl_n1884), V(cpphdl_n1902, cpphdl_n1884), 0.0040000000000000001, 0.69999999999999996, 1.0);
        // device 1428, IC IC247, analog/basic/strongarm_comparator.hpp:35
        I(cpphdl_n1902, Vdd) <+ cpphdl_channel(V(cpphdl_n1898, Vdd), V(cpphdl_n1902, Vdd), 0.002, 0.69999999999999996, -1.0);
        // device 1429, IC IC247, analog/basic/strongarm_comparator.hpp:36
        I(cpphdl_n1898, Vdd) <+ cpphdl_channel(V(cpphdl_n1902, Vdd), V(cpphdl_n1898, Vdd), 0.002, 0.69999999999999996, -1.0);
        // device 1430, IC IC247, analog/basic/strongarm_comparator.hpp:38
        I(cpphdl_n1883, Vdd) <+ cpphdl_channel(V(EVALUATE, Vdd), V(cpphdl_n1883, Vdd), 0.002, 0.69999999999999996, -1.0);
        // device 1431, IC IC247, analog/basic/strongarm_comparator.hpp:39
        I(cpphdl_n1884, Vdd) <+ cpphdl_channel(V(EVALUATE, Vdd), V(cpphdl_n1884, Vdd), 0.002, 0.69999999999999996, -1.0);
        // device 1432, IC IC247, analog/basic/strongarm_comparator.hpp:40
        I(cpphdl_n1902, Vdd) <+ cpphdl_channel(V(EVALUATE, Vdd), V(cpphdl_n1902, Vdd), 0.002, 0.69999999999999996, -1.0);
        // device 1433, IC IC247, analog/basic/strongarm_comparator.hpp:41
        I(cpphdl_n1898, Vdd) <+ cpphdl_channel(V(EVALUATE, Vdd), V(cpphdl_n1898, Vdd), 0.002, 0.69999999999999996, -1.0);
        // device 1434, IC IC247, analog/basic/strongarm_comparator.hpp:42
        I(cpphdl_n1883, Vss) <+ 2.9999999999999998e-14 * ddt(V(cpphdl_n1883, Vss)); // Bench initial voltage = 0.0 V.
        // device 1435, IC IC247, analog/basic/strongarm_comparator.hpp:43
        I(cpphdl_n1884, Vss) <+ 2.9999999999999998e-14 * ddt(V(cpphdl_n1884, Vss)); // Bench initial voltage = 0.0 V.
        // device 1436, IC IC247, analog/basic/strongarm_comparator.hpp:44
        I(cpphdl_n1885, Vss) <+ 2.9999999999999998e-14 * ddt(V(cpphdl_n1885, Vss)); // Bench initial voltage = 0.0 V.
        // device 1437, IC IC247, analog/basic/strongarm_comparator.hpp:45
        I(cpphdl_n1902, Vss) <+ 5.0000000000000002e-14 * ddt(V(cpphdl_n1902, Vss)); // Bench initial voltage = 0.0 V.
        // device 1438, IC IC247, analog/basic/strongarm_comparator.hpp:46
        I(cpphdl_n1898, Vss) <+ 5.0000000000000002e-14 * ddt(V(cpphdl_n1898, Vss)); // Bench initial voltage = 0.0 V.
        // device 1439, IC IC247, analog/basic/strongarm_comparator.hpp:47
        I(cpphdl_n1878, cpphdl_n1885) <+ 2e-14 * ddt(V(cpphdl_n1878, cpphdl_n1885)); // Bench initial voltage = 3.2999999999999998 V.
        // device 1440, IC IC247, analog/basic/strongarm_comparator.hpp:48
        I(cpphdl_n1879, cpphdl_n1885) <+ 2e-14 * ddt(V(cpphdl_n1879, cpphdl_n1885)); // Bench initial voltage = 3.2999999999999998 V.
        // device 1441, IC IC247, analog/basic/strongarm_comparator.hpp:49
        I(cpphdl_n1878, cpphdl_n1883) <+ 2.9999999999999998e-15 * ddt(V(cpphdl_n1878, cpphdl_n1883)); // Bench initial voltage = 3.2999999999999998 V.
        // device 1442, IC IC247, analog/basic/strongarm_comparator.hpp:50
        I(cpphdl_n1879, cpphdl_n1884) <+ 2.9999999999999998e-15 * ddt(V(cpphdl_n1879, cpphdl_n1884)); // Bench initial voltage = 3.2999999999999998 V.
        // device 1443, IC IC249, analog/basic/inverter.hpp:11
        I(cpphdl_n1906, Vdd) <+ cpphdl_channel(V(cpphdl_n1898, Vdd), V(cpphdl_n1906, Vdd), 0.001, 0.69999999999999996, -1.0);
        // device 1444, IC IC249, analog/basic/inverter.hpp:12
        I(cpphdl_n1906, Vss) <+ cpphdl_channel(V(cpphdl_n1898, Vss), V(cpphdl_n1906, Vss), 0.001, 0.69999999999999996, 1.0);
        // device 1445, IC IC251, analog/basic/inverter.hpp:11
        I(cpphdl_n1920, Vdd) <+ cpphdl_channel(V(cpphdl_n1906, Vdd), V(cpphdl_n1920, Vdd), 0.0040000000000000001, 0.69999999999999996, -1.0);
        // device 1446, IC IC251, analog/basic/inverter.hpp:12
        I(cpphdl_n1920, Vss) <+ cpphdl_channel(V(cpphdl_n1906, Vss), V(cpphdl_n1920, Vss), 0.0040000000000000001, 0.69999999999999996, 1.0);
        // device 1447, IC IC248, analog/basic/buffered_nand_latch.hpp:34
        I(cpphdl_n1898, Vss) <+ 2.0000000000000002e-15 * ddt(V(cpphdl_n1898, Vss)); // Bench initial voltage = 0.0 V.
        // device 1448, IC IC248, analog/basic/buffered_nand_latch.hpp:35
        I(cpphdl_n1898, cpphdl_n1906) <+ 1.0000000000000001e-15 * ddt(V(cpphdl_n1898, cpphdl_n1906)); // Bench initial voltage = 0.0 V.
        // device 1449, IC IC248, analog/basic/buffered_nand_latch.hpp:36
        I(cpphdl_n1906, Vss) <+ 5e-15 * ddt(V(cpphdl_n1906, Vss)); // Bench initial voltage = 0.0 V.
        // device 1450, IC IC248, analog/basic/buffered_nand_latch.hpp:37
        I(cpphdl_n1906, Vss) <+ 8.0000000000000006e-15 * ddt(V(cpphdl_n1906, Vss)); // Bench initial voltage = 0.0 V.
        // device 1451, IC IC248, analog/basic/buffered_nand_latch.hpp:38
        I(cpphdl_n1920, Vss) <+ 1e-14 * ddt(V(cpphdl_n1920, Vss)); // Bench initial voltage = 0.0 V.
        // device 1452, IC IC250, analog/basic/inverter.hpp:11
        I(cpphdl_n1910, Vdd) <+ cpphdl_channel(V(cpphdl_n1902, Vdd), V(cpphdl_n1910, Vdd), 0.001, 0.69999999999999996, -1.0);
        // device 1453, IC IC250, analog/basic/inverter.hpp:12
        I(cpphdl_n1910, Vss) <+ cpphdl_channel(V(cpphdl_n1902, Vss), V(cpphdl_n1910, Vss), 0.001, 0.69999999999999996, 1.0);
        // device 1454, IC IC252, analog/basic/inverter.hpp:11
        I(cpphdl_n1926, Vdd) <+ cpphdl_channel(V(cpphdl_n1910, Vdd), V(cpphdl_n1926, Vdd), 0.0040000000000000001, 0.69999999999999996, -1.0);
        // device 1455, IC IC252, analog/basic/inverter.hpp:12
        I(cpphdl_n1926, Vss) <+ cpphdl_channel(V(cpphdl_n1910, Vss), V(cpphdl_n1926, Vss), 0.0040000000000000001, 0.69999999999999996, 1.0);
        // device 1456, IC IC248, analog/basic/buffered_nand_latch.hpp:34
        I(cpphdl_n1902, Vss) <+ 2.0000000000000002e-15 * ddt(V(cpphdl_n1902, Vss)); // Bench initial voltage = 0.0 V.
        // device 1457, IC IC248, analog/basic/buffered_nand_latch.hpp:35
        I(cpphdl_n1902, cpphdl_n1910) <+ 1.0000000000000001e-15 * ddt(V(cpphdl_n1902, cpphdl_n1910)); // Bench initial voltage = 0.0 V.
        // device 1458, IC IC248, analog/basic/buffered_nand_latch.hpp:36
        I(cpphdl_n1910, Vss) <+ 5e-15 * ddt(V(cpphdl_n1910, Vss)); // Bench initial voltage = 0.0 V.
        // device 1459, IC IC248, analog/basic/buffered_nand_latch.hpp:37
        I(cpphdl_n1910, Vss) <+ 8.0000000000000006e-15 * ddt(V(cpphdl_n1910, Vss)); // Bench initial voltage = 0.0 V.
        // device 1460, IC IC248, analog/basic/buffered_nand_latch.hpp:38
        I(cpphdl_n1926, Vss) <+ 1e-14 * ddt(V(cpphdl_n1926, Vss)); // Bench initial voltage = 0.0 V.
        // device 1461, IC IC254, analog/basic/cmos_logic.hpp:17
        I(cpphdl_n2719, Vss) <+ 5.0000000000000002e-14 * ddt(V(cpphdl_n2719, Vss)); // Bench initial voltage = 0.0 V.
        // device 1462, IC IC254, analog/basic/cmos_logic.hpp:18
        I(cpphdl_n2719, Vdd) <+ cpphdl_channel(V(cpphdl_n1920, Vdd), V(cpphdl_n2719, Vdd), 0.01, 0.69999999999999996, -1.0);
        // device 1463, IC IC254, analog/basic/cmos_logic.hpp:19
        I(cpphdl_n2719, Vdd) <+ cpphdl_channel(V(cpphdl_n1928, Vdd), V(cpphdl_n2719, Vdd), 0.01, 0.69999999999999996, -1.0);
        // device 1464, IC IC254, analog/basic/cmos_logic.hpp:20
        I(cpphdl_n2719, cpphdl_n1923) <+ cpphdl_channel(V(cpphdl_n1920, cpphdl_n1923), V(cpphdl_n2719, cpphdl_n1923), 0.01, 0.69999999999999996, 1.0);
        // device 1465, IC IC254, analog/basic/cmos_logic.hpp:21
        I(cpphdl_n1923, Vss) <+ cpphdl_channel(V(cpphdl_n1928, Vss), V(cpphdl_n1923, Vss), 0.01, 0.69999999999999996, 1.0);
        // device 1466, IC IC254, analog/basic/cmos_logic.hpp:23
        I(cpphdl_n2719, Vss) <+ V(cpphdl_n2719, Vss) / 1000000000.0;
        // device 1467, IC IC254, analog/basic/cmos_logic.hpp:24
        I(cpphdl_n1923, Vss) <+ V(cpphdl_n1923, Vss) / 1000000000.0;
        // device 1468, IC IC255, analog/basic/cmos_logic.hpp:17
        I(cpphdl_n1928, Vss) <+ 5.0000000000000002e-14 * ddt(V(cpphdl_n1928, Vss)); // Bench initial voltage = 0.0 V.
        // device 1469, IC IC255, analog/basic/cmos_logic.hpp:18
        I(cpphdl_n1928, Vdd) <+ cpphdl_channel(V(cpphdl_n1926, Vdd), V(cpphdl_n1928, Vdd), 0.01, 0.69999999999999996, -1.0);
        // device 1470, IC IC255, analog/basic/cmos_logic.hpp:19
        I(cpphdl_n1928, Vdd) <+ cpphdl_channel(V(cpphdl_n2719, Vdd), V(cpphdl_n1928, Vdd), 0.01, 0.69999999999999996, -1.0);
        // device 1471, IC IC255, analog/basic/cmos_logic.hpp:20
        I(cpphdl_n1928, cpphdl_n1929) <+ cpphdl_channel(V(cpphdl_n1926, cpphdl_n1929), V(cpphdl_n1928, cpphdl_n1929), 0.01, 0.69999999999999996, 1.0);
        // device 1472, IC IC255, analog/basic/cmos_logic.hpp:21
        I(cpphdl_n1929, Vss) <+ cpphdl_channel(V(cpphdl_n2719, Vss), V(cpphdl_n1929, Vss), 0.01, 0.69999999999999996, 1.0);
        // device 1473, IC IC255, analog/basic/cmos_logic.hpp:23
        I(cpphdl_n1928, Vss) <+ V(cpphdl_n1928, Vss) / 1000000000.0;
        // device 1474, IC IC255, analog/basic/cmos_logic.hpp:24
        I(cpphdl_n1929, Vss) <+ V(cpphdl_n1929, Vss) / 1000000000.0;
        // device 1475, IC IC253, analog/basic/nand_latch.hpp:36
        I(cpphdl_n1920, Vss) <+ 2.9999999999999998e-15 * ddt(V(cpphdl_n1920, Vss)); // Bench initial voltage = 0.0 V.
        // device 1476, IC IC253, analog/basic/nand_latch.hpp:37
        I(cpphdl_n1926, Vss) <+ 2.9999999999999998e-15 * ddt(V(cpphdl_n1926, Vss)); // Bench initial voltage = 0.0 V.
        // device 1477, IC IC256, analog/basic/inverter.hpp:11
        I(cpphdl_n1934, Vdd) <+ cpphdl_channel(V(CLEAR, Vdd), V(cpphdl_n1934, Vdd), 0.01, 0.69999999999999996, -1.0);
        // device 1478, IC IC256, analog/basic/inverter.hpp:12
        I(cpphdl_n1934, Vss) <+ cpphdl_channel(V(CLEAR, Vss), V(cpphdl_n1934, Vss), 0.01, 0.69999999999999996, 1.0);
        // device 1479, IC IC253, analog/basic/nand_latch.hpp:58
        I(cpphdl_n1934, Vss) <+ 2.9999999999999998e-15 * ddt(V(cpphdl_n1934, Vss)); // Bench initial voltage = 0.0 V.
        // device 1480, IC IC253, analog/basic/nand_latch.hpp:59
        I(cpphdl_n2719, Vss) <+ cpphdl_channel(V(CLEAR, Vss), V(cpphdl_n2719, Vss), 0.050000000000000003, 0.69999999999999996, 1.0);
        // device 1481, IC IC253, analog/basic/nand_latch.hpp:60
        I(cpphdl_n1928, Vdd) <+ cpphdl_channel(V(cpphdl_n1934, Vdd), V(cpphdl_n1928, Vdd), 0.050000000000000003, 0.69999999999999996, -1.0);
        // device 1482, IC IC259, analog/basic/inverter.hpp:11
        I(cpphdl_n1958, Vdd) <+ cpphdl_channel(V(TRACK11, Vdd), V(cpphdl_n1958, Vdd), 0.0040000000000000001, 0.69999999999999996, -1.0);
        // device 1483, IC IC259, analog/basic/inverter.hpp:12
        I(cpphdl_n1958, Vss) <+ cpphdl_channel(V(TRACK11, Vss), V(cpphdl_n1958, Vss), 0.0040000000000000001, 0.69999999999999996, 1.0);
        // device 1484, IC IC258, analog/basic/mos_track_hold.hpp:31
        I(cpphdl_n1958, Vss) <+ 2e-14 * ddt(V(cpphdl_n1958, Vss)); // Bench initial voltage = 3.2999999999999998 V.
        // device 1485, IC IC258, analog/basic/mos_track_hold.hpp:32
        I(cpphdl_n2759, cpphdl_n2012) <+ cpphdl_channel(V(TRACK11, cpphdl_n2012), V(cpphdl_n2759, cpphdl_n2012), 0.080000000000000002, 0.69999999999999996, 1.0);
        // device 1486, IC IC258, analog/basic/mos_track_hold.hpp:33
        I(cpphdl_n2012, cpphdl_n2759) <+ cpphdl_channel(V(cpphdl_n1958, cpphdl_n2759), V(cpphdl_n2012, cpphdl_n2759), 0.040000000000000001, 0.69999999999999996, -1.0);
        // device 1487, IC IC258, analog/basic/mos_track_hold.hpp:37
        I(cpphdl_n2012, cpphdl_n2012) <+ cpphdl_channel(V(cpphdl_n1958, cpphdl_n2012), V(cpphdl_n2012, cpphdl_n2012), 0.040000000000000001, 0.69999999999999996, 1.0);
        // device 1488, IC IC258, analog/basic/mos_track_hold.hpp:38
        I(cpphdl_n2012, cpphdl_n2012) <+ cpphdl_channel(V(TRACK11, cpphdl_n2012), V(cpphdl_n2012, cpphdl_n2012), 0.02, 0.69999999999999996, -1.0);
        // device 1489, IC IC258, analog/basic/mos_track_hold.hpp:39
        I(cpphdl_n2012, Vss) <+ 3.0000000000000001e-12 * ddt(V(cpphdl_n2012, Vss)); // Bench initial voltage = 1.6499999999999999 V.
        // device 1490, IC IC258, analog/basic/mos_track_hold.hpp:41
        I(Vss, cpphdl_n2012) <+ V(Vss, cpphdl_n2012) / 1000000000.0;
        // device 1491, IC IC258, analog/basic/mos_track_hold.hpp:42
        I(TRACK11, cpphdl_n2012) <+ 8.0000000000000006e-15 * ddt(V(TRACK11, cpphdl_n2012)); // Bench initial voltage = -1.6499999999999999 V.
        // device 1492, IC IC258, analog/basic/mos_track_hold.hpp:43
        I(cpphdl_n1958, cpphdl_n2012) <+ 8.0000000000000006e-15 * ddt(V(cpphdl_n1958, cpphdl_n2012)); // Bench initial voltage = 1.6499999999999999 V.
        // device 1493, IC IC258, analog/basic/mos_track_hold.hpp:44
        I(cpphdl_n2759, cpphdl_n2012) <+ 4.0000000000000003e-15 * ddt(V(cpphdl_n2759, cpphdl_n2012)); // Bench initial voltage = 0.0 V.
        // device 1494, IC IC261, analog/basic/inverter.hpp:11
        I(cpphdl_n1973, Vdd) <+ cpphdl_channel(V(BIT_N11_0, Vdd), V(cpphdl_n1973, Vdd), 0.080000000000000002, 0.69999999999999996, -1.0);
        // device 1495, IC IC261, analog/basic/inverter.hpp:12
        I(cpphdl_n1973, Vss) <+ cpphdl_channel(V(BIT_N11_0, Vss), V(cpphdl_n1973, Vss), 0.080000000000000002, 0.69999999999999996, 1.0);
        // device 1496, IC IC260, analog/basic/mos_r2r_dac.hpp:27
        I(cpphdl_n1973, Vss) <+ 2.9999999999999998e-15 * ddt(V(cpphdl_n1973, Vss)); // Bench initial voltage = 0.0 V.
        // device 1497, IC IC260, analog/basic/mos_r2r_dac.hpp:28
        I(cpphdl_n1973, cpphdl_n2002) <+ V(cpphdl_n1973, cpphdl_n2002) / 2000.0;
        // device 1498, IC IC260, analog/basic/mos_r2r_dac.hpp:29
        I(cpphdl_n2002, Vss) <+ 2.9999999999999998e-15 * ddt(V(cpphdl_n2002, Vss)); // Bench initial voltage = 0.0 V.
        // device 1499, IC IC262, analog/basic/inverter.hpp:11
        I(cpphdl_n1977, Vdd) <+ cpphdl_channel(V(BIT_N11_1, Vdd), V(cpphdl_n1977, Vdd), 0.080000000000000002, 0.69999999999999996, -1.0);
        // device 1500, IC IC262, analog/basic/inverter.hpp:12
        I(cpphdl_n1977, Vss) <+ cpphdl_channel(V(BIT_N11_1, Vss), V(cpphdl_n1977, Vss), 0.080000000000000002, 0.69999999999999996, 1.0);
        // device 1501, IC IC260, analog/basic/mos_r2r_dac.hpp:27
        I(cpphdl_n1977, Vss) <+ 2.9999999999999998e-15 * ddt(V(cpphdl_n1977, Vss)); // Bench initial voltage = 0.0 V.
        // device 1502, IC IC260, analog/basic/mos_r2r_dac.hpp:28
        I(cpphdl_n1977, cpphdl_n2003) <+ V(cpphdl_n1977, cpphdl_n2003) / 2000.0;
        // device 1503, IC IC260, analog/basic/mos_r2r_dac.hpp:29
        I(cpphdl_n2003, Vss) <+ 2.9999999999999998e-15 * ddt(V(cpphdl_n2003, Vss)); // Bench initial voltage = 0.0 V.
        // device 1504, IC IC260, analog/basic/mos_r2r_dac.hpp:31
        I(cpphdl_n2002, cpphdl_n2003) <+ V(cpphdl_n2002, cpphdl_n2003) / 1000.0;
        // device 1505, IC IC263, analog/basic/inverter.hpp:11
        I(cpphdl_n1981, Vdd) <+ cpphdl_channel(V(BIT_N11_2, Vdd), V(cpphdl_n1981, Vdd), 0.080000000000000002, 0.69999999999999996, -1.0);
        // device 1506, IC IC263, analog/basic/inverter.hpp:12
        I(cpphdl_n1981, Vss) <+ cpphdl_channel(V(BIT_N11_2, Vss), V(cpphdl_n1981, Vss), 0.080000000000000002, 0.69999999999999996, 1.0);
        // device 1507, IC IC260, analog/basic/mos_r2r_dac.hpp:27
        I(cpphdl_n1981, Vss) <+ 2.9999999999999998e-15 * ddt(V(cpphdl_n1981, Vss)); // Bench initial voltage = 0.0 V.
        // device 1508, IC IC260, analog/basic/mos_r2r_dac.hpp:28
        I(cpphdl_n1981, cpphdl_n2004) <+ V(cpphdl_n1981, cpphdl_n2004) / 2000.0;
        // device 1509, IC IC260, analog/basic/mos_r2r_dac.hpp:29
        I(cpphdl_n2004, Vss) <+ 2.9999999999999998e-15 * ddt(V(cpphdl_n2004, Vss)); // Bench initial voltage = 0.0 V.
        // device 1510, IC IC260, analog/basic/mos_r2r_dac.hpp:31
        I(cpphdl_n2003, cpphdl_n2004) <+ V(cpphdl_n2003, cpphdl_n2004) / 1000.0;
        // device 1511, IC IC264, analog/basic/inverter.hpp:11
        I(cpphdl_n1985, Vdd) <+ cpphdl_channel(V(BIT_N11_3, Vdd), V(cpphdl_n1985, Vdd), 0.080000000000000002, 0.69999999999999996, -1.0);
        // device 1512, IC IC264, analog/basic/inverter.hpp:12
        I(cpphdl_n1985, Vss) <+ cpphdl_channel(V(BIT_N11_3, Vss), V(cpphdl_n1985, Vss), 0.080000000000000002, 0.69999999999999996, 1.0);
        // device 1513, IC IC260, analog/basic/mos_r2r_dac.hpp:27
        I(cpphdl_n1985, Vss) <+ 2.9999999999999998e-15 * ddt(V(cpphdl_n1985, Vss)); // Bench initial voltage = 0.0 V.
        // device 1514, IC IC260, analog/basic/mos_r2r_dac.hpp:28
        I(cpphdl_n1985, cpphdl_n2005) <+ V(cpphdl_n1985, cpphdl_n2005) / 2000.0;
        // device 1515, IC IC260, analog/basic/mos_r2r_dac.hpp:29
        I(cpphdl_n2005, Vss) <+ 2.9999999999999998e-15 * ddt(V(cpphdl_n2005, Vss)); // Bench initial voltage = 0.0 V.
        // device 1516, IC IC260, analog/basic/mos_r2r_dac.hpp:31
        I(cpphdl_n2004, cpphdl_n2005) <+ V(cpphdl_n2004, cpphdl_n2005) / 1000.0;
        // device 1517, IC IC265, analog/basic/inverter.hpp:11
        I(cpphdl_n1989, Vdd) <+ cpphdl_channel(V(BIT_N11_4, Vdd), V(cpphdl_n1989, Vdd), 0.080000000000000002, 0.69999999999999996, -1.0);
        // device 1518, IC IC265, analog/basic/inverter.hpp:12
        I(cpphdl_n1989, Vss) <+ cpphdl_channel(V(BIT_N11_4, Vss), V(cpphdl_n1989, Vss), 0.080000000000000002, 0.69999999999999996, 1.0);
        // device 1519, IC IC260, analog/basic/mos_r2r_dac.hpp:27
        I(cpphdl_n1989, Vss) <+ 2.9999999999999998e-15 * ddt(V(cpphdl_n1989, Vss)); // Bench initial voltage = 0.0 V.
        // device 1520, IC IC260, analog/basic/mos_r2r_dac.hpp:28
        I(cpphdl_n1989, cpphdl_n2006) <+ V(cpphdl_n1989, cpphdl_n2006) / 2000.0;
        // device 1521, IC IC260, analog/basic/mos_r2r_dac.hpp:29
        I(cpphdl_n2006, Vss) <+ 2.9999999999999998e-15 * ddt(V(cpphdl_n2006, Vss)); // Bench initial voltage = 0.0 V.
        // device 1522, IC IC260, analog/basic/mos_r2r_dac.hpp:31
        I(cpphdl_n2005, cpphdl_n2006) <+ V(cpphdl_n2005, cpphdl_n2006) / 1000.0;
        // device 1523, IC IC266, analog/basic/inverter.hpp:11
        I(cpphdl_n1993, Vdd) <+ cpphdl_channel(V(BIT_N11_5, Vdd), V(cpphdl_n1993, Vdd), 0.080000000000000002, 0.69999999999999996, -1.0);
        // device 1524, IC IC266, analog/basic/inverter.hpp:12
        I(cpphdl_n1993, Vss) <+ cpphdl_channel(V(BIT_N11_5, Vss), V(cpphdl_n1993, Vss), 0.080000000000000002, 0.69999999999999996, 1.0);
        // device 1525, IC IC260, analog/basic/mos_r2r_dac.hpp:27
        I(cpphdl_n1993, Vss) <+ 2.9999999999999998e-15 * ddt(V(cpphdl_n1993, Vss)); // Bench initial voltage = 0.0 V.
        // device 1526, IC IC260, analog/basic/mos_r2r_dac.hpp:28
        I(cpphdl_n1993, cpphdl_n2007) <+ V(cpphdl_n1993, cpphdl_n2007) / 2000.0;
        // device 1527, IC IC260, analog/basic/mos_r2r_dac.hpp:29
        I(cpphdl_n2007, Vss) <+ 2.9999999999999998e-15 * ddt(V(cpphdl_n2007, Vss)); // Bench initial voltage = 0.0 V.
        // device 1528, IC IC260, analog/basic/mos_r2r_dac.hpp:31
        I(cpphdl_n2006, cpphdl_n2007) <+ V(cpphdl_n2006, cpphdl_n2007) / 1000.0;
        // device 1529, IC IC267, analog/basic/inverter.hpp:11
        I(cpphdl_n1997, Vdd) <+ cpphdl_channel(V(BIT_N11_6, Vdd), V(cpphdl_n1997, Vdd), 0.080000000000000002, 0.69999999999999996, -1.0);
        // device 1530, IC IC267, analog/basic/inverter.hpp:12
        I(cpphdl_n1997, Vss) <+ cpphdl_channel(V(BIT_N11_6, Vss), V(cpphdl_n1997, Vss), 0.080000000000000002, 0.69999999999999996, 1.0);
        // device 1531, IC IC260, analog/basic/mos_r2r_dac.hpp:27
        I(cpphdl_n1997, Vss) <+ 2.9999999999999998e-15 * ddt(V(cpphdl_n1997, Vss)); // Bench initial voltage = 0.0 V.
        // device 1532, IC IC260, analog/basic/mos_r2r_dac.hpp:28
        I(cpphdl_n1997, cpphdl_n2008) <+ V(cpphdl_n1997, cpphdl_n2008) / 2000.0;
        // device 1533, IC IC260, analog/basic/mos_r2r_dac.hpp:29
        I(cpphdl_n2008, Vss) <+ 2.9999999999999998e-15 * ddt(V(cpphdl_n2008, Vss)); // Bench initial voltage = 0.0 V.
        // device 1534, IC IC260, analog/basic/mos_r2r_dac.hpp:31
        I(cpphdl_n2007, cpphdl_n2008) <+ V(cpphdl_n2007, cpphdl_n2008) / 1000.0;
        // device 1535, IC IC268, analog/basic/inverter.hpp:11
        I(cpphdl_n2001, Vdd) <+ cpphdl_channel(V(BIT_N11_7, Vdd), V(cpphdl_n2001, Vdd), 0.080000000000000002, 0.69999999999999996, -1.0);
        // device 1536, IC IC268, analog/basic/inverter.hpp:12
        I(cpphdl_n2001, Vss) <+ cpphdl_channel(V(BIT_N11_7, Vss), V(cpphdl_n2001, Vss), 0.080000000000000002, 0.69999999999999996, 1.0);
        // device 1537, IC IC260, analog/basic/mos_r2r_dac.hpp:27
        I(cpphdl_n2001, Vss) <+ 2.9999999999999998e-15 * ddt(V(cpphdl_n2001, Vss)); // Bench initial voltage = 0.0 V.
        // device 1538, IC IC260, analog/basic/mos_r2r_dac.hpp:28
        I(cpphdl_n2001, cpphdl_n2013) <+ V(cpphdl_n2001, cpphdl_n2013) / 2000.0;
        // device 1539, IC IC260, analog/basic/mos_r2r_dac.hpp:29
        I(cpphdl_n2013, Vss) <+ 2.9999999999999998e-15 * ddt(V(cpphdl_n2013, Vss)); // Bench initial voltage = 0.0 V.
        // device 1540, IC IC260, analog/basic/mos_r2r_dac.hpp:31
        I(cpphdl_n2008, cpphdl_n2013) <+ V(cpphdl_n2008, cpphdl_n2013) / 1000.0;
        // device 1541, IC IC260, analog/basic/mos_r2r_dac.hpp:33
        I(Vss, cpphdl_n2002) <+ V(Vss, cpphdl_n2002) / 2000.0;
        // device 1542, IC IC269, analog/basic/nmos_resistor_amplifier.hpp:23
        I(Vdd, cpphdl_n2022) <+ V(Vdd, cpphdl_n2022) / 500.0;
        // device 1543, IC IC269, analog/basic/nmos_resistor_amplifier.hpp:24
        I(Vdd, cpphdl_n2021) <+ V(Vdd, cpphdl_n2021) / 500.0;
        // device 1544, IC IC269, analog/basic/nmos_resistor_amplifier.hpp:25
        I(cpphdl_n2022, cpphdl_n2016) <+ cpphdl_channel(V(cpphdl_n2012, cpphdl_n2016), V(cpphdl_n2022, cpphdl_n2016), 0.014999999999999999, 0.69999999999999996, 1.0);
        // device 1545, IC IC269, analog/basic/nmos_resistor_amplifier.hpp:26
        I(cpphdl_n2021, cpphdl_n2017) <+ cpphdl_channel(V(cpphdl_n2013, cpphdl_n2017), V(cpphdl_n2021, cpphdl_n2017), 0.014999999999999999, 0.69999999999999996, 1.0);
        // device 1546, IC IC269, analog/basic/nmos_resistor_amplifier.hpp:27
        I(cpphdl_n2018, cpphdl_n2016) <+ V(cpphdl_n2018, cpphdl_n2016) / 50.0;
        // device 1547, IC IC269, analog/basic/nmos_resistor_amplifier.hpp:28
        I(cpphdl_n2018, cpphdl_n2017) <+ V(cpphdl_n2018, cpphdl_n2017) / 50.0;
        // device 1548, IC IC269, analog/basic/nmos_resistor_amplifier.hpp:29
        I(Vss, cpphdl_n2018) <+ V(Vss, cpphdl_n2018) / 150.0;
        // device 1549, IC IC269, analog/basic/nmos_resistor_amplifier.hpp:30
        I(cpphdl_n2022, Vdd) <+ 2.9999999999999998e-13 * ddt(V(cpphdl_n2022, Vdd)); // Bench initial voltage = 0.0 V.
        // device 1550, IC IC269, analog/basic/nmos_resistor_amplifier.hpp:31
        I(cpphdl_n2021, Vdd) <+ 2.9999999999999998e-13 * ddt(V(cpphdl_n2021, Vdd)); // Bench initial voltage = 0.0 V.
        // device 1551, IC IC269, analog/basic/nmos_resistor_amplifier.hpp:32
        I(cpphdl_n2018, Vss) <+ 4e-14 * ddt(V(cpphdl_n2018, Vss)); // Bench initial voltage = 0.0 V.
        // device 1552, IC IC269, analog/basic/nmos_resistor_amplifier.hpp:34
        I(cpphdl_n2012, cpphdl_n2016) <+ 2e-14 * ddt(V(cpphdl_n2012, cpphdl_n2016)); // Bench initial voltage = 1.6499999999999999 V.
        // device 1553, IC IC269, analog/basic/nmos_resistor_amplifier.hpp:35
        I(cpphdl_n2013, cpphdl_n2017) <+ 2e-14 * ddt(V(cpphdl_n2013, cpphdl_n2017)); // Bench initial voltage = 0.0 V.
        // device 1554, IC IC269, analog/basic/nmos_resistor_amplifier.hpp:36
        I(cpphdl_n2012, cpphdl_n2022) <+ 2.9999999999999998e-15 * ddt(V(cpphdl_n2012, cpphdl_n2022)); // Bench initial voltage = -1.6499999999999999 V.
        // device 1555, IC IC269, analog/basic/nmos_resistor_amplifier.hpp:37
        I(cpphdl_n2013, cpphdl_n2021) <+ 2.9999999999999998e-15 * ddt(V(cpphdl_n2013, cpphdl_n2021)); // Bench initial voltage = -3.2999999999999998 V.
        // device 1556, IC IC270, analog/basic/strongarm_comparator.hpp:28
        I(cpphdl_n2026, cpphdl_n2028) <+ cpphdl_channel(V(cpphdl_n2021, cpphdl_n2028), V(cpphdl_n2026, cpphdl_n2028), 0.0080000000000000002, 0.69999999999999996, 1.0);
        // device 1557, IC IC270, analog/basic/strongarm_comparator.hpp:29
        I(cpphdl_n2027, cpphdl_n2028) <+ cpphdl_channel(V(cpphdl_n2022, cpphdl_n2028), V(cpphdl_n2027, cpphdl_n2028), 0.0080000000000000002, 0.69999999999999996, 1.0);
        // device 1558, IC IC270, analog/basic/strongarm_comparator.hpp:30
        I(cpphdl_n2028, Vss) <+ cpphdl_channel(V(EVALUATE, Vss), V(cpphdl_n2028, Vss), 0.0080000000000000002, 0.69999999999999996, 1.0);
        // device 1559, IC IC270, analog/basic/strongarm_comparator.hpp:33
        I(cpphdl_n2041, cpphdl_n2026) <+ cpphdl_channel(V(cpphdl_n2045, cpphdl_n2026), V(cpphdl_n2041, cpphdl_n2026), 0.0040000000000000001, 0.69999999999999996, 1.0);
        // device 1560, IC IC270, analog/basic/strongarm_comparator.hpp:34
        I(cpphdl_n2045, cpphdl_n2027) <+ cpphdl_channel(V(cpphdl_n2041, cpphdl_n2027), V(cpphdl_n2045, cpphdl_n2027), 0.0040000000000000001, 0.69999999999999996, 1.0);
        // device 1561, IC IC270, analog/basic/strongarm_comparator.hpp:35
        I(cpphdl_n2045, Vdd) <+ cpphdl_channel(V(cpphdl_n2041, Vdd), V(cpphdl_n2045, Vdd), 0.002, 0.69999999999999996, -1.0);
        // device 1562, IC IC270, analog/basic/strongarm_comparator.hpp:36
        I(cpphdl_n2041, Vdd) <+ cpphdl_channel(V(cpphdl_n2045, Vdd), V(cpphdl_n2041, Vdd), 0.002, 0.69999999999999996, -1.0);
        // device 1563, IC IC270, analog/basic/strongarm_comparator.hpp:38
        I(cpphdl_n2026, Vdd) <+ cpphdl_channel(V(EVALUATE, Vdd), V(cpphdl_n2026, Vdd), 0.002, 0.69999999999999996, -1.0);
        // device 1564, IC IC270, analog/basic/strongarm_comparator.hpp:39
        I(cpphdl_n2027, Vdd) <+ cpphdl_channel(V(EVALUATE, Vdd), V(cpphdl_n2027, Vdd), 0.002, 0.69999999999999996, -1.0);
        // device 1565, IC IC270, analog/basic/strongarm_comparator.hpp:40
        I(cpphdl_n2045, Vdd) <+ cpphdl_channel(V(EVALUATE, Vdd), V(cpphdl_n2045, Vdd), 0.002, 0.69999999999999996, -1.0);
        // device 1566, IC IC270, analog/basic/strongarm_comparator.hpp:41
        I(cpphdl_n2041, Vdd) <+ cpphdl_channel(V(EVALUATE, Vdd), V(cpphdl_n2041, Vdd), 0.002, 0.69999999999999996, -1.0);
        // device 1567, IC IC270, analog/basic/strongarm_comparator.hpp:42
        I(cpphdl_n2026, Vss) <+ 2.9999999999999998e-14 * ddt(V(cpphdl_n2026, Vss)); // Bench initial voltage = 0.0 V.
        // device 1568, IC IC270, analog/basic/strongarm_comparator.hpp:43
        I(cpphdl_n2027, Vss) <+ 2.9999999999999998e-14 * ddt(V(cpphdl_n2027, Vss)); // Bench initial voltage = 0.0 V.
        // device 1569, IC IC270, analog/basic/strongarm_comparator.hpp:44
        I(cpphdl_n2028, Vss) <+ 2.9999999999999998e-14 * ddt(V(cpphdl_n2028, Vss)); // Bench initial voltage = 0.0 V.
        // device 1570, IC IC270, analog/basic/strongarm_comparator.hpp:45
        I(cpphdl_n2045, Vss) <+ 5.0000000000000002e-14 * ddt(V(cpphdl_n2045, Vss)); // Bench initial voltage = 0.0 V.
        // device 1571, IC IC270, analog/basic/strongarm_comparator.hpp:46
        I(cpphdl_n2041, Vss) <+ 5.0000000000000002e-14 * ddt(V(cpphdl_n2041, Vss)); // Bench initial voltage = 0.0 V.
        // device 1572, IC IC270, analog/basic/strongarm_comparator.hpp:47
        I(cpphdl_n2021, cpphdl_n2028) <+ 2e-14 * ddt(V(cpphdl_n2021, cpphdl_n2028)); // Bench initial voltage = 3.2999999999999998 V.
        // device 1573, IC IC270, analog/basic/strongarm_comparator.hpp:48
        I(cpphdl_n2022, cpphdl_n2028) <+ 2e-14 * ddt(V(cpphdl_n2022, cpphdl_n2028)); // Bench initial voltage = 3.2999999999999998 V.
        // device 1574, IC IC270, analog/basic/strongarm_comparator.hpp:49
        I(cpphdl_n2021, cpphdl_n2026) <+ 2.9999999999999998e-15 * ddt(V(cpphdl_n2021, cpphdl_n2026)); // Bench initial voltage = 3.2999999999999998 V.
        // device 1575, IC IC270, analog/basic/strongarm_comparator.hpp:50
        I(cpphdl_n2022, cpphdl_n2027) <+ 2.9999999999999998e-15 * ddt(V(cpphdl_n2022, cpphdl_n2027)); // Bench initial voltage = 3.2999999999999998 V.
        // device 1576, IC IC272, analog/basic/inverter.hpp:11
        I(cpphdl_n2049, Vdd) <+ cpphdl_channel(V(cpphdl_n2041, Vdd), V(cpphdl_n2049, Vdd), 0.001, 0.69999999999999996, -1.0);
        // device 1577, IC IC272, analog/basic/inverter.hpp:12
        I(cpphdl_n2049, Vss) <+ cpphdl_channel(V(cpphdl_n2041, Vss), V(cpphdl_n2049, Vss), 0.001, 0.69999999999999996, 1.0);
        // device 1578, IC IC274, analog/basic/inverter.hpp:11
        I(cpphdl_n2063, Vdd) <+ cpphdl_channel(V(cpphdl_n2049, Vdd), V(cpphdl_n2063, Vdd), 0.0040000000000000001, 0.69999999999999996, -1.0);
        // device 1579, IC IC274, analog/basic/inverter.hpp:12
        I(cpphdl_n2063, Vss) <+ cpphdl_channel(V(cpphdl_n2049, Vss), V(cpphdl_n2063, Vss), 0.0040000000000000001, 0.69999999999999996, 1.0);
        // device 1580, IC IC271, analog/basic/buffered_nand_latch.hpp:34
        I(cpphdl_n2041, Vss) <+ 2.0000000000000002e-15 * ddt(V(cpphdl_n2041, Vss)); // Bench initial voltage = 0.0 V.
        // device 1581, IC IC271, analog/basic/buffered_nand_latch.hpp:35
        I(cpphdl_n2041, cpphdl_n2049) <+ 1.0000000000000001e-15 * ddt(V(cpphdl_n2041, cpphdl_n2049)); // Bench initial voltage = 0.0 V.
        // device 1582, IC IC271, analog/basic/buffered_nand_latch.hpp:36
        I(cpphdl_n2049, Vss) <+ 5e-15 * ddt(V(cpphdl_n2049, Vss)); // Bench initial voltage = 0.0 V.
        // device 1583, IC IC271, analog/basic/buffered_nand_latch.hpp:37
        I(cpphdl_n2049, Vss) <+ 8.0000000000000006e-15 * ddt(V(cpphdl_n2049, Vss)); // Bench initial voltage = 0.0 V.
        // device 1584, IC IC271, analog/basic/buffered_nand_latch.hpp:38
        I(cpphdl_n2063, Vss) <+ 1e-14 * ddt(V(cpphdl_n2063, Vss)); // Bench initial voltage = 0.0 V.
        // device 1585, IC IC273, analog/basic/inverter.hpp:11
        I(cpphdl_n2053, Vdd) <+ cpphdl_channel(V(cpphdl_n2045, Vdd), V(cpphdl_n2053, Vdd), 0.001, 0.69999999999999996, -1.0);
        // device 1586, IC IC273, analog/basic/inverter.hpp:12
        I(cpphdl_n2053, Vss) <+ cpphdl_channel(V(cpphdl_n2045, Vss), V(cpphdl_n2053, Vss), 0.001, 0.69999999999999996, 1.0);
        // device 1587, IC IC275, analog/basic/inverter.hpp:11
        I(cpphdl_n2069, Vdd) <+ cpphdl_channel(V(cpphdl_n2053, Vdd), V(cpphdl_n2069, Vdd), 0.0040000000000000001, 0.69999999999999996, -1.0);
        // device 1588, IC IC275, analog/basic/inverter.hpp:12
        I(cpphdl_n2069, Vss) <+ cpphdl_channel(V(cpphdl_n2053, Vss), V(cpphdl_n2069, Vss), 0.0040000000000000001, 0.69999999999999996, 1.0);
        // device 1589, IC IC271, analog/basic/buffered_nand_latch.hpp:34
        I(cpphdl_n2045, Vss) <+ 2.0000000000000002e-15 * ddt(V(cpphdl_n2045, Vss)); // Bench initial voltage = 0.0 V.
        // device 1590, IC IC271, analog/basic/buffered_nand_latch.hpp:35
        I(cpphdl_n2045, cpphdl_n2053) <+ 1.0000000000000001e-15 * ddt(V(cpphdl_n2045, cpphdl_n2053)); // Bench initial voltage = 0.0 V.
        // device 1591, IC IC271, analog/basic/buffered_nand_latch.hpp:36
        I(cpphdl_n2053, Vss) <+ 5e-15 * ddt(V(cpphdl_n2053, Vss)); // Bench initial voltage = 0.0 V.
        // device 1592, IC IC271, analog/basic/buffered_nand_latch.hpp:37
        I(cpphdl_n2053, Vss) <+ 8.0000000000000006e-15 * ddt(V(cpphdl_n2053, Vss)); // Bench initial voltage = 0.0 V.
        // device 1593, IC IC271, analog/basic/buffered_nand_latch.hpp:38
        I(cpphdl_n2069, Vss) <+ 1e-14 * ddt(V(cpphdl_n2069, Vss)); // Bench initial voltage = 0.0 V.
        // device 1594, IC IC277, analog/basic/cmos_logic.hpp:17
        I(cpphdl_n2724, Vss) <+ 5.0000000000000002e-14 * ddt(V(cpphdl_n2724, Vss)); // Bench initial voltage = 0.0 V.
        // device 1595, IC IC277, analog/basic/cmos_logic.hpp:18
        I(cpphdl_n2724, Vdd) <+ cpphdl_channel(V(cpphdl_n2063, Vdd), V(cpphdl_n2724, Vdd), 0.01, 0.69999999999999996, -1.0);
        // device 1596, IC IC277, analog/basic/cmos_logic.hpp:19
        I(cpphdl_n2724, Vdd) <+ cpphdl_channel(V(cpphdl_n2071, Vdd), V(cpphdl_n2724, Vdd), 0.01, 0.69999999999999996, -1.0);
        // device 1597, IC IC277, analog/basic/cmos_logic.hpp:20
        I(cpphdl_n2724, cpphdl_n2066) <+ cpphdl_channel(V(cpphdl_n2063, cpphdl_n2066), V(cpphdl_n2724, cpphdl_n2066), 0.01, 0.69999999999999996, 1.0);
        // device 1598, IC IC277, analog/basic/cmos_logic.hpp:21
        I(cpphdl_n2066, Vss) <+ cpphdl_channel(V(cpphdl_n2071, Vss), V(cpphdl_n2066, Vss), 0.01, 0.69999999999999996, 1.0);
        // device 1599, IC IC277, analog/basic/cmos_logic.hpp:23
        I(cpphdl_n2724, Vss) <+ V(cpphdl_n2724, Vss) / 1000000000.0;
        // device 1600, IC IC277, analog/basic/cmos_logic.hpp:24
        I(cpphdl_n2066, Vss) <+ V(cpphdl_n2066, Vss) / 1000000000.0;
        // device 1601, IC IC278, analog/basic/cmos_logic.hpp:17
        I(cpphdl_n2071, Vss) <+ 5.0000000000000002e-14 * ddt(V(cpphdl_n2071, Vss)); // Bench initial voltage = 0.0 V.
        // device 1602, IC IC278, analog/basic/cmos_logic.hpp:18
        I(cpphdl_n2071, Vdd) <+ cpphdl_channel(V(cpphdl_n2069, Vdd), V(cpphdl_n2071, Vdd), 0.01, 0.69999999999999996, -1.0);
        // device 1603, IC IC278, analog/basic/cmos_logic.hpp:19
        I(cpphdl_n2071, Vdd) <+ cpphdl_channel(V(cpphdl_n2724, Vdd), V(cpphdl_n2071, Vdd), 0.01, 0.69999999999999996, -1.0);
        // device 1604, IC IC278, analog/basic/cmos_logic.hpp:20
        I(cpphdl_n2071, cpphdl_n2072) <+ cpphdl_channel(V(cpphdl_n2069, cpphdl_n2072), V(cpphdl_n2071, cpphdl_n2072), 0.01, 0.69999999999999996, 1.0);
        // device 1605, IC IC278, analog/basic/cmos_logic.hpp:21
        I(cpphdl_n2072, Vss) <+ cpphdl_channel(V(cpphdl_n2724, Vss), V(cpphdl_n2072, Vss), 0.01, 0.69999999999999996, 1.0);
        // device 1606, IC IC278, analog/basic/cmos_logic.hpp:23
        I(cpphdl_n2071, Vss) <+ V(cpphdl_n2071, Vss) / 1000000000.0;
        // device 1607, IC IC278, analog/basic/cmos_logic.hpp:24
        I(cpphdl_n2072, Vss) <+ V(cpphdl_n2072, Vss) / 1000000000.0;
        // device 1608, IC IC276, analog/basic/nand_latch.hpp:36
        I(cpphdl_n2063, Vss) <+ 2.9999999999999998e-15 * ddt(V(cpphdl_n2063, Vss)); // Bench initial voltage = 0.0 V.
        // device 1609, IC IC276, analog/basic/nand_latch.hpp:37
        I(cpphdl_n2069, Vss) <+ 2.9999999999999998e-15 * ddt(V(cpphdl_n2069, Vss)); // Bench initial voltage = 0.0 V.
        // device 1610, IC IC279, analog/basic/inverter.hpp:11
        I(cpphdl_n2077, Vdd) <+ cpphdl_channel(V(CLEAR, Vdd), V(cpphdl_n2077, Vdd), 0.01, 0.69999999999999996, -1.0);
        // device 1611, IC IC279, analog/basic/inverter.hpp:12
        I(cpphdl_n2077, Vss) <+ cpphdl_channel(V(CLEAR, Vss), V(cpphdl_n2077, Vss), 0.01, 0.69999999999999996, 1.0);
        // device 1612, IC IC276, analog/basic/nand_latch.hpp:58
        I(cpphdl_n2077, Vss) <+ 2.9999999999999998e-15 * ddt(V(cpphdl_n2077, Vss)); // Bench initial voltage = 0.0 V.
        // device 1613, IC IC276, analog/basic/nand_latch.hpp:59
        I(cpphdl_n2724, Vss) <+ cpphdl_channel(V(CLEAR, Vss), V(cpphdl_n2724, Vss), 0.050000000000000003, 0.69999999999999996, 1.0);
        // device 1614, IC IC276, analog/basic/nand_latch.hpp:60
        I(cpphdl_n2071, Vdd) <+ cpphdl_channel(V(cpphdl_n2077, Vdd), V(cpphdl_n2071, Vdd), 0.050000000000000003, 0.69999999999999996, -1.0);
        // device 1615, IC IC282, analog/basic/inverter.hpp:11
        I(cpphdl_n2101, Vdd) <+ cpphdl_channel(V(TRACK12, Vdd), V(cpphdl_n2101, Vdd), 0.0040000000000000001, 0.69999999999999996, -1.0);
        // device 1616, IC IC282, analog/basic/inverter.hpp:12
        I(cpphdl_n2101, Vss) <+ cpphdl_channel(V(TRACK12, Vss), V(cpphdl_n2101, Vss), 0.0040000000000000001, 0.69999999999999996, 1.0);
        // device 1617, IC IC281, analog/basic/mos_track_hold.hpp:31
        I(cpphdl_n2101, Vss) <+ 2e-14 * ddt(V(cpphdl_n2101, Vss)); // Bench initial voltage = 3.2999999999999998 V.
        // device 1618, IC IC281, analog/basic/mos_track_hold.hpp:32
        I(cpphdl_n2759, cpphdl_n2155) <+ cpphdl_channel(V(TRACK12, cpphdl_n2155), V(cpphdl_n2759, cpphdl_n2155), 0.080000000000000002, 0.69999999999999996, 1.0);
        // device 1619, IC IC281, analog/basic/mos_track_hold.hpp:33
        I(cpphdl_n2155, cpphdl_n2759) <+ cpphdl_channel(V(cpphdl_n2101, cpphdl_n2759), V(cpphdl_n2155, cpphdl_n2759), 0.040000000000000001, 0.69999999999999996, -1.0);
        // device 1620, IC IC281, analog/basic/mos_track_hold.hpp:37
        I(cpphdl_n2155, cpphdl_n2155) <+ cpphdl_channel(V(cpphdl_n2101, cpphdl_n2155), V(cpphdl_n2155, cpphdl_n2155), 0.040000000000000001, 0.69999999999999996, 1.0);
        // device 1621, IC IC281, analog/basic/mos_track_hold.hpp:38
        I(cpphdl_n2155, cpphdl_n2155) <+ cpphdl_channel(V(TRACK12, cpphdl_n2155), V(cpphdl_n2155, cpphdl_n2155), 0.02, 0.69999999999999996, -1.0);
        // device 1622, IC IC281, analog/basic/mos_track_hold.hpp:39
        I(cpphdl_n2155, Vss) <+ 3.0000000000000001e-12 * ddt(V(cpphdl_n2155, Vss)); // Bench initial voltage = 1.6499999999999999 V.
        // device 1623, IC IC281, analog/basic/mos_track_hold.hpp:41
        I(Vss, cpphdl_n2155) <+ V(Vss, cpphdl_n2155) / 1000000000.0;
        // device 1624, IC IC281, analog/basic/mos_track_hold.hpp:42
        I(TRACK12, cpphdl_n2155) <+ 8.0000000000000006e-15 * ddt(V(TRACK12, cpphdl_n2155)); // Bench initial voltage = -1.6499999999999999 V.
        // device 1625, IC IC281, analog/basic/mos_track_hold.hpp:43
        I(cpphdl_n2101, cpphdl_n2155) <+ 8.0000000000000006e-15 * ddt(V(cpphdl_n2101, cpphdl_n2155)); // Bench initial voltage = 1.6499999999999999 V.
        // device 1626, IC IC281, analog/basic/mos_track_hold.hpp:44
        I(cpphdl_n2759, cpphdl_n2155) <+ 4.0000000000000003e-15 * ddt(V(cpphdl_n2759, cpphdl_n2155)); // Bench initial voltage = 0.0 V.
        // device 1627, IC IC284, analog/basic/inverter.hpp:11
        I(cpphdl_n2116, Vdd) <+ cpphdl_channel(V(BIT_N12_0, Vdd), V(cpphdl_n2116, Vdd), 0.080000000000000002, 0.69999999999999996, -1.0);
        // device 1628, IC IC284, analog/basic/inverter.hpp:12
        I(cpphdl_n2116, Vss) <+ cpphdl_channel(V(BIT_N12_0, Vss), V(cpphdl_n2116, Vss), 0.080000000000000002, 0.69999999999999996, 1.0);
        // device 1629, IC IC283, analog/basic/mos_r2r_dac.hpp:27
        I(cpphdl_n2116, Vss) <+ 2.9999999999999998e-15 * ddt(V(cpphdl_n2116, Vss)); // Bench initial voltage = 0.0 V.
        // device 1630, IC IC283, analog/basic/mos_r2r_dac.hpp:28
        I(cpphdl_n2116, cpphdl_n2145) <+ V(cpphdl_n2116, cpphdl_n2145) / 2000.0;
        // device 1631, IC IC283, analog/basic/mos_r2r_dac.hpp:29
        I(cpphdl_n2145, Vss) <+ 2.9999999999999998e-15 * ddt(V(cpphdl_n2145, Vss)); // Bench initial voltage = 0.0 V.
        // device 1632, IC IC285, analog/basic/inverter.hpp:11
        I(cpphdl_n2120, Vdd) <+ cpphdl_channel(V(BIT_N12_1, Vdd), V(cpphdl_n2120, Vdd), 0.080000000000000002, 0.69999999999999996, -1.0);
        // device 1633, IC IC285, analog/basic/inverter.hpp:12
        I(cpphdl_n2120, Vss) <+ cpphdl_channel(V(BIT_N12_1, Vss), V(cpphdl_n2120, Vss), 0.080000000000000002, 0.69999999999999996, 1.0);
        // device 1634, IC IC283, analog/basic/mos_r2r_dac.hpp:27
        I(cpphdl_n2120, Vss) <+ 2.9999999999999998e-15 * ddt(V(cpphdl_n2120, Vss)); // Bench initial voltage = 0.0 V.
        // device 1635, IC IC283, analog/basic/mos_r2r_dac.hpp:28
        I(cpphdl_n2120, cpphdl_n2146) <+ V(cpphdl_n2120, cpphdl_n2146) / 2000.0;
        // device 1636, IC IC283, analog/basic/mos_r2r_dac.hpp:29
        I(cpphdl_n2146, Vss) <+ 2.9999999999999998e-15 * ddt(V(cpphdl_n2146, Vss)); // Bench initial voltage = 0.0 V.
        // device 1637, IC IC283, analog/basic/mos_r2r_dac.hpp:31
        I(cpphdl_n2145, cpphdl_n2146) <+ V(cpphdl_n2145, cpphdl_n2146) / 1000.0;
        // device 1638, IC IC286, analog/basic/inverter.hpp:11
        I(cpphdl_n2124, Vdd) <+ cpphdl_channel(V(BIT_N12_2, Vdd), V(cpphdl_n2124, Vdd), 0.080000000000000002, 0.69999999999999996, -1.0);
        // device 1639, IC IC286, analog/basic/inverter.hpp:12
        I(cpphdl_n2124, Vss) <+ cpphdl_channel(V(BIT_N12_2, Vss), V(cpphdl_n2124, Vss), 0.080000000000000002, 0.69999999999999996, 1.0);
        // device 1640, IC IC283, analog/basic/mos_r2r_dac.hpp:27
        I(cpphdl_n2124, Vss) <+ 2.9999999999999998e-15 * ddt(V(cpphdl_n2124, Vss)); // Bench initial voltage = 0.0 V.
        // device 1641, IC IC283, analog/basic/mos_r2r_dac.hpp:28
        I(cpphdl_n2124, cpphdl_n2147) <+ V(cpphdl_n2124, cpphdl_n2147) / 2000.0;
        // device 1642, IC IC283, analog/basic/mos_r2r_dac.hpp:29
        I(cpphdl_n2147, Vss) <+ 2.9999999999999998e-15 * ddt(V(cpphdl_n2147, Vss)); // Bench initial voltage = 0.0 V.
        // device 1643, IC IC283, analog/basic/mos_r2r_dac.hpp:31
        I(cpphdl_n2146, cpphdl_n2147) <+ V(cpphdl_n2146, cpphdl_n2147) / 1000.0;
        // device 1644, IC IC287, analog/basic/inverter.hpp:11
        I(cpphdl_n2128, Vdd) <+ cpphdl_channel(V(BIT_N12_3, Vdd), V(cpphdl_n2128, Vdd), 0.080000000000000002, 0.69999999999999996, -1.0);
        // device 1645, IC IC287, analog/basic/inverter.hpp:12
        I(cpphdl_n2128, Vss) <+ cpphdl_channel(V(BIT_N12_3, Vss), V(cpphdl_n2128, Vss), 0.080000000000000002, 0.69999999999999996, 1.0);
        // device 1646, IC IC283, analog/basic/mos_r2r_dac.hpp:27
        I(cpphdl_n2128, Vss) <+ 2.9999999999999998e-15 * ddt(V(cpphdl_n2128, Vss)); // Bench initial voltage = 0.0 V.
        // device 1647, IC IC283, analog/basic/mos_r2r_dac.hpp:28
        I(cpphdl_n2128, cpphdl_n2148) <+ V(cpphdl_n2128, cpphdl_n2148) / 2000.0;
        // device 1648, IC IC283, analog/basic/mos_r2r_dac.hpp:29
        I(cpphdl_n2148, Vss) <+ 2.9999999999999998e-15 * ddt(V(cpphdl_n2148, Vss)); // Bench initial voltage = 0.0 V.
        // device 1649, IC IC283, analog/basic/mos_r2r_dac.hpp:31
        I(cpphdl_n2147, cpphdl_n2148) <+ V(cpphdl_n2147, cpphdl_n2148) / 1000.0;
        // device 1650, IC IC288, analog/basic/inverter.hpp:11
        I(cpphdl_n2132, Vdd) <+ cpphdl_channel(V(BIT_N12_4, Vdd), V(cpphdl_n2132, Vdd), 0.080000000000000002, 0.69999999999999996, -1.0);
        // device 1651, IC IC288, analog/basic/inverter.hpp:12
        I(cpphdl_n2132, Vss) <+ cpphdl_channel(V(BIT_N12_4, Vss), V(cpphdl_n2132, Vss), 0.080000000000000002, 0.69999999999999996, 1.0);
        // device 1652, IC IC283, analog/basic/mos_r2r_dac.hpp:27
        I(cpphdl_n2132, Vss) <+ 2.9999999999999998e-15 * ddt(V(cpphdl_n2132, Vss)); // Bench initial voltage = 0.0 V.
        // device 1653, IC IC283, analog/basic/mos_r2r_dac.hpp:28
        I(cpphdl_n2132, cpphdl_n2149) <+ V(cpphdl_n2132, cpphdl_n2149) / 2000.0;
        // device 1654, IC IC283, analog/basic/mos_r2r_dac.hpp:29
        I(cpphdl_n2149, Vss) <+ 2.9999999999999998e-15 * ddt(V(cpphdl_n2149, Vss)); // Bench initial voltage = 0.0 V.
        // device 1655, IC IC283, analog/basic/mos_r2r_dac.hpp:31
        I(cpphdl_n2148, cpphdl_n2149) <+ V(cpphdl_n2148, cpphdl_n2149) / 1000.0;
        // device 1656, IC IC289, analog/basic/inverter.hpp:11
        I(cpphdl_n2136, Vdd) <+ cpphdl_channel(V(BIT_N12_5, Vdd), V(cpphdl_n2136, Vdd), 0.080000000000000002, 0.69999999999999996, -1.0);
        // device 1657, IC IC289, analog/basic/inverter.hpp:12
        I(cpphdl_n2136, Vss) <+ cpphdl_channel(V(BIT_N12_5, Vss), V(cpphdl_n2136, Vss), 0.080000000000000002, 0.69999999999999996, 1.0);
        // device 1658, IC IC283, analog/basic/mos_r2r_dac.hpp:27
        I(cpphdl_n2136, Vss) <+ 2.9999999999999998e-15 * ddt(V(cpphdl_n2136, Vss)); // Bench initial voltage = 0.0 V.
        // device 1659, IC IC283, analog/basic/mos_r2r_dac.hpp:28
        I(cpphdl_n2136, cpphdl_n2150) <+ V(cpphdl_n2136, cpphdl_n2150) / 2000.0;
        // device 1660, IC IC283, analog/basic/mos_r2r_dac.hpp:29
        I(cpphdl_n2150, Vss) <+ 2.9999999999999998e-15 * ddt(V(cpphdl_n2150, Vss)); // Bench initial voltage = 0.0 V.
        // device 1661, IC IC283, analog/basic/mos_r2r_dac.hpp:31
        I(cpphdl_n2149, cpphdl_n2150) <+ V(cpphdl_n2149, cpphdl_n2150) / 1000.0;
        // device 1662, IC IC290, analog/basic/inverter.hpp:11
        I(cpphdl_n2140, Vdd) <+ cpphdl_channel(V(BIT_N12_6, Vdd), V(cpphdl_n2140, Vdd), 0.080000000000000002, 0.69999999999999996, -1.0);
        // device 1663, IC IC290, analog/basic/inverter.hpp:12
        I(cpphdl_n2140, Vss) <+ cpphdl_channel(V(BIT_N12_6, Vss), V(cpphdl_n2140, Vss), 0.080000000000000002, 0.69999999999999996, 1.0);
        // device 1664, IC IC283, analog/basic/mos_r2r_dac.hpp:27
        I(cpphdl_n2140, Vss) <+ 2.9999999999999998e-15 * ddt(V(cpphdl_n2140, Vss)); // Bench initial voltage = 0.0 V.
        // device 1665, IC IC283, analog/basic/mos_r2r_dac.hpp:28
        I(cpphdl_n2140, cpphdl_n2151) <+ V(cpphdl_n2140, cpphdl_n2151) / 2000.0;
        // device 1666, IC IC283, analog/basic/mos_r2r_dac.hpp:29
        I(cpphdl_n2151, Vss) <+ 2.9999999999999998e-15 * ddt(V(cpphdl_n2151, Vss)); // Bench initial voltage = 0.0 V.
        // device 1667, IC IC283, analog/basic/mos_r2r_dac.hpp:31
        I(cpphdl_n2150, cpphdl_n2151) <+ V(cpphdl_n2150, cpphdl_n2151) / 1000.0;
        // device 1668, IC IC291, analog/basic/inverter.hpp:11
        I(cpphdl_n2144, Vdd) <+ cpphdl_channel(V(BIT_N12_7, Vdd), V(cpphdl_n2144, Vdd), 0.080000000000000002, 0.69999999999999996, -1.0);
        // device 1669, IC IC291, analog/basic/inverter.hpp:12
        I(cpphdl_n2144, Vss) <+ cpphdl_channel(V(BIT_N12_7, Vss), V(cpphdl_n2144, Vss), 0.080000000000000002, 0.69999999999999996, 1.0);
        // device 1670, IC IC283, analog/basic/mos_r2r_dac.hpp:27
        I(cpphdl_n2144, Vss) <+ 2.9999999999999998e-15 * ddt(V(cpphdl_n2144, Vss)); // Bench initial voltage = 0.0 V.
        // device 1671, IC IC283, analog/basic/mos_r2r_dac.hpp:28
        I(cpphdl_n2144, cpphdl_n2156) <+ V(cpphdl_n2144, cpphdl_n2156) / 2000.0;
        // device 1672, IC IC283, analog/basic/mos_r2r_dac.hpp:29
        I(cpphdl_n2156, Vss) <+ 2.9999999999999998e-15 * ddt(V(cpphdl_n2156, Vss)); // Bench initial voltage = 0.0 V.
        // device 1673, IC IC283, analog/basic/mos_r2r_dac.hpp:31
        I(cpphdl_n2151, cpphdl_n2156) <+ V(cpphdl_n2151, cpphdl_n2156) / 1000.0;
        // device 1674, IC IC283, analog/basic/mos_r2r_dac.hpp:33
        I(Vss, cpphdl_n2145) <+ V(Vss, cpphdl_n2145) / 2000.0;
        // device 1675, IC IC292, analog/basic/nmos_resistor_amplifier.hpp:23
        I(Vdd, cpphdl_n2165) <+ V(Vdd, cpphdl_n2165) / 500.0;
        // device 1676, IC IC292, analog/basic/nmos_resistor_amplifier.hpp:24
        I(Vdd, cpphdl_n2164) <+ V(Vdd, cpphdl_n2164) / 500.0;
        // device 1677, IC IC292, analog/basic/nmos_resistor_amplifier.hpp:25
        I(cpphdl_n2165, cpphdl_n2159) <+ cpphdl_channel(V(cpphdl_n2155, cpphdl_n2159), V(cpphdl_n2165, cpphdl_n2159), 0.014999999999999999, 0.69999999999999996, 1.0);
        // device 1678, IC IC292, analog/basic/nmos_resistor_amplifier.hpp:26
        I(cpphdl_n2164, cpphdl_n2160) <+ cpphdl_channel(V(cpphdl_n2156, cpphdl_n2160), V(cpphdl_n2164, cpphdl_n2160), 0.014999999999999999, 0.69999999999999996, 1.0);
        // device 1679, IC IC292, analog/basic/nmos_resistor_amplifier.hpp:27
        I(cpphdl_n2161, cpphdl_n2159) <+ V(cpphdl_n2161, cpphdl_n2159) / 50.0;
        // device 1680, IC IC292, analog/basic/nmos_resistor_amplifier.hpp:28
        I(cpphdl_n2161, cpphdl_n2160) <+ V(cpphdl_n2161, cpphdl_n2160) / 50.0;
        // device 1681, IC IC292, analog/basic/nmos_resistor_amplifier.hpp:29
        I(Vss, cpphdl_n2161) <+ V(Vss, cpphdl_n2161) / 150.0;
        // device 1682, IC IC292, analog/basic/nmos_resistor_amplifier.hpp:30
        I(cpphdl_n2165, Vdd) <+ 2.9999999999999998e-13 * ddt(V(cpphdl_n2165, Vdd)); // Bench initial voltage = 0.0 V.
        // device 1683, IC IC292, analog/basic/nmos_resistor_amplifier.hpp:31
        I(cpphdl_n2164, Vdd) <+ 2.9999999999999998e-13 * ddt(V(cpphdl_n2164, Vdd)); // Bench initial voltage = 0.0 V.
        // device 1684, IC IC292, analog/basic/nmos_resistor_amplifier.hpp:32
        I(cpphdl_n2161, Vss) <+ 4e-14 * ddt(V(cpphdl_n2161, Vss)); // Bench initial voltage = 0.0 V.
        // device 1685, IC IC292, analog/basic/nmos_resistor_amplifier.hpp:34
        I(cpphdl_n2155, cpphdl_n2159) <+ 2e-14 * ddt(V(cpphdl_n2155, cpphdl_n2159)); // Bench initial voltage = 1.6499999999999999 V.
        // device 1686, IC IC292, analog/basic/nmos_resistor_amplifier.hpp:35
        I(cpphdl_n2156, cpphdl_n2160) <+ 2e-14 * ddt(V(cpphdl_n2156, cpphdl_n2160)); // Bench initial voltage = 0.0 V.
        // device 1687, IC IC292, analog/basic/nmos_resistor_amplifier.hpp:36
        I(cpphdl_n2155, cpphdl_n2165) <+ 2.9999999999999998e-15 * ddt(V(cpphdl_n2155, cpphdl_n2165)); // Bench initial voltage = -1.6499999999999999 V.
        // device 1688, IC IC292, analog/basic/nmos_resistor_amplifier.hpp:37
        I(cpphdl_n2156, cpphdl_n2164) <+ 2.9999999999999998e-15 * ddt(V(cpphdl_n2156, cpphdl_n2164)); // Bench initial voltage = -3.2999999999999998 V.
        // device 1689, IC IC293, analog/basic/strongarm_comparator.hpp:28
        I(cpphdl_n2169, cpphdl_n2171) <+ cpphdl_channel(V(cpphdl_n2164, cpphdl_n2171), V(cpphdl_n2169, cpphdl_n2171), 0.0080000000000000002, 0.69999999999999996, 1.0);
        // device 1690, IC IC293, analog/basic/strongarm_comparator.hpp:29
        I(cpphdl_n2170, cpphdl_n2171) <+ cpphdl_channel(V(cpphdl_n2165, cpphdl_n2171), V(cpphdl_n2170, cpphdl_n2171), 0.0080000000000000002, 0.69999999999999996, 1.0);
        // device 1691, IC IC293, analog/basic/strongarm_comparator.hpp:30
        I(cpphdl_n2171, Vss) <+ cpphdl_channel(V(EVALUATE, Vss), V(cpphdl_n2171, Vss), 0.0080000000000000002, 0.69999999999999996, 1.0);
        // device 1692, IC IC293, analog/basic/strongarm_comparator.hpp:33
        I(cpphdl_n2184, cpphdl_n2169) <+ cpphdl_channel(V(cpphdl_n2188, cpphdl_n2169), V(cpphdl_n2184, cpphdl_n2169), 0.0040000000000000001, 0.69999999999999996, 1.0);
        // device 1693, IC IC293, analog/basic/strongarm_comparator.hpp:34
        I(cpphdl_n2188, cpphdl_n2170) <+ cpphdl_channel(V(cpphdl_n2184, cpphdl_n2170), V(cpphdl_n2188, cpphdl_n2170), 0.0040000000000000001, 0.69999999999999996, 1.0);
        // device 1694, IC IC293, analog/basic/strongarm_comparator.hpp:35
        I(cpphdl_n2188, Vdd) <+ cpphdl_channel(V(cpphdl_n2184, Vdd), V(cpphdl_n2188, Vdd), 0.002, 0.69999999999999996, -1.0);
        // device 1695, IC IC293, analog/basic/strongarm_comparator.hpp:36
        I(cpphdl_n2184, Vdd) <+ cpphdl_channel(V(cpphdl_n2188, Vdd), V(cpphdl_n2184, Vdd), 0.002, 0.69999999999999996, -1.0);
        // device 1696, IC IC293, analog/basic/strongarm_comparator.hpp:38
        I(cpphdl_n2169, Vdd) <+ cpphdl_channel(V(EVALUATE, Vdd), V(cpphdl_n2169, Vdd), 0.002, 0.69999999999999996, -1.0);
        // device 1697, IC IC293, analog/basic/strongarm_comparator.hpp:39
        I(cpphdl_n2170, Vdd) <+ cpphdl_channel(V(EVALUATE, Vdd), V(cpphdl_n2170, Vdd), 0.002, 0.69999999999999996, -1.0);
        // device 1698, IC IC293, analog/basic/strongarm_comparator.hpp:40
        I(cpphdl_n2188, Vdd) <+ cpphdl_channel(V(EVALUATE, Vdd), V(cpphdl_n2188, Vdd), 0.002, 0.69999999999999996, -1.0);
        // device 1699, IC IC293, analog/basic/strongarm_comparator.hpp:41
        I(cpphdl_n2184, Vdd) <+ cpphdl_channel(V(EVALUATE, Vdd), V(cpphdl_n2184, Vdd), 0.002, 0.69999999999999996, -1.0);
        // device 1700, IC IC293, analog/basic/strongarm_comparator.hpp:42
        I(cpphdl_n2169, Vss) <+ 2.9999999999999998e-14 * ddt(V(cpphdl_n2169, Vss)); // Bench initial voltage = 0.0 V.
        // device 1701, IC IC293, analog/basic/strongarm_comparator.hpp:43
        I(cpphdl_n2170, Vss) <+ 2.9999999999999998e-14 * ddt(V(cpphdl_n2170, Vss)); // Bench initial voltage = 0.0 V.
        // device 1702, IC IC293, analog/basic/strongarm_comparator.hpp:44
        I(cpphdl_n2171, Vss) <+ 2.9999999999999998e-14 * ddt(V(cpphdl_n2171, Vss)); // Bench initial voltage = 0.0 V.
        // device 1703, IC IC293, analog/basic/strongarm_comparator.hpp:45
        I(cpphdl_n2188, Vss) <+ 5.0000000000000002e-14 * ddt(V(cpphdl_n2188, Vss)); // Bench initial voltage = 0.0 V.
        // device 1704, IC IC293, analog/basic/strongarm_comparator.hpp:46
        I(cpphdl_n2184, Vss) <+ 5.0000000000000002e-14 * ddt(V(cpphdl_n2184, Vss)); // Bench initial voltage = 0.0 V.
        // device 1705, IC IC293, analog/basic/strongarm_comparator.hpp:47
        I(cpphdl_n2164, cpphdl_n2171) <+ 2e-14 * ddt(V(cpphdl_n2164, cpphdl_n2171)); // Bench initial voltage = 3.2999999999999998 V.
        // device 1706, IC IC293, analog/basic/strongarm_comparator.hpp:48
        I(cpphdl_n2165, cpphdl_n2171) <+ 2e-14 * ddt(V(cpphdl_n2165, cpphdl_n2171)); // Bench initial voltage = 3.2999999999999998 V.
        // device 1707, IC IC293, analog/basic/strongarm_comparator.hpp:49
        I(cpphdl_n2164, cpphdl_n2169) <+ 2.9999999999999998e-15 * ddt(V(cpphdl_n2164, cpphdl_n2169)); // Bench initial voltage = 3.2999999999999998 V.
        // device 1708, IC IC293, analog/basic/strongarm_comparator.hpp:50
        I(cpphdl_n2165, cpphdl_n2170) <+ 2.9999999999999998e-15 * ddt(V(cpphdl_n2165, cpphdl_n2170)); // Bench initial voltage = 3.2999999999999998 V.
        // device 1709, IC IC295, analog/basic/inverter.hpp:11
        I(cpphdl_n2192, Vdd) <+ cpphdl_channel(V(cpphdl_n2184, Vdd), V(cpphdl_n2192, Vdd), 0.001, 0.69999999999999996, -1.0);
        // device 1710, IC IC295, analog/basic/inverter.hpp:12
        I(cpphdl_n2192, Vss) <+ cpphdl_channel(V(cpphdl_n2184, Vss), V(cpphdl_n2192, Vss), 0.001, 0.69999999999999996, 1.0);
        // device 1711, IC IC297, analog/basic/inverter.hpp:11
        I(cpphdl_n2206, Vdd) <+ cpphdl_channel(V(cpphdl_n2192, Vdd), V(cpphdl_n2206, Vdd), 0.0040000000000000001, 0.69999999999999996, -1.0);
        // device 1712, IC IC297, analog/basic/inverter.hpp:12
        I(cpphdl_n2206, Vss) <+ cpphdl_channel(V(cpphdl_n2192, Vss), V(cpphdl_n2206, Vss), 0.0040000000000000001, 0.69999999999999996, 1.0);
        // device 1713, IC IC294, analog/basic/buffered_nand_latch.hpp:34
        I(cpphdl_n2184, Vss) <+ 2.0000000000000002e-15 * ddt(V(cpphdl_n2184, Vss)); // Bench initial voltage = 0.0 V.
        // device 1714, IC IC294, analog/basic/buffered_nand_latch.hpp:35
        I(cpphdl_n2184, cpphdl_n2192) <+ 1.0000000000000001e-15 * ddt(V(cpphdl_n2184, cpphdl_n2192)); // Bench initial voltage = 0.0 V.
        // device 1715, IC IC294, analog/basic/buffered_nand_latch.hpp:36
        I(cpphdl_n2192, Vss) <+ 5e-15 * ddt(V(cpphdl_n2192, Vss)); // Bench initial voltage = 0.0 V.
        // device 1716, IC IC294, analog/basic/buffered_nand_latch.hpp:37
        I(cpphdl_n2192, Vss) <+ 8.0000000000000006e-15 * ddt(V(cpphdl_n2192, Vss)); // Bench initial voltage = 0.0 V.
        // device 1717, IC IC294, analog/basic/buffered_nand_latch.hpp:38
        I(cpphdl_n2206, Vss) <+ 1e-14 * ddt(V(cpphdl_n2206, Vss)); // Bench initial voltage = 0.0 V.
        // device 1718, IC IC296, analog/basic/inverter.hpp:11
        I(cpphdl_n2196, Vdd) <+ cpphdl_channel(V(cpphdl_n2188, Vdd), V(cpphdl_n2196, Vdd), 0.001, 0.69999999999999996, -1.0);
        // device 1719, IC IC296, analog/basic/inverter.hpp:12
        I(cpphdl_n2196, Vss) <+ cpphdl_channel(V(cpphdl_n2188, Vss), V(cpphdl_n2196, Vss), 0.001, 0.69999999999999996, 1.0);
        // device 1720, IC IC298, analog/basic/inverter.hpp:11
        I(cpphdl_n2212, Vdd) <+ cpphdl_channel(V(cpphdl_n2196, Vdd), V(cpphdl_n2212, Vdd), 0.0040000000000000001, 0.69999999999999996, -1.0);
        // device 1721, IC IC298, analog/basic/inverter.hpp:12
        I(cpphdl_n2212, Vss) <+ cpphdl_channel(V(cpphdl_n2196, Vss), V(cpphdl_n2212, Vss), 0.0040000000000000001, 0.69999999999999996, 1.0);
        // device 1722, IC IC294, analog/basic/buffered_nand_latch.hpp:34
        I(cpphdl_n2188, Vss) <+ 2.0000000000000002e-15 * ddt(V(cpphdl_n2188, Vss)); // Bench initial voltage = 0.0 V.
        // device 1723, IC IC294, analog/basic/buffered_nand_latch.hpp:35
        I(cpphdl_n2188, cpphdl_n2196) <+ 1.0000000000000001e-15 * ddt(V(cpphdl_n2188, cpphdl_n2196)); // Bench initial voltage = 0.0 V.
        // device 1724, IC IC294, analog/basic/buffered_nand_latch.hpp:36
        I(cpphdl_n2196, Vss) <+ 5e-15 * ddt(V(cpphdl_n2196, Vss)); // Bench initial voltage = 0.0 V.
        // device 1725, IC IC294, analog/basic/buffered_nand_latch.hpp:37
        I(cpphdl_n2196, Vss) <+ 8.0000000000000006e-15 * ddt(V(cpphdl_n2196, Vss)); // Bench initial voltage = 0.0 V.
        // device 1726, IC IC294, analog/basic/buffered_nand_latch.hpp:38
        I(cpphdl_n2212, Vss) <+ 1e-14 * ddt(V(cpphdl_n2212, Vss)); // Bench initial voltage = 0.0 V.
        // device 1727, IC IC300, analog/basic/cmos_logic.hpp:17
        I(cpphdl_n2729, Vss) <+ 5.0000000000000002e-14 * ddt(V(cpphdl_n2729, Vss)); // Bench initial voltage = 0.0 V.
        // device 1728, IC IC300, analog/basic/cmos_logic.hpp:18
        I(cpphdl_n2729, Vdd) <+ cpphdl_channel(V(cpphdl_n2206, Vdd), V(cpphdl_n2729, Vdd), 0.01, 0.69999999999999996, -1.0);
        // device 1729, IC IC300, analog/basic/cmos_logic.hpp:19
        I(cpphdl_n2729, Vdd) <+ cpphdl_channel(V(cpphdl_n2214, Vdd), V(cpphdl_n2729, Vdd), 0.01, 0.69999999999999996, -1.0);
        // device 1730, IC IC300, analog/basic/cmos_logic.hpp:20
        I(cpphdl_n2729, cpphdl_n2209) <+ cpphdl_channel(V(cpphdl_n2206, cpphdl_n2209), V(cpphdl_n2729, cpphdl_n2209), 0.01, 0.69999999999999996, 1.0);
        // device 1731, IC IC300, analog/basic/cmos_logic.hpp:21
        I(cpphdl_n2209, Vss) <+ cpphdl_channel(V(cpphdl_n2214, Vss), V(cpphdl_n2209, Vss), 0.01, 0.69999999999999996, 1.0);
        // device 1732, IC IC300, analog/basic/cmos_logic.hpp:23
        I(cpphdl_n2729, Vss) <+ V(cpphdl_n2729, Vss) / 1000000000.0;
        // device 1733, IC IC300, analog/basic/cmos_logic.hpp:24
        I(cpphdl_n2209, Vss) <+ V(cpphdl_n2209, Vss) / 1000000000.0;
        // device 1734, IC IC301, analog/basic/cmos_logic.hpp:17
        I(cpphdl_n2214, Vss) <+ 5.0000000000000002e-14 * ddt(V(cpphdl_n2214, Vss)); // Bench initial voltage = 0.0 V.
        // device 1735, IC IC301, analog/basic/cmos_logic.hpp:18
        I(cpphdl_n2214, Vdd) <+ cpphdl_channel(V(cpphdl_n2212, Vdd), V(cpphdl_n2214, Vdd), 0.01, 0.69999999999999996, -1.0);
        // device 1736, IC IC301, analog/basic/cmos_logic.hpp:19
        I(cpphdl_n2214, Vdd) <+ cpphdl_channel(V(cpphdl_n2729, Vdd), V(cpphdl_n2214, Vdd), 0.01, 0.69999999999999996, -1.0);
        // device 1737, IC IC301, analog/basic/cmos_logic.hpp:20
        I(cpphdl_n2214, cpphdl_n2215) <+ cpphdl_channel(V(cpphdl_n2212, cpphdl_n2215), V(cpphdl_n2214, cpphdl_n2215), 0.01, 0.69999999999999996, 1.0);
        // device 1738, IC IC301, analog/basic/cmos_logic.hpp:21
        I(cpphdl_n2215, Vss) <+ cpphdl_channel(V(cpphdl_n2729, Vss), V(cpphdl_n2215, Vss), 0.01, 0.69999999999999996, 1.0);
        // device 1739, IC IC301, analog/basic/cmos_logic.hpp:23
        I(cpphdl_n2214, Vss) <+ V(cpphdl_n2214, Vss) / 1000000000.0;
        // device 1740, IC IC301, analog/basic/cmos_logic.hpp:24
        I(cpphdl_n2215, Vss) <+ V(cpphdl_n2215, Vss) / 1000000000.0;
        // device 1741, IC IC299, analog/basic/nand_latch.hpp:36
        I(cpphdl_n2206, Vss) <+ 2.9999999999999998e-15 * ddt(V(cpphdl_n2206, Vss)); // Bench initial voltage = 0.0 V.
        // device 1742, IC IC299, analog/basic/nand_latch.hpp:37
        I(cpphdl_n2212, Vss) <+ 2.9999999999999998e-15 * ddt(V(cpphdl_n2212, Vss)); // Bench initial voltage = 0.0 V.
        // device 1743, IC IC302, analog/basic/inverter.hpp:11
        I(cpphdl_n2220, Vdd) <+ cpphdl_channel(V(CLEAR, Vdd), V(cpphdl_n2220, Vdd), 0.01, 0.69999999999999996, -1.0);
        // device 1744, IC IC302, analog/basic/inverter.hpp:12
        I(cpphdl_n2220, Vss) <+ cpphdl_channel(V(CLEAR, Vss), V(cpphdl_n2220, Vss), 0.01, 0.69999999999999996, 1.0);
        // device 1745, IC IC299, analog/basic/nand_latch.hpp:58
        I(cpphdl_n2220, Vss) <+ 2.9999999999999998e-15 * ddt(V(cpphdl_n2220, Vss)); // Bench initial voltage = 0.0 V.
        // device 1746, IC IC299, analog/basic/nand_latch.hpp:59
        I(cpphdl_n2729, Vss) <+ cpphdl_channel(V(CLEAR, Vss), V(cpphdl_n2729, Vss), 0.050000000000000003, 0.69999999999999996, 1.0);
        // device 1747, IC IC299, analog/basic/nand_latch.hpp:60
        I(cpphdl_n2214, Vdd) <+ cpphdl_channel(V(cpphdl_n2220, Vdd), V(cpphdl_n2214, Vdd), 0.050000000000000003, 0.69999999999999996, -1.0);
        // device 1748, IC IC305, analog/basic/inverter.hpp:11
        I(cpphdl_n2244, Vdd) <+ cpphdl_channel(V(TRACK13, Vdd), V(cpphdl_n2244, Vdd), 0.0040000000000000001, 0.69999999999999996, -1.0);
        // device 1749, IC IC305, analog/basic/inverter.hpp:12
        I(cpphdl_n2244, Vss) <+ cpphdl_channel(V(TRACK13, Vss), V(cpphdl_n2244, Vss), 0.0040000000000000001, 0.69999999999999996, 1.0);
        // device 1750, IC IC304, analog/basic/mos_track_hold.hpp:31
        I(cpphdl_n2244, Vss) <+ 2e-14 * ddt(V(cpphdl_n2244, Vss)); // Bench initial voltage = 3.2999999999999998 V.
        // device 1751, IC IC304, analog/basic/mos_track_hold.hpp:32
        I(cpphdl_n2759, cpphdl_n2298) <+ cpphdl_channel(V(TRACK13, cpphdl_n2298), V(cpphdl_n2759, cpphdl_n2298), 0.080000000000000002, 0.69999999999999996, 1.0);
        // device 1752, IC IC304, analog/basic/mos_track_hold.hpp:33
        I(cpphdl_n2298, cpphdl_n2759) <+ cpphdl_channel(V(cpphdl_n2244, cpphdl_n2759), V(cpphdl_n2298, cpphdl_n2759), 0.040000000000000001, 0.69999999999999996, -1.0);
        // device 1753, IC IC304, analog/basic/mos_track_hold.hpp:37
        I(cpphdl_n2298, cpphdl_n2298) <+ cpphdl_channel(V(cpphdl_n2244, cpphdl_n2298), V(cpphdl_n2298, cpphdl_n2298), 0.040000000000000001, 0.69999999999999996, 1.0);
        // device 1754, IC IC304, analog/basic/mos_track_hold.hpp:38
        I(cpphdl_n2298, cpphdl_n2298) <+ cpphdl_channel(V(TRACK13, cpphdl_n2298), V(cpphdl_n2298, cpphdl_n2298), 0.02, 0.69999999999999996, -1.0);
        // device 1755, IC IC304, analog/basic/mos_track_hold.hpp:39
        I(cpphdl_n2298, Vss) <+ 3.0000000000000001e-12 * ddt(V(cpphdl_n2298, Vss)); // Bench initial voltage = 1.6499999999999999 V.
        // device 1756, IC IC304, analog/basic/mos_track_hold.hpp:41
        I(Vss, cpphdl_n2298) <+ V(Vss, cpphdl_n2298) / 1000000000.0;
        // device 1757, IC IC304, analog/basic/mos_track_hold.hpp:42
        I(TRACK13, cpphdl_n2298) <+ 8.0000000000000006e-15 * ddt(V(TRACK13, cpphdl_n2298)); // Bench initial voltage = -1.6499999999999999 V.
        // device 1758, IC IC304, analog/basic/mos_track_hold.hpp:43
        I(cpphdl_n2244, cpphdl_n2298) <+ 8.0000000000000006e-15 * ddt(V(cpphdl_n2244, cpphdl_n2298)); // Bench initial voltage = 1.6499999999999999 V.
        // device 1759, IC IC304, analog/basic/mos_track_hold.hpp:44
        I(cpphdl_n2759, cpphdl_n2298) <+ 4.0000000000000003e-15 * ddt(V(cpphdl_n2759, cpphdl_n2298)); // Bench initial voltage = 0.0 V.
        // device 1760, IC IC307, analog/basic/inverter.hpp:11
        I(cpphdl_n2259, Vdd) <+ cpphdl_channel(V(BIT_N13_0, Vdd), V(cpphdl_n2259, Vdd), 0.080000000000000002, 0.69999999999999996, -1.0);
        // device 1761, IC IC307, analog/basic/inverter.hpp:12
        I(cpphdl_n2259, Vss) <+ cpphdl_channel(V(BIT_N13_0, Vss), V(cpphdl_n2259, Vss), 0.080000000000000002, 0.69999999999999996, 1.0);
        // device 1762, IC IC306, analog/basic/mos_r2r_dac.hpp:27
        I(cpphdl_n2259, Vss) <+ 2.9999999999999998e-15 * ddt(V(cpphdl_n2259, Vss)); // Bench initial voltage = 0.0 V.
        // device 1763, IC IC306, analog/basic/mos_r2r_dac.hpp:28
        I(cpphdl_n2259, cpphdl_n2288) <+ V(cpphdl_n2259, cpphdl_n2288) / 2000.0;
        // device 1764, IC IC306, analog/basic/mos_r2r_dac.hpp:29
        I(cpphdl_n2288, Vss) <+ 2.9999999999999998e-15 * ddt(V(cpphdl_n2288, Vss)); // Bench initial voltage = 0.0 V.
        // device 1765, IC IC308, analog/basic/inverter.hpp:11
        I(cpphdl_n2263, Vdd) <+ cpphdl_channel(V(BIT_N13_1, Vdd), V(cpphdl_n2263, Vdd), 0.080000000000000002, 0.69999999999999996, -1.0);
        // device 1766, IC IC308, analog/basic/inverter.hpp:12
        I(cpphdl_n2263, Vss) <+ cpphdl_channel(V(BIT_N13_1, Vss), V(cpphdl_n2263, Vss), 0.080000000000000002, 0.69999999999999996, 1.0);
        // device 1767, IC IC306, analog/basic/mos_r2r_dac.hpp:27
        I(cpphdl_n2263, Vss) <+ 2.9999999999999998e-15 * ddt(V(cpphdl_n2263, Vss)); // Bench initial voltage = 0.0 V.
        // device 1768, IC IC306, analog/basic/mos_r2r_dac.hpp:28
        I(cpphdl_n2263, cpphdl_n2289) <+ V(cpphdl_n2263, cpphdl_n2289) / 2000.0;
        // device 1769, IC IC306, analog/basic/mos_r2r_dac.hpp:29
        I(cpphdl_n2289, Vss) <+ 2.9999999999999998e-15 * ddt(V(cpphdl_n2289, Vss)); // Bench initial voltage = 0.0 V.
        // device 1770, IC IC306, analog/basic/mos_r2r_dac.hpp:31
        I(cpphdl_n2288, cpphdl_n2289) <+ V(cpphdl_n2288, cpphdl_n2289) / 1000.0;
        // device 1771, IC IC309, analog/basic/inverter.hpp:11
        I(cpphdl_n2267, Vdd) <+ cpphdl_channel(V(BIT_N13_2, Vdd), V(cpphdl_n2267, Vdd), 0.080000000000000002, 0.69999999999999996, -1.0);
        // device 1772, IC IC309, analog/basic/inverter.hpp:12
        I(cpphdl_n2267, Vss) <+ cpphdl_channel(V(BIT_N13_2, Vss), V(cpphdl_n2267, Vss), 0.080000000000000002, 0.69999999999999996, 1.0);
        // device 1773, IC IC306, analog/basic/mos_r2r_dac.hpp:27
        I(cpphdl_n2267, Vss) <+ 2.9999999999999998e-15 * ddt(V(cpphdl_n2267, Vss)); // Bench initial voltage = 0.0 V.
        // device 1774, IC IC306, analog/basic/mos_r2r_dac.hpp:28
        I(cpphdl_n2267, cpphdl_n2290) <+ V(cpphdl_n2267, cpphdl_n2290) / 2000.0;
        // device 1775, IC IC306, analog/basic/mos_r2r_dac.hpp:29
        I(cpphdl_n2290, Vss) <+ 2.9999999999999998e-15 * ddt(V(cpphdl_n2290, Vss)); // Bench initial voltage = 0.0 V.
        // device 1776, IC IC306, analog/basic/mos_r2r_dac.hpp:31
        I(cpphdl_n2289, cpphdl_n2290) <+ V(cpphdl_n2289, cpphdl_n2290) / 1000.0;
        // device 1777, IC IC310, analog/basic/inverter.hpp:11
        I(cpphdl_n2271, Vdd) <+ cpphdl_channel(V(BIT_N13_3, Vdd), V(cpphdl_n2271, Vdd), 0.080000000000000002, 0.69999999999999996, -1.0);
        // device 1778, IC IC310, analog/basic/inverter.hpp:12
        I(cpphdl_n2271, Vss) <+ cpphdl_channel(V(BIT_N13_3, Vss), V(cpphdl_n2271, Vss), 0.080000000000000002, 0.69999999999999996, 1.0);
        // device 1779, IC IC306, analog/basic/mos_r2r_dac.hpp:27
        I(cpphdl_n2271, Vss) <+ 2.9999999999999998e-15 * ddt(V(cpphdl_n2271, Vss)); // Bench initial voltage = 0.0 V.
        // device 1780, IC IC306, analog/basic/mos_r2r_dac.hpp:28
        I(cpphdl_n2271, cpphdl_n2291) <+ V(cpphdl_n2271, cpphdl_n2291) / 2000.0;
        // device 1781, IC IC306, analog/basic/mos_r2r_dac.hpp:29
        I(cpphdl_n2291, Vss) <+ 2.9999999999999998e-15 * ddt(V(cpphdl_n2291, Vss)); // Bench initial voltage = 0.0 V.
        // device 1782, IC IC306, analog/basic/mos_r2r_dac.hpp:31
        I(cpphdl_n2290, cpphdl_n2291) <+ V(cpphdl_n2290, cpphdl_n2291) / 1000.0;
        // device 1783, IC IC311, analog/basic/inverter.hpp:11
        I(cpphdl_n2275, Vdd) <+ cpphdl_channel(V(BIT_N13_4, Vdd), V(cpphdl_n2275, Vdd), 0.080000000000000002, 0.69999999999999996, -1.0);
        // device 1784, IC IC311, analog/basic/inverter.hpp:12
        I(cpphdl_n2275, Vss) <+ cpphdl_channel(V(BIT_N13_4, Vss), V(cpphdl_n2275, Vss), 0.080000000000000002, 0.69999999999999996, 1.0);
        // device 1785, IC IC306, analog/basic/mos_r2r_dac.hpp:27
        I(cpphdl_n2275, Vss) <+ 2.9999999999999998e-15 * ddt(V(cpphdl_n2275, Vss)); // Bench initial voltage = 0.0 V.
        // device 1786, IC IC306, analog/basic/mos_r2r_dac.hpp:28
        I(cpphdl_n2275, cpphdl_n2292) <+ V(cpphdl_n2275, cpphdl_n2292) / 2000.0;
        // device 1787, IC IC306, analog/basic/mos_r2r_dac.hpp:29
        I(cpphdl_n2292, Vss) <+ 2.9999999999999998e-15 * ddt(V(cpphdl_n2292, Vss)); // Bench initial voltage = 0.0 V.
        // device 1788, IC IC306, analog/basic/mos_r2r_dac.hpp:31
        I(cpphdl_n2291, cpphdl_n2292) <+ V(cpphdl_n2291, cpphdl_n2292) / 1000.0;
        // device 1789, IC IC312, analog/basic/inverter.hpp:11
        I(cpphdl_n2279, Vdd) <+ cpphdl_channel(V(BIT_N13_5, Vdd), V(cpphdl_n2279, Vdd), 0.080000000000000002, 0.69999999999999996, -1.0);
        // device 1790, IC IC312, analog/basic/inverter.hpp:12
        I(cpphdl_n2279, Vss) <+ cpphdl_channel(V(BIT_N13_5, Vss), V(cpphdl_n2279, Vss), 0.080000000000000002, 0.69999999999999996, 1.0);
        // device 1791, IC IC306, analog/basic/mos_r2r_dac.hpp:27
        I(cpphdl_n2279, Vss) <+ 2.9999999999999998e-15 * ddt(V(cpphdl_n2279, Vss)); // Bench initial voltage = 0.0 V.
        // device 1792, IC IC306, analog/basic/mos_r2r_dac.hpp:28
        I(cpphdl_n2279, cpphdl_n2293) <+ V(cpphdl_n2279, cpphdl_n2293) / 2000.0;
        // device 1793, IC IC306, analog/basic/mos_r2r_dac.hpp:29
        I(cpphdl_n2293, Vss) <+ 2.9999999999999998e-15 * ddt(V(cpphdl_n2293, Vss)); // Bench initial voltage = 0.0 V.
        // device 1794, IC IC306, analog/basic/mos_r2r_dac.hpp:31
        I(cpphdl_n2292, cpphdl_n2293) <+ V(cpphdl_n2292, cpphdl_n2293) / 1000.0;
        // device 1795, IC IC313, analog/basic/inverter.hpp:11
        I(cpphdl_n2283, Vdd) <+ cpphdl_channel(V(BIT_N13_6, Vdd), V(cpphdl_n2283, Vdd), 0.080000000000000002, 0.69999999999999996, -1.0);
        // device 1796, IC IC313, analog/basic/inverter.hpp:12
        I(cpphdl_n2283, Vss) <+ cpphdl_channel(V(BIT_N13_6, Vss), V(cpphdl_n2283, Vss), 0.080000000000000002, 0.69999999999999996, 1.0);
        // device 1797, IC IC306, analog/basic/mos_r2r_dac.hpp:27
        I(cpphdl_n2283, Vss) <+ 2.9999999999999998e-15 * ddt(V(cpphdl_n2283, Vss)); // Bench initial voltage = 0.0 V.
        // device 1798, IC IC306, analog/basic/mos_r2r_dac.hpp:28
        I(cpphdl_n2283, cpphdl_n2294) <+ V(cpphdl_n2283, cpphdl_n2294) / 2000.0;
        // device 1799, IC IC306, analog/basic/mos_r2r_dac.hpp:29
        I(cpphdl_n2294, Vss) <+ 2.9999999999999998e-15 * ddt(V(cpphdl_n2294, Vss)); // Bench initial voltage = 0.0 V.
        // device 1800, IC IC306, analog/basic/mos_r2r_dac.hpp:31
        I(cpphdl_n2293, cpphdl_n2294) <+ V(cpphdl_n2293, cpphdl_n2294) / 1000.0;
        // device 1801, IC IC314, analog/basic/inverter.hpp:11
        I(cpphdl_n2287, Vdd) <+ cpphdl_channel(V(BIT_N13_7, Vdd), V(cpphdl_n2287, Vdd), 0.080000000000000002, 0.69999999999999996, -1.0);
        // device 1802, IC IC314, analog/basic/inverter.hpp:12
        I(cpphdl_n2287, Vss) <+ cpphdl_channel(V(BIT_N13_7, Vss), V(cpphdl_n2287, Vss), 0.080000000000000002, 0.69999999999999996, 1.0);
        // device 1803, IC IC306, analog/basic/mos_r2r_dac.hpp:27
        I(cpphdl_n2287, Vss) <+ 2.9999999999999998e-15 * ddt(V(cpphdl_n2287, Vss)); // Bench initial voltage = 0.0 V.
        // device 1804, IC IC306, analog/basic/mos_r2r_dac.hpp:28
        I(cpphdl_n2287, cpphdl_n2299) <+ V(cpphdl_n2287, cpphdl_n2299) / 2000.0;
        // device 1805, IC IC306, analog/basic/mos_r2r_dac.hpp:29
        I(cpphdl_n2299, Vss) <+ 2.9999999999999998e-15 * ddt(V(cpphdl_n2299, Vss)); // Bench initial voltage = 0.0 V.
        // device 1806, IC IC306, analog/basic/mos_r2r_dac.hpp:31
        I(cpphdl_n2294, cpphdl_n2299) <+ V(cpphdl_n2294, cpphdl_n2299) / 1000.0;
        // device 1807, IC IC306, analog/basic/mos_r2r_dac.hpp:33
        I(Vss, cpphdl_n2288) <+ V(Vss, cpphdl_n2288) / 2000.0;
        // device 1808, IC IC315, analog/basic/nmos_resistor_amplifier.hpp:23
        I(Vdd, cpphdl_n2308) <+ V(Vdd, cpphdl_n2308) / 500.0;
        // device 1809, IC IC315, analog/basic/nmos_resistor_amplifier.hpp:24
        I(Vdd, cpphdl_n2307) <+ V(Vdd, cpphdl_n2307) / 500.0;
        // device 1810, IC IC315, analog/basic/nmos_resistor_amplifier.hpp:25
        I(cpphdl_n2308, cpphdl_n2302) <+ cpphdl_channel(V(cpphdl_n2298, cpphdl_n2302), V(cpphdl_n2308, cpphdl_n2302), 0.014999999999999999, 0.69999999999999996, 1.0);
        // device 1811, IC IC315, analog/basic/nmos_resistor_amplifier.hpp:26
        I(cpphdl_n2307, cpphdl_n2303) <+ cpphdl_channel(V(cpphdl_n2299, cpphdl_n2303), V(cpphdl_n2307, cpphdl_n2303), 0.014999999999999999, 0.69999999999999996, 1.0);
        // device 1812, IC IC315, analog/basic/nmos_resistor_amplifier.hpp:27
        I(cpphdl_n2304, cpphdl_n2302) <+ V(cpphdl_n2304, cpphdl_n2302) / 50.0;
        // device 1813, IC IC315, analog/basic/nmos_resistor_amplifier.hpp:28
        I(cpphdl_n2304, cpphdl_n2303) <+ V(cpphdl_n2304, cpphdl_n2303) / 50.0;
        // device 1814, IC IC315, analog/basic/nmos_resistor_amplifier.hpp:29
        I(Vss, cpphdl_n2304) <+ V(Vss, cpphdl_n2304) / 150.0;
        // device 1815, IC IC315, analog/basic/nmos_resistor_amplifier.hpp:30
        I(cpphdl_n2308, Vdd) <+ 2.9999999999999998e-13 * ddt(V(cpphdl_n2308, Vdd)); // Bench initial voltage = 0.0 V.
        // device 1816, IC IC315, analog/basic/nmos_resistor_amplifier.hpp:31
        I(cpphdl_n2307, Vdd) <+ 2.9999999999999998e-13 * ddt(V(cpphdl_n2307, Vdd)); // Bench initial voltage = 0.0 V.
        // device 1817, IC IC315, analog/basic/nmos_resistor_amplifier.hpp:32
        I(cpphdl_n2304, Vss) <+ 4e-14 * ddt(V(cpphdl_n2304, Vss)); // Bench initial voltage = 0.0 V.
        // device 1818, IC IC315, analog/basic/nmos_resistor_amplifier.hpp:34
        I(cpphdl_n2298, cpphdl_n2302) <+ 2e-14 * ddt(V(cpphdl_n2298, cpphdl_n2302)); // Bench initial voltage = 1.6499999999999999 V.
        // device 1819, IC IC315, analog/basic/nmos_resistor_amplifier.hpp:35
        I(cpphdl_n2299, cpphdl_n2303) <+ 2e-14 * ddt(V(cpphdl_n2299, cpphdl_n2303)); // Bench initial voltage = 0.0 V.
        // device 1820, IC IC315, analog/basic/nmos_resistor_amplifier.hpp:36
        I(cpphdl_n2298, cpphdl_n2308) <+ 2.9999999999999998e-15 * ddt(V(cpphdl_n2298, cpphdl_n2308)); // Bench initial voltage = -1.6499999999999999 V.
        // device 1821, IC IC315, analog/basic/nmos_resistor_amplifier.hpp:37
        I(cpphdl_n2299, cpphdl_n2307) <+ 2.9999999999999998e-15 * ddt(V(cpphdl_n2299, cpphdl_n2307)); // Bench initial voltage = -3.2999999999999998 V.
        // device 1822, IC IC316, analog/basic/strongarm_comparator.hpp:28
        I(cpphdl_n2312, cpphdl_n2314) <+ cpphdl_channel(V(cpphdl_n2307, cpphdl_n2314), V(cpphdl_n2312, cpphdl_n2314), 0.0080000000000000002, 0.69999999999999996, 1.0);
        // device 1823, IC IC316, analog/basic/strongarm_comparator.hpp:29
        I(cpphdl_n2313, cpphdl_n2314) <+ cpphdl_channel(V(cpphdl_n2308, cpphdl_n2314), V(cpphdl_n2313, cpphdl_n2314), 0.0080000000000000002, 0.69999999999999996, 1.0);
        // device 1824, IC IC316, analog/basic/strongarm_comparator.hpp:30
        I(cpphdl_n2314, Vss) <+ cpphdl_channel(V(EVALUATE, Vss), V(cpphdl_n2314, Vss), 0.0080000000000000002, 0.69999999999999996, 1.0);
        // device 1825, IC IC316, analog/basic/strongarm_comparator.hpp:33
        I(cpphdl_n2327, cpphdl_n2312) <+ cpphdl_channel(V(cpphdl_n2331, cpphdl_n2312), V(cpphdl_n2327, cpphdl_n2312), 0.0040000000000000001, 0.69999999999999996, 1.0);
        // device 1826, IC IC316, analog/basic/strongarm_comparator.hpp:34
        I(cpphdl_n2331, cpphdl_n2313) <+ cpphdl_channel(V(cpphdl_n2327, cpphdl_n2313), V(cpphdl_n2331, cpphdl_n2313), 0.0040000000000000001, 0.69999999999999996, 1.0);
        // device 1827, IC IC316, analog/basic/strongarm_comparator.hpp:35
        I(cpphdl_n2331, Vdd) <+ cpphdl_channel(V(cpphdl_n2327, Vdd), V(cpphdl_n2331, Vdd), 0.002, 0.69999999999999996, -1.0);
        // device 1828, IC IC316, analog/basic/strongarm_comparator.hpp:36
        I(cpphdl_n2327, Vdd) <+ cpphdl_channel(V(cpphdl_n2331, Vdd), V(cpphdl_n2327, Vdd), 0.002, 0.69999999999999996, -1.0);
        // device 1829, IC IC316, analog/basic/strongarm_comparator.hpp:38
        I(cpphdl_n2312, Vdd) <+ cpphdl_channel(V(EVALUATE, Vdd), V(cpphdl_n2312, Vdd), 0.002, 0.69999999999999996, -1.0);
        // device 1830, IC IC316, analog/basic/strongarm_comparator.hpp:39
        I(cpphdl_n2313, Vdd) <+ cpphdl_channel(V(EVALUATE, Vdd), V(cpphdl_n2313, Vdd), 0.002, 0.69999999999999996, -1.0);
        // device 1831, IC IC316, analog/basic/strongarm_comparator.hpp:40
        I(cpphdl_n2331, Vdd) <+ cpphdl_channel(V(EVALUATE, Vdd), V(cpphdl_n2331, Vdd), 0.002, 0.69999999999999996, -1.0);
        // device 1832, IC IC316, analog/basic/strongarm_comparator.hpp:41
        I(cpphdl_n2327, Vdd) <+ cpphdl_channel(V(EVALUATE, Vdd), V(cpphdl_n2327, Vdd), 0.002, 0.69999999999999996, -1.0);
        // device 1833, IC IC316, analog/basic/strongarm_comparator.hpp:42
        I(cpphdl_n2312, Vss) <+ 2.9999999999999998e-14 * ddt(V(cpphdl_n2312, Vss)); // Bench initial voltage = 0.0 V.
        // device 1834, IC IC316, analog/basic/strongarm_comparator.hpp:43
        I(cpphdl_n2313, Vss) <+ 2.9999999999999998e-14 * ddt(V(cpphdl_n2313, Vss)); // Bench initial voltage = 0.0 V.
        // device 1835, IC IC316, analog/basic/strongarm_comparator.hpp:44
        I(cpphdl_n2314, Vss) <+ 2.9999999999999998e-14 * ddt(V(cpphdl_n2314, Vss)); // Bench initial voltage = 0.0 V.
        // device 1836, IC IC316, analog/basic/strongarm_comparator.hpp:45
        I(cpphdl_n2331, Vss) <+ 5.0000000000000002e-14 * ddt(V(cpphdl_n2331, Vss)); // Bench initial voltage = 0.0 V.
        // device 1837, IC IC316, analog/basic/strongarm_comparator.hpp:46
        I(cpphdl_n2327, Vss) <+ 5.0000000000000002e-14 * ddt(V(cpphdl_n2327, Vss)); // Bench initial voltage = 0.0 V.
        // device 1838, IC IC316, analog/basic/strongarm_comparator.hpp:47
        I(cpphdl_n2307, cpphdl_n2314) <+ 2e-14 * ddt(V(cpphdl_n2307, cpphdl_n2314)); // Bench initial voltage = 3.2999999999999998 V.
        // device 1839, IC IC316, analog/basic/strongarm_comparator.hpp:48
        I(cpphdl_n2308, cpphdl_n2314) <+ 2e-14 * ddt(V(cpphdl_n2308, cpphdl_n2314)); // Bench initial voltage = 3.2999999999999998 V.
        // device 1840, IC IC316, analog/basic/strongarm_comparator.hpp:49
        I(cpphdl_n2307, cpphdl_n2312) <+ 2.9999999999999998e-15 * ddt(V(cpphdl_n2307, cpphdl_n2312)); // Bench initial voltage = 3.2999999999999998 V.
        // device 1841, IC IC316, analog/basic/strongarm_comparator.hpp:50
        I(cpphdl_n2308, cpphdl_n2313) <+ 2.9999999999999998e-15 * ddt(V(cpphdl_n2308, cpphdl_n2313)); // Bench initial voltage = 3.2999999999999998 V.
        // device 1842, IC IC318, analog/basic/inverter.hpp:11
        I(cpphdl_n2335, Vdd) <+ cpphdl_channel(V(cpphdl_n2327, Vdd), V(cpphdl_n2335, Vdd), 0.001, 0.69999999999999996, -1.0);
        // device 1843, IC IC318, analog/basic/inverter.hpp:12
        I(cpphdl_n2335, Vss) <+ cpphdl_channel(V(cpphdl_n2327, Vss), V(cpphdl_n2335, Vss), 0.001, 0.69999999999999996, 1.0);
        // device 1844, IC IC320, analog/basic/inverter.hpp:11
        I(cpphdl_n2349, Vdd) <+ cpphdl_channel(V(cpphdl_n2335, Vdd), V(cpphdl_n2349, Vdd), 0.0040000000000000001, 0.69999999999999996, -1.0);
        // device 1845, IC IC320, analog/basic/inverter.hpp:12
        I(cpphdl_n2349, Vss) <+ cpphdl_channel(V(cpphdl_n2335, Vss), V(cpphdl_n2349, Vss), 0.0040000000000000001, 0.69999999999999996, 1.0);
        // device 1846, IC IC317, analog/basic/buffered_nand_latch.hpp:34
        I(cpphdl_n2327, Vss) <+ 2.0000000000000002e-15 * ddt(V(cpphdl_n2327, Vss)); // Bench initial voltage = 0.0 V.
        // device 1847, IC IC317, analog/basic/buffered_nand_latch.hpp:35
        I(cpphdl_n2327, cpphdl_n2335) <+ 1.0000000000000001e-15 * ddt(V(cpphdl_n2327, cpphdl_n2335)); // Bench initial voltage = 0.0 V.
        // device 1848, IC IC317, analog/basic/buffered_nand_latch.hpp:36
        I(cpphdl_n2335, Vss) <+ 5e-15 * ddt(V(cpphdl_n2335, Vss)); // Bench initial voltage = 0.0 V.
        // device 1849, IC IC317, analog/basic/buffered_nand_latch.hpp:37
        I(cpphdl_n2335, Vss) <+ 8.0000000000000006e-15 * ddt(V(cpphdl_n2335, Vss)); // Bench initial voltage = 0.0 V.
        // device 1850, IC IC317, analog/basic/buffered_nand_latch.hpp:38
        I(cpphdl_n2349, Vss) <+ 1e-14 * ddt(V(cpphdl_n2349, Vss)); // Bench initial voltage = 0.0 V.
        // device 1851, IC IC319, analog/basic/inverter.hpp:11
        I(cpphdl_n2339, Vdd) <+ cpphdl_channel(V(cpphdl_n2331, Vdd), V(cpphdl_n2339, Vdd), 0.001, 0.69999999999999996, -1.0);
        // device 1852, IC IC319, analog/basic/inverter.hpp:12
        I(cpphdl_n2339, Vss) <+ cpphdl_channel(V(cpphdl_n2331, Vss), V(cpphdl_n2339, Vss), 0.001, 0.69999999999999996, 1.0);
        // device 1853, IC IC321, analog/basic/inverter.hpp:11
        I(cpphdl_n2355, Vdd) <+ cpphdl_channel(V(cpphdl_n2339, Vdd), V(cpphdl_n2355, Vdd), 0.0040000000000000001, 0.69999999999999996, -1.0);
        // device 1854, IC IC321, analog/basic/inverter.hpp:12
        I(cpphdl_n2355, Vss) <+ cpphdl_channel(V(cpphdl_n2339, Vss), V(cpphdl_n2355, Vss), 0.0040000000000000001, 0.69999999999999996, 1.0);
        // device 1855, IC IC317, analog/basic/buffered_nand_latch.hpp:34
        I(cpphdl_n2331, Vss) <+ 2.0000000000000002e-15 * ddt(V(cpphdl_n2331, Vss)); // Bench initial voltage = 0.0 V.
        // device 1856, IC IC317, analog/basic/buffered_nand_latch.hpp:35
        I(cpphdl_n2331, cpphdl_n2339) <+ 1.0000000000000001e-15 * ddt(V(cpphdl_n2331, cpphdl_n2339)); // Bench initial voltage = 0.0 V.
        // device 1857, IC IC317, analog/basic/buffered_nand_latch.hpp:36
        I(cpphdl_n2339, Vss) <+ 5e-15 * ddt(V(cpphdl_n2339, Vss)); // Bench initial voltage = 0.0 V.
        // device 1858, IC IC317, analog/basic/buffered_nand_latch.hpp:37
        I(cpphdl_n2339, Vss) <+ 8.0000000000000006e-15 * ddt(V(cpphdl_n2339, Vss)); // Bench initial voltage = 0.0 V.
        // device 1859, IC IC317, analog/basic/buffered_nand_latch.hpp:38
        I(cpphdl_n2355, Vss) <+ 1e-14 * ddt(V(cpphdl_n2355, Vss)); // Bench initial voltage = 0.0 V.
        // device 1860, IC IC323, analog/basic/cmos_logic.hpp:17
        I(cpphdl_n2734, Vss) <+ 5.0000000000000002e-14 * ddt(V(cpphdl_n2734, Vss)); // Bench initial voltage = 0.0 V.
        // device 1861, IC IC323, analog/basic/cmos_logic.hpp:18
        I(cpphdl_n2734, Vdd) <+ cpphdl_channel(V(cpphdl_n2349, Vdd), V(cpphdl_n2734, Vdd), 0.01, 0.69999999999999996, -1.0);
        // device 1862, IC IC323, analog/basic/cmos_logic.hpp:19
        I(cpphdl_n2734, Vdd) <+ cpphdl_channel(V(cpphdl_n2357, Vdd), V(cpphdl_n2734, Vdd), 0.01, 0.69999999999999996, -1.0);
        // device 1863, IC IC323, analog/basic/cmos_logic.hpp:20
        I(cpphdl_n2734, cpphdl_n2352) <+ cpphdl_channel(V(cpphdl_n2349, cpphdl_n2352), V(cpphdl_n2734, cpphdl_n2352), 0.01, 0.69999999999999996, 1.0);
        // device 1864, IC IC323, analog/basic/cmos_logic.hpp:21
        I(cpphdl_n2352, Vss) <+ cpphdl_channel(V(cpphdl_n2357, Vss), V(cpphdl_n2352, Vss), 0.01, 0.69999999999999996, 1.0);
        // device 1865, IC IC323, analog/basic/cmos_logic.hpp:23
        I(cpphdl_n2734, Vss) <+ V(cpphdl_n2734, Vss) / 1000000000.0;
        // device 1866, IC IC323, analog/basic/cmos_logic.hpp:24
        I(cpphdl_n2352, Vss) <+ V(cpphdl_n2352, Vss) / 1000000000.0;
        // device 1867, IC IC324, analog/basic/cmos_logic.hpp:17
        I(cpphdl_n2357, Vss) <+ 5.0000000000000002e-14 * ddt(V(cpphdl_n2357, Vss)); // Bench initial voltage = 0.0 V.
        // device 1868, IC IC324, analog/basic/cmos_logic.hpp:18
        I(cpphdl_n2357, Vdd) <+ cpphdl_channel(V(cpphdl_n2355, Vdd), V(cpphdl_n2357, Vdd), 0.01, 0.69999999999999996, -1.0);
        // device 1869, IC IC324, analog/basic/cmos_logic.hpp:19
        I(cpphdl_n2357, Vdd) <+ cpphdl_channel(V(cpphdl_n2734, Vdd), V(cpphdl_n2357, Vdd), 0.01, 0.69999999999999996, -1.0);
        // device 1870, IC IC324, analog/basic/cmos_logic.hpp:20
        I(cpphdl_n2357, cpphdl_n2358) <+ cpphdl_channel(V(cpphdl_n2355, cpphdl_n2358), V(cpphdl_n2357, cpphdl_n2358), 0.01, 0.69999999999999996, 1.0);
        // device 1871, IC IC324, analog/basic/cmos_logic.hpp:21
        I(cpphdl_n2358, Vss) <+ cpphdl_channel(V(cpphdl_n2734, Vss), V(cpphdl_n2358, Vss), 0.01, 0.69999999999999996, 1.0);
        // device 1872, IC IC324, analog/basic/cmos_logic.hpp:23
        I(cpphdl_n2357, Vss) <+ V(cpphdl_n2357, Vss) / 1000000000.0;
        // device 1873, IC IC324, analog/basic/cmos_logic.hpp:24
        I(cpphdl_n2358, Vss) <+ V(cpphdl_n2358, Vss) / 1000000000.0;
        // device 1874, IC IC322, analog/basic/nand_latch.hpp:36
        I(cpphdl_n2349, Vss) <+ 2.9999999999999998e-15 * ddt(V(cpphdl_n2349, Vss)); // Bench initial voltage = 0.0 V.
        // device 1875, IC IC322, analog/basic/nand_latch.hpp:37
        I(cpphdl_n2355, Vss) <+ 2.9999999999999998e-15 * ddt(V(cpphdl_n2355, Vss)); // Bench initial voltage = 0.0 V.
        // device 1876, IC IC325, analog/basic/inverter.hpp:11
        I(cpphdl_n2363, Vdd) <+ cpphdl_channel(V(CLEAR, Vdd), V(cpphdl_n2363, Vdd), 0.01, 0.69999999999999996, -1.0);
        // device 1877, IC IC325, analog/basic/inverter.hpp:12
        I(cpphdl_n2363, Vss) <+ cpphdl_channel(V(CLEAR, Vss), V(cpphdl_n2363, Vss), 0.01, 0.69999999999999996, 1.0);
        // device 1878, IC IC322, analog/basic/nand_latch.hpp:58
        I(cpphdl_n2363, Vss) <+ 2.9999999999999998e-15 * ddt(V(cpphdl_n2363, Vss)); // Bench initial voltage = 0.0 V.
        // device 1879, IC IC322, analog/basic/nand_latch.hpp:59
        I(cpphdl_n2734, Vss) <+ cpphdl_channel(V(CLEAR, Vss), V(cpphdl_n2734, Vss), 0.050000000000000003, 0.69999999999999996, 1.0);
        // device 1880, IC IC322, analog/basic/nand_latch.hpp:60
        I(cpphdl_n2357, Vdd) <+ cpphdl_channel(V(cpphdl_n2363, Vdd), V(cpphdl_n2357, Vdd), 0.050000000000000003, 0.69999999999999996, -1.0);
        // device 1881, IC IC328, analog/basic/inverter.hpp:11
        I(cpphdl_n2387, Vdd) <+ cpphdl_channel(V(TRACK14, Vdd), V(cpphdl_n2387, Vdd), 0.0040000000000000001, 0.69999999999999996, -1.0);
        // device 1882, IC IC328, analog/basic/inverter.hpp:12
        I(cpphdl_n2387, Vss) <+ cpphdl_channel(V(TRACK14, Vss), V(cpphdl_n2387, Vss), 0.0040000000000000001, 0.69999999999999996, 1.0);
        // device 1883, IC IC327, analog/basic/mos_track_hold.hpp:31
        I(cpphdl_n2387, Vss) <+ 2e-14 * ddt(V(cpphdl_n2387, Vss)); // Bench initial voltage = 3.2999999999999998 V.
        // device 1884, IC IC327, analog/basic/mos_track_hold.hpp:32
        I(cpphdl_n2759, cpphdl_n2441) <+ cpphdl_channel(V(TRACK14, cpphdl_n2441), V(cpphdl_n2759, cpphdl_n2441), 0.080000000000000002, 0.69999999999999996, 1.0);
        // device 1885, IC IC327, analog/basic/mos_track_hold.hpp:33
        I(cpphdl_n2441, cpphdl_n2759) <+ cpphdl_channel(V(cpphdl_n2387, cpphdl_n2759), V(cpphdl_n2441, cpphdl_n2759), 0.040000000000000001, 0.69999999999999996, -1.0);
        // device 1886, IC IC327, analog/basic/mos_track_hold.hpp:37
        I(cpphdl_n2441, cpphdl_n2441) <+ cpphdl_channel(V(cpphdl_n2387, cpphdl_n2441), V(cpphdl_n2441, cpphdl_n2441), 0.040000000000000001, 0.69999999999999996, 1.0);
        // device 1887, IC IC327, analog/basic/mos_track_hold.hpp:38
        I(cpphdl_n2441, cpphdl_n2441) <+ cpphdl_channel(V(TRACK14, cpphdl_n2441), V(cpphdl_n2441, cpphdl_n2441), 0.02, 0.69999999999999996, -1.0);
        // device 1888, IC IC327, analog/basic/mos_track_hold.hpp:39
        I(cpphdl_n2441, Vss) <+ 3.0000000000000001e-12 * ddt(V(cpphdl_n2441, Vss)); // Bench initial voltage = 1.6499999999999999 V.
        // device 1889, IC IC327, analog/basic/mos_track_hold.hpp:41
        I(Vss, cpphdl_n2441) <+ V(Vss, cpphdl_n2441) / 1000000000.0;
        // device 1890, IC IC327, analog/basic/mos_track_hold.hpp:42
        I(TRACK14, cpphdl_n2441) <+ 8.0000000000000006e-15 * ddt(V(TRACK14, cpphdl_n2441)); // Bench initial voltage = -1.6499999999999999 V.
        // device 1891, IC IC327, analog/basic/mos_track_hold.hpp:43
        I(cpphdl_n2387, cpphdl_n2441) <+ 8.0000000000000006e-15 * ddt(V(cpphdl_n2387, cpphdl_n2441)); // Bench initial voltage = 1.6499999999999999 V.
        // device 1892, IC IC327, analog/basic/mos_track_hold.hpp:44
        I(cpphdl_n2759, cpphdl_n2441) <+ 4.0000000000000003e-15 * ddt(V(cpphdl_n2759, cpphdl_n2441)); // Bench initial voltage = 0.0 V.
        // device 1893, IC IC330, analog/basic/inverter.hpp:11
        I(cpphdl_n2402, Vdd) <+ cpphdl_channel(V(BIT_N14_0, Vdd), V(cpphdl_n2402, Vdd), 0.080000000000000002, 0.69999999999999996, -1.0);
        // device 1894, IC IC330, analog/basic/inverter.hpp:12
        I(cpphdl_n2402, Vss) <+ cpphdl_channel(V(BIT_N14_0, Vss), V(cpphdl_n2402, Vss), 0.080000000000000002, 0.69999999999999996, 1.0);
        // device 1895, IC IC329, analog/basic/mos_r2r_dac.hpp:27
        I(cpphdl_n2402, Vss) <+ 2.9999999999999998e-15 * ddt(V(cpphdl_n2402, Vss)); // Bench initial voltage = 0.0 V.
        // device 1896, IC IC329, analog/basic/mos_r2r_dac.hpp:28
        I(cpphdl_n2402, cpphdl_n2431) <+ V(cpphdl_n2402, cpphdl_n2431) / 2000.0;
        // device 1897, IC IC329, analog/basic/mos_r2r_dac.hpp:29
        I(cpphdl_n2431, Vss) <+ 2.9999999999999998e-15 * ddt(V(cpphdl_n2431, Vss)); // Bench initial voltage = 0.0 V.
        // device 1898, IC IC331, analog/basic/inverter.hpp:11
        I(cpphdl_n2406, Vdd) <+ cpphdl_channel(V(BIT_N14_1, Vdd), V(cpphdl_n2406, Vdd), 0.080000000000000002, 0.69999999999999996, -1.0);
        // device 1899, IC IC331, analog/basic/inverter.hpp:12
        I(cpphdl_n2406, Vss) <+ cpphdl_channel(V(BIT_N14_1, Vss), V(cpphdl_n2406, Vss), 0.080000000000000002, 0.69999999999999996, 1.0);
        // device 1900, IC IC329, analog/basic/mos_r2r_dac.hpp:27
        I(cpphdl_n2406, Vss) <+ 2.9999999999999998e-15 * ddt(V(cpphdl_n2406, Vss)); // Bench initial voltage = 0.0 V.
        // device 1901, IC IC329, analog/basic/mos_r2r_dac.hpp:28
        I(cpphdl_n2406, cpphdl_n2432) <+ V(cpphdl_n2406, cpphdl_n2432) / 2000.0;
        // device 1902, IC IC329, analog/basic/mos_r2r_dac.hpp:29
        I(cpphdl_n2432, Vss) <+ 2.9999999999999998e-15 * ddt(V(cpphdl_n2432, Vss)); // Bench initial voltage = 0.0 V.
        // device 1903, IC IC329, analog/basic/mos_r2r_dac.hpp:31
        I(cpphdl_n2431, cpphdl_n2432) <+ V(cpphdl_n2431, cpphdl_n2432) / 1000.0;
        // device 1904, IC IC332, analog/basic/inverter.hpp:11
        I(cpphdl_n2410, Vdd) <+ cpphdl_channel(V(BIT_N14_2, Vdd), V(cpphdl_n2410, Vdd), 0.080000000000000002, 0.69999999999999996, -1.0);
        // device 1905, IC IC332, analog/basic/inverter.hpp:12
        I(cpphdl_n2410, Vss) <+ cpphdl_channel(V(BIT_N14_2, Vss), V(cpphdl_n2410, Vss), 0.080000000000000002, 0.69999999999999996, 1.0);
        // device 1906, IC IC329, analog/basic/mos_r2r_dac.hpp:27
        I(cpphdl_n2410, Vss) <+ 2.9999999999999998e-15 * ddt(V(cpphdl_n2410, Vss)); // Bench initial voltage = 0.0 V.
        // device 1907, IC IC329, analog/basic/mos_r2r_dac.hpp:28
        I(cpphdl_n2410, cpphdl_n2433) <+ V(cpphdl_n2410, cpphdl_n2433) / 2000.0;
        // device 1908, IC IC329, analog/basic/mos_r2r_dac.hpp:29
        I(cpphdl_n2433, Vss) <+ 2.9999999999999998e-15 * ddt(V(cpphdl_n2433, Vss)); // Bench initial voltage = 0.0 V.
        // device 1909, IC IC329, analog/basic/mos_r2r_dac.hpp:31
        I(cpphdl_n2432, cpphdl_n2433) <+ V(cpphdl_n2432, cpphdl_n2433) / 1000.0;
        // device 1910, IC IC333, analog/basic/inverter.hpp:11
        I(cpphdl_n2414, Vdd) <+ cpphdl_channel(V(BIT_N14_3, Vdd), V(cpphdl_n2414, Vdd), 0.080000000000000002, 0.69999999999999996, -1.0);
        // device 1911, IC IC333, analog/basic/inverter.hpp:12
        I(cpphdl_n2414, Vss) <+ cpphdl_channel(V(BIT_N14_3, Vss), V(cpphdl_n2414, Vss), 0.080000000000000002, 0.69999999999999996, 1.0);
        // device 1912, IC IC329, analog/basic/mos_r2r_dac.hpp:27
        I(cpphdl_n2414, Vss) <+ 2.9999999999999998e-15 * ddt(V(cpphdl_n2414, Vss)); // Bench initial voltage = 0.0 V.
        // device 1913, IC IC329, analog/basic/mos_r2r_dac.hpp:28
        I(cpphdl_n2414, cpphdl_n2434) <+ V(cpphdl_n2414, cpphdl_n2434) / 2000.0;
        // device 1914, IC IC329, analog/basic/mos_r2r_dac.hpp:29
        I(cpphdl_n2434, Vss) <+ 2.9999999999999998e-15 * ddt(V(cpphdl_n2434, Vss)); // Bench initial voltage = 0.0 V.
        // device 1915, IC IC329, analog/basic/mos_r2r_dac.hpp:31
        I(cpphdl_n2433, cpphdl_n2434) <+ V(cpphdl_n2433, cpphdl_n2434) / 1000.0;
        // device 1916, IC IC334, analog/basic/inverter.hpp:11
        I(cpphdl_n2418, Vdd) <+ cpphdl_channel(V(BIT_N14_4, Vdd), V(cpphdl_n2418, Vdd), 0.080000000000000002, 0.69999999999999996, -1.0);
        // device 1917, IC IC334, analog/basic/inverter.hpp:12
        I(cpphdl_n2418, Vss) <+ cpphdl_channel(V(BIT_N14_4, Vss), V(cpphdl_n2418, Vss), 0.080000000000000002, 0.69999999999999996, 1.0);
        // device 1918, IC IC329, analog/basic/mos_r2r_dac.hpp:27
        I(cpphdl_n2418, Vss) <+ 2.9999999999999998e-15 * ddt(V(cpphdl_n2418, Vss)); // Bench initial voltage = 0.0 V.
        // device 1919, IC IC329, analog/basic/mos_r2r_dac.hpp:28
        I(cpphdl_n2418, cpphdl_n2435) <+ V(cpphdl_n2418, cpphdl_n2435) / 2000.0;
        // device 1920, IC IC329, analog/basic/mos_r2r_dac.hpp:29
        I(cpphdl_n2435, Vss) <+ 2.9999999999999998e-15 * ddt(V(cpphdl_n2435, Vss)); // Bench initial voltage = 0.0 V.
        // device 1921, IC IC329, analog/basic/mos_r2r_dac.hpp:31
        I(cpphdl_n2434, cpphdl_n2435) <+ V(cpphdl_n2434, cpphdl_n2435) / 1000.0;
        // device 1922, IC IC335, analog/basic/inverter.hpp:11
        I(cpphdl_n2422, Vdd) <+ cpphdl_channel(V(BIT_N14_5, Vdd), V(cpphdl_n2422, Vdd), 0.080000000000000002, 0.69999999999999996, -1.0);
        // device 1923, IC IC335, analog/basic/inverter.hpp:12
        I(cpphdl_n2422, Vss) <+ cpphdl_channel(V(BIT_N14_5, Vss), V(cpphdl_n2422, Vss), 0.080000000000000002, 0.69999999999999996, 1.0);
        // device 1924, IC IC329, analog/basic/mos_r2r_dac.hpp:27
        I(cpphdl_n2422, Vss) <+ 2.9999999999999998e-15 * ddt(V(cpphdl_n2422, Vss)); // Bench initial voltage = 0.0 V.
        // device 1925, IC IC329, analog/basic/mos_r2r_dac.hpp:28
        I(cpphdl_n2422, cpphdl_n2436) <+ V(cpphdl_n2422, cpphdl_n2436) / 2000.0;
        // device 1926, IC IC329, analog/basic/mos_r2r_dac.hpp:29
        I(cpphdl_n2436, Vss) <+ 2.9999999999999998e-15 * ddt(V(cpphdl_n2436, Vss)); // Bench initial voltage = 0.0 V.
        // device 1927, IC IC329, analog/basic/mos_r2r_dac.hpp:31
        I(cpphdl_n2435, cpphdl_n2436) <+ V(cpphdl_n2435, cpphdl_n2436) / 1000.0;
        // device 1928, IC IC336, analog/basic/inverter.hpp:11
        I(cpphdl_n2426, Vdd) <+ cpphdl_channel(V(BIT_N14_6, Vdd), V(cpphdl_n2426, Vdd), 0.080000000000000002, 0.69999999999999996, -1.0);
        // device 1929, IC IC336, analog/basic/inverter.hpp:12
        I(cpphdl_n2426, Vss) <+ cpphdl_channel(V(BIT_N14_6, Vss), V(cpphdl_n2426, Vss), 0.080000000000000002, 0.69999999999999996, 1.0);
        // device 1930, IC IC329, analog/basic/mos_r2r_dac.hpp:27
        I(cpphdl_n2426, Vss) <+ 2.9999999999999998e-15 * ddt(V(cpphdl_n2426, Vss)); // Bench initial voltage = 0.0 V.
        // device 1931, IC IC329, analog/basic/mos_r2r_dac.hpp:28
        I(cpphdl_n2426, cpphdl_n2437) <+ V(cpphdl_n2426, cpphdl_n2437) / 2000.0;
        // device 1932, IC IC329, analog/basic/mos_r2r_dac.hpp:29
        I(cpphdl_n2437, Vss) <+ 2.9999999999999998e-15 * ddt(V(cpphdl_n2437, Vss)); // Bench initial voltage = 0.0 V.
        // device 1933, IC IC329, analog/basic/mos_r2r_dac.hpp:31
        I(cpphdl_n2436, cpphdl_n2437) <+ V(cpphdl_n2436, cpphdl_n2437) / 1000.0;
        // device 1934, IC IC337, analog/basic/inverter.hpp:11
        I(cpphdl_n2430, Vdd) <+ cpphdl_channel(V(BIT_N14_7, Vdd), V(cpphdl_n2430, Vdd), 0.080000000000000002, 0.69999999999999996, -1.0);
        // device 1935, IC IC337, analog/basic/inverter.hpp:12
        I(cpphdl_n2430, Vss) <+ cpphdl_channel(V(BIT_N14_7, Vss), V(cpphdl_n2430, Vss), 0.080000000000000002, 0.69999999999999996, 1.0);
        // device 1936, IC IC329, analog/basic/mos_r2r_dac.hpp:27
        I(cpphdl_n2430, Vss) <+ 2.9999999999999998e-15 * ddt(V(cpphdl_n2430, Vss)); // Bench initial voltage = 0.0 V.
        // device 1937, IC IC329, analog/basic/mos_r2r_dac.hpp:28
        I(cpphdl_n2430, cpphdl_n2442) <+ V(cpphdl_n2430, cpphdl_n2442) / 2000.0;
        // device 1938, IC IC329, analog/basic/mos_r2r_dac.hpp:29
        I(cpphdl_n2442, Vss) <+ 2.9999999999999998e-15 * ddt(V(cpphdl_n2442, Vss)); // Bench initial voltage = 0.0 V.
        // device 1939, IC IC329, analog/basic/mos_r2r_dac.hpp:31
        I(cpphdl_n2437, cpphdl_n2442) <+ V(cpphdl_n2437, cpphdl_n2442) / 1000.0;
        // device 1940, IC IC329, analog/basic/mos_r2r_dac.hpp:33
        I(Vss, cpphdl_n2431) <+ V(Vss, cpphdl_n2431) / 2000.0;
        // device 1941, IC IC338, analog/basic/nmos_resistor_amplifier.hpp:23
        I(Vdd, cpphdl_n2451) <+ V(Vdd, cpphdl_n2451) / 500.0;
        // device 1942, IC IC338, analog/basic/nmos_resistor_amplifier.hpp:24
        I(Vdd, cpphdl_n2450) <+ V(Vdd, cpphdl_n2450) / 500.0;
        // device 1943, IC IC338, analog/basic/nmos_resistor_amplifier.hpp:25
        I(cpphdl_n2451, cpphdl_n2445) <+ cpphdl_channel(V(cpphdl_n2441, cpphdl_n2445), V(cpphdl_n2451, cpphdl_n2445), 0.014999999999999999, 0.69999999999999996, 1.0);
        // device 1944, IC IC338, analog/basic/nmos_resistor_amplifier.hpp:26
        I(cpphdl_n2450, cpphdl_n2446) <+ cpphdl_channel(V(cpphdl_n2442, cpphdl_n2446), V(cpphdl_n2450, cpphdl_n2446), 0.014999999999999999, 0.69999999999999996, 1.0);
        // device 1945, IC IC338, analog/basic/nmos_resistor_amplifier.hpp:27
        I(cpphdl_n2447, cpphdl_n2445) <+ V(cpphdl_n2447, cpphdl_n2445) / 50.0;
        // device 1946, IC IC338, analog/basic/nmos_resistor_amplifier.hpp:28
        I(cpphdl_n2447, cpphdl_n2446) <+ V(cpphdl_n2447, cpphdl_n2446) / 50.0;
        // device 1947, IC IC338, analog/basic/nmos_resistor_amplifier.hpp:29
        I(Vss, cpphdl_n2447) <+ V(Vss, cpphdl_n2447) / 150.0;
        // device 1948, IC IC338, analog/basic/nmos_resistor_amplifier.hpp:30
        I(cpphdl_n2451, Vdd) <+ 2.9999999999999998e-13 * ddt(V(cpphdl_n2451, Vdd)); // Bench initial voltage = 0.0 V.
        // device 1949, IC IC338, analog/basic/nmos_resistor_amplifier.hpp:31
        I(cpphdl_n2450, Vdd) <+ 2.9999999999999998e-13 * ddt(V(cpphdl_n2450, Vdd)); // Bench initial voltage = 0.0 V.
        // device 1950, IC IC338, analog/basic/nmos_resistor_amplifier.hpp:32
        I(cpphdl_n2447, Vss) <+ 4e-14 * ddt(V(cpphdl_n2447, Vss)); // Bench initial voltage = 0.0 V.
        // device 1951, IC IC338, analog/basic/nmos_resistor_amplifier.hpp:34
        I(cpphdl_n2441, cpphdl_n2445) <+ 2e-14 * ddt(V(cpphdl_n2441, cpphdl_n2445)); // Bench initial voltage = 1.6499999999999999 V.
        // device 1952, IC IC338, analog/basic/nmos_resistor_amplifier.hpp:35
        I(cpphdl_n2442, cpphdl_n2446) <+ 2e-14 * ddt(V(cpphdl_n2442, cpphdl_n2446)); // Bench initial voltage = 0.0 V.
        // device 1953, IC IC338, analog/basic/nmos_resistor_amplifier.hpp:36
        I(cpphdl_n2441, cpphdl_n2451) <+ 2.9999999999999998e-15 * ddt(V(cpphdl_n2441, cpphdl_n2451)); // Bench initial voltage = -1.6499999999999999 V.
        // device 1954, IC IC338, analog/basic/nmos_resistor_amplifier.hpp:37
        I(cpphdl_n2442, cpphdl_n2450) <+ 2.9999999999999998e-15 * ddt(V(cpphdl_n2442, cpphdl_n2450)); // Bench initial voltage = -3.2999999999999998 V.
        // device 1955, IC IC339, analog/basic/strongarm_comparator.hpp:28
        I(cpphdl_n2455, cpphdl_n2457) <+ cpphdl_channel(V(cpphdl_n2450, cpphdl_n2457), V(cpphdl_n2455, cpphdl_n2457), 0.0080000000000000002, 0.69999999999999996, 1.0);
        // device 1956, IC IC339, analog/basic/strongarm_comparator.hpp:29
        I(cpphdl_n2456, cpphdl_n2457) <+ cpphdl_channel(V(cpphdl_n2451, cpphdl_n2457), V(cpphdl_n2456, cpphdl_n2457), 0.0080000000000000002, 0.69999999999999996, 1.0);
        // device 1957, IC IC339, analog/basic/strongarm_comparator.hpp:30
        I(cpphdl_n2457, Vss) <+ cpphdl_channel(V(EVALUATE, Vss), V(cpphdl_n2457, Vss), 0.0080000000000000002, 0.69999999999999996, 1.0);
        // device 1958, IC IC339, analog/basic/strongarm_comparator.hpp:33
        I(cpphdl_n2470, cpphdl_n2455) <+ cpphdl_channel(V(cpphdl_n2474, cpphdl_n2455), V(cpphdl_n2470, cpphdl_n2455), 0.0040000000000000001, 0.69999999999999996, 1.0);
        // device 1959, IC IC339, analog/basic/strongarm_comparator.hpp:34
        I(cpphdl_n2474, cpphdl_n2456) <+ cpphdl_channel(V(cpphdl_n2470, cpphdl_n2456), V(cpphdl_n2474, cpphdl_n2456), 0.0040000000000000001, 0.69999999999999996, 1.0);
        // device 1960, IC IC339, analog/basic/strongarm_comparator.hpp:35
        I(cpphdl_n2474, Vdd) <+ cpphdl_channel(V(cpphdl_n2470, Vdd), V(cpphdl_n2474, Vdd), 0.002, 0.69999999999999996, -1.0);
        // device 1961, IC IC339, analog/basic/strongarm_comparator.hpp:36
        I(cpphdl_n2470, Vdd) <+ cpphdl_channel(V(cpphdl_n2474, Vdd), V(cpphdl_n2470, Vdd), 0.002, 0.69999999999999996, -1.0);
        // device 1962, IC IC339, analog/basic/strongarm_comparator.hpp:38
        I(cpphdl_n2455, Vdd) <+ cpphdl_channel(V(EVALUATE, Vdd), V(cpphdl_n2455, Vdd), 0.002, 0.69999999999999996, -1.0);
        // device 1963, IC IC339, analog/basic/strongarm_comparator.hpp:39
        I(cpphdl_n2456, Vdd) <+ cpphdl_channel(V(EVALUATE, Vdd), V(cpphdl_n2456, Vdd), 0.002, 0.69999999999999996, -1.0);
        // device 1964, IC IC339, analog/basic/strongarm_comparator.hpp:40
        I(cpphdl_n2474, Vdd) <+ cpphdl_channel(V(EVALUATE, Vdd), V(cpphdl_n2474, Vdd), 0.002, 0.69999999999999996, -1.0);
        // device 1965, IC IC339, analog/basic/strongarm_comparator.hpp:41
        I(cpphdl_n2470, Vdd) <+ cpphdl_channel(V(EVALUATE, Vdd), V(cpphdl_n2470, Vdd), 0.002, 0.69999999999999996, -1.0);
        // device 1966, IC IC339, analog/basic/strongarm_comparator.hpp:42
        I(cpphdl_n2455, Vss) <+ 2.9999999999999998e-14 * ddt(V(cpphdl_n2455, Vss)); // Bench initial voltage = 0.0 V.
        // device 1967, IC IC339, analog/basic/strongarm_comparator.hpp:43
        I(cpphdl_n2456, Vss) <+ 2.9999999999999998e-14 * ddt(V(cpphdl_n2456, Vss)); // Bench initial voltage = 0.0 V.
        // device 1968, IC IC339, analog/basic/strongarm_comparator.hpp:44
        I(cpphdl_n2457, Vss) <+ 2.9999999999999998e-14 * ddt(V(cpphdl_n2457, Vss)); // Bench initial voltage = 0.0 V.
        // device 1969, IC IC339, analog/basic/strongarm_comparator.hpp:45
        I(cpphdl_n2474, Vss) <+ 5.0000000000000002e-14 * ddt(V(cpphdl_n2474, Vss)); // Bench initial voltage = 0.0 V.
        // device 1970, IC IC339, analog/basic/strongarm_comparator.hpp:46
        I(cpphdl_n2470, Vss) <+ 5.0000000000000002e-14 * ddt(V(cpphdl_n2470, Vss)); // Bench initial voltage = 0.0 V.
        // device 1971, IC IC339, analog/basic/strongarm_comparator.hpp:47
        I(cpphdl_n2450, cpphdl_n2457) <+ 2e-14 * ddt(V(cpphdl_n2450, cpphdl_n2457)); // Bench initial voltage = 3.2999999999999998 V.
        // device 1972, IC IC339, analog/basic/strongarm_comparator.hpp:48
        I(cpphdl_n2451, cpphdl_n2457) <+ 2e-14 * ddt(V(cpphdl_n2451, cpphdl_n2457)); // Bench initial voltage = 3.2999999999999998 V.
        // device 1973, IC IC339, analog/basic/strongarm_comparator.hpp:49
        I(cpphdl_n2450, cpphdl_n2455) <+ 2.9999999999999998e-15 * ddt(V(cpphdl_n2450, cpphdl_n2455)); // Bench initial voltage = 3.2999999999999998 V.
        // device 1974, IC IC339, analog/basic/strongarm_comparator.hpp:50
        I(cpphdl_n2451, cpphdl_n2456) <+ 2.9999999999999998e-15 * ddt(V(cpphdl_n2451, cpphdl_n2456)); // Bench initial voltage = 3.2999999999999998 V.
        // device 1975, IC IC341, analog/basic/inverter.hpp:11
        I(cpphdl_n2478, Vdd) <+ cpphdl_channel(V(cpphdl_n2470, Vdd), V(cpphdl_n2478, Vdd), 0.001, 0.69999999999999996, -1.0);
        // device 1976, IC IC341, analog/basic/inverter.hpp:12
        I(cpphdl_n2478, Vss) <+ cpphdl_channel(V(cpphdl_n2470, Vss), V(cpphdl_n2478, Vss), 0.001, 0.69999999999999996, 1.0);
        // device 1977, IC IC343, analog/basic/inverter.hpp:11
        I(cpphdl_n2492, Vdd) <+ cpphdl_channel(V(cpphdl_n2478, Vdd), V(cpphdl_n2492, Vdd), 0.0040000000000000001, 0.69999999999999996, -1.0);
        // device 1978, IC IC343, analog/basic/inverter.hpp:12
        I(cpphdl_n2492, Vss) <+ cpphdl_channel(V(cpphdl_n2478, Vss), V(cpphdl_n2492, Vss), 0.0040000000000000001, 0.69999999999999996, 1.0);
        // device 1979, IC IC340, analog/basic/buffered_nand_latch.hpp:34
        I(cpphdl_n2470, Vss) <+ 2.0000000000000002e-15 * ddt(V(cpphdl_n2470, Vss)); // Bench initial voltage = 0.0 V.
        // device 1980, IC IC340, analog/basic/buffered_nand_latch.hpp:35
        I(cpphdl_n2470, cpphdl_n2478) <+ 1.0000000000000001e-15 * ddt(V(cpphdl_n2470, cpphdl_n2478)); // Bench initial voltage = 0.0 V.
        // device 1981, IC IC340, analog/basic/buffered_nand_latch.hpp:36
        I(cpphdl_n2478, Vss) <+ 5e-15 * ddt(V(cpphdl_n2478, Vss)); // Bench initial voltage = 0.0 V.
        // device 1982, IC IC340, analog/basic/buffered_nand_latch.hpp:37
        I(cpphdl_n2478, Vss) <+ 8.0000000000000006e-15 * ddt(V(cpphdl_n2478, Vss)); // Bench initial voltage = 0.0 V.
        // device 1983, IC IC340, analog/basic/buffered_nand_latch.hpp:38
        I(cpphdl_n2492, Vss) <+ 1e-14 * ddt(V(cpphdl_n2492, Vss)); // Bench initial voltage = 0.0 V.
        // device 1984, IC IC342, analog/basic/inverter.hpp:11
        I(cpphdl_n2482, Vdd) <+ cpphdl_channel(V(cpphdl_n2474, Vdd), V(cpphdl_n2482, Vdd), 0.001, 0.69999999999999996, -1.0);
        // device 1985, IC IC342, analog/basic/inverter.hpp:12
        I(cpphdl_n2482, Vss) <+ cpphdl_channel(V(cpphdl_n2474, Vss), V(cpphdl_n2482, Vss), 0.001, 0.69999999999999996, 1.0);
        // device 1986, IC IC344, analog/basic/inverter.hpp:11
        I(cpphdl_n2498, Vdd) <+ cpphdl_channel(V(cpphdl_n2482, Vdd), V(cpphdl_n2498, Vdd), 0.0040000000000000001, 0.69999999999999996, -1.0);
        // device 1987, IC IC344, analog/basic/inverter.hpp:12
        I(cpphdl_n2498, Vss) <+ cpphdl_channel(V(cpphdl_n2482, Vss), V(cpphdl_n2498, Vss), 0.0040000000000000001, 0.69999999999999996, 1.0);
        // device 1988, IC IC340, analog/basic/buffered_nand_latch.hpp:34
        I(cpphdl_n2474, Vss) <+ 2.0000000000000002e-15 * ddt(V(cpphdl_n2474, Vss)); // Bench initial voltage = 0.0 V.
        // device 1989, IC IC340, analog/basic/buffered_nand_latch.hpp:35
        I(cpphdl_n2474, cpphdl_n2482) <+ 1.0000000000000001e-15 * ddt(V(cpphdl_n2474, cpphdl_n2482)); // Bench initial voltage = 0.0 V.
        // device 1990, IC IC340, analog/basic/buffered_nand_latch.hpp:36
        I(cpphdl_n2482, Vss) <+ 5e-15 * ddt(V(cpphdl_n2482, Vss)); // Bench initial voltage = 0.0 V.
        // device 1991, IC IC340, analog/basic/buffered_nand_latch.hpp:37
        I(cpphdl_n2482, Vss) <+ 8.0000000000000006e-15 * ddt(V(cpphdl_n2482, Vss)); // Bench initial voltage = 0.0 V.
        // device 1992, IC IC340, analog/basic/buffered_nand_latch.hpp:38
        I(cpphdl_n2498, Vss) <+ 1e-14 * ddt(V(cpphdl_n2498, Vss)); // Bench initial voltage = 0.0 V.
        // device 1993, IC IC346, analog/basic/cmos_logic.hpp:17
        I(cpphdl_n2739, Vss) <+ 5.0000000000000002e-14 * ddt(V(cpphdl_n2739, Vss)); // Bench initial voltage = 0.0 V.
        // device 1994, IC IC346, analog/basic/cmos_logic.hpp:18
        I(cpphdl_n2739, Vdd) <+ cpphdl_channel(V(cpphdl_n2492, Vdd), V(cpphdl_n2739, Vdd), 0.01, 0.69999999999999996, -1.0);
        // device 1995, IC IC346, analog/basic/cmos_logic.hpp:19
        I(cpphdl_n2739, Vdd) <+ cpphdl_channel(V(cpphdl_n2500, Vdd), V(cpphdl_n2739, Vdd), 0.01, 0.69999999999999996, -1.0);
        // device 1996, IC IC346, analog/basic/cmos_logic.hpp:20
        I(cpphdl_n2739, cpphdl_n2495) <+ cpphdl_channel(V(cpphdl_n2492, cpphdl_n2495), V(cpphdl_n2739, cpphdl_n2495), 0.01, 0.69999999999999996, 1.0);
        // device 1997, IC IC346, analog/basic/cmos_logic.hpp:21
        I(cpphdl_n2495, Vss) <+ cpphdl_channel(V(cpphdl_n2500, Vss), V(cpphdl_n2495, Vss), 0.01, 0.69999999999999996, 1.0);
        // device 1998, IC IC346, analog/basic/cmos_logic.hpp:23
        I(cpphdl_n2739, Vss) <+ V(cpphdl_n2739, Vss) / 1000000000.0;
        // device 1999, IC IC346, analog/basic/cmos_logic.hpp:24
        I(cpphdl_n2495, Vss) <+ V(cpphdl_n2495, Vss) / 1000000000.0;
        // device 2000, IC IC347, analog/basic/cmos_logic.hpp:17
        I(cpphdl_n2500, Vss) <+ 5.0000000000000002e-14 * ddt(V(cpphdl_n2500, Vss)); // Bench initial voltage = 0.0 V.
        // device 2001, IC IC347, analog/basic/cmos_logic.hpp:18
        I(cpphdl_n2500, Vdd) <+ cpphdl_channel(V(cpphdl_n2498, Vdd), V(cpphdl_n2500, Vdd), 0.01, 0.69999999999999996, -1.0);
        // device 2002, IC IC347, analog/basic/cmos_logic.hpp:19
        I(cpphdl_n2500, Vdd) <+ cpphdl_channel(V(cpphdl_n2739, Vdd), V(cpphdl_n2500, Vdd), 0.01, 0.69999999999999996, -1.0);
        // device 2003, IC IC347, analog/basic/cmos_logic.hpp:20
        I(cpphdl_n2500, cpphdl_n2501) <+ cpphdl_channel(V(cpphdl_n2498, cpphdl_n2501), V(cpphdl_n2500, cpphdl_n2501), 0.01, 0.69999999999999996, 1.0);
        // device 2004, IC IC347, analog/basic/cmos_logic.hpp:21
        I(cpphdl_n2501, Vss) <+ cpphdl_channel(V(cpphdl_n2739, Vss), V(cpphdl_n2501, Vss), 0.01, 0.69999999999999996, 1.0);
        // device 2005, IC IC347, analog/basic/cmos_logic.hpp:23
        I(cpphdl_n2500, Vss) <+ V(cpphdl_n2500, Vss) / 1000000000.0;
        // device 2006, IC IC347, analog/basic/cmos_logic.hpp:24
        I(cpphdl_n2501, Vss) <+ V(cpphdl_n2501, Vss) / 1000000000.0;
        // device 2007, IC IC345, analog/basic/nand_latch.hpp:36
        I(cpphdl_n2492, Vss) <+ 2.9999999999999998e-15 * ddt(V(cpphdl_n2492, Vss)); // Bench initial voltage = 0.0 V.
        // device 2008, IC IC345, analog/basic/nand_latch.hpp:37
        I(cpphdl_n2498, Vss) <+ 2.9999999999999998e-15 * ddt(V(cpphdl_n2498, Vss)); // Bench initial voltage = 0.0 V.
        // device 2009, IC IC348, analog/basic/inverter.hpp:11
        I(cpphdl_n2506, Vdd) <+ cpphdl_channel(V(CLEAR, Vdd), V(cpphdl_n2506, Vdd), 0.01, 0.69999999999999996, -1.0);
        // device 2010, IC IC348, analog/basic/inverter.hpp:12
        I(cpphdl_n2506, Vss) <+ cpphdl_channel(V(CLEAR, Vss), V(cpphdl_n2506, Vss), 0.01, 0.69999999999999996, 1.0);
        // device 2011, IC IC345, analog/basic/nand_latch.hpp:58
        I(cpphdl_n2506, Vss) <+ 2.9999999999999998e-15 * ddt(V(cpphdl_n2506, Vss)); // Bench initial voltage = 0.0 V.
        // device 2012, IC IC345, analog/basic/nand_latch.hpp:59
        I(cpphdl_n2739, Vss) <+ cpphdl_channel(V(CLEAR, Vss), V(cpphdl_n2739, Vss), 0.050000000000000003, 0.69999999999999996, 1.0);
        // device 2013, IC IC345, analog/basic/nand_latch.hpp:60
        I(cpphdl_n2500, Vdd) <+ cpphdl_channel(V(cpphdl_n2506, Vdd), V(cpphdl_n2500, Vdd), 0.050000000000000003, 0.69999999999999996, -1.0);
        // device 2014, IC IC351, analog/basic/inverter.hpp:11
        I(cpphdl_n2530, Vdd) <+ cpphdl_channel(V(TRACK15, Vdd), V(cpphdl_n2530, Vdd), 0.0040000000000000001, 0.69999999999999996, -1.0);
        // device 2015, IC IC351, analog/basic/inverter.hpp:12
        I(cpphdl_n2530, Vss) <+ cpphdl_channel(V(TRACK15, Vss), V(cpphdl_n2530, Vss), 0.0040000000000000001, 0.69999999999999996, 1.0);
        // device 2016, IC IC350, analog/basic/mos_track_hold.hpp:31
        I(cpphdl_n2530, Vss) <+ 2e-14 * ddt(V(cpphdl_n2530, Vss)); // Bench initial voltage = 3.2999999999999998 V.
        // device 2017, IC IC350, analog/basic/mos_track_hold.hpp:32
        I(cpphdl_n2759, cpphdl_n2584) <+ cpphdl_channel(V(TRACK15, cpphdl_n2584), V(cpphdl_n2759, cpphdl_n2584), 0.080000000000000002, 0.69999999999999996, 1.0);
        // device 2018, IC IC350, analog/basic/mos_track_hold.hpp:33
        I(cpphdl_n2584, cpphdl_n2759) <+ cpphdl_channel(V(cpphdl_n2530, cpphdl_n2759), V(cpphdl_n2584, cpphdl_n2759), 0.040000000000000001, 0.69999999999999996, -1.0);
        // device 2019, IC IC350, analog/basic/mos_track_hold.hpp:37
        I(cpphdl_n2584, cpphdl_n2584) <+ cpphdl_channel(V(cpphdl_n2530, cpphdl_n2584), V(cpphdl_n2584, cpphdl_n2584), 0.040000000000000001, 0.69999999999999996, 1.0);
        // device 2020, IC IC350, analog/basic/mos_track_hold.hpp:38
        I(cpphdl_n2584, cpphdl_n2584) <+ cpphdl_channel(V(TRACK15, cpphdl_n2584), V(cpphdl_n2584, cpphdl_n2584), 0.02, 0.69999999999999996, -1.0);
        // device 2021, IC IC350, analog/basic/mos_track_hold.hpp:39
        I(cpphdl_n2584, Vss) <+ 3.0000000000000001e-12 * ddt(V(cpphdl_n2584, Vss)); // Bench initial voltage = 1.6499999999999999 V.
        // device 2022, IC IC350, analog/basic/mos_track_hold.hpp:41
        I(Vss, cpphdl_n2584) <+ V(Vss, cpphdl_n2584) / 1000000000.0;
        // device 2023, IC IC350, analog/basic/mos_track_hold.hpp:42
        I(TRACK15, cpphdl_n2584) <+ 8.0000000000000006e-15 * ddt(V(TRACK15, cpphdl_n2584)); // Bench initial voltage = -1.6499999999999999 V.
        // device 2024, IC IC350, analog/basic/mos_track_hold.hpp:43
        I(cpphdl_n2530, cpphdl_n2584) <+ 8.0000000000000006e-15 * ddt(V(cpphdl_n2530, cpphdl_n2584)); // Bench initial voltage = 1.6499999999999999 V.
        // device 2025, IC IC350, analog/basic/mos_track_hold.hpp:44
        I(cpphdl_n2759, cpphdl_n2584) <+ 4.0000000000000003e-15 * ddt(V(cpphdl_n2759, cpphdl_n2584)); // Bench initial voltage = 0.0 V.
        // device 2026, IC IC353, analog/basic/inverter.hpp:11
        I(cpphdl_n2545, Vdd) <+ cpphdl_channel(V(BIT_N15_0, Vdd), V(cpphdl_n2545, Vdd), 0.080000000000000002, 0.69999999999999996, -1.0);
        // device 2027, IC IC353, analog/basic/inverter.hpp:12
        I(cpphdl_n2545, Vss) <+ cpphdl_channel(V(BIT_N15_0, Vss), V(cpphdl_n2545, Vss), 0.080000000000000002, 0.69999999999999996, 1.0);
        // device 2028, IC IC352, analog/basic/mos_r2r_dac.hpp:27
        I(cpphdl_n2545, Vss) <+ 2.9999999999999998e-15 * ddt(V(cpphdl_n2545, Vss)); // Bench initial voltage = 0.0 V.
        // device 2029, IC IC352, analog/basic/mos_r2r_dac.hpp:28
        I(cpphdl_n2545, cpphdl_n2574) <+ V(cpphdl_n2545, cpphdl_n2574) / 2000.0;
        // device 2030, IC IC352, analog/basic/mos_r2r_dac.hpp:29
        I(cpphdl_n2574, Vss) <+ 2.9999999999999998e-15 * ddt(V(cpphdl_n2574, Vss)); // Bench initial voltage = 0.0 V.
        // device 2031, IC IC354, analog/basic/inverter.hpp:11
        I(cpphdl_n2549, Vdd) <+ cpphdl_channel(V(BIT_N15_1, Vdd), V(cpphdl_n2549, Vdd), 0.080000000000000002, 0.69999999999999996, -1.0);
        // device 2032, IC IC354, analog/basic/inverter.hpp:12
        I(cpphdl_n2549, Vss) <+ cpphdl_channel(V(BIT_N15_1, Vss), V(cpphdl_n2549, Vss), 0.080000000000000002, 0.69999999999999996, 1.0);
        // device 2033, IC IC352, analog/basic/mos_r2r_dac.hpp:27
        I(cpphdl_n2549, Vss) <+ 2.9999999999999998e-15 * ddt(V(cpphdl_n2549, Vss)); // Bench initial voltage = 0.0 V.
        // device 2034, IC IC352, analog/basic/mos_r2r_dac.hpp:28
        I(cpphdl_n2549, cpphdl_n2575) <+ V(cpphdl_n2549, cpphdl_n2575) / 2000.0;
        // device 2035, IC IC352, analog/basic/mos_r2r_dac.hpp:29
        I(cpphdl_n2575, Vss) <+ 2.9999999999999998e-15 * ddt(V(cpphdl_n2575, Vss)); // Bench initial voltage = 0.0 V.
        // device 2036, IC IC352, analog/basic/mos_r2r_dac.hpp:31
        I(cpphdl_n2574, cpphdl_n2575) <+ V(cpphdl_n2574, cpphdl_n2575) / 1000.0;
        // device 2037, IC IC355, analog/basic/inverter.hpp:11
        I(cpphdl_n2553, Vdd) <+ cpphdl_channel(V(BIT_N15_2, Vdd), V(cpphdl_n2553, Vdd), 0.080000000000000002, 0.69999999999999996, -1.0);
        // device 2038, IC IC355, analog/basic/inverter.hpp:12
        I(cpphdl_n2553, Vss) <+ cpphdl_channel(V(BIT_N15_2, Vss), V(cpphdl_n2553, Vss), 0.080000000000000002, 0.69999999999999996, 1.0);
        // device 2039, IC IC352, analog/basic/mos_r2r_dac.hpp:27
        I(cpphdl_n2553, Vss) <+ 2.9999999999999998e-15 * ddt(V(cpphdl_n2553, Vss)); // Bench initial voltage = 0.0 V.
        // device 2040, IC IC352, analog/basic/mos_r2r_dac.hpp:28
        I(cpphdl_n2553, cpphdl_n2576) <+ V(cpphdl_n2553, cpphdl_n2576) / 2000.0;
        // device 2041, IC IC352, analog/basic/mos_r2r_dac.hpp:29
        I(cpphdl_n2576, Vss) <+ 2.9999999999999998e-15 * ddt(V(cpphdl_n2576, Vss)); // Bench initial voltage = 0.0 V.
        // device 2042, IC IC352, analog/basic/mos_r2r_dac.hpp:31
        I(cpphdl_n2575, cpphdl_n2576) <+ V(cpphdl_n2575, cpphdl_n2576) / 1000.0;
        // device 2043, IC IC356, analog/basic/inverter.hpp:11
        I(cpphdl_n2557, Vdd) <+ cpphdl_channel(V(BIT_N15_3, Vdd), V(cpphdl_n2557, Vdd), 0.080000000000000002, 0.69999999999999996, -1.0);
        // device 2044, IC IC356, analog/basic/inverter.hpp:12
        I(cpphdl_n2557, Vss) <+ cpphdl_channel(V(BIT_N15_3, Vss), V(cpphdl_n2557, Vss), 0.080000000000000002, 0.69999999999999996, 1.0);
        // device 2045, IC IC352, analog/basic/mos_r2r_dac.hpp:27
        I(cpphdl_n2557, Vss) <+ 2.9999999999999998e-15 * ddt(V(cpphdl_n2557, Vss)); // Bench initial voltage = 0.0 V.
        // device 2046, IC IC352, analog/basic/mos_r2r_dac.hpp:28
        I(cpphdl_n2557, cpphdl_n2577) <+ V(cpphdl_n2557, cpphdl_n2577) / 2000.0;
        // device 2047, IC IC352, analog/basic/mos_r2r_dac.hpp:29
        I(cpphdl_n2577, Vss) <+ 2.9999999999999998e-15 * ddt(V(cpphdl_n2577, Vss)); // Bench initial voltage = 0.0 V.
        // device 2048, IC IC352, analog/basic/mos_r2r_dac.hpp:31
        I(cpphdl_n2576, cpphdl_n2577) <+ V(cpphdl_n2576, cpphdl_n2577) / 1000.0;
        // device 2049, IC IC357, analog/basic/inverter.hpp:11
        I(cpphdl_n2561, Vdd) <+ cpphdl_channel(V(BIT_N15_4, Vdd), V(cpphdl_n2561, Vdd), 0.080000000000000002, 0.69999999999999996, -1.0);
        // device 2050, IC IC357, analog/basic/inverter.hpp:12
        I(cpphdl_n2561, Vss) <+ cpphdl_channel(V(BIT_N15_4, Vss), V(cpphdl_n2561, Vss), 0.080000000000000002, 0.69999999999999996, 1.0);
        // device 2051, IC IC352, analog/basic/mos_r2r_dac.hpp:27
        I(cpphdl_n2561, Vss) <+ 2.9999999999999998e-15 * ddt(V(cpphdl_n2561, Vss)); // Bench initial voltage = 0.0 V.
        // device 2052, IC IC352, analog/basic/mos_r2r_dac.hpp:28
        I(cpphdl_n2561, cpphdl_n2578) <+ V(cpphdl_n2561, cpphdl_n2578) / 2000.0;
        // device 2053, IC IC352, analog/basic/mos_r2r_dac.hpp:29
        I(cpphdl_n2578, Vss) <+ 2.9999999999999998e-15 * ddt(V(cpphdl_n2578, Vss)); // Bench initial voltage = 0.0 V.
        // device 2054, IC IC352, analog/basic/mos_r2r_dac.hpp:31
        I(cpphdl_n2577, cpphdl_n2578) <+ V(cpphdl_n2577, cpphdl_n2578) / 1000.0;
        // device 2055, IC IC358, analog/basic/inverter.hpp:11
        I(cpphdl_n2565, Vdd) <+ cpphdl_channel(V(BIT_N15_5, Vdd), V(cpphdl_n2565, Vdd), 0.080000000000000002, 0.69999999999999996, -1.0);
        // device 2056, IC IC358, analog/basic/inverter.hpp:12
        I(cpphdl_n2565, Vss) <+ cpphdl_channel(V(BIT_N15_5, Vss), V(cpphdl_n2565, Vss), 0.080000000000000002, 0.69999999999999996, 1.0);
        // device 2057, IC IC352, analog/basic/mos_r2r_dac.hpp:27
        I(cpphdl_n2565, Vss) <+ 2.9999999999999998e-15 * ddt(V(cpphdl_n2565, Vss)); // Bench initial voltage = 0.0 V.
        // device 2058, IC IC352, analog/basic/mos_r2r_dac.hpp:28
        I(cpphdl_n2565, cpphdl_n2579) <+ V(cpphdl_n2565, cpphdl_n2579) / 2000.0;
        // device 2059, IC IC352, analog/basic/mos_r2r_dac.hpp:29
        I(cpphdl_n2579, Vss) <+ 2.9999999999999998e-15 * ddt(V(cpphdl_n2579, Vss)); // Bench initial voltage = 0.0 V.
        // device 2060, IC IC352, analog/basic/mos_r2r_dac.hpp:31
        I(cpphdl_n2578, cpphdl_n2579) <+ V(cpphdl_n2578, cpphdl_n2579) / 1000.0;
        // device 2061, IC IC359, analog/basic/inverter.hpp:11
        I(cpphdl_n2569, Vdd) <+ cpphdl_channel(V(BIT_N15_6, Vdd), V(cpphdl_n2569, Vdd), 0.080000000000000002, 0.69999999999999996, -1.0);
        // device 2062, IC IC359, analog/basic/inverter.hpp:12
        I(cpphdl_n2569, Vss) <+ cpphdl_channel(V(BIT_N15_6, Vss), V(cpphdl_n2569, Vss), 0.080000000000000002, 0.69999999999999996, 1.0);
        // device 2063, IC IC352, analog/basic/mos_r2r_dac.hpp:27
        I(cpphdl_n2569, Vss) <+ 2.9999999999999998e-15 * ddt(V(cpphdl_n2569, Vss)); // Bench initial voltage = 0.0 V.
        // device 2064, IC IC352, analog/basic/mos_r2r_dac.hpp:28
        I(cpphdl_n2569, cpphdl_n2580) <+ V(cpphdl_n2569, cpphdl_n2580) / 2000.0;
        // device 2065, IC IC352, analog/basic/mos_r2r_dac.hpp:29
        I(cpphdl_n2580, Vss) <+ 2.9999999999999998e-15 * ddt(V(cpphdl_n2580, Vss)); // Bench initial voltage = 0.0 V.
        // device 2066, IC IC352, analog/basic/mos_r2r_dac.hpp:31
        I(cpphdl_n2579, cpphdl_n2580) <+ V(cpphdl_n2579, cpphdl_n2580) / 1000.0;
        // device 2067, IC IC360, analog/basic/inverter.hpp:11
        I(cpphdl_n2573, Vdd) <+ cpphdl_channel(V(BIT_N15_7, Vdd), V(cpphdl_n2573, Vdd), 0.080000000000000002, 0.69999999999999996, -1.0);
        // device 2068, IC IC360, analog/basic/inverter.hpp:12
        I(cpphdl_n2573, Vss) <+ cpphdl_channel(V(BIT_N15_7, Vss), V(cpphdl_n2573, Vss), 0.080000000000000002, 0.69999999999999996, 1.0);
        // device 2069, IC IC352, analog/basic/mos_r2r_dac.hpp:27
        I(cpphdl_n2573, Vss) <+ 2.9999999999999998e-15 * ddt(V(cpphdl_n2573, Vss)); // Bench initial voltage = 0.0 V.
        // device 2070, IC IC352, analog/basic/mos_r2r_dac.hpp:28
        I(cpphdl_n2573, cpphdl_n2585) <+ V(cpphdl_n2573, cpphdl_n2585) / 2000.0;
        // device 2071, IC IC352, analog/basic/mos_r2r_dac.hpp:29
        I(cpphdl_n2585, Vss) <+ 2.9999999999999998e-15 * ddt(V(cpphdl_n2585, Vss)); // Bench initial voltage = 0.0 V.
        // device 2072, IC IC352, analog/basic/mos_r2r_dac.hpp:31
        I(cpphdl_n2580, cpphdl_n2585) <+ V(cpphdl_n2580, cpphdl_n2585) / 1000.0;
        // device 2073, IC IC352, analog/basic/mos_r2r_dac.hpp:33
        I(Vss, cpphdl_n2574) <+ V(Vss, cpphdl_n2574) / 2000.0;
        // device 2074, IC IC361, analog/basic/nmos_resistor_amplifier.hpp:23
        I(Vdd, cpphdl_n2594) <+ V(Vdd, cpphdl_n2594) / 500.0;
        // device 2075, IC IC361, analog/basic/nmos_resistor_amplifier.hpp:24
        I(Vdd, cpphdl_n2593) <+ V(Vdd, cpphdl_n2593) / 500.0;
        // device 2076, IC IC361, analog/basic/nmos_resistor_amplifier.hpp:25
        I(cpphdl_n2594, cpphdl_n2588) <+ cpphdl_channel(V(cpphdl_n2584, cpphdl_n2588), V(cpphdl_n2594, cpphdl_n2588), 0.014999999999999999, 0.69999999999999996, 1.0);
        // device 2077, IC IC361, analog/basic/nmos_resistor_amplifier.hpp:26
        I(cpphdl_n2593, cpphdl_n2589) <+ cpphdl_channel(V(cpphdl_n2585, cpphdl_n2589), V(cpphdl_n2593, cpphdl_n2589), 0.014999999999999999, 0.69999999999999996, 1.0);
        // device 2078, IC IC361, analog/basic/nmos_resistor_amplifier.hpp:27
        I(cpphdl_n2590, cpphdl_n2588) <+ V(cpphdl_n2590, cpphdl_n2588) / 50.0;
        // device 2079, IC IC361, analog/basic/nmos_resistor_amplifier.hpp:28
        I(cpphdl_n2590, cpphdl_n2589) <+ V(cpphdl_n2590, cpphdl_n2589) / 50.0;
        // device 2080, IC IC361, analog/basic/nmos_resistor_amplifier.hpp:29
        I(Vss, cpphdl_n2590) <+ V(Vss, cpphdl_n2590) / 150.0;
        // device 2081, IC IC361, analog/basic/nmos_resistor_amplifier.hpp:30
        I(cpphdl_n2594, Vdd) <+ 2.9999999999999998e-13 * ddt(V(cpphdl_n2594, Vdd)); // Bench initial voltage = 0.0 V.
        // device 2082, IC IC361, analog/basic/nmos_resistor_amplifier.hpp:31
        I(cpphdl_n2593, Vdd) <+ 2.9999999999999998e-13 * ddt(V(cpphdl_n2593, Vdd)); // Bench initial voltage = 0.0 V.
        // device 2083, IC IC361, analog/basic/nmos_resistor_amplifier.hpp:32
        I(cpphdl_n2590, Vss) <+ 4e-14 * ddt(V(cpphdl_n2590, Vss)); // Bench initial voltage = 0.0 V.
        // device 2084, IC IC361, analog/basic/nmos_resistor_amplifier.hpp:34
        I(cpphdl_n2584, cpphdl_n2588) <+ 2e-14 * ddt(V(cpphdl_n2584, cpphdl_n2588)); // Bench initial voltage = 1.6499999999999999 V.
        // device 2085, IC IC361, analog/basic/nmos_resistor_amplifier.hpp:35
        I(cpphdl_n2585, cpphdl_n2589) <+ 2e-14 * ddt(V(cpphdl_n2585, cpphdl_n2589)); // Bench initial voltage = 0.0 V.
        // device 2086, IC IC361, analog/basic/nmos_resistor_amplifier.hpp:36
        I(cpphdl_n2584, cpphdl_n2594) <+ 2.9999999999999998e-15 * ddt(V(cpphdl_n2584, cpphdl_n2594)); // Bench initial voltage = -1.6499999999999999 V.
        // device 2087, IC IC361, analog/basic/nmos_resistor_amplifier.hpp:37
        I(cpphdl_n2585, cpphdl_n2593) <+ 2.9999999999999998e-15 * ddt(V(cpphdl_n2585, cpphdl_n2593)); // Bench initial voltage = -3.2999999999999998 V.
        // device 2088, IC IC362, analog/basic/strongarm_comparator.hpp:28
        I(cpphdl_n2598, cpphdl_n2600) <+ cpphdl_channel(V(cpphdl_n2593, cpphdl_n2600), V(cpphdl_n2598, cpphdl_n2600), 0.0080000000000000002, 0.69999999999999996, 1.0);
        // device 2089, IC IC362, analog/basic/strongarm_comparator.hpp:29
        I(cpphdl_n2599, cpphdl_n2600) <+ cpphdl_channel(V(cpphdl_n2594, cpphdl_n2600), V(cpphdl_n2599, cpphdl_n2600), 0.0080000000000000002, 0.69999999999999996, 1.0);
        // device 2090, IC IC362, analog/basic/strongarm_comparator.hpp:30
        I(cpphdl_n2600, Vss) <+ cpphdl_channel(V(EVALUATE, Vss), V(cpphdl_n2600, Vss), 0.0080000000000000002, 0.69999999999999996, 1.0);
        // device 2091, IC IC362, analog/basic/strongarm_comparator.hpp:33
        I(cpphdl_n2613, cpphdl_n2598) <+ cpphdl_channel(V(cpphdl_n2617, cpphdl_n2598), V(cpphdl_n2613, cpphdl_n2598), 0.0040000000000000001, 0.69999999999999996, 1.0);
        // device 2092, IC IC362, analog/basic/strongarm_comparator.hpp:34
        I(cpphdl_n2617, cpphdl_n2599) <+ cpphdl_channel(V(cpphdl_n2613, cpphdl_n2599), V(cpphdl_n2617, cpphdl_n2599), 0.0040000000000000001, 0.69999999999999996, 1.0);
        // device 2093, IC IC362, analog/basic/strongarm_comparator.hpp:35
        I(cpphdl_n2617, Vdd) <+ cpphdl_channel(V(cpphdl_n2613, Vdd), V(cpphdl_n2617, Vdd), 0.002, 0.69999999999999996, -1.0);
        // device 2094, IC IC362, analog/basic/strongarm_comparator.hpp:36
        I(cpphdl_n2613, Vdd) <+ cpphdl_channel(V(cpphdl_n2617, Vdd), V(cpphdl_n2613, Vdd), 0.002, 0.69999999999999996, -1.0);
        // device 2095, IC IC362, analog/basic/strongarm_comparator.hpp:38
        I(cpphdl_n2598, Vdd) <+ cpphdl_channel(V(EVALUATE, Vdd), V(cpphdl_n2598, Vdd), 0.002, 0.69999999999999996, -1.0);
        // device 2096, IC IC362, analog/basic/strongarm_comparator.hpp:39
        I(cpphdl_n2599, Vdd) <+ cpphdl_channel(V(EVALUATE, Vdd), V(cpphdl_n2599, Vdd), 0.002, 0.69999999999999996, -1.0);
        // device 2097, IC IC362, analog/basic/strongarm_comparator.hpp:40
        I(cpphdl_n2617, Vdd) <+ cpphdl_channel(V(EVALUATE, Vdd), V(cpphdl_n2617, Vdd), 0.002, 0.69999999999999996, -1.0);
        // device 2098, IC IC362, analog/basic/strongarm_comparator.hpp:41
        I(cpphdl_n2613, Vdd) <+ cpphdl_channel(V(EVALUATE, Vdd), V(cpphdl_n2613, Vdd), 0.002, 0.69999999999999996, -1.0);
        // device 2099, IC IC362, analog/basic/strongarm_comparator.hpp:42
        I(cpphdl_n2598, Vss) <+ 2.9999999999999998e-14 * ddt(V(cpphdl_n2598, Vss)); // Bench initial voltage = 0.0 V.
        // device 2100, IC IC362, analog/basic/strongarm_comparator.hpp:43
        I(cpphdl_n2599, Vss) <+ 2.9999999999999998e-14 * ddt(V(cpphdl_n2599, Vss)); // Bench initial voltage = 0.0 V.
        // device 2101, IC IC362, analog/basic/strongarm_comparator.hpp:44
        I(cpphdl_n2600, Vss) <+ 2.9999999999999998e-14 * ddt(V(cpphdl_n2600, Vss)); // Bench initial voltage = 0.0 V.
        // device 2102, IC IC362, analog/basic/strongarm_comparator.hpp:45
        I(cpphdl_n2617, Vss) <+ 5.0000000000000002e-14 * ddt(V(cpphdl_n2617, Vss)); // Bench initial voltage = 0.0 V.
        // device 2103, IC IC362, analog/basic/strongarm_comparator.hpp:46
        I(cpphdl_n2613, Vss) <+ 5.0000000000000002e-14 * ddt(V(cpphdl_n2613, Vss)); // Bench initial voltage = 0.0 V.
        // device 2104, IC IC362, analog/basic/strongarm_comparator.hpp:47
        I(cpphdl_n2593, cpphdl_n2600) <+ 2e-14 * ddt(V(cpphdl_n2593, cpphdl_n2600)); // Bench initial voltage = 3.2999999999999998 V.
        // device 2105, IC IC362, analog/basic/strongarm_comparator.hpp:48
        I(cpphdl_n2594, cpphdl_n2600) <+ 2e-14 * ddt(V(cpphdl_n2594, cpphdl_n2600)); // Bench initial voltage = 3.2999999999999998 V.
        // device 2106, IC IC362, analog/basic/strongarm_comparator.hpp:49
        I(cpphdl_n2593, cpphdl_n2598) <+ 2.9999999999999998e-15 * ddt(V(cpphdl_n2593, cpphdl_n2598)); // Bench initial voltage = 3.2999999999999998 V.
        // device 2107, IC IC362, analog/basic/strongarm_comparator.hpp:50
        I(cpphdl_n2594, cpphdl_n2599) <+ 2.9999999999999998e-15 * ddt(V(cpphdl_n2594, cpphdl_n2599)); // Bench initial voltage = 3.2999999999999998 V.
        // device 2108, IC IC364, analog/basic/inverter.hpp:11
        I(cpphdl_n2621, Vdd) <+ cpphdl_channel(V(cpphdl_n2613, Vdd), V(cpphdl_n2621, Vdd), 0.001, 0.69999999999999996, -1.0);
        // device 2109, IC IC364, analog/basic/inverter.hpp:12
        I(cpphdl_n2621, Vss) <+ cpphdl_channel(V(cpphdl_n2613, Vss), V(cpphdl_n2621, Vss), 0.001, 0.69999999999999996, 1.0);
        // device 2110, IC IC366, analog/basic/inverter.hpp:11
        I(cpphdl_n2635, Vdd) <+ cpphdl_channel(V(cpphdl_n2621, Vdd), V(cpphdl_n2635, Vdd), 0.0040000000000000001, 0.69999999999999996, -1.0);
        // device 2111, IC IC366, analog/basic/inverter.hpp:12
        I(cpphdl_n2635, Vss) <+ cpphdl_channel(V(cpphdl_n2621, Vss), V(cpphdl_n2635, Vss), 0.0040000000000000001, 0.69999999999999996, 1.0);
        // device 2112, IC IC363, analog/basic/buffered_nand_latch.hpp:34
        I(cpphdl_n2613, Vss) <+ 2.0000000000000002e-15 * ddt(V(cpphdl_n2613, Vss)); // Bench initial voltage = 0.0 V.
        // device 2113, IC IC363, analog/basic/buffered_nand_latch.hpp:35
        I(cpphdl_n2613, cpphdl_n2621) <+ 1.0000000000000001e-15 * ddt(V(cpphdl_n2613, cpphdl_n2621)); // Bench initial voltage = 0.0 V.
        // device 2114, IC IC363, analog/basic/buffered_nand_latch.hpp:36
        I(cpphdl_n2621, Vss) <+ 5e-15 * ddt(V(cpphdl_n2621, Vss)); // Bench initial voltage = 0.0 V.
        // device 2115, IC IC363, analog/basic/buffered_nand_latch.hpp:37
        I(cpphdl_n2621, Vss) <+ 8.0000000000000006e-15 * ddt(V(cpphdl_n2621, Vss)); // Bench initial voltage = 0.0 V.
        // device 2116, IC IC363, analog/basic/buffered_nand_latch.hpp:38
        I(cpphdl_n2635, Vss) <+ 1e-14 * ddt(V(cpphdl_n2635, Vss)); // Bench initial voltage = 0.0 V.
        // device 2117, IC IC365, analog/basic/inverter.hpp:11
        I(cpphdl_n2625, Vdd) <+ cpphdl_channel(V(cpphdl_n2617, Vdd), V(cpphdl_n2625, Vdd), 0.001, 0.69999999999999996, -1.0);
        // device 2118, IC IC365, analog/basic/inverter.hpp:12
        I(cpphdl_n2625, Vss) <+ cpphdl_channel(V(cpphdl_n2617, Vss), V(cpphdl_n2625, Vss), 0.001, 0.69999999999999996, 1.0);
        // device 2119, IC IC367, analog/basic/inverter.hpp:11
        I(cpphdl_n2641, Vdd) <+ cpphdl_channel(V(cpphdl_n2625, Vdd), V(cpphdl_n2641, Vdd), 0.0040000000000000001, 0.69999999999999996, -1.0);
        // device 2120, IC IC367, analog/basic/inverter.hpp:12
        I(cpphdl_n2641, Vss) <+ cpphdl_channel(V(cpphdl_n2625, Vss), V(cpphdl_n2641, Vss), 0.0040000000000000001, 0.69999999999999996, 1.0);
        // device 2121, IC IC363, analog/basic/buffered_nand_latch.hpp:34
        I(cpphdl_n2617, Vss) <+ 2.0000000000000002e-15 * ddt(V(cpphdl_n2617, Vss)); // Bench initial voltage = 0.0 V.
        // device 2122, IC IC363, analog/basic/buffered_nand_latch.hpp:35
        I(cpphdl_n2617, cpphdl_n2625) <+ 1.0000000000000001e-15 * ddt(V(cpphdl_n2617, cpphdl_n2625)); // Bench initial voltage = 0.0 V.
        // device 2123, IC IC363, analog/basic/buffered_nand_latch.hpp:36
        I(cpphdl_n2625, Vss) <+ 5e-15 * ddt(V(cpphdl_n2625, Vss)); // Bench initial voltage = 0.0 V.
        // device 2124, IC IC363, analog/basic/buffered_nand_latch.hpp:37
        I(cpphdl_n2625, Vss) <+ 8.0000000000000006e-15 * ddt(V(cpphdl_n2625, Vss)); // Bench initial voltage = 0.0 V.
        // device 2125, IC IC363, analog/basic/buffered_nand_latch.hpp:38
        I(cpphdl_n2641, Vss) <+ 1e-14 * ddt(V(cpphdl_n2641, Vss)); // Bench initial voltage = 0.0 V.
        // device 2126, IC IC369, analog/basic/cmos_logic.hpp:17
        I(cpphdl_n2744, Vss) <+ 5.0000000000000002e-14 * ddt(V(cpphdl_n2744, Vss)); // Bench initial voltage = 0.0 V.
        // device 2127, IC IC369, analog/basic/cmos_logic.hpp:18
        I(cpphdl_n2744, Vdd) <+ cpphdl_channel(V(cpphdl_n2635, Vdd), V(cpphdl_n2744, Vdd), 0.01, 0.69999999999999996, -1.0);
        // device 2128, IC IC369, analog/basic/cmos_logic.hpp:19
        I(cpphdl_n2744, Vdd) <+ cpphdl_channel(V(cpphdl_n2643, Vdd), V(cpphdl_n2744, Vdd), 0.01, 0.69999999999999996, -1.0);
        // device 2129, IC IC369, analog/basic/cmos_logic.hpp:20
        I(cpphdl_n2744, cpphdl_n2638) <+ cpphdl_channel(V(cpphdl_n2635, cpphdl_n2638), V(cpphdl_n2744, cpphdl_n2638), 0.01, 0.69999999999999996, 1.0);
        // device 2130, IC IC369, analog/basic/cmos_logic.hpp:21
        I(cpphdl_n2638, Vss) <+ cpphdl_channel(V(cpphdl_n2643, Vss), V(cpphdl_n2638, Vss), 0.01, 0.69999999999999996, 1.0);
        // device 2131, IC IC369, analog/basic/cmos_logic.hpp:23
        I(cpphdl_n2744, Vss) <+ V(cpphdl_n2744, Vss) / 1000000000.0;
        // device 2132, IC IC369, analog/basic/cmos_logic.hpp:24
        I(cpphdl_n2638, Vss) <+ V(cpphdl_n2638, Vss) / 1000000000.0;
        // device 2133, IC IC370, analog/basic/cmos_logic.hpp:17
        I(cpphdl_n2643, Vss) <+ 5.0000000000000002e-14 * ddt(V(cpphdl_n2643, Vss)); // Bench initial voltage = 0.0 V.
        // device 2134, IC IC370, analog/basic/cmos_logic.hpp:18
        I(cpphdl_n2643, Vdd) <+ cpphdl_channel(V(cpphdl_n2641, Vdd), V(cpphdl_n2643, Vdd), 0.01, 0.69999999999999996, -1.0);
        // device 2135, IC IC370, analog/basic/cmos_logic.hpp:19
        I(cpphdl_n2643, Vdd) <+ cpphdl_channel(V(cpphdl_n2744, Vdd), V(cpphdl_n2643, Vdd), 0.01, 0.69999999999999996, -1.0);
        // device 2136, IC IC370, analog/basic/cmos_logic.hpp:20
        I(cpphdl_n2643, cpphdl_n2644) <+ cpphdl_channel(V(cpphdl_n2641, cpphdl_n2644), V(cpphdl_n2643, cpphdl_n2644), 0.01, 0.69999999999999996, 1.0);
        // device 2137, IC IC370, analog/basic/cmos_logic.hpp:21
        I(cpphdl_n2644, Vss) <+ cpphdl_channel(V(cpphdl_n2744, Vss), V(cpphdl_n2644, Vss), 0.01, 0.69999999999999996, 1.0);
        // device 2138, IC IC370, analog/basic/cmos_logic.hpp:23
        I(cpphdl_n2643, Vss) <+ V(cpphdl_n2643, Vss) / 1000000000.0;
        // device 2139, IC IC370, analog/basic/cmos_logic.hpp:24
        I(cpphdl_n2644, Vss) <+ V(cpphdl_n2644, Vss) / 1000000000.0;
        // device 2140, IC IC368, analog/basic/nand_latch.hpp:36
        I(cpphdl_n2635, Vss) <+ 2.9999999999999998e-15 * ddt(V(cpphdl_n2635, Vss)); // Bench initial voltage = 0.0 V.
        // device 2141, IC IC368, analog/basic/nand_latch.hpp:37
        I(cpphdl_n2641, Vss) <+ 2.9999999999999998e-15 * ddt(V(cpphdl_n2641, Vss)); // Bench initial voltage = 0.0 V.
        // device 2142, IC IC371, analog/basic/inverter.hpp:11
        I(cpphdl_n2649, Vdd) <+ cpphdl_channel(V(CLEAR, Vdd), V(cpphdl_n2649, Vdd), 0.01, 0.69999999999999996, -1.0);
        // device 2143, IC IC371, analog/basic/inverter.hpp:12
        I(cpphdl_n2649, Vss) <+ cpphdl_channel(V(CLEAR, Vss), V(cpphdl_n2649, Vss), 0.01, 0.69999999999999996, 1.0);
        // device 2144, IC IC368, analog/basic/nand_latch.hpp:58
        I(cpphdl_n2649, Vss) <+ 2.9999999999999998e-15 * ddt(V(cpphdl_n2649, Vss)); // Bench initial voltage = 0.0 V.
        // device 2145, IC IC368, analog/basic/nand_latch.hpp:59
        I(cpphdl_n2744, Vss) <+ cpphdl_channel(V(CLEAR, Vss), V(cpphdl_n2744, Vss), 0.050000000000000003, 0.69999999999999996, 1.0);
        // device 2146, IC IC368, analog/basic/nand_latch.hpp:60
        I(cpphdl_n2643, Vdd) <+ cpphdl_channel(V(cpphdl_n2649, Vdd), V(cpphdl_n2643, Vdd), 0.050000000000000003, 0.69999999999999996, -1.0);
        // device 2147, IC IC372, analog/basic/level_down.hpp:23
        I(cpphdl_n2671, Vlogic) <+ cpphdl_channel(V(Vss, Vlogic), V(cpphdl_n2671, Vlogic), 0.00050000000000000001, 0.34999999999999998, -1.0);
        // device 2148, IC IC372, analog/basic/level_down.hpp:24
        I(cpphdl_n2671, Vss) <+ cpphdl_channel(V(cpphdl_n2669, Vss), V(cpphdl_n2671, Vss), 0.0040000000000000001, 0.69999999999999996, 1.0);
        // device 2149, IC IC372, analog/basic/level_down.hpp:25
        I(CORE_DECISION0, Vlogic) <+ cpphdl_channel(V(cpphdl_n2671, Vlogic), V(CORE_DECISION0, Vlogic), 0.0050000000000000001, 0.34999999999999998, -1.0);
        // device 2150, IC IC372, analog/basic/level_down.hpp:26
        I(CORE_DECISION0, Vss) <+ cpphdl_channel(V(cpphdl_n2671, Vss), V(CORE_DECISION0, Vss), 0.01, 0.34999999999999998, 1.0);
        // device 2151, IC IC372, analog/basic/level_down.hpp:27
        I(cpphdl_n2669, Vss) <+ 5e-15 * ddt(V(cpphdl_n2669, Vss)); // Bench initial voltage = 0.0 V.
        // device 2152, IC IC372, analog/basic/level_down.hpp:28
        I(cpphdl_n2669, Vlogic) <+ 5e-15 * ddt(V(cpphdl_n2669, Vlogic)); // Bench initial voltage = 0.0 V.
        // device 2153, IC IC372, analog/basic/level_down.hpp:29
        I(cpphdl_n2669, cpphdl_n2671) <+ 2.0000000000000002e-15 * ddt(V(cpphdl_n2669, cpphdl_n2671)); // Bench initial voltage = 0.0 V.
        // device 2154, IC IC372, analog/basic/level_down.hpp:30
        I(cpphdl_n2671, Vss) <+ 8e-14 * ddt(V(cpphdl_n2671, Vss)); // Bench initial voltage = 0.0 V.
        // device 2155, IC IC372, analog/basic/level_down.hpp:31
        I(cpphdl_n2671, Vlogic) <+ 5e-15 * ddt(V(cpphdl_n2671, Vlogic)); // Bench initial voltage = 0.0 V.
        // device 2156, IC IC372, analog/basic/level_down.hpp:32
        I(cpphdl_n2671, CORE_DECISION0) <+ 2.0000000000000002e-15 * ddt(V(cpphdl_n2671, CORE_DECISION0)); // Bench initial voltage = 0.0 V.
        // device 2157, IC IC372, analog/basic/level_down.hpp:33
        I(CORE_DECISION0, Vss) <+ 1e-14 * ddt(V(CORE_DECISION0, Vss)); // Bench initial voltage = 0.0 V.
        // device 2158, IC IC373, analog/basic/level_down.hpp:23
        I(cpphdl_n2676, Vlogic) <+ cpphdl_channel(V(Vss, Vlogic), V(cpphdl_n2676, Vlogic), 0.00050000000000000001, 0.34999999999999998, -1.0);
        // device 2159, IC IC373, analog/basic/level_down.hpp:24
        I(cpphdl_n2676, Vss) <+ cpphdl_channel(V(cpphdl_n2674, Vss), V(cpphdl_n2676, Vss), 0.0040000000000000001, 0.69999999999999996, 1.0);
        // device 2160, IC IC373, analog/basic/level_down.hpp:25
        I(CORE_DECISION1, Vlogic) <+ cpphdl_channel(V(cpphdl_n2676, Vlogic), V(CORE_DECISION1, Vlogic), 0.0050000000000000001, 0.34999999999999998, -1.0);
        // device 2161, IC IC373, analog/basic/level_down.hpp:26
        I(CORE_DECISION1, Vss) <+ cpphdl_channel(V(cpphdl_n2676, Vss), V(CORE_DECISION1, Vss), 0.01, 0.34999999999999998, 1.0);
        // device 2162, IC IC373, analog/basic/level_down.hpp:27
        I(cpphdl_n2674, Vss) <+ 5e-15 * ddt(V(cpphdl_n2674, Vss)); // Bench initial voltage = 0.0 V.
        // device 2163, IC IC373, analog/basic/level_down.hpp:28
        I(cpphdl_n2674, Vlogic) <+ 5e-15 * ddt(V(cpphdl_n2674, Vlogic)); // Bench initial voltage = 0.0 V.
        // device 2164, IC IC373, analog/basic/level_down.hpp:29
        I(cpphdl_n2674, cpphdl_n2676) <+ 2.0000000000000002e-15 * ddt(V(cpphdl_n2674, cpphdl_n2676)); // Bench initial voltage = 0.0 V.
        // device 2165, IC IC373, analog/basic/level_down.hpp:30
        I(cpphdl_n2676, Vss) <+ 8e-14 * ddt(V(cpphdl_n2676, Vss)); // Bench initial voltage = 0.0 V.
        // device 2166, IC IC373, analog/basic/level_down.hpp:31
        I(cpphdl_n2676, Vlogic) <+ 5e-15 * ddt(V(cpphdl_n2676, Vlogic)); // Bench initial voltage = 0.0 V.
        // device 2167, IC IC373, analog/basic/level_down.hpp:32
        I(cpphdl_n2676, CORE_DECISION1) <+ 2.0000000000000002e-15 * ddt(V(cpphdl_n2676, CORE_DECISION1)); // Bench initial voltage = 0.0 V.
        // device 2168, IC IC373, analog/basic/level_down.hpp:33
        I(CORE_DECISION1, Vss) <+ 1e-14 * ddt(V(CORE_DECISION1, Vss)); // Bench initial voltage = 0.0 V.
        // device 2169, IC IC374, analog/basic/level_down.hpp:23
        I(cpphdl_n2681, Vlogic) <+ cpphdl_channel(V(Vss, Vlogic), V(cpphdl_n2681, Vlogic), 0.00050000000000000001, 0.34999999999999998, -1.0);
        // device 2170, IC IC374, analog/basic/level_down.hpp:24
        I(cpphdl_n2681, Vss) <+ cpphdl_channel(V(cpphdl_n2679, Vss), V(cpphdl_n2681, Vss), 0.0040000000000000001, 0.69999999999999996, 1.0);
        // device 2171, IC IC374, analog/basic/level_down.hpp:25
        I(CORE_DECISION2, Vlogic) <+ cpphdl_channel(V(cpphdl_n2681, Vlogic), V(CORE_DECISION2, Vlogic), 0.0050000000000000001, 0.34999999999999998, -1.0);
        // device 2172, IC IC374, analog/basic/level_down.hpp:26
        I(CORE_DECISION2, Vss) <+ cpphdl_channel(V(cpphdl_n2681, Vss), V(CORE_DECISION2, Vss), 0.01, 0.34999999999999998, 1.0);
        // device 2173, IC IC374, analog/basic/level_down.hpp:27
        I(cpphdl_n2679, Vss) <+ 5e-15 * ddt(V(cpphdl_n2679, Vss)); // Bench initial voltage = 0.0 V.
        // device 2174, IC IC374, analog/basic/level_down.hpp:28
        I(cpphdl_n2679, Vlogic) <+ 5e-15 * ddt(V(cpphdl_n2679, Vlogic)); // Bench initial voltage = 0.0 V.
        // device 2175, IC IC374, analog/basic/level_down.hpp:29
        I(cpphdl_n2679, cpphdl_n2681) <+ 2.0000000000000002e-15 * ddt(V(cpphdl_n2679, cpphdl_n2681)); // Bench initial voltage = 0.0 V.
        // device 2176, IC IC374, analog/basic/level_down.hpp:30
        I(cpphdl_n2681, Vss) <+ 8e-14 * ddt(V(cpphdl_n2681, Vss)); // Bench initial voltage = 0.0 V.
        // device 2177, IC IC374, analog/basic/level_down.hpp:31
        I(cpphdl_n2681, Vlogic) <+ 5e-15 * ddt(V(cpphdl_n2681, Vlogic)); // Bench initial voltage = 0.0 V.
        // device 2178, IC IC374, analog/basic/level_down.hpp:32
        I(cpphdl_n2681, CORE_DECISION2) <+ 2.0000000000000002e-15 * ddt(V(cpphdl_n2681, CORE_DECISION2)); // Bench initial voltage = 0.0 V.
        // device 2179, IC IC374, analog/basic/level_down.hpp:33
        I(CORE_DECISION2, Vss) <+ 1e-14 * ddt(V(CORE_DECISION2, Vss)); // Bench initial voltage = 0.0 V.
        // device 2180, IC IC375, analog/basic/level_down.hpp:23
        I(cpphdl_n2686, Vlogic) <+ cpphdl_channel(V(Vss, Vlogic), V(cpphdl_n2686, Vlogic), 0.00050000000000000001, 0.34999999999999998, -1.0);
        // device 2181, IC IC375, analog/basic/level_down.hpp:24
        I(cpphdl_n2686, Vss) <+ cpphdl_channel(V(cpphdl_n2684, Vss), V(cpphdl_n2686, Vss), 0.0040000000000000001, 0.69999999999999996, 1.0);
        // device 2182, IC IC375, analog/basic/level_down.hpp:25
        I(CORE_DECISION3, Vlogic) <+ cpphdl_channel(V(cpphdl_n2686, Vlogic), V(CORE_DECISION3, Vlogic), 0.0050000000000000001, 0.34999999999999998, -1.0);
        // device 2183, IC IC375, analog/basic/level_down.hpp:26
        I(CORE_DECISION3, Vss) <+ cpphdl_channel(V(cpphdl_n2686, Vss), V(CORE_DECISION3, Vss), 0.01, 0.34999999999999998, 1.0);
        // device 2184, IC IC375, analog/basic/level_down.hpp:27
        I(cpphdl_n2684, Vss) <+ 5e-15 * ddt(V(cpphdl_n2684, Vss)); // Bench initial voltage = 0.0 V.
        // device 2185, IC IC375, analog/basic/level_down.hpp:28
        I(cpphdl_n2684, Vlogic) <+ 5e-15 * ddt(V(cpphdl_n2684, Vlogic)); // Bench initial voltage = 0.0 V.
        // device 2186, IC IC375, analog/basic/level_down.hpp:29
        I(cpphdl_n2684, cpphdl_n2686) <+ 2.0000000000000002e-15 * ddt(V(cpphdl_n2684, cpphdl_n2686)); // Bench initial voltage = 0.0 V.
        // device 2187, IC IC375, analog/basic/level_down.hpp:30
        I(cpphdl_n2686, Vss) <+ 8e-14 * ddt(V(cpphdl_n2686, Vss)); // Bench initial voltage = 0.0 V.
        // device 2188, IC IC375, analog/basic/level_down.hpp:31
        I(cpphdl_n2686, Vlogic) <+ 5e-15 * ddt(V(cpphdl_n2686, Vlogic)); // Bench initial voltage = 0.0 V.
        // device 2189, IC IC375, analog/basic/level_down.hpp:32
        I(cpphdl_n2686, CORE_DECISION3) <+ 2.0000000000000002e-15 * ddt(V(cpphdl_n2686, CORE_DECISION3)); // Bench initial voltage = 0.0 V.
        // device 2190, IC IC375, analog/basic/level_down.hpp:33
        I(CORE_DECISION3, Vss) <+ 1e-14 * ddt(V(CORE_DECISION3, Vss)); // Bench initial voltage = 0.0 V.
        // device 2191, IC IC376, analog/basic/level_down.hpp:23
        I(cpphdl_n2691, Vlogic) <+ cpphdl_channel(V(Vss, Vlogic), V(cpphdl_n2691, Vlogic), 0.00050000000000000001, 0.34999999999999998, -1.0);
        // device 2192, IC IC376, analog/basic/level_down.hpp:24
        I(cpphdl_n2691, Vss) <+ cpphdl_channel(V(cpphdl_n2689, Vss), V(cpphdl_n2691, Vss), 0.0040000000000000001, 0.69999999999999996, 1.0);
        // device 2193, IC IC376, analog/basic/level_down.hpp:25
        I(CORE_DECISION4, Vlogic) <+ cpphdl_channel(V(cpphdl_n2691, Vlogic), V(CORE_DECISION4, Vlogic), 0.0050000000000000001, 0.34999999999999998, -1.0);
        // device 2194, IC IC376, analog/basic/level_down.hpp:26
        I(CORE_DECISION4, Vss) <+ cpphdl_channel(V(cpphdl_n2691, Vss), V(CORE_DECISION4, Vss), 0.01, 0.34999999999999998, 1.0);
        // device 2195, IC IC376, analog/basic/level_down.hpp:27
        I(cpphdl_n2689, Vss) <+ 5e-15 * ddt(V(cpphdl_n2689, Vss)); // Bench initial voltage = 0.0 V.
        // device 2196, IC IC376, analog/basic/level_down.hpp:28
        I(cpphdl_n2689, Vlogic) <+ 5e-15 * ddt(V(cpphdl_n2689, Vlogic)); // Bench initial voltage = 0.0 V.
        // device 2197, IC IC376, analog/basic/level_down.hpp:29
        I(cpphdl_n2689, cpphdl_n2691) <+ 2.0000000000000002e-15 * ddt(V(cpphdl_n2689, cpphdl_n2691)); // Bench initial voltage = 0.0 V.
        // device 2198, IC IC376, analog/basic/level_down.hpp:30
        I(cpphdl_n2691, Vss) <+ 8e-14 * ddt(V(cpphdl_n2691, Vss)); // Bench initial voltage = 0.0 V.
        // device 2199, IC IC376, analog/basic/level_down.hpp:31
        I(cpphdl_n2691, Vlogic) <+ 5e-15 * ddt(V(cpphdl_n2691, Vlogic)); // Bench initial voltage = 0.0 V.
        // device 2200, IC IC376, analog/basic/level_down.hpp:32
        I(cpphdl_n2691, CORE_DECISION4) <+ 2.0000000000000002e-15 * ddt(V(cpphdl_n2691, CORE_DECISION4)); // Bench initial voltage = 0.0 V.
        // device 2201, IC IC376, analog/basic/level_down.hpp:33
        I(CORE_DECISION4, Vss) <+ 1e-14 * ddt(V(CORE_DECISION4, Vss)); // Bench initial voltage = 0.0 V.
        // device 2202, IC IC377, analog/basic/level_down.hpp:23
        I(cpphdl_n2696, Vlogic) <+ cpphdl_channel(V(Vss, Vlogic), V(cpphdl_n2696, Vlogic), 0.00050000000000000001, 0.34999999999999998, -1.0);
        // device 2203, IC IC377, analog/basic/level_down.hpp:24
        I(cpphdl_n2696, Vss) <+ cpphdl_channel(V(cpphdl_n2694, Vss), V(cpphdl_n2696, Vss), 0.0040000000000000001, 0.69999999999999996, 1.0);
        // device 2204, IC IC377, analog/basic/level_down.hpp:25
        I(CORE_DECISION5, Vlogic) <+ cpphdl_channel(V(cpphdl_n2696, Vlogic), V(CORE_DECISION5, Vlogic), 0.0050000000000000001, 0.34999999999999998, -1.0);
        // device 2205, IC IC377, analog/basic/level_down.hpp:26
        I(CORE_DECISION5, Vss) <+ cpphdl_channel(V(cpphdl_n2696, Vss), V(CORE_DECISION5, Vss), 0.01, 0.34999999999999998, 1.0);
        // device 2206, IC IC377, analog/basic/level_down.hpp:27
        I(cpphdl_n2694, Vss) <+ 5e-15 * ddt(V(cpphdl_n2694, Vss)); // Bench initial voltage = 0.0 V.
        // device 2207, IC IC377, analog/basic/level_down.hpp:28
        I(cpphdl_n2694, Vlogic) <+ 5e-15 * ddt(V(cpphdl_n2694, Vlogic)); // Bench initial voltage = 0.0 V.
        // device 2208, IC IC377, analog/basic/level_down.hpp:29
        I(cpphdl_n2694, cpphdl_n2696) <+ 2.0000000000000002e-15 * ddt(V(cpphdl_n2694, cpphdl_n2696)); // Bench initial voltage = 0.0 V.
        // device 2209, IC IC377, analog/basic/level_down.hpp:30
        I(cpphdl_n2696, Vss) <+ 8e-14 * ddt(V(cpphdl_n2696, Vss)); // Bench initial voltage = 0.0 V.
        // device 2210, IC IC377, analog/basic/level_down.hpp:31
        I(cpphdl_n2696, Vlogic) <+ 5e-15 * ddt(V(cpphdl_n2696, Vlogic)); // Bench initial voltage = 0.0 V.
        // device 2211, IC IC377, analog/basic/level_down.hpp:32
        I(cpphdl_n2696, CORE_DECISION5) <+ 2.0000000000000002e-15 * ddt(V(cpphdl_n2696, CORE_DECISION5)); // Bench initial voltage = 0.0 V.
        // device 2212, IC IC377, analog/basic/level_down.hpp:33
        I(CORE_DECISION5, Vss) <+ 1e-14 * ddt(V(CORE_DECISION5, Vss)); // Bench initial voltage = 0.0 V.
        // device 2213, IC IC378, analog/basic/level_down.hpp:23
        I(cpphdl_n2701, Vlogic) <+ cpphdl_channel(V(Vss, Vlogic), V(cpphdl_n2701, Vlogic), 0.00050000000000000001, 0.34999999999999998, -1.0);
        // device 2214, IC IC378, analog/basic/level_down.hpp:24
        I(cpphdl_n2701, Vss) <+ cpphdl_channel(V(cpphdl_n2699, Vss), V(cpphdl_n2701, Vss), 0.0040000000000000001, 0.69999999999999996, 1.0);
        // device 2215, IC IC378, analog/basic/level_down.hpp:25
        I(CORE_DECISION6, Vlogic) <+ cpphdl_channel(V(cpphdl_n2701, Vlogic), V(CORE_DECISION6, Vlogic), 0.0050000000000000001, 0.34999999999999998, -1.0);
        // device 2216, IC IC378, analog/basic/level_down.hpp:26
        I(CORE_DECISION6, Vss) <+ cpphdl_channel(V(cpphdl_n2701, Vss), V(CORE_DECISION6, Vss), 0.01, 0.34999999999999998, 1.0);
        // device 2217, IC IC378, analog/basic/level_down.hpp:27
        I(cpphdl_n2699, Vss) <+ 5e-15 * ddt(V(cpphdl_n2699, Vss)); // Bench initial voltage = 0.0 V.
        // device 2218, IC IC378, analog/basic/level_down.hpp:28
        I(cpphdl_n2699, Vlogic) <+ 5e-15 * ddt(V(cpphdl_n2699, Vlogic)); // Bench initial voltage = 0.0 V.
        // device 2219, IC IC378, analog/basic/level_down.hpp:29
        I(cpphdl_n2699, cpphdl_n2701) <+ 2.0000000000000002e-15 * ddt(V(cpphdl_n2699, cpphdl_n2701)); // Bench initial voltage = 0.0 V.
        // device 2220, IC IC378, analog/basic/level_down.hpp:30
        I(cpphdl_n2701, Vss) <+ 8e-14 * ddt(V(cpphdl_n2701, Vss)); // Bench initial voltage = 0.0 V.
        // device 2221, IC IC378, analog/basic/level_down.hpp:31
        I(cpphdl_n2701, Vlogic) <+ 5e-15 * ddt(V(cpphdl_n2701, Vlogic)); // Bench initial voltage = 0.0 V.
        // device 2222, IC IC378, analog/basic/level_down.hpp:32
        I(cpphdl_n2701, CORE_DECISION6) <+ 2.0000000000000002e-15 * ddt(V(cpphdl_n2701, CORE_DECISION6)); // Bench initial voltage = 0.0 V.
        // device 2223, IC IC378, analog/basic/level_down.hpp:33
        I(CORE_DECISION6, Vss) <+ 1e-14 * ddt(V(CORE_DECISION6, Vss)); // Bench initial voltage = 0.0 V.
        // device 2224, IC IC379, analog/basic/level_down.hpp:23
        I(cpphdl_n2706, Vlogic) <+ cpphdl_channel(V(Vss, Vlogic), V(cpphdl_n2706, Vlogic), 0.00050000000000000001, 0.34999999999999998, -1.0);
        // device 2225, IC IC379, analog/basic/level_down.hpp:24
        I(cpphdl_n2706, Vss) <+ cpphdl_channel(V(cpphdl_n2704, Vss), V(cpphdl_n2706, Vss), 0.0040000000000000001, 0.69999999999999996, 1.0);
        // device 2226, IC IC379, analog/basic/level_down.hpp:25
        I(CORE_DECISION7, Vlogic) <+ cpphdl_channel(V(cpphdl_n2706, Vlogic), V(CORE_DECISION7, Vlogic), 0.0050000000000000001, 0.34999999999999998, -1.0);
        // device 2227, IC IC379, analog/basic/level_down.hpp:26
        I(CORE_DECISION7, Vss) <+ cpphdl_channel(V(cpphdl_n2706, Vss), V(CORE_DECISION7, Vss), 0.01, 0.34999999999999998, 1.0);
        // device 2228, IC IC379, analog/basic/level_down.hpp:27
        I(cpphdl_n2704, Vss) <+ 5e-15 * ddt(V(cpphdl_n2704, Vss)); // Bench initial voltage = 0.0 V.
        // device 2229, IC IC379, analog/basic/level_down.hpp:28
        I(cpphdl_n2704, Vlogic) <+ 5e-15 * ddt(V(cpphdl_n2704, Vlogic)); // Bench initial voltage = 0.0 V.
        // device 2230, IC IC379, analog/basic/level_down.hpp:29
        I(cpphdl_n2704, cpphdl_n2706) <+ 2.0000000000000002e-15 * ddt(V(cpphdl_n2704, cpphdl_n2706)); // Bench initial voltage = 0.0 V.
        // device 2231, IC IC379, analog/basic/level_down.hpp:30
        I(cpphdl_n2706, Vss) <+ 8e-14 * ddt(V(cpphdl_n2706, Vss)); // Bench initial voltage = 0.0 V.
        // device 2232, IC IC379, analog/basic/level_down.hpp:31
        I(cpphdl_n2706, Vlogic) <+ 5e-15 * ddt(V(cpphdl_n2706, Vlogic)); // Bench initial voltage = 0.0 V.
        // device 2233, IC IC379, analog/basic/level_down.hpp:32
        I(cpphdl_n2706, CORE_DECISION7) <+ 2.0000000000000002e-15 * ddt(V(cpphdl_n2706, CORE_DECISION7)); // Bench initial voltage = 0.0 V.
        // device 2234, IC IC379, analog/basic/level_down.hpp:33
        I(CORE_DECISION7, Vss) <+ 1e-14 * ddt(V(CORE_DECISION7, Vss)); // Bench initial voltage = 0.0 V.
        // device 2235, IC IC380, analog/basic/level_down.hpp:23
        I(cpphdl_n2711, Vlogic) <+ cpphdl_channel(V(Vss, Vlogic), V(cpphdl_n2711, Vlogic), 0.00050000000000000001, 0.34999999999999998, -1.0);
        // device 2236, IC IC380, analog/basic/level_down.hpp:24
        I(cpphdl_n2711, Vss) <+ cpphdl_channel(V(cpphdl_n2709, Vss), V(cpphdl_n2711, Vss), 0.0040000000000000001, 0.69999999999999996, 1.0);
        // device 2237, IC IC380, analog/basic/level_down.hpp:25
        I(CORE_DECISION8, Vlogic) <+ cpphdl_channel(V(cpphdl_n2711, Vlogic), V(CORE_DECISION8, Vlogic), 0.0050000000000000001, 0.34999999999999998, -1.0);
        // device 2238, IC IC380, analog/basic/level_down.hpp:26
        I(CORE_DECISION8, Vss) <+ cpphdl_channel(V(cpphdl_n2711, Vss), V(CORE_DECISION8, Vss), 0.01, 0.34999999999999998, 1.0);
        // device 2239, IC IC380, analog/basic/level_down.hpp:27
        I(cpphdl_n2709, Vss) <+ 5e-15 * ddt(V(cpphdl_n2709, Vss)); // Bench initial voltage = 0.0 V.
        // device 2240, IC IC380, analog/basic/level_down.hpp:28
        I(cpphdl_n2709, Vlogic) <+ 5e-15 * ddt(V(cpphdl_n2709, Vlogic)); // Bench initial voltage = 0.0 V.
        // device 2241, IC IC380, analog/basic/level_down.hpp:29
        I(cpphdl_n2709, cpphdl_n2711) <+ 2.0000000000000002e-15 * ddt(V(cpphdl_n2709, cpphdl_n2711)); // Bench initial voltage = 0.0 V.
        // device 2242, IC IC380, analog/basic/level_down.hpp:30
        I(cpphdl_n2711, Vss) <+ 8e-14 * ddt(V(cpphdl_n2711, Vss)); // Bench initial voltage = 0.0 V.
        // device 2243, IC IC380, analog/basic/level_down.hpp:31
        I(cpphdl_n2711, Vlogic) <+ 5e-15 * ddt(V(cpphdl_n2711, Vlogic)); // Bench initial voltage = 0.0 V.
        // device 2244, IC IC380, analog/basic/level_down.hpp:32
        I(cpphdl_n2711, CORE_DECISION8) <+ 2.0000000000000002e-15 * ddt(V(cpphdl_n2711, CORE_DECISION8)); // Bench initial voltage = 0.0 V.
        // device 2245, IC IC380, analog/basic/level_down.hpp:33
        I(CORE_DECISION8, Vss) <+ 1e-14 * ddt(V(CORE_DECISION8, Vss)); // Bench initial voltage = 0.0 V.
        // device 2246, IC IC381, analog/basic/level_down.hpp:23
        I(cpphdl_n2716, Vlogic) <+ cpphdl_channel(V(Vss, Vlogic), V(cpphdl_n2716, Vlogic), 0.00050000000000000001, 0.34999999999999998, -1.0);
        // device 2247, IC IC381, analog/basic/level_down.hpp:24
        I(cpphdl_n2716, Vss) <+ cpphdl_channel(V(cpphdl_n2714, Vss), V(cpphdl_n2716, Vss), 0.0040000000000000001, 0.69999999999999996, 1.0);
        // device 2248, IC IC381, analog/basic/level_down.hpp:25
        I(CORE_DECISION9, Vlogic) <+ cpphdl_channel(V(cpphdl_n2716, Vlogic), V(CORE_DECISION9, Vlogic), 0.0050000000000000001, 0.34999999999999998, -1.0);
        // device 2249, IC IC381, analog/basic/level_down.hpp:26
        I(CORE_DECISION9, Vss) <+ cpphdl_channel(V(cpphdl_n2716, Vss), V(CORE_DECISION9, Vss), 0.01, 0.34999999999999998, 1.0);
        // device 2250, IC IC381, analog/basic/level_down.hpp:27
        I(cpphdl_n2714, Vss) <+ 5e-15 * ddt(V(cpphdl_n2714, Vss)); // Bench initial voltage = 0.0 V.
        // device 2251, IC IC381, analog/basic/level_down.hpp:28
        I(cpphdl_n2714, Vlogic) <+ 5e-15 * ddt(V(cpphdl_n2714, Vlogic)); // Bench initial voltage = 0.0 V.
        // device 2252, IC IC381, analog/basic/level_down.hpp:29
        I(cpphdl_n2714, cpphdl_n2716) <+ 2.0000000000000002e-15 * ddt(V(cpphdl_n2714, cpphdl_n2716)); // Bench initial voltage = 0.0 V.
        // device 2253, IC IC381, analog/basic/level_down.hpp:30
        I(cpphdl_n2716, Vss) <+ 8e-14 * ddt(V(cpphdl_n2716, Vss)); // Bench initial voltage = 0.0 V.
        // device 2254, IC IC381, analog/basic/level_down.hpp:31
        I(cpphdl_n2716, Vlogic) <+ 5e-15 * ddt(V(cpphdl_n2716, Vlogic)); // Bench initial voltage = 0.0 V.
        // device 2255, IC IC381, analog/basic/level_down.hpp:32
        I(cpphdl_n2716, CORE_DECISION9) <+ 2.0000000000000002e-15 * ddt(V(cpphdl_n2716, CORE_DECISION9)); // Bench initial voltage = 0.0 V.
        // device 2256, IC IC381, analog/basic/level_down.hpp:33
        I(CORE_DECISION9, Vss) <+ 1e-14 * ddt(V(CORE_DECISION9, Vss)); // Bench initial voltage = 0.0 V.
        // device 2257, IC IC382, analog/basic/level_down.hpp:23
        I(cpphdl_n2721, Vlogic) <+ cpphdl_channel(V(Vss, Vlogic), V(cpphdl_n2721, Vlogic), 0.00050000000000000001, 0.34999999999999998, -1.0);
        // device 2258, IC IC382, analog/basic/level_down.hpp:24
        I(cpphdl_n2721, Vss) <+ cpphdl_channel(V(cpphdl_n2719, Vss), V(cpphdl_n2721, Vss), 0.0040000000000000001, 0.69999999999999996, 1.0);
        // device 2259, IC IC382, analog/basic/level_down.hpp:25
        I(CORE_DECISION10, Vlogic) <+ cpphdl_channel(V(cpphdl_n2721, Vlogic), V(CORE_DECISION10, Vlogic), 0.0050000000000000001, 0.34999999999999998, -1.0);
        // device 2260, IC IC382, analog/basic/level_down.hpp:26
        I(CORE_DECISION10, Vss) <+ cpphdl_channel(V(cpphdl_n2721, Vss), V(CORE_DECISION10, Vss), 0.01, 0.34999999999999998, 1.0);
        // device 2261, IC IC382, analog/basic/level_down.hpp:27
        I(cpphdl_n2719, Vss) <+ 5e-15 * ddt(V(cpphdl_n2719, Vss)); // Bench initial voltage = 0.0 V.
        // device 2262, IC IC382, analog/basic/level_down.hpp:28
        I(cpphdl_n2719, Vlogic) <+ 5e-15 * ddt(V(cpphdl_n2719, Vlogic)); // Bench initial voltage = 0.0 V.
        // device 2263, IC IC382, analog/basic/level_down.hpp:29
        I(cpphdl_n2719, cpphdl_n2721) <+ 2.0000000000000002e-15 * ddt(V(cpphdl_n2719, cpphdl_n2721)); // Bench initial voltage = 0.0 V.
        // device 2264, IC IC382, analog/basic/level_down.hpp:30
        I(cpphdl_n2721, Vss) <+ 8e-14 * ddt(V(cpphdl_n2721, Vss)); // Bench initial voltage = 0.0 V.
        // device 2265, IC IC382, analog/basic/level_down.hpp:31
        I(cpphdl_n2721, Vlogic) <+ 5e-15 * ddt(V(cpphdl_n2721, Vlogic)); // Bench initial voltage = 0.0 V.
        // device 2266, IC IC382, analog/basic/level_down.hpp:32
        I(cpphdl_n2721, CORE_DECISION10) <+ 2.0000000000000002e-15 * ddt(V(cpphdl_n2721, CORE_DECISION10)); // Bench initial voltage = 0.0 V.
        // device 2267, IC IC382, analog/basic/level_down.hpp:33
        I(CORE_DECISION10, Vss) <+ 1e-14 * ddt(V(CORE_DECISION10, Vss)); // Bench initial voltage = 0.0 V.
        // device 2268, IC IC383, analog/basic/level_down.hpp:23
        I(cpphdl_n2726, Vlogic) <+ cpphdl_channel(V(Vss, Vlogic), V(cpphdl_n2726, Vlogic), 0.00050000000000000001, 0.34999999999999998, -1.0);
        // device 2269, IC IC383, analog/basic/level_down.hpp:24
        I(cpphdl_n2726, Vss) <+ cpphdl_channel(V(cpphdl_n2724, Vss), V(cpphdl_n2726, Vss), 0.0040000000000000001, 0.69999999999999996, 1.0);
        // device 2270, IC IC383, analog/basic/level_down.hpp:25
        I(CORE_DECISION11, Vlogic) <+ cpphdl_channel(V(cpphdl_n2726, Vlogic), V(CORE_DECISION11, Vlogic), 0.0050000000000000001, 0.34999999999999998, -1.0);
        // device 2271, IC IC383, analog/basic/level_down.hpp:26
        I(CORE_DECISION11, Vss) <+ cpphdl_channel(V(cpphdl_n2726, Vss), V(CORE_DECISION11, Vss), 0.01, 0.34999999999999998, 1.0);
        // device 2272, IC IC383, analog/basic/level_down.hpp:27
        I(cpphdl_n2724, Vss) <+ 5e-15 * ddt(V(cpphdl_n2724, Vss)); // Bench initial voltage = 0.0 V.
        // device 2273, IC IC383, analog/basic/level_down.hpp:28
        I(cpphdl_n2724, Vlogic) <+ 5e-15 * ddt(V(cpphdl_n2724, Vlogic)); // Bench initial voltage = 0.0 V.
        // device 2274, IC IC383, analog/basic/level_down.hpp:29
        I(cpphdl_n2724, cpphdl_n2726) <+ 2.0000000000000002e-15 * ddt(V(cpphdl_n2724, cpphdl_n2726)); // Bench initial voltage = 0.0 V.
        // device 2275, IC IC383, analog/basic/level_down.hpp:30
        I(cpphdl_n2726, Vss) <+ 8e-14 * ddt(V(cpphdl_n2726, Vss)); // Bench initial voltage = 0.0 V.
        // device 2276, IC IC383, analog/basic/level_down.hpp:31
        I(cpphdl_n2726, Vlogic) <+ 5e-15 * ddt(V(cpphdl_n2726, Vlogic)); // Bench initial voltage = 0.0 V.
        // device 2277, IC IC383, analog/basic/level_down.hpp:32
        I(cpphdl_n2726, CORE_DECISION11) <+ 2.0000000000000002e-15 * ddt(V(cpphdl_n2726, CORE_DECISION11)); // Bench initial voltage = 0.0 V.
        // device 2278, IC IC383, analog/basic/level_down.hpp:33
        I(CORE_DECISION11, Vss) <+ 1e-14 * ddt(V(CORE_DECISION11, Vss)); // Bench initial voltage = 0.0 V.
        // device 2279, IC IC384, analog/basic/level_down.hpp:23
        I(cpphdl_n2731, Vlogic) <+ cpphdl_channel(V(Vss, Vlogic), V(cpphdl_n2731, Vlogic), 0.00050000000000000001, 0.34999999999999998, -1.0);
        // device 2280, IC IC384, analog/basic/level_down.hpp:24
        I(cpphdl_n2731, Vss) <+ cpphdl_channel(V(cpphdl_n2729, Vss), V(cpphdl_n2731, Vss), 0.0040000000000000001, 0.69999999999999996, 1.0);
        // device 2281, IC IC384, analog/basic/level_down.hpp:25
        I(CORE_DECISION12, Vlogic) <+ cpphdl_channel(V(cpphdl_n2731, Vlogic), V(CORE_DECISION12, Vlogic), 0.0050000000000000001, 0.34999999999999998, -1.0);
        // device 2282, IC IC384, analog/basic/level_down.hpp:26
        I(CORE_DECISION12, Vss) <+ cpphdl_channel(V(cpphdl_n2731, Vss), V(CORE_DECISION12, Vss), 0.01, 0.34999999999999998, 1.0);
        // device 2283, IC IC384, analog/basic/level_down.hpp:27
        I(cpphdl_n2729, Vss) <+ 5e-15 * ddt(V(cpphdl_n2729, Vss)); // Bench initial voltage = 0.0 V.
        // device 2284, IC IC384, analog/basic/level_down.hpp:28
        I(cpphdl_n2729, Vlogic) <+ 5e-15 * ddt(V(cpphdl_n2729, Vlogic)); // Bench initial voltage = 0.0 V.
        // device 2285, IC IC384, analog/basic/level_down.hpp:29
        I(cpphdl_n2729, cpphdl_n2731) <+ 2.0000000000000002e-15 * ddt(V(cpphdl_n2729, cpphdl_n2731)); // Bench initial voltage = 0.0 V.
        // device 2286, IC IC384, analog/basic/level_down.hpp:30
        I(cpphdl_n2731, Vss) <+ 8e-14 * ddt(V(cpphdl_n2731, Vss)); // Bench initial voltage = 0.0 V.
        // device 2287, IC IC384, analog/basic/level_down.hpp:31
        I(cpphdl_n2731, Vlogic) <+ 5e-15 * ddt(V(cpphdl_n2731, Vlogic)); // Bench initial voltage = 0.0 V.
        // device 2288, IC IC384, analog/basic/level_down.hpp:32
        I(cpphdl_n2731, CORE_DECISION12) <+ 2.0000000000000002e-15 * ddt(V(cpphdl_n2731, CORE_DECISION12)); // Bench initial voltage = 0.0 V.
        // device 2289, IC IC384, analog/basic/level_down.hpp:33
        I(CORE_DECISION12, Vss) <+ 1e-14 * ddt(V(CORE_DECISION12, Vss)); // Bench initial voltage = 0.0 V.
        // device 2290, IC IC385, analog/basic/level_down.hpp:23
        I(cpphdl_n2736, Vlogic) <+ cpphdl_channel(V(Vss, Vlogic), V(cpphdl_n2736, Vlogic), 0.00050000000000000001, 0.34999999999999998, -1.0);
        // device 2291, IC IC385, analog/basic/level_down.hpp:24
        I(cpphdl_n2736, Vss) <+ cpphdl_channel(V(cpphdl_n2734, Vss), V(cpphdl_n2736, Vss), 0.0040000000000000001, 0.69999999999999996, 1.0);
        // device 2292, IC IC385, analog/basic/level_down.hpp:25
        I(CORE_DECISION13, Vlogic) <+ cpphdl_channel(V(cpphdl_n2736, Vlogic), V(CORE_DECISION13, Vlogic), 0.0050000000000000001, 0.34999999999999998, -1.0);
        // device 2293, IC IC385, analog/basic/level_down.hpp:26
        I(CORE_DECISION13, Vss) <+ cpphdl_channel(V(cpphdl_n2736, Vss), V(CORE_DECISION13, Vss), 0.01, 0.34999999999999998, 1.0);
        // device 2294, IC IC385, analog/basic/level_down.hpp:27
        I(cpphdl_n2734, Vss) <+ 5e-15 * ddt(V(cpphdl_n2734, Vss)); // Bench initial voltage = 0.0 V.
        // device 2295, IC IC385, analog/basic/level_down.hpp:28
        I(cpphdl_n2734, Vlogic) <+ 5e-15 * ddt(V(cpphdl_n2734, Vlogic)); // Bench initial voltage = 0.0 V.
        // device 2296, IC IC385, analog/basic/level_down.hpp:29
        I(cpphdl_n2734, cpphdl_n2736) <+ 2.0000000000000002e-15 * ddt(V(cpphdl_n2734, cpphdl_n2736)); // Bench initial voltage = 0.0 V.
        // device 2297, IC IC385, analog/basic/level_down.hpp:30
        I(cpphdl_n2736, Vss) <+ 8e-14 * ddt(V(cpphdl_n2736, Vss)); // Bench initial voltage = 0.0 V.
        // device 2298, IC IC385, analog/basic/level_down.hpp:31
        I(cpphdl_n2736, Vlogic) <+ 5e-15 * ddt(V(cpphdl_n2736, Vlogic)); // Bench initial voltage = 0.0 V.
        // device 2299, IC IC385, analog/basic/level_down.hpp:32
        I(cpphdl_n2736, CORE_DECISION13) <+ 2.0000000000000002e-15 * ddt(V(cpphdl_n2736, CORE_DECISION13)); // Bench initial voltage = 0.0 V.
        // device 2300, IC IC385, analog/basic/level_down.hpp:33
        I(CORE_DECISION13, Vss) <+ 1e-14 * ddt(V(CORE_DECISION13, Vss)); // Bench initial voltage = 0.0 V.
        // device 2301, IC IC386, analog/basic/level_down.hpp:23
        I(cpphdl_n2741, Vlogic) <+ cpphdl_channel(V(Vss, Vlogic), V(cpphdl_n2741, Vlogic), 0.00050000000000000001, 0.34999999999999998, -1.0);
        // device 2302, IC IC386, analog/basic/level_down.hpp:24
        I(cpphdl_n2741, Vss) <+ cpphdl_channel(V(cpphdl_n2739, Vss), V(cpphdl_n2741, Vss), 0.0040000000000000001, 0.69999999999999996, 1.0);
        // device 2303, IC IC386, analog/basic/level_down.hpp:25
        I(CORE_DECISION14, Vlogic) <+ cpphdl_channel(V(cpphdl_n2741, Vlogic), V(CORE_DECISION14, Vlogic), 0.0050000000000000001, 0.34999999999999998, -1.0);
        // device 2304, IC IC386, analog/basic/level_down.hpp:26
        I(CORE_DECISION14, Vss) <+ cpphdl_channel(V(cpphdl_n2741, Vss), V(CORE_DECISION14, Vss), 0.01, 0.34999999999999998, 1.0);
        // device 2305, IC IC386, analog/basic/level_down.hpp:27
        I(cpphdl_n2739, Vss) <+ 5e-15 * ddt(V(cpphdl_n2739, Vss)); // Bench initial voltage = 0.0 V.
        // device 2306, IC IC386, analog/basic/level_down.hpp:28
        I(cpphdl_n2739, Vlogic) <+ 5e-15 * ddt(V(cpphdl_n2739, Vlogic)); // Bench initial voltage = 0.0 V.
        // device 2307, IC IC386, analog/basic/level_down.hpp:29
        I(cpphdl_n2739, cpphdl_n2741) <+ 2.0000000000000002e-15 * ddt(V(cpphdl_n2739, cpphdl_n2741)); // Bench initial voltage = 0.0 V.
        // device 2308, IC IC386, analog/basic/level_down.hpp:30
        I(cpphdl_n2741, Vss) <+ 8e-14 * ddt(V(cpphdl_n2741, Vss)); // Bench initial voltage = 0.0 V.
        // device 2309, IC IC386, analog/basic/level_down.hpp:31
        I(cpphdl_n2741, Vlogic) <+ 5e-15 * ddt(V(cpphdl_n2741, Vlogic)); // Bench initial voltage = 0.0 V.
        // device 2310, IC IC386, analog/basic/level_down.hpp:32
        I(cpphdl_n2741, CORE_DECISION14) <+ 2.0000000000000002e-15 * ddt(V(cpphdl_n2741, CORE_DECISION14)); // Bench initial voltage = 0.0 V.
        // device 2311, IC IC386, analog/basic/level_down.hpp:33
        I(CORE_DECISION14, Vss) <+ 1e-14 * ddt(V(CORE_DECISION14, Vss)); // Bench initial voltage = 0.0 V.
        // device 2312, IC IC387, analog/basic/level_down.hpp:23
        I(cpphdl_n2746, Vlogic) <+ cpphdl_channel(V(Vss, Vlogic), V(cpphdl_n2746, Vlogic), 0.00050000000000000001, 0.34999999999999998, -1.0);
        // device 2313, IC IC387, analog/basic/level_down.hpp:24
        I(cpphdl_n2746, Vss) <+ cpphdl_channel(V(cpphdl_n2744, Vss), V(cpphdl_n2746, Vss), 0.0040000000000000001, 0.69999999999999996, 1.0);
        // device 2314, IC IC387, analog/basic/level_down.hpp:25
        I(CORE_DECISION15, Vlogic) <+ cpphdl_channel(V(cpphdl_n2746, Vlogic), V(CORE_DECISION15, Vlogic), 0.0050000000000000001, 0.34999999999999998, -1.0);
        // device 2315, IC IC387, analog/basic/level_down.hpp:26
        I(CORE_DECISION15, Vss) <+ cpphdl_channel(V(cpphdl_n2746, Vss), V(CORE_DECISION15, Vss), 0.01, 0.34999999999999998, 1.0);
        // device 2316, IC IC387, analog/basic/level_down.hpp:27
        I(cpphdl_n2744, Vss) <+ 5e-15 * ddt(V(cpphdl_n2744, Vss)); // Bench initial voltage = 0.0 V.
        // device 2317, IC IC387, analog/basic/level_down.hpp:28
        I(cpphdl_n2744, Vlogic) <+ 5e-15 * ddt(V(cpphdl_n2744, Vlogic)); // Bench initial voltage = 0.0 V.
        // device 2318, IC IC387, analog/basic/level_down.hpp:29
        I(cpphdl_n2744, cpphdl_n2746) <+ 2.0000000000000002e-15 * ddt(V(cpphdl_n2744, cpphdl_n2746)); // Bench initial voltage = 0.0 V.
        // device 2319, IC IC387, analog/basic/level_down.hpp:30
        I(cpphdl_n2746, Vss) <+ 8e-14 * ddt(V(cpphdl_n2746, Vss)); // Bench initial voltage = 0.0 V.
        // device 2320, IC IC387, analog/basic/level_down.hpp:31
        I(cpphdl_n2746, Vlogic) <+ 5e-15 * ddt(V(cpphdl_n2746, Vlogic)); // Bench initial voltage = 0.0 V.
        // device 2321, IC IC387, analog/basic/level_down.hpp:32
        I(cpphdl_n2746, CORE_DECISION15) <+ 2.0000000000000002e-15 * ddt(V(cpphdl_n2746, CORE_DECISION15)); // Bench initial voltage = 0.0 V.
        // device 2322, IC IC387, analog/basic/level_down.hpp:33
        I(CORE_DECISION15, Vss) <+ 1e-14 * ddt(V(CORE_DECISION15, Vss)); // Bench initial voltage = 0.0 V.
        // device 2323, IC IC388, analog/basic/nmos_resistor_amplifier.hpp:23
        I(Vdd, cpphdl_n2752) <+ V(Vdd, cpphdl_n2752) / 500.0;
        // device 2324, IC IC388, analog/basic/nmos_resistor_amplifier.hpp:24
        I(Vdd, cpphdl_n2758) <+ V(Vdd, cpphdl_n2758) / 500.0;
        // device 2325, IC IC388, analog/basic/nmos_resistor_amplifier.hpp:25
        I(cpphdl_n2752, cpphdl_n2753) <+ cpphdl_channel(V(PLUS, cpphdl_n2753), V(cpphdl_n2752, cpphdl_n2753), 0.014999999999999999, 0.69999999999999996, 1.0);
        // device 2326, IC IC388, analog/basic/nmos_resistor_amplifier.hpp:26
        I(cpphdl_n2758, cpphdl_n2754) <+ cpphdl_channel(V(MINUS, cpphdl_n2754), V(cpphdl_n2758, cpphdl_n2754), 0.014999999999999999, 0.69999999999999996, 1.0);
        // device 2327, IC IC388, analog/basic/nmos_resistor_amplifier.hpp:27
        I(cpphdl_n2755, cpphdl_n2753) <+ V(cpphdl_n2755, cpphdl_n2753) / 50.0;
        // device 2328, IC IC388, analog/basic/nmos_resistor_amplifier.hpp:28
        I(cpphdl_n2755, cpphdl_n2754) <+ V(cpphdl_n2755, cpphdl_n2754) / 50.0;
        // device 2329, IC IC388, analog/basic/nmos_resistor_amplifier.hpp:29
        I(Vss, cpphdl_n2755) <+ V(Vss, cpphdl_n2755) / 150.0;
        // device 2330, IC IC388, analog/basic/nmos_resistor_amplifier.hpp:30
        I(cpphdl_n2752, Vdd) <+ 1e-13 * ddt(V(cpphdl_n2752, Vdd)); // Bench initial voltage = 0.0 V.
        // device 2331, IC IC388, analog/basic/nmos_resistor_amplifier.hpp:31
        I(cpphdl_n2758, Vdd) <+ 1e-13 * ddt(V(cpphdl_n2758, Vdd)); // Bench initial voltage = 0.0 V.
        // device 2332, IC IC388, analog/basic/nmos_resistor_amplifier.hpp:32
        I(cpphdl_n2755, Vss) <+ 4e-14 * ddt(V(cpphdl_n2755, Vss)); // Bench initial voltage = 0.0 V.
        // device 2333, IC IC388, analog/basic/nmos_resistor_amplifier.hpp:34
        I(PLUS, cpphdl_n2753) <+ 1.4999999999999999e-13 * ddt(V(PLUS, cpphdl_n2753)); // Bench initial voltage = 1.6499999999999999 V.
        // device 2334, IC IC388, analog/basic/nmos_resistor_amplifier.hpp:35
        I(MINUS, cpphdl_n2754) <+ 1.4999999999999999e-13 * ddt(V(MINUS, cpphdl_n2754)); // Bench initial voltage = 1.6499999999999999 V.
        // device 2335, IC IC388, analog/basic/nmos_resistor_amplifier.hpp:36
        I(PLUS, cpphdl_n2752) <+ 2e-14 * ddt(V(PLUS, cpphdl_n2752)); // Bench initial voltage = -1.6499999999999999 V.
        // device 2336, IC IC388, analog/basic/nmos_resistor_amplifier.hpp:37
        I(MINUS, cpphdl_n2758) <+ 2e-14 * ddt(V(MINUS, cpphdl_n2758)); // Bench initial voltage = -1.6499999999999999 V.
        // device 2337, IC IC389, analog/basic/nmos_source_follower.hpp:19
        I(Vdd, cpphdl_n2759) <+ cpphdl_channel(V(cpphdl_n2758, cpphdl_n2759), V(Vdd, cpphdl_n2759), 0.10000000000000001, 0.69999999999999996, 1.0);
        // device 2338, IC IC389, analog/basic/nmos_source_follower.hpp:20
        I(Vss, cpphdl_n2759) <+ V(Vss, cpphdl_n2759) / 250.0;
        // device 2339, IC IC389, analog/basic/nmos_source_follower.hpp:23
        I(cpphdl_n2758, cpphdl_n2759) <+ 4e-14 * ddt(V(cpphdl_n2758, cpphdl_n2759)); // Bench initial voltage = 1.6499999999999999 V.
        // device 2340, IC IC389, analog/basic/nmos_source_follower.hpp:24
        I(cpphdl_n2758, Vdd) <+ 1e-14 * ddt(V(cpphdl_n2758, Vdd)); // Bench initial voltage = 0.0 V.
        // device 2341, IC IC389, analog/basic/nmos_source_follower.hpp:25
        I(cpphdl_n2759, Vss) <+ 4e-14 * ddt(V(cpphdl_n2759, Vss)); // Bench initial voltage = 1.6499999999999999 V.
    end
endmodule
