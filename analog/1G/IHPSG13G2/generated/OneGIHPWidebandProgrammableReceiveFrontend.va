// SIMULATION APPROXIMATION: controlled conductances are not physical MOS devices.
// Generated from elaborated C++HDL IC purposes; all contributions coexist.
// Capacitor initialization belongs to the host analysis; declared initial voltages appear below.
`include "disciplines.vams"

module OneGIHPWidebandProgrammableReceiveFrontend(Vdd, Vss, Vlogic, PLUS, MINUS, EVALUATE, CLEAR, SELECT_N0, SELECT_N1, SELECT_N2, SELECT_N3, SELECT_N4, TRACK0, CORE_DECISION0, BIT_N0_0, BIT_N0_1, BIT_N0_2, BIT_N0_3, BIT_N0_4, BIT_N0_5, BIT_N0_6, BIT_N0_7, TRACK1, CORE_DECISION1, BIT_N1_0, BIT_N1_1, BIT_N1_2, BIT_N1_3, BIT_N1_4, BIT_N1_5, BIT_N1_6, BIT_N1_7, TRACK2, CORE_DECISION2, BIT_N2_0, BIT_N2_1, BIT_N2_2, BIT_N2_3, BIT_N2_4, BIT_N2_5, BIT_N2_6, BIT_N2_7, TRACK3, CORE_DECISION3, BIT_N3_0, BIT_N3_1, BIT_N3_2, BIT_N3_3, BIT_N3_4, BIT_N3_5, BIT_N3_6, BIT_N3_7, TRACK4, CORE_DECISION4, BIT_N4_0, BIT_N4_1, BIT_N4_2, BIT_N4_3, BIT_N4_4, BIT_N4_5, BIT_N4_6, BIT_N4_7, TRACK5, CORE_DECISION5, BIT_N5_0, BIT_N5_1, BIT_N5_2, BIT_N5_3, BIT_N5_4, BIT_N5_5, BIT_N5_6, BIT_N5_7, TRACK6, CORE_DECISION6, BIT_N6_0, BIT_N6_1, BIT_N6_2, BIT_N6_3, BIT_N6_4, BIT_N6_5, BIT_N6_6, BIT_N6_7, TRACK7, CORE_DECISION7, BIT_N7_0, BIT_N7_1, BIT_N7_2, BIT_N7_3, BIT_N7_4, BIT_N7_5, BIT_N7_6, BIT_N7_7, TRACK8, CORE_DECISION8, BIT_N8_0, BIT_N8_1, BIT_N8_2, BIT_N8_3, BIT_N8_4, BIT_N8_5, BIT_N8_6, BIT_N8_7, TRACK9, CORE_DECISION9, BIT_N9_0, BIT_N9_1, BIT_N9_2, BIT_N9_3, BIT_N9_4, BIT_N9_5, BIT_N9_6, BIT_N9_7, TRACK10, CORE_DECISION10, BIT_N10_0, BIT_N10_1, BIT_N10_2, BIT_N10_3, BIT_N10_4, BIT_N10_5, BIT_N10_6, BIT_N10_7, TRACK11, CORE_DECISION11, BIT_N11_0, BIT_N11_1, BIT_N11_2, BIT_N11_3, BIT_N11_4, BIT_N11_5, BIT_N11_6, BIT_N11_7, TRACK12, CORE_DECISION12, BIT_N12_0, BIT_N12_1, BIT_N12_2, BIT_N12_3, BIT_N12_4, BIT_N12_5, BIT_N12_6, BIT_N12_7, TRACK13, CORE_DECISION13, BIT_N13_0, BIT_N13_1, BIT_N13_2, BIT_N13_3, BIT_N13_4, BIT_N13_5, BIT_N13_6, BIT_N13_7, TRACK14, CORE_DECISION14, BIT_N14_0, BIT_N14_1, BIT_N14_2, BIT_N14_3, BIT_N14_4, BIT_N14_5, BIT_N14_6, BIT_N14_7, TRACK15, CORE_DECISION15, BIT_N15_0, BIT_N15_1, BIT_N15_2, BIT_N15_3, BIT_N15_4, BIT_N15_5, BIT_N15_6, BIT_N15_7);
    inout Vdd, Vss, Vlogic, PLUS, MINUS, EVALUATE, CLEAR, SELECT_N0, SELECT_N1, SELECT_N2, SELECT_N3, SELECT_N4, TRACK0, CORE_DECISION0, BIT_N0_0, BIT_N0_1, BIT_N0_2, BIT_N0_3, BIT_N0_4, BIT_N0_5, BIT_N0_6, BIT_N0_7, TRACK1, CORE_DECISION1, BIT_N1_0, BIT_N1_1, BIT_N1_2, BIT_N1_3, BIT_N1_4, BIT_N1_5, BIT_N1_6, BIT_N1_7, TRACK2, CORE_DECISION2, BIT_N2_0, BIT_N2_1, BIT_N2_2, BIT_N2_3, BIT_N2_4, BIT_N2_5, BIT_N2_6, BIT_N2_7, TRACK3, CORE_DECISION3, BIT_N3_0, BIT_N3_1, BIT_N3_2, BIT_N3_3, BIT_N3_4, BIT_N3_5, BIT_N3_6, BIT_N3_7, TRACK4, CORE_DECISION4, BIT_N4_0, BIT_N4_1, BIT_N4_2, BIT_N4_3, BIT_N4_4, BIT_N4_5, BIT_N4_6, BIT_N4_7, TRACK5, CORE_DECISION5, BIT_N5_0, BIT_N5_1, BIT_N5_2, BIT_N5_3, BIT_N5_4, BIT_N5_5, BIT_N5_6, BIT_N5_7, TRACK6, CORE_DECISION6, BIT_N6_0, BIT_N6_1, BIT_N6_2, BIT_N6_3, BIT_N6_4, BIT_N6_5, BIT_N6_6, BIT_N6_7, TRACK7, CORE_DECISION7, BIT_N7_0, BIT_N7_1, BIT_N7_2, BIT_N7_3, BIT_N7_4, BIT_N7_5, BIT_N7_6, BIT_N7_7, TRACK8, CORE_DECISION8, BIT_N8_0, BIT_N8_1, BIT_N8_2, BIT_N8_3, BIT_N8_4, BIT_N8_5, BIT_N8_6, BIT_N8_7, TRACK9, CORE_DECISION9, BIT_N9_0, BIT_N9_1, BIT_N9_2, BIT_N9_3, BIT_N9_4, BIT_N9_5, BIT_N9_6, BIT_N9_7, TRACK10, CORE_DECISION10, BIT_N10_0, BIT_N10_1, BIT_N10_2, BIT_N10_3, BIT_N10_4, BIT_N10_5, BIT_N10_6, BIT_N10_7, TRACK11, CORE_DECISION11, BIT_N11_0, BIT_N11_1, BIT_N11_2, BIT_N11_3, BIT_N11_4, BIT_N11_5, BIT_N11_6, BIT_N11_7, TRACK12, CORE_DECISION12, BIT_N12_0, BIT_N12_1, BIT_N12_2, BIT_N12_3, BIT_N12_4, BIT_N12_5, BIT_N12_6, BIT_N12_7, TRACK13, CORE_DECISION13, BIT_N13_0, BIT_N13_1, BIT_N13_2, BIT_N13_3, BIT_N13_4, BIT_N13_5, BIT_N13_6, BIT_N13_7, TRACK14, CORE_DECISION14, BIT_N14_0, BIT_N14_1, BIT_N14_2, BIT_N14_3, BIT_N14_4, BIT_N14_5, BIT_N14_6, BIT_N14_7, TRACK15, CORE_DECISION15, BIT_N15_0, BIT_N15_1, BIT_N15_2, BIT_N15_3, BIT_N15_4, BIT_N15_5, BIT_N15_6, BIT_N15_7;
    electrical Vdd, Vss, Vlogic, PLUS, MINUS, EVALUATE, CLEAR, SELECT_N0, SELECT_N1, SELECT_N2, SELECT_N3, SELECT_N4, TRACK0, CORE_DECISION0, BIT_N0_0, BIT_N0_1, BIT_N0_2, BIT_N0_3, BIT_N0_4, BIT_N0_5, BIT_N0_6, BIT_N0_7, TRACK1, CORE_DECISION1, BIT_N1_0, BIT_N1_1, BIT_N1_2, BIT_N1_3, BIT_N1_4, BIT_N1_5, BIT_N1_6, BIT_N1_7, TRACK2, CORE_DECISION2, BIT_N2_0, BIT_N2_1, BIT_N2_2, BIT_N2_3, BIT_N2_4, BIT_N2_5, BIT_N2_6, BIT_N2_7, TRACK3, CORE_DECISION3, BIT_N3_0, BIT_N3_1, BIT_N3_2, BIT_N3_3, BIT_N3_4, BIT_N3_5, BIT_N3_6, BIT_N3_7, TRACK4, CORE_DECISION4, BIT_N4_0, BIT_N4_1, BIT_N4_2, BIT_N4_3, BIT_N4_4, BIT_N4_5, BIT_N4_6, BIT_N4_7, TRACK5, CORE_DECISION5, BIT_N5_0, BIT_N5_1, BIT_N5_2, BIT_N5_3, BIT_N5_4, BIT_N5_5, BIT_N5_6, BIT_N5_7, TRACK6, CORE_DECISION6, BIT_N6_0, BIT_N6_1, BIT_N6_2, BIT_N6_3, BIT_N6_4, BIT_N6_5, BIT_N6_6, BIT_N6_7, TRACK7, CORE_DECISION7, BIT_N7_0, BIT_N7_1, BIT_N7_2, BIT_N7_3, BIT_N7_4, BIT_N7_5, BIT_N7_6, BIT_N7_7, TRACK8, CORE_DECISION8, BIT_N8_0, BIT_N8_1, BIT_N8_2, BIT_N8_3, BIT_N8_4, BIT_N8_5, BIT_N8_6, BIT_N8_7, TRACK9, CORE_DECISION9, BIT_N9_0, BIT_N9_1, BIT_N9_2, BIT_N9_3, BIT_N9_4, BIT_N9_5, BIT_N9_6, BIT_N9_7, TRACK10, CORE_DECISION10, BIT_N10_0, BIT_N10_1, BIT_N10_2, BIT_N10_3, BIT_N10_4, BIT_N10_5, BIT_N10_6, BIT_N10_7, TRACK11, CORE_DECISION11, BIT_N11_0, BIT_N11_1, BIT_N11_2, BIT_N11_3, BIT_N11_4, BIT_N11_5, BIT_N11_6, BIT_N11_7, TRACK12, CORE_DECISION12, BIT_N12_0, BIT_N12_1, BIT_N12_2, BIT_N12_3, BIT_N12_4, BIT_N12_5, BIT_N12_6, BIT_N12_7, TRACK13, CORE_DECISION13, BIT_N13_0, BIT_N13_1, BIT_N13_2, BIT_N13_3, BIT_N13_4, BIT_N13_5, BIT_N13_6, BIT_N13_7, TRACK14, CORE_DECISION14, BIT_N14_0, BIT_N14_1, BIT_N14_2, BIT_N14_3, BIT_N14_4, BIT_N14_5, BIT_N14_6, BIT_N14_7, TRACK15, CORE_DECISION15, BIT_N15_0, BIT_N15_1, BIT_N15_2, BIT_N15_3, BIT_N15_4, BIT_N15_5, BIT_N15_6, BIT_N15_7;
    electrical cpphdl_n179;
    electrical cpphdl_n180;
    electrical cpphdl_n181;
    electrical cpphdl_n187;
    electrical cpphdl_n188;
    electrical cpphdl_n189;
    electrical cpphdl_n190;
    electrical cpphdl_n197;
    electrical cpphdl_n198;
    electrical cpphdl_n212;
    electrical cpphdl_n213;
    electrical cpphdl_n214;
    electrical cpphdl_n215;
    electrical cpphdl_n216;
    electrical cpphdl_n217;
    electrical cpphdl_n218;
    electrical cpphdl_n219;
    electrical cpphdl_n220;
    electrical cpphdl_n221;
    electrical cpphdl_n222;
    electrical cpphdl_n223;
    electrical cpphdl_n226;
    electrical cpphdl_n227;
    electrical cpphdl_n229;
    electrical cpphdl_n230;
    electrical cpphdl_n231;
    electrical cpphdl_n232;
    electrical cpphdl_n233;
    electrical cpphdl_n234;
    electrical cpphdl_n235;
    electrical cpphdl_n236;
    electrical cpphdl_n237;
    electrical cpphdl_n240;
    electrical cpphdl_n456;
    electrical cpphdl_n471;
    electrical cpphdl_n475;
    electrical cpphdl_n479;
    electrical cpphdl_n483;
    electrical cpphdl_n487;
    electrical cpphdl_n491;
    electrical cpphdl_n495;
    electrical cpphdl_n499;
    electrical cpphdl_n500;
    electrical cpphdl_n501;
    electrical cpphdl_n502;
    electrical cpphdl_n503;
    electrical cpphdl_n504;
    electrical cpphdl_n505;
    electrical cpphdl_n506;
    electrical cpphdl_n510;
    electrical cpphdl_n511;
    electrical cpphdl_n514;
    electrical cpphdl_n515;
    electrical cpphdl_n516;
    electrical cpphdl_n519;
    electrical cpphdl_n520;
    electrical cpphdl_n524;
    electrical cpphdl_n525;
    electrical cpphdl_n526;
    electrical cpphdl_n539;
    electrical cpphdl_n543;
    electrical cpphdl_n547;
    electrical cpphdl_n551;
    electrical cpphdl_n561;
    electrical cpphdl_n564;
    electrical cpphdl_n567;
    electrical cpphdl_n569;
    electrical cpphdl_n570;
    electrical cpphdl_n575;
    electrical cpphdl_n599;
    electrical cpphdl_n614;
    electrical cpphdl_n618;
    electrical cpphdl_n622;
    electrical cpphdl_n626;
    electrical cpphdl_n630;
    electrical cpphdl_n634;
    electrical cpphdl_n638;
    electrical cpphdl_n642;
    electrical cpphdl_n643;
    electrical cpphdl_n644;
    electrical cpphdl_n645;
    electrical cpphdl_n646;
    electrical cpphdl_n647;
    electrical cpphdl_n648;
    electrical cpphdl_n649;
    electrical cpphdl_n653;
    electrical cpphdl_n654;
    electrical cpphdl_n657;
    electrical cpphdl_n658;
    electrical cpphdl_n659;
    electrical cpphdl_n662;
    electrical cpphdl_n663;
    electrical cpphdl_n667;
    electrical cpphdl_n668;
    electrical cpphdl_n669;
    electrical cpphdl_n682;
    electrical cpphdl_n686;
    electrical cpphdl_n690;
    electrical cpphdl_n694;
    electrical cpphdl_n704;
    electrical cpphdl_n707;
    electrical cpphdl_n710;
    electrical cpphdl_n712;
    electrical cpphdl_n713;
    electrical cpphdl_n718;
    electrical cpphdl_n742;
    electrical cpphdl_n757;
    electrical cpphdl_n761;
    electrical cpphdl_n765;
    electrical cpphdl_n769;
    electrical cpphdl_n773;
    electrical cpphdl_n777;
    electrical cpphdl_n781;
    electrical cpphdl_n785;
    electrical cpphdl_n786;
    electrical cpphdl_n787;
    electrical cpphdl_n788;
    electrical cpphdl_n789;
    electrical cpphdl_n790;
    electrical cpphdl_n791;
    electrical cpphdl_n792;
    electrical cpphdl_n796;
    electrical cpphdl_n797;
    electrical cpphdl_n800;
    electrical cpphdl_n801;
    electrical cpphdl_n802;
    electrical cpphdl_n805;
    electrical cpphdl_n806;
    electrical cpphdl_n810;
    electrical cpphdl_n811;
    electrical cpphdl_n812;
    electrical cpphdl_n825;
    electrical cpphdl_n829;
    electrical cpphdl_n833;
    electrical cpphdl_n837;
    electrical cpphdl_n847;
    electrical cpphdl_n850;
    electrical cpphdl_n853;
    electrical cpphdl_n855;
    electrical cpphdl_n856;
    electrical cpphdl_n861;
    electrical cpphdl_n885;
    electrical cpphdl_n900;
    electrical cpphdl_n904;
    electrical cpphdl_n908;
    electrical cpphdl_n912;
    electrical cpphdl_n916;
    electrical cpphdl_n920;
    electrical cpphdl_n924;
    electrical cpphdl_n928;
    electrical cpphdl_n929;
    electrical cpphdl_n930;
    electrical cpphdl_n931;
    electrical cpphdl_n932;
    electrical cpphdl_n933;
    electrical cpphdl_n934;
    electrical cpphdl_n935;
    electrical cpphdl_n939;
    electrical cpphdl_n940;
    electrical cpphdl_n943;
    electrical cpphdl_n944;
    electrical cpphdl_n945;
    electrical cpphdl_n948;
    electrical cpphdl_n949;
    electrical cpphdl_n953;
    electrical cpphdl_n954;
    electrical cpphdl_n955;
    electrical cpphdl_n968;
    electrical cpphdl_n972;
    electrical cpphdl_n976;
    electrical cpphdl_n980;
    electrical cpphdl_n990;
    electrical cpphdl_n993;
    electrical cpphdl_n996;
    electrical cpphdl_n998;
    electrical cpphdl_n999;
    electrical cpphdl_n1004;
    electrical cpphdl_n1028;
    electrical cpphdl_n1043;
    electrical cpphdl_n1047;
    electrical cpphdl_n1051;
    electrical cpphdl_n1055;
    electrical cpphdl_n1059;
    electrical cpphdl_n1063;
    electrical cpphdl_n1067;
    electrical cpphdl_n1071;
    electrical cpphdl_n1072;
    electrical cpphdl_n1073;
    electrical cpphdl_n1074;
    electrical cpphdl_n1075;
    electrical cpphdl_n1076;
    electrical cpphdl_n1077;
    electrical cpphdl_n1078;
    electrical cpphdl_n1082;
    electrical cpphdl_n1083;
    electrical cpphdl_n1086;
    electrical cpphdl_n1087;
    electrical cpphdl_n1088;
    electrical cpphdl_n1091;
    electrical cpphdl_n1092;
    electrical cpphdl_n1096;
    electrical cpphdl_n1097;
    electrical cpphdl_n1098;
    electrical cpphdl_n1111;
    electrical cpphdl_n1115;
    electrical cpphdl_n1119;
    electrical cpphdl_n1123;
    electrical cpphdl_n1133;
    electrical cpphdl_n1136;
    electrical cpphdl_n1139;
    electrical cpphdl_n1141;
    electrical cpphdl_n1142;
    electrical cpphdl_n1147;
    electrical cpphdl_n1171;
    electrical cpphdl_n1186;
    electrical cpphdl_n1190;
    electrical cpphdl_n1194;
    electrical cpphdl_n1198;
    electrical cpphdl_n1202;
    electrical cpphdl_n1206;
    electrical cpphdl_n1210;
    electrical cpphdl_n1214;
    electrical cpphdl_n1215;
    electrical cpphdl_n1216;
    electrical cpphdl_n1217;
    electrical cpphdl_n1218;
    electrical cpphdl_n1219;
    electrical cpphdl_n1220;
    electrical cpphdl_n1221;
    electrical cpphdl_n1225;
    electrical cpphdl_n1226;
    electrical cpphdl_n1229;
    electrical cpphdl_n1230;
    electrical cpphdl_n1231;
    electrical cpphdl_n1234;
    electrical cpphdl_n1235;
    electrical cpphdl_n1239;
    electrical cpphdl_n1240;
    electrical cpphdl_n1241;
    electrical cpphdl_n1254;
    electrical cpphdl_n1258;
    electrical cpphdl_n1262;
    electrical cpphdl_n1266;
    electrical cpphdl_n1276;
    electrical cpphdl_n1279;
    electrical cpphdl_n1282;
    electrical cpphdl_n1284;
    electrical cpphdl_n1285;
    electrical cpphdl_n1290;
    electrical cpphdl_n1314;
    electrical cpphdl_n1329;
    electrical cpphdl_n1333;
    electrical cpphdl_n1337;
    electrical cpphdl_n1341;
    electrical cpphdl_n1345;
    electrical cpphdl_n1349;
    electrical cpphdl_n1353;
    electrical cpphdl_n1357;
    electrical cpphdl_n1358;
    electrical cpphdl_n1359;
    electrical cpphdl_n1360;
    electrical cpphdl_n1361;
    electrical cpphdl_n1362;
    electrical cpphdl_n1363;
    electrical cpphdl_n1364;
    electrical cpphdl_n1368;
    electrical cpphdl_n1369;
    electrical cpphdl_n1372;
    electrical cpphdl_n1373;
    electrical cpphdl_n1374;
    electrical cpphdl_n1377;
    electrical cpphdl_n1378;
    electrical cpphdl_n1382;
    electrical cpphdl_n1383;
    electrical cpphdl_n1384;
    electrical cpphdl_n1397;
    electrical cpphdl_n1401;
    electrical cpphdl_n1405;
    electrical cpphdl_n1409;
    electrical cpphdl_n1419;
    electrical cpphdl_n1422;
    electrical cpphdl_n1425;
    electrical cpphdl_n1427;
    electrical cpphdl_n1428;
    electrical cpphdl_n1433;
    electrical cpphdl_n1457;
    electrical cpphdl_n1472;
    electrical cpphdl_n1476;
    electrical cpphdl_n1480;
    electrical cpphdl_n1484;
    electrical cpphdl_n1488;
    electrical cpphdl_n1492;
    electrical cpphdl_n1496;
    electrical cpphdl_n1500;
    electrical cpphdl_n1501;
    electrical cpphdl_n1502;
    electrical cpphdl_n1503;
    electrical cpphdl_n1504;
    electrical cpphdl_n1505;
    electrical cpphdl_n1506;
    electrical cpphdl_n1507;
    electrical cpphdl_n1511;
    electrical cpphdl_n1512;
    electrical cpphdl_n1515;
    electrical cpphdl_n1516;
    electrical cpphdl_n1517;
    electrical cpphdl_n1520;
    electrical cpphdl_n1521;
    electrical cpphdl_n1525;
    electrical cpphdl_n1526;
    electrical cpphdl_n1527;
    electrical cpphdl_n1540;
    electrical cpphdl_n1544;
    electrical cpphdl_n1548;
    electrical cpphdl_n1552;
    electrical cpphdl_n1562;
    electrical cpphdl_n1565;
    electrical cpphdl_n1568;
    electrical cpphdl_n1570;
    electrical cpphdl_n1571;
    electrical cpphdl_n1576;
    electrical cpphdl_n1600;
    electrical cpphdl_n1615;
    electrical cpphdl_n1619;
    electrical cpphdl_n1623;
    electrical cpphdl_n1627;
    electrical cpphdl_n1631;
    electrical cpphdl_n1635;
    electrical cpphdl_n1639;
    electrical cpphdl_n1643;
    electrical cpphdl_n1644;
    electrical cpphdl_n1645;
    electrical cpphdl_n1646;
    electrical cpphdl_n1647;
    electrical cpphdl_n1648;
    electrical cpphdl_n1649;
    electrical cpphdl_n1650;
    electrical cpphdl_n1654;
    electrical cpphdl_n1655;
    electrical cpphdl_n1658;
    electrical cpphdl_n1659;
    electrical cpphdl_n1660;
    electrical cpphdl_n1663;
    electrical cpphdl_n1664;
    electrical cpphdl_n1668;
    electrical cpphdl_n1669;
    electrical cpphdl_n1670;
    electrical cpphdl_n1683;
    electrical cpphdl_n1687;
    electrical cpphdl_n1691;
    electrical cpphdl_n1695;
    electrical cpphdl_n1705;
    electrical cpphdl_n1708;
    electrical cpphdl_n1711;
    electrical cpphdl_n1713;
    electrical cpphdl_n1714;
    electrical cpphdl_n1719;
    electrical cpphdl_n1743;
    electrical cpphdl_n1758;
    electrical cpphdl_n1762;
    electrical cpphdl_n1766;
    electrical cpphdl_n1770;
    electrical cpphdl_n1774;
    electrical cpphdl_n1778;
    electrical cpphdl_n1782;
    electrical cpphdl_n1786;
    electrical cpphdl_n1787;
    electrical cpphdl_n1788;
    electrical cpphdl_n1789;
    electrical cpphdl_n1790;
    electrical cpphdl_n1791;
    electrical cpphdl_n1792;
    electrical cpphdl_n1793;
    electrical cpphdl_n1797;
    electrical cpphdl_n1798;
    electrical cpphdl_n1801;
    electrical cpphdl_n1802;
    electrical cpphdl_n1803;
    electrical cpphdl_n1806;
    electrical cpphdl_n1807;
    electrical cpphdl_n1811;
    electrical cpphdl_n1812;
    electrical cpphdl_n1813;
    electrical cpphdl_n1826;
    electrical cpphdl_n1830;
    electrical cpphdl_n1834;
    electrical cpphdl_n1838;
    electrical cpphdl_n1848;
    electrical cpphdl_n1851;
    electrical cpphdl_n1854;
    electrical cpphdl_n1856;
    electrical cpphdl_n1857;
    electrical cpphdl_n1862;
    electrical cpphdl_n1886;
    electrical cpphdl_n1901;
    electrical cpphdl_n1905;
    electrical cpphdl_n1909;
    electrical cpphdl_n1913;
    electrical cpphdl_n1917;
    electrical cpphdl_n1921;
    electrical cpphdl_n1925;
    electrical cpphdl_n1929;
    electrical cpphdl_n1930;
    electrical cpphdl_n1931;
    electrical cpphdl_n1932;
    electrical cpphdl_n1933;
    electrical cpphdl_n1934;
    electrical cpphdl_n1935;
    electrical cpphdl_n1936;
    electrical cpphdl_n1940;
    electrical cpphdl_n1941;
    electrical cpphdl_n1944;
    electrical cpphdl_n1945;
    electrical cpphdl_n1946;
    electrical cpphdl_n1949;
    electrical cpphdl_n1950;
    electrical cpphdl_n1954;
    electrical cpphdl_n1955;
    electrical cpphdl_n1956;
    electrical cpphdl_n1969;
    electrical cpphdl_n1973;
    electrical cpphdl_n1977;
    electrical cpphdl_n1981;
    electrical cpphdl_n1991;
    electrical cpphdl_n1994;
    electrical cpphdl_n1997;
    electrical cpphdl_n1999;
    electrical cpphdl_n2000;
    electrical cpphdl_n2005;
    electrical cpphdl_n2029;
    electrical cpphdl_n2044;
    electrical cpphdl_n2048;
    electrical cpphdl_n2052;
    electrical cpphdl_n2056;
    electrical cpphdl_n2060;
    electrical cpphdl_n2064;
    electrical cpphdl_n2068;
    electrical cpphdl_n2072;
    electrical cpphdl_n2073;
    electrical cpphdl_n2074;
    electrical cpphdl_n2075;
    electrical cpphdl_n2076;
    electrical cpphdl_n2077;
    electrical cpphdl_n2078;
    electrical cpphdl_n2079;
    electrical cpphdl_n2083;
    electrical cpphdl_n2084;
    electrical cpphdl_n2087;
    electrical cpphdl_n2088;
    electrical cpphdl_n2089;
    electrical cpphdl_n2092;
    electrical cpphdl_n2093;
    electrical cpphdl_n2097;
    electrical cpphdl_n2098;
    electrical cpphdl_n2099;
    electrical cpphdl_n2112;
    electrical cpphdl_n2116;
    electrical cpphdl_n2120;
    electrical cpphdl_n2124;
    electrical cpphdl_n2134;
    electrical cpphdl_n2137;
    electrical cpphdl_n2140;
    electrical cpphdl_n2142;
    electrical cpphdl_n2143;
    electrical cpphdl_n2148;
    electrical cpphdl_n2172;
    electrical cpphdl_n2187;
    electrical cpphdl_n2191;
    electrical cpphdl_n2195;
    electrical cpphdl_n2199;
    electrical cpphdl_n2203;
    electrical cpphdl_n2207;
    electrical cpphdl_n2211;
    electrical cpphdl_n2215;
    electrical cpphdl_n2216;
    electrical cpphdl_n2217;
    electrical cpphdl_n2218;
    electrical cpphdl_n2219;
    electrical cpphdl_n2220;
    electrical cpphdl_n2221;
    electrical cpphdl_n2222;
    electrical cpphdl_n2226;
    electrical cpphdl_n2227;
    electrical cpphdl_n2230;
    electrical cpphdl_n2231;
    electrical cpphdl_n2232;
    electrical cpphdl_n2235;
    electrical cpphdl_n2236;
    electrical cpphdl_n2240;
    electrical cpphdl_n2241;
    electrical cpphdl_n2242;
    electrical cpphdl_n2255;
    electrical cpphdl_n2259;
    electrical cpphdl_n2263;
    electrical cpphdl_n2267;
    electrical cpphdl_n2277;
    electrical cpphdl_n2280;
    electrical cpphdl_n2283;
    electrical cpphdl_n2285;
    electrical cpphdl_n2286;
    electrical cpphdl_n2291;
    electrical cpphdl_n2315;
    electrical cpphdl_n2330;
    electrical cpphdl_n2334;
    electrical cpphdl_n2338;
    electrical cpphdl_n2342;
    electrical cpphdl_n2346;
    electrical cpphdl_n2350;
    electrical cpphdl_n2354;
    electrical cpphdl_n2358;
    electrical cpphdl_n2359;
    electrical cpphdl_n2360;
    electrical cpphdl_n2361;
    electrical cpphdl_n2362;
    electrical cpphdl_n2363;
    electrical cpphdl_n2364;
    electrical cpphdl_n2365;
    electrical cpphdl_n2369;
    electrical cpphdl_n2370;
    electrical cpphdl_n2373;
    electrical cpphdl_n2374;
    electrical cpphdl_n2375;
    electrical cpphdl_n2378;
    electrical cpphdl_n2379;
    electrical cpphdl_n2383;
    electrical cpphdl_n2384;
    electrical cpphdl_n2385;
    electrical cpphdl_n2398;
    electrical cpphdl_n2402;
    electrical cpphdl_n2406;
    electrical cpphdl_n2410;
    electrical cpphdl_n2420;
    electrical cpphdl_n2423;
    electrical cpphdl_n2426;
    electrical cpphdl_n2428;
    electrical cpphdl_n2429;
    electrical cpphdl_n2434;
    electrical cpphdl_n2458;
    electrical cpphdl_n2473;
    electrical cpphdl_n2477;
    electrical cpphdl_n2481;
    electrical cpphdl_n2485;
    electrical cpphdl_n2489;
    electrical cpphdl_n2493;
    electrical cpphdl_n2497;
    electrical cpphdl_n2501;
    electrical cpphdl_n2502;
    electrical cpphdl_n2503;
    electrical cpphdl_n2504;
    electrical cpphdl_n2505;
    electrical cpphdl_n2506;
    electrical cpphdl_n2507;
    electrical cpphdl_n2508;
    electrical cpphdl_n2512;
    electrical cpphdl_n2513;
    electrical cpphdl_n2516;
    electrical cpphdl_n2517;
    electrical cpphdl_n2518;
    electrical cpphdl_n2521;
    electrical cpphdl_n2522;
    electrical cpphdl_n2526;
    electrical cpphdl_n2527;
    electrical cpphdl_n2528;
    electrical cpphdl_n2541;
    electrical cpphdl_n2545;
    electrical cpphdl_n2549;
    electrical cpphdl_n2553;
    electrical cpphdl_n2563;
    electrical cpphdl_n2566;
    electrical cpphdl_n2569;
    electrical cpphdl_n2571;
    electrical cpphdl_n2572;
    electrical cpphdl_n2577;
    electrical cpphdl_n2595;
    electrical cpphdl_n2601;
    electrical cpphdl_n2616;
    electrical cpphdl_n2620;
    electrical cpphdl_n2624;
    electrical cpphdl_n2628;
    electrical cpphdl_n2632;
    electrical cpphdl_n2636;
    electrical cpphdl_n2640;
    electrical cpphdl_n2644;
    electrical cpphdl_n2645;
    electrical cpphdl_n2646;
    electrical cpphdl_n2647;
    electrical cpphdl_n2648;
    electrical cpphdl_n2649;
    electrical cpphdl_n2650;
    electrical cpphdl_n2651;
    electrical cpphdl_n2655;
    electrical cpphdl_n2656;
    electrical cpphdl_n2659;
    electrical cpphdl_n2660;
    electrical cpphdl_n2661;
    electrical cpphdl_n2664;
    electrical cpphdl_n2665;
    electrical cpphdl_n2669;
    electrical cpphdl_n2670;
    electrical cpphdl_n2671;
    electrical cpphdl_n2684;
    electrical cpphdl_n2688;
    electrical cpphdl_n2692;
    electrical cpphdl_n2696;
    electrical cpphdl_n2706;
    electrical cpphdl_n2709;
    electrical cpphdl_n2712;
    electrical cpphdl_n2714;
    electrical cpphdl_n2715;
    electrical cpphdl_n2720;
    electrical cpphdl_n2740;
    electrical cpphdl_n2742;
    electrical cpphdl_n2745;
    electrical cpphdl_n2747;
    electrical cpphdl_n2750;
    electrical cpphdl_n2752;
    electrical cpphdl_n2755;
    electrical cpphdl_n2757;
    electrical cpphdl_n2760;
    electrical cpphdl_n2762;
    electrical cpphdl_n2765;
    electrical cpphdl_n2767;
    electrical cpphdl_n2770;
    electrical cpphdl_n2772;
    electrical cpphdl_n2775;
    electrical cpphdl_n2777;
    electrical cpphdl_n2780;
    electrical cpphdl_n2782;
    electrical cpphdl_n2785;
    electrical cpphdl_n2787;
    electrical cpphdl_n2790;
    electrical cpphdl_n2792;
    electrical cpphdl_n2795;
    electrical cpphdl_n2797;
    electrical cpphdl_n2800;
    electrical cpphdl_n2802;
    electrical cpphdl_n2805;
    electrical cpphdl_n2807;
    electrical cpphdl_n2810;
    electrical cpphdl_n2812;
    electrical cpphdl_n2815;
    electrical cpphdl_n2817;

    // Square-law channel, including reverse conduction. This is not a BSIM model.
    analog function real cpphdl_channel;
        input vgs, vds, beta, threshold, polarity;
        real vgs, vds, beta, threshold, polarity;
        real gate, drain, direction, overdrive, current;
        begin
            gate = polarity * vgs;
            drain = polarity * vds;
            direction = 1.0;
            if (drain < 0.0) begin
                gate = gate - drain;
                drain = -drain;
                direction = -1.0;
            end
            overdrive = gate - threshold;
            current = 0.0;
            if (overdrive > 0.0) begin
                if (drain < overdrive)
                    current = beta * (overdrive * drain - drain * drain / 2.0);
                else
                    current = beta * overdrive * overdrive / 2.0;
            end
            cpphdl_channel = polarity * direction * current;
        end
    endfunction

    analog begin
        // device 0, IC OneGIHPWidebandProgrammableReceiveFrontend, analog/1G/IHPSG13G2/programmable_receive_frontend.hpp:45
        I(PLUS, MINUS) <+ V(PLUS, MINUS) / 100.0;
        // device 1, IC IC1, analog/basic/nmos_resistor_amplifier.hpp:23
        I(Vdd, cpphdl_n187) <+ V(Vdd, cpphdl_n187) / 500.0;
        // device 2, IC IC1, analog/basic/nmos_resistor_amplifier.hpp:24
        I(Vdd, cpphdl_n197) <+ V(Vdd, cpphdl_n197) / 500.0;
        // device 3, IC IC1, analog/basic/nmos_resistor_amplifier.hpp:25
        I(cpphdl_n187, cpphdl_n179) <+ cpphdl_channel(V(PLUS, cpphdl_n179), V(cpphdl_n187, cpphdl_n179), 0.014999999999999999, 0.69999999999999996, 1.0);
        // device 4, IC IC1, analog/basic/nmos_resistor_amplifier.hpp:26
        I(cpphdl_n197, cpphdl_n180) <+ cpphdl_channel(V(MINUS, cpphdl_n180), V(cpphdl_n197, cpphdl_n180), 0.014999999999999999, 0.69999999999999996, 1.0);
        // device 5, IC IC1, analog/basic/nmos_resistor_amplifier.hpp:27
        I(cpphdl_n181, cpphdl_n179) <+ V(cpphdl_n181, cpphdl_n179) / 50.0;
        // device 6, IC IC1, analog/basic/nmos_resistor_amplifier.hpp:28
        I(cpphdl_n181, cpphdl_n180) <+ V(cpphdl_n181, cpphdl_n180) / 50.0;
        // device 7, IC IC1, analog/basic/nmos_resistor_amplifier.hpp:29
        I(Vss, cpphdl_n181) <+ V(Vss, cpphdl_n181) / 150.0;
        // device 8, IC IC1, analog/basic/nmos_resistor_amplifier.hpp:30
        I(cpphdl_n187, Vdd) <+ 1e-13 * ddt(V(cpphdl_n187, Vdd)); // Bench initial voltage = 0.0 V.
        // device 9, IC IC1, analog/basic/nmos_resistor_amplifier.hpp:31
        I(cpphdl_n197, Vdd) <+ 1e-13 * ddt(V(cpphdl_n197, Vdd)); // Bench initial voltage = 0.0 V.
        // device 10, IC IC1, analog/basic/nmos_resistor_amplifier.hpp:32
        I(cpphdl_n181, Vss) <+ 4e-14 * ddt(V(cpphdl_n181, Vss)); // Bench initial voltage = 0.0 V.
        // device 11, IC IC1, analog/basic/nmos_resistor_amplifier.hpp:34
        I(PLUS, cpphdl_n179) <+ 1.4999999999999999e-13 * ddt(V(PLUS, cpphdl_n179)); // Bench initial voltage = 1.6499999999999999 V.
        // device 12, IC IC1, analog/basic/nmos_resistor_amplifier.hpp:35
        I(MINUS, cpphdl_n180) <+ 1.4999999999999999e-13 * ddt(V(MINUS, cpphdl_n180)); // Bench initial voltage = 1.6499999999999999 V.
        // device 13, IC IC1, analog/basic/nmos_resistor_amplifier.hpp:36
        I(PLUS, cpphdl_n187) <+ 2e-14 * ddt(V(PLUS, cpphdl_n187)); // Bench initial voltage = -1.6499999999999999 V.
        // device 14, IC IC1, analog/basic/nmos_resistor_amplifier.hpp:37
        I(MINUS, cpphdl_n197) <+ 2e-14 * ddt(V(MINUS, cpphdl_n197)); // Bench initial voltage = -1.6499999999999999 V.
        // device 15, IC IC3, analog/basic/nmos_source_follower.hpp:19
        I(Vdd, cpphdl_n198) <+ cpphdl_channel(V(cpphdl_n197, cpphdl_n198), V(Vdd, cpphdl_n198), 0.10000000000000001, 0.69999999999999996, 1.0);
        // device 16, IC IC3, analog/basic/nmos_source_follower.hpp:20
        I(Vss, cpphdl_n198) <+ V(Vss, cpphdl_n198) / 250.0;
        // device 17, IC IC3, analog/basic/nmos_source_follower.hpp:23
        I(cpphdl_n197, cpphdl_n198) <+ 4e-14 * ddt(V(cpphdl_n197, cpphdl_n198)); // Bench initial voltage = 1.6499999999999999 V.
        // device 18, IC IC3, analog/basic/nmos_source_follower.hpp:24
        I(cpphdl_n197, Vdd) <+ 1e-14 * ddt(V(cpphdl_n197, Vdd)); // Bench initial voltage = 0.0 V.
        // device 19, IC IC3, analog/basic/nmos_source_follower.hpp:25
        I(cpphdl_n198, Vss) <+ 4e-14 * ddt(V(cpphdl_n198, Vss)); // Bench initial voltage = 1.6499999999999999 V.
        // device 20, IC IC2, analog/basic/nmos_resistor_amplifier.hpp:23
        I(Vdd, cpphdl_n187) <+ V(Vdd, cpphdl_n187) / 500.0;
        // device 21, IC IC2, analog/basic/nmos_resistor_amplifier.hpp:24
        I(Vdd, cpphdl_n197) <+ V(Vdd, cpphdl_n197) / 500.0;
        // device 22, IC IC2, analog/basic/nmos_resistor_amplifier.hpp:25
        I(cpphdl_n187, cpphdl_n188) <+ cpphdl_channel(V(PLUS, cpphdl_n188), V(cpphdl_n187, cpphdl_n188), 0.014999999999999999, 0.69999999999999996, 1.0);
        // device 23, IC IC2, analog/basic/nmos_resistor_amplifier.hpp:26
        I(cpphdl_n197, cpphdl_n189) <+ cpphdl_channel(V(MINUS, cpphdl_n189), V(cpphdl_n197, cpphdl_n189), 0.014999999999999999, 0.69999999999999996, 1.0);
        // device 24, IC IC2, analog/basic/nmos_resistor_amplifier.hpp:27
        I(cpphdl_n190, cpphdl_n188) <+ V(cpphdl_n190, cpphdl_n188) / 50.0;
        // device 25, IC IC2, analog/basic/nmos_resistor_amplifier.hpp:28
        I(cpphdl_n190, cpphdl_n189) <+ V(cpphdl_n190, cpphdl_n189) / 50.0;
        // device 26, IC IC2, analog/basic/nmos_resistor_amplifier.hpp:29
        I(Vss, cpphdl_n190) <+ V(Vss, cpphdl_n190) / 150.0;
        // device 27, IC IC2, analog/basic/nmos_resistor_amplifier.hpp:30
        I(cpphdl_n187, Vdd) <+ 1e-13 * ddt(V(cpphdl_n187, Vdd)); // Bench initial voltage = 0.0 V.
        // device 28, IC IC2, analog/basic/nmos_resistor_amplifier.hpp:31
        I(cpphdl_n197, Vdd) <+ 1e-13 * ddt(V(cpphdl_n197, Vdd)); // Bench initial voltage = 0.0 V.
        // device 29, IC IC2, analog/basic/nmos_resistor_amplifier.hpp:32
        I(cpphdl_n190, Vss) <+ 4e-14 * ddt(V(cpphdl_n190, Vss)); // Bench initial voltage = 0.0 V.
        // device 30, IC IC2, analog/basic/nmos_resistor_amplifier.hpp:34
        I(PLUS, cpphdl_n188) <+ 1.4999999999999999e-13 * ddt(V(PLUS, cpphdl_n188)); // Bench initial voltage = 1.6499999999999999 V.
        // device 31, IC IC2, analog/basic/nmos_resistor_amplifier.hpp:35
        I(MINUS, cpphdl_n189) <+ 1.4999999999999999e-13 * ddt(V(MINUS, cpphdl_n189)); // Bench initial voltage = 1.6499999999999999 V.
        // device 32, IC IC2, analog/basic/nmos_resistor_amplifier.hpp:36
        I(PLUS, cpphdl_n187) <+ 2e-14 * ddt(V(PLUS, cpphdl_n187)); // Bench initial voltage = -1.6499999999999999 V.
        // device 33, IC IC2, analog/basic/nmos_resistor_amplifier.hpp:37
        I(MINUS, cpphdl_n197) <+ 2e-14 * ddt(V(MINUS, cpphdl_n197)); // Bench initial voltage = -1.6499999999999999 V.
        // device 34, IC IC4, analog/basic/nmos_source_follower.hpp:19
        I(Vdd, cpphdl_n198) <+ cpphdl_channel(V(cpphdl_n197, cpphdl_n198), V(Vdd, cpphdl_n198), 0.10000000000000001, 0.69999999999999996, 1.0);
        // device 35, IC IC4, analog/basic/nmos_source_follower.hpp:20
        I(Vss, cpphdl_n198) <+ V(Vss, cpphdl_n198) / 250.0;
        // device 36, IC IC4, analog/basic/nmos_source_follower.hpp:23
        I(cpphdl_n197, cpphdl_n198) <+ 4e-14 * ddt(V(cpphdl_n197, cpphdl_n198)); // Bench initial voltage = 1.6499999999999999 V.
        // device 37, IC IC4, analog/basic/nmos_source_follower.hpp:24
        I(cpphdl_n197, Vdd) <+ 1e-14 * ddt(V(cpphdl_n197, Vdd)); // Bench initial voltage = 0.0 V.
        // device 38, IC IC4, analog/basic/nmos_source_follower.hpp:25
        I(cpphdl_n198, Vss) <+ 4e-14 * ddt(V(cpphdl_n198, Vss)); // Bench initial voltage = 1.6499999999999999 V.
        // device 39, IC OneGIHPWidebandProgrammableReceiveFrontend, analog/1G/IHPSG13G2/programmable_receive_frontend.hpp:81
        I(cpphdl_n2595, Vss) <+ 3.0000000000000001e-12 * ddt(V(cpphdl_n2595, Vss)); // Bench initial voltage = 1.6499999999999999 V.
        // device 40, IC IC5, analog/1G/IHPSG13G2/programmable_receive_gain.hpp:31
        I(cpphdl_n198, cpphdl_n226) <+ V(cpphdl_n198, cpphdl_n226) / 100000.0;
        // device 41, IC IC5, analog/1G/IHPSG13G2/programmable_receive_gain.hpp:32
        I(cpphdl_n226, Vss) <+ 9.9999999999999994e-12 * ddt(V(cpphdl_n226, Vss)); // Bench initial voltage = 0.0 V.
        // device 42, IC IC8, analog/basic/resistor_divider.hpp:15
        I(Vdd, cpphdl_n229) <+ V(Vdd, cpphdl_n229) / 15000.0;
        // device 43, IC IC8, analog/basic/resistor_divider.hpp:16
        I(cpphdl_n229, Vss) <+ V(cpphdl_n229, Vss) / 18000.0;
        // device 44, IC IC9, analog/basic/resistor_divider.hpp:15
        I(Vdd, cpphdl_n230) <+ V(Vdd, cpphdl_n230) / 23000.0;
        // device 45, IC IC9, analog/basic/resistor_divider.hpp:16
        I(cpphdl_n230, Vss) <+ V(cpphdl_n230, Vss) / 43000.0;
        // device 46, IC IC5, analog/1G/IHPSG13G2/programmable_receive_gain.hpp:43
        I(cpphdl_n229, Vss) <+ 9.9999999999999994e-12 * ddt(V(cpphdl_n229, Vss)); // Bench initial voltage = 0.0 V.
        // device 47, IC IC5, analog/1G/IHPSG13G2/programmable_receive_gain.hpp:44
        I(cpphdl_n230, Vss) <+ 9.9999999999999994e-12 * ddt(V(cpphdl_n230, Vss)); // Bench initial voltage = 0.0 V.
        // device 48, IC IC5, analog/1G/IHPSG13G2/programmable_receive_gain.hpp:45
        I(Vdd, cpphdl_n231) <+ V(Vdd, cpphdl_n231) / 2500.0;
        // device 49, IC IC5, analog/1G/IHPSG13G2/programmable_receive_gain.hpp:46
        I(cpphdl_n231, Vss) <+ cpphdl_channel(V(cpphdl_n231, Vss), V(cpphdl_n231, Vss), 0.029999999999999999, 0.69999999999999996, 1.0);
        // device 50, IC IC5, analog/1G/IHPSG13G2/programmable_receive_gain.hpp:47
        I(cpphdl_n231, Vss) <+ 9.9999999999999994e-12 * ddt(V(cpphdl_n231, Vss)); // Bench initial voltage = 0.0 V.
        // device 51, IC IC5, analog/1G/IHPSG13G2/programmable_receive_gain.hpp:49
        I(cpphdl_n2595, cpphdl_n212) <+ V(cpphdl_n2595, cpphdl_n212) / 50.0;
        // device 52, IC IC5, analog/1G/IHPSG13G2/programmable_receive_gain.hpp:51
        I(cpphdl_n212, cpphdl_n213) <+ V(cpphdl_n212, cpphdl_n213) / 50.0;
        // device 53, IC IC5, analog/1G/IHPSG13G2/programmable_receive_gain.hpp:51
        I(cpphdl_n213, cpphdl_n214) <+ V(cpphdl_n213, cpphdl_n214) / 50.0;
        // device 54, IC IC5, analog/1G/IHPSG13G2/programmable_receive_gain.hpp:51
        I(cpphdl_n214, cpphdl_n215) <+ V(cpphdl_n214, cpphdl_n215) / 50.0;
        // device 55, IC IC5, analog/1G/IHPSG13G2/programmable_receive_gain.hpp:51
        I(cpphdl_n215, cpphdl_n216) <+ V(cpphdl_n215, cpphdl_n216) / 50.0;
        // device 56, IC IC5, analog/1G/IHPSG13G2/programmable_receive_gain.hpp:51
        I(cpphdl_n216, cpphdl_n217) <+ V(cpphdl_n216, cpphdl_n217) / 50.0;
        // device 57, IC IC5, analog/1G/IHPSG13G2/programmable_receive_gain.hpp:51
        I(cpphdl_n217, cpphdl_n218) <+ V(cpphdl_n217, cpphdl_n218) / 50.0;
        // device 58, IC IC5, analog/1G/IHPSG13G2/programmable_receive_gain.hpp:51
        I(cpphdl_n218, cpphdl_n219) <+ V(cpphdl_n218, cpphdl_n219) / 50.0;
        // device 59, IC IC5, analog/1G/IHPSG13G2/programmable_receive_gain.hpp:52
        I(cpphdl_n219, cpphdl_n198) <+ V(cpphdl_n219, cpphdl_n198) / 50.0;
        // device 60, IC IC5, analog/1G/IHPSG13G2/programmable_receive_gain.hpp:55
        I(cpphdl_n227, cpphdl_n215) <+ cpphdl_channel(V(SELECT_N0, cpphdl_n215), V(cpphdl_n227, cpphdl_n215), 0.02, 0.69999999999999996, -1.0);
        // device 61, IC IC5, analog/1G/IHPSG13G2/programmable_receive_gain.hpp:57
        I(cpphdl_n220, cpphdl_n240) <+ cpphdl_channel(V(SELECT_N0, cpphdl_n240), V(cpphdl_n220, cpphdl_n240), 0.02, 0.69999999999999996, -1.0);
        // device 62, IC IC5, analog/1G/IHPSG13G2/programmable_receive_gain.hpp:58
        I(cpphdl_n220, Vss) <+ 9.9999999999999998e-13 * ddt(V(cpphdl_n220, Vss)); // Bench initial voltage = 0.0 V.
        // device 63, IC IC5, analog/1G/IHPSG13G2/programmable_receive_gain.hpp:55
        I(cpphdl_n227, cpphdl_n216) <+ cpphdl_channel(V(SELECT_N1, cpphdl_n216), V(cpphdl_n227, cpphdl_n216), 0.02, 0.69999999999999996, -1.0);
        // device 64, IC IC5, analog/1G/IHPSG13G2/programmable_receive_gain.hpp:57
        I(cpphdl_n221, cpphdl_n240) <+ cpphdl_channel(V(SELECT_N1, cpphdl_n240), V(cpphdl_n221, cpphdl_n240), 0.02, 0.69999999999999996, -1.0);
        // device 65, IC IC5, analog/1G/IHPSG13G2/programmable_receive_gain.hpp:58
        I(cpphdl_n221, Vss) <+ 7.5000000000000004e-13 * ddt(V(cpphdl_n221, Vss)); // Bench initial voltage = 0.0 V.
        // device 66, IC IC5, analog/1G/IHPSG13G2/programmable_receive_gain.hpp:55
        I(cpphdl_n227, cpphdl_n217) <+ cpphdl_channel(V(SELECT_N2, cpphdl_n217), V(cpphdl_n227, cpphdl_n217), 0.02, 0.69999999999999996, -1.0);
        // device 67, IC IC5, analog/1G/IHPSG13G2/programmable_receive_gain.hpp:57
        I(cpphdl_n222, cpphdl_n240) <+ cpphdl_channel(V(SELECT_N2, cpphdl_n240), V(cpphdl_n222, cpphdl_n240), 0.02, 0.69999999999999996, -1.0);
        // device 68, IC IC5, analog/1G/IHPSG13G2/programmable_receive_gain.hpp:58
        I(cpphdl_n222, Vss) <+ 4.9999999999999999e-13 * ddt(V(cpphdl_n222, Vss)); // Bench initial voltage = 0.0 V.
        // device 69, IC IC5, analog/1G/IHPSG13G2/programmable_receive_gain.hpp:55
        I(cpphdl_n227, cpphdl_n218) <+ cpphdl_channel(V(SELECT_N3, cpphdl_n218), V(cpphdl_n227, cpphdl_n218), 0.02, 0.69999999999999996, -1.0);
        // device 70, IC IC5, analog/1G/IHPSG13G2/programmable_receive_gain.hpp:57
        I(cpphdl_n223, cpphdl_n240) <+ cpphdl_channel(V(SELECT_N3, cpphdl_n240), V(cpphdl_n223, cpphdl_n240), 0.02, 0.69999999999999996, -1.0);
        // device 71, IC IC5, analog/1G/IHPSG13G2/programmable_receive_gain.hpp:58
        I(cpphdl_n223, Vss) <+ 2.4999999999999999e-13 * ddt(V(cpphdl_n223, Vss)); // Bench initial voltage = 0.0 V.
        // device 72, IC IC5, analog/1G/IHPSG13G2/programmable_receive_gain.hpp:55
        I(cpphdl_n227, cpphdl_n219) <+ cpphdl_channel(V(SELECT_N4, cpphdl_n219), V(cpphdl_n227, cpphdl_n219), 0.02, 0.69999999999999996, -1.0);
        // device 73, IC IC6, analog/basic/cascode_opamp.hpp:29
        I(cpphdl_n232, cpphdl_n237) <+ cpphdl_channel(V(cpphdl_n226, cpphdl_n237), V(cpphdl_n232, cpphdl_n237), 0.029999999999999999, 0.69999999999999996, 1.0);
        // device 74, IC IC6, analog/basic/cascode_opamp.hpp:30
        I(cpphdl_n233, cpphdl_n237) <+ cpphdl_channel(V(cpphdl_n227, cpphdl_n237), V(cpphdl_n233, cpphdl_n237), 0.029999999999999999, 0.69999999999999996, 1.0);
        // device 75, IC IC6, analog/basic/cascode_opamp.hpp:31
        I(cpphdl_n234, cpphdl_n232) <+ cpphdl_channel(V(cpphdl_n229, cpphdl_n232), V(cpphdl_n234, cpphdl_n232), 0.059999999999999998, 0.69999999999999996, 1.0);
        // device 76, IC IC6, analog/basic/cascode_opamp.hpp:32
        I(cpphdl_n240, cpphdl_n233) <+ cpphdl_channel(V(cpphdl_n229, cpphdl_n233), V(cpphdl_n240, cpphdl_n233), 0.059999999999999998, 0.69999999999999996, 1.0);
        // device 77, IC IC6, analog/basic/cascode_opamp.hpp:33
        I(cpphdl_n235, Vdd) <+ cpphdl_channel(V(cpphdl_n234, Vdd), V(cpphdl_n235, Vdd), 0.029999999999999999, 0.69999999999999996, -1.0);
        // device 78, IC IC6, analog/basic/cascode_opamp.hpp:34
        I(cpphdl_n236, Vdd) <+ cpphdl_channel(V(cpphdl_n234, Vdd), V(cpphdl_n236, Vdd), 0.029999999999999999, 0.69999999999999996, -1.0);
        // device 79, IC IC6, analog/basic/cascode_opamp.hpp:35
        I(cpphdl_n234, cpphdl_n235) <+ cpphdl_channel(V(cpphdl_n230, cpphdl_n235), V(cpphdl_n234, cpphdl_n235), 0.059999999999999998, 0.69999999999999996, -1.0);
        // device 80, IC IC6, analog/basic/cascode_opamp.hpp:36
        I(cpphdl_n240, cpphdl_n236) <+ cpphdl_channel(V(cpphdl_n230, cpphdl_n236), V(cpphdl_n240, cpphdl_n236), 0.059999999999999998, 0.69999999999999996, -1.0);
        // device 81, IC IC6, analog/basic/cascode_opamp.hpp:37
        I(cpphdl_n237, Vss) <+ cpphdl_channel(V(cpphdl_n231, Vss), V(cpphdl_n237, Vss), 0.059999999999999998, 0.69999999999999996, 1.0);
        // device 82, IC IC6, analog/basic/cascode_opamp.hpp:38
        I(Vss, cpphdl_n240) <+ V(Vss, cpphdl_n240) / 100000.0;
        // device 83, IC IC6, analog/basic/cascode_opamp.hpp:39
        I(cpphdl_n240, Vss) <+ 2.4999999999999999e-13 * ddt(V(cpphdl_n240, Vss)); // Bench initial voltage = 2.3999999999999999 V.
        // device 84, IC IC6, analog/basic/cascode_opamp.hpp:40
        I(cpphdl_n232, Vss) <+ 4e-14 * ddt(V(cpphdl_n232, Vss)); // Bench initial voltage = 0.0 V.
        // device 85, IC IC6, analog/basic/cascode_opamp.hpp:41
        I(cpphdl_n233, Vss) <+ 4e-14 * ddt(V(cpphdl_n233, Vss)); // Bench initial voltage = 0.0 V.
        // device 86, IC IC6, analog/basic/cascode_opamp.hpp:42
        I(cpphdl_n237, Vss) <+ 4e-14 * ddt(V(cpphdl_n237, Vss)); // Bench initial voltage = 0.0 V.
        // device 87, IC IC6, analog/basic/cascode_opamp.hpp:43
        I(cpphdl_n235, Vdd) <+ 4e-14 * ddt(V(cpphdl_n235, Vdd)); // Bench initial voltage = 0.0 V.
        // device 88, IC IC6, analog/basic/cascode_opamp.hpp:44
        I(cpphdl_n236, Vdd) <+ 4e-14 * ddt(V(cpphdl_n236, Vdd)); // Bench initial voltage = 0.0 V.
        // device 89, IC IC6, analog/basic/cascode_opamp.hpp:45
        I(cpphdl_n234, Vss) <+ 4e-14 * ddt(V(cpphdl_n234, Vss)); // Bench initial voltage = 0.0 V.
        // device 90, IC IC6, analog/basic/cascode_opamp.hpp:46
        I(cpphdl_n226, cpphdl_n237) <+ 4e-14 * ddt(V(cpphdl_n226, cpphdl_n237)); // Bench initial voltage = 0.0 V.
        // device 91, IC IC6, analog/basic/cascode_opamp.hpp:47
        I(cpphdl_n227, cpphdl_n237) <+ 4e-14 * ddt(V(cpphdl_n227, cpphdl_n237)); // Bench initial voltage = 0.0 V.
        // device 92, IC IC6, analog/basic/cascode_opamp.hpp:48
        I(cpphdl_n226, cpphdl_n232) <+ 1e-14 * ddt(V(cpphdl_n226, cpphdl_n232)); // Bench initial voltage = 0.0 V.
        // device 93, IC IC6, analog/basic/cascode_opamp.hpp:49
        I(cpphdl_n227, cpphdl_n233) <+ 1e-14 * ddt(V(cpphdl_n227, cpphdl_n233)); // Bench initial voltage = 0.0 V.
        // device 94, IC IC7, analog/basic/nmos_source_follower.hpp:19
        I(Vdd, cpphdl_n2595) <+ cpphdl_channel(V(cpphdl_n240, cpphdl_n2595), V(Vdd, cpphdl_n2595), 0.20000000000000001, 0.69999999999999996, 1.0);
        // device 95, IC IC7, analog/basic/nmos_source_follower.hpp:20
        I(Vss, cpphdl_n2595) <+ V(Vss, cpphdl_n2595) / 250.0;
        // device 96, IC IC7, analog/basic/nmos_source_follower.hpp:23
        I(cpphdl_n240, cpphdl_n2595) <+ 8e-14 * ddt(V(cpphdl_n240, cpphdl_n2595)); // Bench initial voltage = 0.75 V.
        // device 97, IC IC7, analog/basic/nmos_source_follower.hpp:24
        I(cpphdl_n240, Vdd) <+ 2e-14 * ddt(V(cpphdl_n240, Vdd)); // Bench initial voltage = -0.89999999999999991 V.
        // device 98, IC IC7, analog/basic/nmos_source_follower.hpp:25
        I(cpphdl_n2595, Vss) <+ 8e-14 * ddt(V(cpphdl_n2595, Vss)); // Bench initial voltage = 1.6499999999999999 V.
        // device 99, IC IC13, analog/basic/inverter.hpp:11
        I(cpphdl_n456, Vdd) <+ cpphdl_channel(V(TRACK0, Vdd), V(cpphdl_n456, Vdd), 0.0040000000000000001, 0.69999999999999996, -1.0);
        // device 100, IC IC13, analog/basic/inverter.hpp:12
        I(cpphdl_n456, Vss) <+ cpphdl_channel(V(TRACK0, Vss), V(cpphdl_n456, Vss), 0.0040000000000000001, 0.69999999999999996, 1.0);
        // device 101, IC IC12, analog/basic/mos_track_hold.hpp:30
        I(cpphdl_n456, Vss) <+ 2e-14 * ddt(V(cpphdl_n456, Vss)); // Bench initial voltage = 3.2999999999999998 V.
        // device 102, IC IC12, analog/basic/mos_track_hold.hpp:31
        I(cpphdl_n2595, cpphdl_n510) <+ cpphdl_channel(V(TRACK0, cpphdl_n510), V(cpphdl_n2595, cpphdl_n510), 0.02, 0.69999999999999996, 1.0);
        // device 103, IC IC12, analog/basic/mos_track_hold.hpp:32
        I(cpphdl_n510, cpphdl_n2595) <+ cpphdl_channel(V(cpphdl_n456, cpphdl_n2595), V(cpphdl_n510, cpphdl_n2595), 0.01, 0.69999999999999996, -1.0);
        // device 104, IC IC12, analog/basic/mos_track_hold.hpp:36
        I(cpphdl_n510, cpphdl_n510) <+ cpphdl_channel(V(cpphdl_n456, cpphdl_n510), V(cpphdl_n510, cpphdl_n510), 0.01, 0.69999999999999996, 1.0);
        // device 105, IC IC12, analog/basic/mos_track_hold.hpp:37
        I(cpphdl_n510, cpphdl_n510) <+ cpphdl_channel(V(TRACK0, cpphdl_n510), V(cpphdl_n510, cpphdl_n510), 0.0050000000000000001, 0.69999999999999996, -1.0);
        // device 106, IC IC12, analog/basic/mos_track_hold.hpp:38
        I(cpphdl_n510, Vss) <+ 1.5000000000000001e-12 * ddt(V(cpphdl_n510, Vss)); // Bench initial voltage = 1.6499999999999999 V.
        // device 107, IC IC12, analog/basic/mos_track_hold.hpp:39
        I(Vss, cpphdl_n510) <+ V(Vss, cpphdl_n510) / 1000000000.0;
        // device 108, IC IC12, analog/basic/mos_track_hold.hpp:40
        I(TRACK0, cpphdl_n510) <+ 2.0000000000000002e-15 * ddt(V(TRACK0, cpphdl_n510)); // Bench initial voltage = -1.6499999999999999 V.
        // device 109, IC IC12, analog/basic/mos_track_hold.hpp:41
        I(cpphdl_n456, cpphdl_n510) <+ 2.0000000000000002e-15 * ddt(V(cpphdl_n456, cpphdl_n510)); // Bench initial voltage = 1.6499999999999999 V.
        // device 110, IC IC12, analog/basic/mos_track_hold.hpp:42
        I(cpphdl_n2595, cpphdl_n510) <+ 1.0000000000000001e-15 * ddt(V(cpphdl_n2595, cpphdl_n510)); // Bench initial voltage = 0.0 V.
        // device 111, IC IC15, analog/basic/inverter.hpp:11
        I(cpphdl_n471, Vdd) <+ cpphdl_channel(V(BIT_N0_0, Vdd), V(cpphdl_n471, Vdd), 0.080000000000000002, 0.69999999999999996, -1.0);
        // device 112, IC IC15, analog/basic/inverter.hpp:12
        I(cpphdl_n471, Vss) <+ cpphdl_channel(V(BIT_N0_0, Vss), V(cpphdl_n471, Vss), 0.080000000000000002, 0.69999999999999996, 1.0);
        // device 113, IC IC14, analog/basic/mos_r2r_dac.hpp:27
        I(cpphdl_n471, Vss) <+ 2.9999999999999998e-15 * ddt(V(cpphdl_n471, Vss)); // Bench initial voltage = 0.0 V.
        // device 114, IC IC14, analog/basic/mos_r2r_dac.hpp:28
        I(cpphdl_n471, cpphdl_n500) <+ V(cpphdl_n471, cpphdl_n500) / 2000.0;
        // device 115, IC IC14, analog/basic/mos_r2r_dac.hpp:29
        I(cpphdl_n500, Vss) <+ 2.9999999999999998e-15 * ddt(V(cpphdl_n500, Vss)); // Bench initial voltage = 0.0 V.
        // device 116, IC IC16, analog/basic/inverter.hpp:11
        I(cpphdl_n475, Vdd) <+ cpphdl_channel(V(BIT_N0_1, Vdd), V(cpphdl_n475, Vdd), 0.080000000000000002, 0.69999999999999996, -1.0);
        // device 117, IC IC16, analog/basic/inverter.hpp:12
        I(cpphdl_n475, Vss) <+ cpphdl_channel(V(BIT_N0_1, Vss), V(cpphdl_n475, Vss), 0.080000000000000002, 0.69999999999999996, 1.0);
        // device 118, IC IC14, analog/basic/mos_r2r_dac.hpp:27
        I(cpphdl_n475, Vss) <+ 2.9999999999999998e-15 * ddt(V(cpphdl_n475, Vss)); // Bench initial voltage = 0.0 V.
        // device 119, IC IC14, analog/basic/mos_r2r_dac.hpp:28
        I(cpphdl_n475, cpphdl_n501) <+ V(cpphdl_n475, cpphdl_n501) / 2000.0;
        // device 120, IC IC14, analog/basic/mos_r2r_dac.hpp:29
        I(cpphdl_n501, Vss) <+ 2.9999999999999998e-15 * ddt(V(cpphdl_n501, Vss)); // Bench initial voltage = 0.0 V.
        // device 121, IC IC14, analog/basic/mos_r2r_dac.hpp:31
        I(cpphdl_n500, cpphdl_n501) <+ V(cpphdl_n500, cpphdl_n501) / 1000.0;
        // device 122, IC IC17, analog/basic/inverter.hpp:11
        I(cpphdl_n479, Vdd) <+ cpphdl_channel(V(BIT_N0_2, Vdd), V(cpphdl_n479, Vdd), 0.080000000000000002, 0.69999999999999996, -1.0);
        // device 123, IC IC17, analog/basic/inverter.hpp:12
        I(cpphdl_n479, Vss) <+ cpphdl_channel(V(BIT_N0_2, Vss), V(cpphdl_n479, Vss), 0.080000000000000002, 0.69999999999999996, 1.0);
        // device 124, IC IC14, analog/basic/mos_r2r_dac.hpp:27
        I(cpphdl_n479, Vss) <+ 2.9999999999999998e-15 * ddt(V(cpphdl_n479, Vss)); // Bench initial voltage = 0.0 V.
        // device 125, IC IC14, analog/basic/mos_r2r_dac.hpp:28
        I(cpphdl_n479, cpphdl_n502) <+ V(cpphdl_n479, cpphdl_n502) / 2000.0;
        // device 126, IC IC14, analog/basic/mos_r2r_dac.hpp:29
        I(cpphdl_n502, Vss) <+ 2.9999999999999998e-15 * ddt(V(cpphdl_n502, Vss)); // Bench initial voltage = 0.0 V.
        // device 127, IC IC14, analog/basic/mos_r2r_dac.hpp:31
        I(cpphdl_n501, cpphdl_n502) <+ V(cpphdl_n501, cpphdl_n502) / 1000.0;
        // device 128, IC IC18, analog/basic/inverter.hpp:11
        I(cpphdl_n483, Vdd) <+ cpphdl_channel(V(BIT_N0_3, Vdd), V(cpphdl_n483, Vdd), 0.080000000000000002, 0.69999999999999996, -1.0);
        // device 129, IC IC18, analog/basic/inverter.hpp:12
        I(cpphdl_n483, Vss) <+ cpphdl_channel(V(BIT_N0_3, Vss), V(cpphdl_n483, Vss), 0.080000000000000002, 0.69999999999999996, 1.0);
        // device 130, IC IC14, analog/basic/mos_r2r_dac.hpp:27
        I(cpphdl_n483, Vss) <+ 2.9999999999999998e-15 * ddt(V(cpphdl_n483, Vss)); // Bench initial voltage = 0.0 V.
        // device 131, IC IC14, analog/basic/mos_r2r_dac.hpp:28
        I(cpphdl_n483, cpphdl_n503) <+ V(cpphdl_n483, cpphdl_n503) / 2000.0;
        // device 132, IC IC14, analog/basic/mos_r2r_dac.hpp:29
        I(cpphdl_n503, Vss) <+ 2.9999999999999998e-15 * ddt(V(cpphdl_n503, Vss)); // Bench initial voltage = 0.0 V.
        // device 133, IC IC14, analog/basic/mos_r2r_dac.hpp:31
        I(cpphdl_n502, cpphdl_n503) <+ V(cpphdl_n502, cpphdl_n503) / 1000.0;
        // device 134, IC IC19, analog/basic/inverter.hpp:11
        I(cpphdl_n487, Vdd) <+ cpphdl_channel(V(BIT_N0_4, Vdd), V(cpphdl_n487, Vdd), 0.080000000000000002, 0.69999999999999996, -1.0);
        // device 135, IC IC19, analog/basic/inverter.hpp:12
        I(cpphdl_n487, Vss) <+ cpphdl_channel(V(BIT_N0_4, Vss), V(cpphdl_n487, Vss), 0.080000000000000002, 0.69999999999999996, 1.0);
        // device 136, IC IC14, analog/basic/mos_r2r_dac.hpp:27
        I(cpphdl_n487, Vss) <+ 2.9999999999999998e-15 * ddt(V(cpphdl_n487, Vss)); // Bench initial voltage = 0.0 V.
        // device 137, IC IC14, analog/basic/mos_r2r_dac.hpp:28
        I(cpphdl_n487, cpphdl_n504) <+ V(cpphdl_n487, cpphdl_n504) / 2000.0;
        // device 138, IC IC14, analog/basic/mos_r2r_dac.hpp:29
        I(cpphdl_n504, Vss) <+ 2.9999999999999998e-15 * ddt(V(cpphdl_n504, Vss)); // Bench initial voltage = 0.0 V.
        // device 139, IC IC14, analog/basic/mos_r2r_dac.hpp:31
        I(cpphdl_n503, cpphdl_n504) <+ V(cpphdl_n503, cpphdl_n504) / 1000.0;
        // device 140, IC IC20, analog/basic/inverter.hpp:11
        I(cpphdl_n491, Vdd) <+ cpphdl_channel(V(BIT_N0_5, Vdd), V(cpphdl_n491, Vdd), 0.080000000000000002, 0.69999999999999996, -1.0);
        // device 141, IC IC20, analog/basic/inverter.hpp:12
        I(cpphdl_n491, Vss) <+ cpphdl_channel(V(BIT_N0_5, Vss), V(cpphdl_n491, Vss), 0.080000000000000002, 0.69999999999999996, 1.0);
        // device 142, IC IC14, analog/basic/mos_r2r_dac.hpp:27
        I(cpphdl_n491, Vss) <+ 2.9999999999999998e-15 * ddt(V(cpphdl_n491, Vss)); // Bench initial voltage = 0.0 V.
        // device 143, IC IC14, analog/basic/mos_r2r_dac.hpp:28
        I(cpphdl_n491, cpphdl_n505) <+ V(cpphdl_n491, cpphdl_n505) / 2000.0;
        // device 144, IC IC14, analog/basic/mos_r2r_dac.hpp:29
        I(cpphdl_n505, Vss) <+ 2.9999999999999998e-15 * ddt(V(cpphdl_n505, Vss)); // Bench initial voltage = 0.0 V.
        // device 145, IC IC14, analog/basic/mos_r2r_dac.hpp:31
        I(cpphdl_n504, cpphdl_n505) <+ V(cpphdl_n504, cpphdl_n505) / 1000.0;
        // device 146, IC IC21, analog/basic/inverter.hpp:11
        I(cpphdl_n495, Vdd) <+ cpphdl_channel(V(BIT_N0_6, Vdd), V(cpphdl_n495, Vdd), 0.080000000000000002, 0.69999999999999996, -1.0);
        // device 147, IC IC21, analog/basic/inverter.hpp:12
        I(cpphdl_n495, Vss) <+ cpphdl_channel(V(BIT_N0_6, Vss), V(cpphdl_n495, Vss), 0.080000000000000002, 0.69999999999999996, 1.0);
        // device 148, IC IC14, analog/basic/mos_r2r_dac.hpp:27
        I(cpphdl_n495, Vss) <+ 2.9999999999999998e-15 * ddt(V(cpphdl_n495, Vss)); // Bench initial voltage = 0.0 V.
        // device 149, IC IC14, analog/basic/mos_r2r_dac.hpp:28
        I(cpphdl_n495, cpphdl_n506) <+ V(cpphdl_n495, cpphdl_n506) / 2000.0;
        // device 150, IC IC14, analog/basic/mos_r2r_dac.hpp:29
        I(cpphdl_n506, Vss) <+ 2.9999999999999998e-15 * ddt(V(cpphdl_n506, Vss)); // Bench initial voltage = 0.0 V.
        // device 151, IC IC14, analog/basic/mos_r2r_dac.hpp:31
        I(cpphdl_n505, cpphdl_n506) <+ V(cpphdl_n505, cpphdl_n506) / 1000.0;
        // device 152, IC IC22, analog/basic/inverter.hpp:11
        I(cpphdl_n499, Vdd) <+ cpphdl_channel(V(BIT_N0_7, Vdd), V(cpphdl_n499, Vdd), 0.080000000000000002, 0.69999999999999996, -1.0);
        // device 153, IC IC22, analog/basic/inverter.hpp:12
        I(cpphdl_n499, Vss) <+ cpphdl_channel(V(BIT_N0_7, Vss), V(cpphdl_n499, Vss), 0.080000000000000002, 0.69999999999999996, 1.0);
        // device 154, IC IC14, analog/basic/mos_r2r_dac.hpp:27
        I(cpphdl_n499, Vss) <+ 2.9999999999999998e-15 * ddt(V(cpphdl_n499, Vss)); // Bench initial voltage = 0.0 V.
        // device 155, IC IC14, analog/basic/mos_r2r_dac.hpp:28
        I(cpphdl_n499, cpphdl_n511) <+ V(cpphdl_n499, cpphdl_n511) / 2000.0;
        // device 156, IC IC14, analog/basic/mos_r2r_dac.hpp:29
        I(cpphdl_n511, Vss) <+ 2.9999999999999998e-15 * ddt(V(cpphdl_n511, Vss)); // Bench initial voltage = 0.0 V.
        // device 157, IC IC14, analog/basic/mos_r2r_dac.hpp:31
        I(cpphdl_n506, cpphdl_n511) <+ V(cpphdl_n506, cpphdl_n511) / 1000.0;
        // device 158, IC IC14, analog/basic/mos_r2r_dac.hpp:33
        I(Vss, cpphdl_n500) <+ V(Vss, cpphdl_n500) / 2000.0;
        // device 159, IC IC23, analog/basic/nmos_resistor_amplifier.hpp:23
        I(Vdd, cpphdl_n520) <+ V(Vdd, cpphdl_n520) / 500.0;
        // device 160, IC IC23, analog/basic/nmos_resistor_amplifier.hpp:24
        I(Vdd, cpphdl_n519) <+ V(Vdd, cpphdl_n519) / 500.0;
        // device 161, IC IC23, analog/basic/nmos_resistor_amplifier.hpp:25
        I(cpphdl_n520, cpphdl_n514) <+ cpphdl_channel(V(cpphdl_n510, cpphdl_n514), V(cpphdl_n520, cpphdl_n514), 0.014999999999999999, 0.69999999999999996, 1.0);
        // device 162, IC IC23, analog/basic/nmos_resistor_amplifier.hpp:26
        I(cpphdl_n519, cpphdl_n515) <+ cpphdl_channel(V(cpphdl_n511, cpphdl_n515), V(cpphdl_n519, cpphdl_n515), 0.014999999999999999, 0.69999999999999996, 1.0);
        // device 163, IC IC23, analog/basic/nmos_resistor_amplifier.hpp:27
        I(cpphdl_n516, cpphdl_n514) <+ V(cpphdl_n516, cpphdl_n514) / 50.0;
        // device 164, IC IC23, analog/basic/nmos_resistor_amplifier.hpp:28
        I(cpphdl_n516, cpphdl_n515) <+ V(cpphdl_n516, cpphdl_n515) / 50.0;
        // device 165, IC IC23, analog/basic/nmos_resistor_amplifier.hpp:29
        I(Vss, cpphdl_n516) <+ V(Vss, cpphdl_n516) / 150.0;
        // device 166, IC IC23, analog/basic/nmos_resistor_amplifier.hpp:30
        I(cpphdl_n520, Vdd) <+ 2.9999999999999998e-13 * ddt(V(cpphdl_n520, Vdd)); // Bench initial voltage = 0.0 V.
        // device 167, IC IC23, analog/basic/nmos_resistor_amplifier.hpp:31
        I(cpphdl_n519, Vdd) <+ 2.9999999999999998e-13 * ddt(V(cpphdl_n519, Vdd)); // Bench initial voltage = 0.0 V.
        // device 168, IC IC23, analog/basic/nmos_resistor_amplifier.hpp:32
        I(cpphdl_n516, Vss) <+ 4e-14 * ddt(V(cpphdl_n516, Vss)); // Bench initial voltage = 0.0 V.
        // device 169, IC IC23, analog/basic/nmos_resistor_amplifier.hpp:34
        I(cpphdl_n510, cpphdl_n514) <+ 2e-14 * ddt(V(cpphdl_n510, cpphdl_n514)); // Bench initial voltage = 1.6499999999999999 V.
        // device 170, IC IC23, analog/basic/nmos_resistor_amplifier.hpp:35
        I(cpphdl_n511, cpphdl_n515) <+ 2e-14 * ddt(V(cpphdl_n511, cpphdl_n515)); // Bench initial voltage = 0.0 V.
        // device 171, IC IC23, analog/basic/nmos_resistor_amplifier.hpp:36
        I(cpphdl_n510, cpphdl_n520) <+ 2.9999999999999998e-15 * ddt(V(cpphdl_n510, cpphdl_n520)); // Bench initial voltage = -1.6499999999999999 V.
        // device 172, IC IC23, analog/basic/nmos_resistor_amplifier.hpp:37
        I(cpphdl_n511, cpphdl_n519) <+ 2.9999999999999998e-15 * ddt(V(cpphdl_n511, cpphdl_n519)); // Bench initial voltage = -3.2999999999999998 V.
        // device 173, IC IC24, analog/basic/strongarm_comparator.hpp:28
        I(cpphdl_n524, cpphdl_n526) <+ cpphdl_channel(V(cpphdl_n519, cpphdl_n526), V(cpphdl_n524, cpphdl_n526), 0.0080000000000000002, 0.69999999999999996, 1.0);
        // device 174, IC IC24, analog/basic/strongarm_comparator.hpp:29
        I(cpphdl_n525, cpphdl_n526) <+ cpphdl_channel(V(cpphdl_n520, cpphdl_n526), V(cpphdl_n525, cpphdl_n526), 0.0080000000000000002, 0.69999999999999996, 1.0);
        // device 175, IC IC24, analog/basic/strongarm_comparator.hpp:30
        I(cpphdl_n526, Vss) <+ cpphdl_channel(V(EVALUATE, Vss), V(cpphdl_n526, Vss), 0.0080000000000000002, 0.69999999999999996, 1.0);
        // device 176, IC IC24, analog/basic/strongarm_comparator.hpp:33
        I(cpphdl_n539, cpphdl_n524) <+ cpphdl_channel(V(cpphdl_n543, cpphdl_n524), V(cpphdl_n539, cpphdl_n524), 0.0040000000000000001, 0.69999999999999996, 1.0);
        // device 177, IC IC24, analog/basic/strongarm_comparator.hpp:34
        I(cpphdl_n543, cpphdl_n525) <+ cpphdl_channel(V(cpphdl_n539, cpphdl_n525), V(cpphdl_n543, cpphdl_n525), 0.0040000000000000001, 0.69999999999999996, 1.0);
        // device 178, IC IC24, analog/basic/strongarm_comparator.hpp:35
        I(cpphdl_n543, Vdd) <+ cpphdl_channel(V(cpphdl_n539, Vdd), V(cpphdl_n543, Vdd), 0.002, 0.69999999999999996, -1.0);
        // device 179, IC IC24, analog/basic/strongarm_comparator.hpp:36
        I(cpphdl_n539, Vdd) <+ cpphdl_channel(V(cpphdl_n543, Vdd), V(cpphdl_n539, Vdd), 0.002, 0.69999999999999996, -1.0);
        // device 180, IC IC24, analog/basic/strongarm_comparator.hpp:38
        I(cpphdl_n524, Vdd) <+ cpphdl_channel(V(EVALUATE, Vdd), V(cpphdl_n524, Vdd), 0.002, 0.69999999999999996, -1.0);
        // device 181, IC IC24, analog/basic/strongarm_comparator.hpp:39
        I(cpphdl_n525, Vdd) <+ cpphdl_channel(V(EVALUATE, Vdd), V(cpphdl_n525, Vdd), 0.002, 0.69999999999999996, -1.0);
        // device 182, IC IC24, analog/basic/strongarm_comparator.hpp:40
        I(cpphdl_n543, Vdd) <+ cpphdl_channel(V(EVALUATE, Vdd), V(cpphdl_n543, Vdd), 0.002, 0.69999999999999996, -1.0);
        // device 183, IC IC24, analog/basic/strongarm_comparator.hpp:41
        I(cpphdl_n539, Vdd) <+ cpphdl_channel(V(EVALUATE, Vdd), V(cpphdl_n539, Vdd), 0.002, 0.69999999999999996, -1.0);
        // device 184, IC IC24, analog/basic/strongarm_comparator.hpp:42
        I(cpphdl_n524, Vss) <+ 2.9999999999999998e-14 * ddt(V(cpphdl_n524, Vss)); // Bench initial voltage = 0.0 V.
        // device 185, IC IC24, analog/basic/strongarm_comparator.hpp:43
        I(cpphdl_n525, Vss) <+ 2.9999999999999998e-14 * ddt(V(cpphdl_n525, Vss)); // Bench initial voltage = 0.0 V.
        // device 186, IC IC24, analog/basic/strongarm_comparator.hpp:44
        I(cpphdl_n526, Vss) <+ 2.9999999999999998e-14 * ddt(V(cpphdl_n526, Vss)); // Bench initial voltage = 0.0 V.
        // device 187, IC IC24, analog/basic/strongarm_comparator.hpp:45
        I(cpphdl_n543, Vss) <+ 5.0000000000000002e-14 * ddt(V(cpphdl_n543, Vss)); // Bench initial voltage = 0.0 V.
        // device 188, IC IC24, analog/basic/strongarm_comparator.hpp:46
        I(cpphdl_n539, Vss) <+ 5.0000000000000002e-14 * ddt(V(cpphdl_n539, Vss)); // Bench initial voltage = 0.0 V.
        // device 189, IC IC24, analog/basic/strongarm_comparator.hpp:47
        I(cpphdl_n519, cpphdl_n526) <+ 2e-14 * ddt(V(cpphdl_n519, cpphdl_n526)); // Bench initial voltage = 3.2999999999999998 V.
        // device 190, IC IC24, analog/basic/strongarm_comparator.hpp:48
        I(cpphdl_n520, cpphdl_n526) <+ 2e-14 * ddt(V(cpphdl_n520, cpphdl_n526)); // Bench initial voltage = 3.2999999999999998 V.
        // device 191, IC IC24, analog/basic/strongarm_comparator.hpp:49
        I(cpphdl_n519, cpphdl_n524) <+ 2.9999999999999998e-15 * ddt(V(cpphdl_n519, cpphdl_n524)); // Bench initial voltage = 3.2999999999999998 V.
        // device 192, IC IC24, analog/basic/strongarm_comparator.hpp:50
        I(cpphdl_n520, cpphdl_n525) <+ 2.9999999999999998e-15 * ddt(V(cpphdl_n520, cpphdl_n525)); // Bench initial voltage = 3.2999999999999998 V.
        // device 193, IC IC26, analog/basic/inverter.hpp:11
        I(cpphdl_n547, Vdd) <+ cpphdl_channel(V(cpphdl_n539, Vdd), V(cpphdl_n547, Vdd), 0.001, 0.69999999999999996, -1.0);
        // device 194, IC IC26, analog/basic/inverter.hpp:12
        I(cpphdl_n547, Vss) <+ cpphdl_channel(V(cpphdl_n539, Vss), V(cpphdl_n547, Vss), 0.001, 0.69999999999999996, 1.0);
        // device 195, IC IC28, analog/basic/inverter.hpp:11
        I(cpphdl_n561, Vdd) <+ cpphdl_channel(V(cpphdl_n547, Vdd), V(cpphdl_n561, Vdd), 0.0040000000000000001, 0.69999999999999996, -1.0);
        // device 196, IC IC28, analog/basic/inverter.hpp:12
        I(cpphdl_n561, Vss) <+ cpphdl_channel(V(cpphdl_n547, Vss), V(cpphdl_n561, Vss), 0.0040000000000000001, 0.69999999999999996, 1.0);
        // device 197, IC IC25, analog/basic/buffered_nand_latch.hpp:33
        I(cpphdl_n539, Vss) <+ 2.0000000000000002e-15 * ddt(V(cpphdl_n539, Vss)); // Bench initial voltage = 0.0 V.
        // device 198, IC IC25, analog/basic/buffered_nand_latch.hpp:34
        I(cpphdl_n539, cpphdl_n547) <+ 1.0000000000000001e-15 * ddt(V(cpphdl_n539, cpphdl_n547)); // Bench initial voltage = 0.0 V.
        // device 199, IC IC25, analog/basic/buffered_nand_latch.hpp:35
        I(cpphdl_n547, Vss) <+ 5e-15 * ddt(V(cpphdl_n547, Vss)); // Bench initial voltage = 0.0 V.
        // device 200, IC IC25, analog/basic/buffered_nand_latch.hpp:36
        I(cpphdl_n547, Vss) <+ 8.0000000000000006e-15 * ddt(V(cpphdl_n547, Vss)); // Bench initial voltage = 0.0 V.
        // device 201, IC IC25, analog/basic/buffered_nand_latch.hpp:37
        I(cpphdl_n561, Vss) <+ 1e-14 * ddt(V(cpphdl_n561, Vss)); // Bench initial voltage = 0.0 V.
        // device 202, IC IC27, analog/basic/inverter.hpp:11
        I(cpphdl_n551, Vdd) <+ cpphdl_channel(V(cpphdl_n543, Vdd), V(cpphdl_n551, Vdd), 0.001, 0.69999999999999996, -1.0);
        // device 203, IC IC27, analog/basic/inverter.hpp:12
        I(cpphdl_n551, Vss) <+ cpphdl_channel(V(cpphdl_n543, Vss), V(cpphdl_n551, Vss), 0.001, 0.69999999999999996, 1.0);
        // device 204, IC IC29, analog/basic/inverter.hpp:11
        I(cpphdl_n567, Vdd) <+ cpphdl_channel(V(cpphdl_n551, Vdd), V(cpphdl_n567, Vdd), 0.0040000000000000001, 0.69999999999999996, -1.0);
        // device 205, IC IC29, analog/basic/inverter.hpp:12
        I(cpphdl_n567, Vss) <+ cpphdl_channel(V(cpphdl_n551, Vss), V(cpphdl_n567, Vss), 0.0040000000000000001, 0.69999999999999996, 1.0);
        // device 206, IC IC25, analog/basic/buffered_nand_latch.hpp:33
        I(cpphdl_n543, Vss) <+ 2.0000000000000002e-15 * ddt(V(cpphdl_n543, Vss)); // Bench initial voltage = 0.0 V.
        // device 207, IC IC25, analog/basic/buffered_nand_latch.hpp:34
        I(cpphdl_n543, cpphdl_n551) <+ 1.0000000000000001e-15 * ddt(V(cpphdl_n543, cpphdl_n551)); // Bench initial voltage = 0.0 V.
        // device 208, IC IC25, analog/basic/buffered_nand_latch.hpp:35
        I(cpphdl_n551, Vss) <+ 5e-15 * ddt(V(cpphdl_n551, Vss)); // Bench initial voltage = 0.0 V.
        // device 209, IC IC25, analog/basic/buffered_nand_latch.hpp:36
        I(cpphdl_n551, Vss) <+ 8.0000000000000006e-15 * ddt(V(cpphdl_n551, Vss)); // Bench initial voltage = 0.0 V.
        // device 210, IC IC25, analog/basic/buffered_nand_latch.hpp:37
        I(cpphdl_n567, Vss) <+ 1e-14 * ddt(V(cpphdl_n567, Vss)); // Bench initial voltage = 0.0 V.
        // device 211, IC IC31, analog/basic/cmos_logic.hpp:15
        I(cpphdl_n2740, Vss) <+ 5.0000000000000002e-14 * ddt(V(cpphdl_n2740, Vss)); // Bench initial voltage = 0.0 V.
        // device 212, IC IC31, analog/basic/cmos_logic.hpp:16
        I(cpphdl_n2740, Vdd) <+ cpphdl_channel(V(cpphdl_n561, Vdd), V(cpphdl_n2740, Vdd), 0.01, 0.69999999999999996, -1.0);
        // device 213, IC IC31, analog/basic/cmos_logic.hpp:17
        I(cpphdl_n2740, Vdd) <+ cpphdl_channel(V(cpphdl_n569, Vdd), V(cpphdl_n2740, Vdd), 0.01, 0.69999999999999996, -1.0);
        // device 214, IC IC31, analog/basic/cmos_logic.hpp:18
        I(cpphdl_n2740, cpphdl_n564) <+ cpphdl_channel(V(cpphdl_n561, cpphdl_n564), V(cpphdl_n2740, cpphdl_n564), 0.01, 0.69999999999999996, 1.0);
        // device 215, IC IC31, analog/basic/cmos_logic.hpp:19
        I(cpphdl_n564, Vss) <+ cpphdl_channel(V(cpphdl_n569, Vss), V(cpphdl_n564, Vss), 0.01, 0.69999999999999996, 1.0);
        // device 216, IC IC31, analog/basic/cmos_logic.hpp:20
        I(cpphdl_n2740, Vss) <+ V(cpphdl_n2740, Vss) / 1000000000.0;
        // device 217, IC IC31, analog/basic/cmos_logic.hpp:21
        I(cpphdl_n564, Vss) <+ V(cpphdl_n564, Vss) / 1000000000.0;
        // device 218, IC IC32, analog/basic/cmos_logic.hpp:15
        I(cpphdl_n569, Vss) <+ 5.0000000000000002e-14 * ddt(V(cpphdl_n569, Vss)); // Bench initial voltage = 0.0 V.
        // device 219, IC IC32, analog/basic/cmos_logic.hpp:16
        I(cpphdl_n569, Vdd) <+ cpphdl_channel(V(cpphdl_n567, Vdd), V(cpphdl_n569, Vdd), 0.01, 0.69999999999999996, -1.0);
        // device 220, IC IC32, analog/basic/cmos_logic.hpp:17
        I(cpphdl_n569, Vdd) <+ cpphdl_channel(V(cpphdl_n2740, Vdd), V(cpphdl_n569, Vdd), 0.01, 0.69999999999999996, -1.0);
        // device 221, IC IC32, analog/basic/cmos_logic.hpp:18
        I(cpphdl_n569, cpphdl_n570) <+ cpphdl_channel(V(cpphdl_n567, cpphdl_n570), V(cpphdl_n569, cpphdl_n570), 0.01, 0.69999999999999996, 1.0);
        // device 222, IC IC32, analog/basic/cmos_logic.hpp:19
        I(cpphdl_n570, Vss) <+ cpphdl_channel(V(cpphdl_n2740, Vss), V(cpphdl_n570, Vss), 0.01, 0.69999999999999996, 1.0);
        // device 223, IC IC32, analog/basic/cmos_logic.hpp:20
        I(cpphdl_n569, Vss) <+ V(cpphdl_n569, Vss) / 1000000000.0;
        // device 224, IC IC32, analog/basic/cmos_logic.hpp:21
        I(cpphdl_n570, Vss) <+ V(cpphdl_n570, Vss) / 1000000000.0;
        // device 225, IC IC30, analog/basic/nand_latch.hpp:34
        I(cpphdl_n561, Vss) <+ 2.9999999999999998e-15 * ddt(V(cpphdl_n561, Vss)); // Bench initial voltage = 0.0 V.
        // device 226, IC IC30, analog/basic/nand_latch.hpp:35
        I(cpphdl_n567, Vss) <+ 2.9999999999999998e-15 * ddt(V(cpphdl_n567, Vss)); // Bench initial voltage = 0.0 V.
        // device 227, IC IC33, analog/basic/inverter.hpp:11
        I(cpphdl_n575, Vdd) <+ cpphdl_channel(V(CLEAR, Vdd), V(cpphdl_n575, Vdd), 0.01, 0.69999999999999996, -1.0);
        // device 228, IC IC33, analog/basic/inverter.hpp:12
        I(cpphdl_n575, Vss) <+ cpphdl_channel(V(CLEAR, Vss), V(cpphdl_n575, Vss), 0.01, 0.69999999999999996, 1.0);
        // device 229, IC IC30, analog/basic/nand_latch.hpp:56
        I(cpphdl_n575, Vss) <+ 2.9999999999999998e-15 * ddt(V(cpphdl_n575, Vss)); // Bench initial voltage = 0.0 V.
        // device 230, IC IC30, analog/basic/nand_latch.hpp:57
        I(cpphdl_n2740, Vss) <+ cpphdl_channel(V(CLEAR, Vss), V(cpphdl_n2740, Vss), 0.050000000000000003, 0.69999999999999996, 1.0);
        // device 231, IC IC30, analog/basic/nand_latch.hpp:58
        I(cpphdl_n569, Vdd) <+ cpphdl_channel(V(cpphdl_n575, Vdd), V(cpphdl_n569, Vdd), 0.050000000000000003, 0.69999999999999996, -1.0);
        // device 232, IC IC36, analog/basic/inverter.hpp:11
        I(cpphdl_n599, Vdd) <+ cpphdl_channel(V(TRACK1, Vdd), V(cpphdl_n599, Vdd), 0.0040000000000000001, 0.69999999999999996, -1.0);
        // device 233, IC IC36, analog/basic/inverter.hpp:12
        I(cpphdl_n599, Vss) <+ cpphdl_channel(V(TRACK1, Vss), V(cpphdl_n599, Vss), 0.0040000000000000001, 0.69999999999999996, 1.0);
        // device 234, IC IC35, analog/basic/mos_track_hold.hpp:30
        I(cpphdl_n599, Vss) <+ 2e-14 * ddt(V(cpphdl_n599, Vss)); // Bench initial voltage = 3.2999999999999998 V.
        // device 235, IC IC35, analog/basic/mos_track_hold.hpp:31
        I(cpphdl_n2595, cpphdl_n653) <+ cpphdl_channel(V(TRACK1, cpphdl_n653), V(cpphdl_n2595, cpphdl_n653), 0.02, 0.69999999999999996, 1.0);
        // device 236, IC IC35, analog/basic/mos_track_hold.hpp:32
        I(cpphdl_n653, cpphdl_n2595) <+ cpphdl_channel(V(cpphdl_n599, cpphdl_n2595), V(cpphdl_n653, cpphdl_n2595), 0.01, 0.69999999999999996, -1.0);
        // device 237, IC IC35, analog/basic/mos_track_hold.hpp:36
        I(cpphdl_n653, cpphdl_n653) <+ cpphdl_channel(V(cpphdl_n599, cpphdl_n653), V(cpphdl_n653, cpphdl_n653), 0.01, 0.69999999999999996, 1.0);
        // device 238, IC IC35, analog/basic/mos_track_hold.hpp:37
        I(cpphdl_n653, cpphdl_n653) <+ cpphdl_channel(V(TRACK1, cpphdl_n653), V(cpphdl_n653, cpphdl_n653), 0.0050000000000000001, 0.69999999999999996, -1.0);
        // device 239, IC IC35, analog/basic/mos_track_hold.hpp:38
        I(cpphdl_n653, Vss) <+ 1.5000000000000001e-12 * ddt(V(cpphdl_n653, Vss)); // Bench initial voltage = 1.6499999999999999 V.
        // device 240, IC IC35, analog/basic/mos_track_hold.hpp:39
        I(Vss, cpphdl_n653) <+ V(Vss, cpphdl_n653) / 1000000000.0;
        // device 241, IC IC35, analog/basic/mos_track_hold.hpp:40
        I(TRACK1, cpphdl_n653) <+ 2.0000000000000002e-15 * ddt(V(TRACK1, cpphdl_n653)); // Bench initial voltage = -1.6499999999999999 V.
        // device 242, IC IC35, analog/basic/mos_track_hold.hpp:41
        I(cpphdl_n599, cpphdl_n653) <+ 2.0000000000000002e-15 * ddt(V(cpphdl_n599, cpphdl_n653)); // Bench initial voltage = 1.6499999999999999 V.
        // device 243, IC IC35, analog/basic/mos_track_hold.hpp:42
        I(cpphdl_n2595, cpphdl_n653) <+ 1.0000000000000001e-15 * ddt(V(cpphdl_n2595, cpphdl_n653)); // Bench initial voltage = 0.0 V.
        // device 244, IC IC38, analog/basic/inverter.hpp:11
        I(cpphdl_n614, Vdd) <+ cpphdl_channel(V(BIT_N1_0, Vdd), V(cpphdl_n614, Vdd), 0.080000000000000002, 0.69999999999999996, -1.0);
        // device 245, IC IC38, analog/basic/inverter.hpp:12
        I(cpphdl_n614, Vss) <+ cpphdl_channel(V(BIT_N1_0, Vss), V(cpphdl_n614, Vss), 0.080000000000000002, 0.69999999999999996, 1.0);
        // device 246, IC IC37, analog/basic/mos_r2r_dac.hpp:27
        I(cpphdl_n614, Vss) <+ 2.9999999999999998e-15 * ddt(V(cpphdl_n614, Vss)); // Bench initial voltage = 0.0 V.
        // device 247, IC IC37, analog/basic/mos_r2r_dac.hpp:28
        I(cpphdl_n614, cpphdl_n643) <+ V(cpphdl_n614, cpphdl_n643) / 2000.0;
        // device 248, IC IC37, analog/basic/mos_r2r_dac.hpp:29
        I(cpphdl_n643, Vss) <+ 2.9999999999999998e-15 * ddt(V(cpphdl_n643, Vss)); // Bench initial voltage = 0.0 V.
        // device 249, IC IC39, analog/basic/inverter.hpp:11
        I(cpphdl_n618, Vdd) <+ cpphdl_channel(V(BIT_N1_1, Vdd), V(cpphdl_n618, Vdd), 0.080000000000000002, 0.69999999999999996, -1.0);
        // device 250, IC IC39, analog/basic/inverter.hpp:12
        I(cpphdl_n618, Vss) <+ cpphdl_channel(V(BIT_N1_1, Vss), V(cpphdl_n618, Vss), 0.080000000000000002, 0.69999999999999996, 1.0);
        // device 251, IC IC37, analog/basic/mos_r2r_dac.hpp:27
        I(cpphdl_n618, Vss) <+ 2.9999999999999998e-15 * ddt(V(cpphdl_n618, Vss)); // Bench initial voltage = 0.0 V.
        // device 252, IC IC37, analog/basic/mos_r2r_dac.hpp:28
        I(cpphdl_n618, cpphdl_n644) <+ V(cpphdl_n618, cpphdl_n644) / 2000.0;
        // device 253, IC IC37, analog/basic/mos_r2r_dac.hpp:29
        I(cpphdl_n644, Vss) <+ 2.9999999999999998e-15 * ddt(V(cpphdl_n644, Vss)); // Bench initial voltage = 0.0 V.
        // device 254, IC IC37, analog/basic/mos_r2r_dac.hpp:31
        I(cpphdl_n643, cpphdl_n644) <+ V(cpphdl_n643, cpphdl_n644) / 1000.0;
        // device 255, IC IC40, analog/basic/inverter.hpp:11
        I(cpphdl_n622, Vdd) <+ cpphdl_channel(V(BIT_N1_2, Vdd), V(cpphdl_n622, Vdd), 0.080000000000000002, 0.69999999999999996, -1.0);
        // device 256, IC IC40, analog/basic/inverter.hpp:12
        I(cpphdl_n622, Vss) <+ cpphdl_channel(V(BIT_N1_2, Vss), V(cpphdl_n622, Vss), 0.080000000000000002, 0.69999999999999996, 1.0);
        // device 257, IC IC37, analog/basic/mos_r2r_dac.hpp:27
        I(cpphdl_n622, Vss) <+ 2.9999999999999998e-15 * ddt(V(cpphdl_n622, Vss)); // Bench initial voltage = 0.0 V.
        // device 258, IC IC37, analog/basic/mos_r2r_dac.hpp:28
        I(cpphdl_n622, cpphdl_n645) <+ V(cpphdl_n622, cpphdl_n645) / 2000.0;
        // device 259, IC IC37, analog/basic/mos_r2r_dac.hpp:29
        I(cpphdl_n645, Vss) <+ 2.9999999999999998e-15 * ddt(V(cpphdl_n645, Vss)); // Bench initial voltage = 0.0 V.
        // device 260, IC IC37, analog/basic/mos_r2r_dac.hpp:31
        I(cpphdl_n644, cpphdl_n645) <+ V(cpphdl_n644, cpphdl_n645) / 1000.0;
        // device 261, IC IC41, analog/basic/inverter.hpp:11
        I(cpphdl_n626, Vdd) <+ cpphdl_channel(V(BIT_N1_3, Vdd), V(cpphdl_n626, Vdd), 0.080000000000000002, 0.69999999999999996, -1.0);
        // device 262, IC IC41, analog/basic/inverter.hpp:12
        I(cpphdl_n626, Vss) <+ cpphdl_channel(V(BIT_N1_3, Vss), V(cpphdl_n626, Vss), 0.080000000000000002, 0.69999999999999996, 1.0);
        // device 263, IC IC37, analog/basic/mos_r2r_dac.hpp:27
        I(cpphdl_n626, Vss) <+ 2.9999999999999998e-15 * ddt(V(cpphdl_n626, Vss)); // Bench initial voltage = 0.0 V.
        // device 264, IC IC37, analog/basic/mos_r2r_dac.hpp:28
        I(cpphdl_n626, cpphdl_n646) <+ V(cpphdl_n626, cpphdl_n646) / 2000.0;
        // device 265, IC IC37, analog/basic/mos_r2r_dac.hpp:29
        I(cpphdl_n646, Vss) <+ 2.9999999999999998e-15 * ddt(V(cpphdl_n646, Vss)); // Bench initial voltage = 0.0 V.
        // device 266, IC IC37, analog/basic/mos_r2r_dac.hpp:31
        I(cpphdl_n645, cpphdl_n646) <+ V(cpphdl_n645, cpphdl_n646) / 1000.0;
        // device 267, IC IC42, analog/basic/inverter.hpp:11
        I(cpphdl_n630, Vdd) <+ cpphdl_channel(V(BIT_N1_4, Vdd), V(cpphdl_n630, Vdd), 0.080000000000000002, 0.69999999999999996, -1.0);
        // device 268, IC IC42, analog/basic/inverter.hpp:12
        I(cpphdl_n630, Vss) <+ cpphdl_channel(V(BIT_N1_4, Vss), V(cpphdl_n630, Vss), 0.080000000000000002, 0.69999999999999996, 1.0);
        // device 269, IC IC37, analog/basic/mos_r2r_dac.hpp:27
        I(cpphdl_n630, Vss) <+ 2.9999999999999998e-15 * ddt(V(cpphdl_n630, Vss)); // Bench initial voltage = 0.0 V.
        // device 270, IC IC37, analog/basic/mos_r2r_dac.hpp:28
        I(cpphdl_n630, cpphdl_n647) <+ V(cpphdl_n630, cpphdl_n647) / 2000.0;
        // device 271, IC IC37, analog/basic/mos_r2r_dac.hpp:29
        I(cpphdl_n647, Vss) <+ 2.9999999999999998e-15 * ddt(V(cpphdl_n647, Vss)); // Bench initial voltage = 0.0 V.
        // device 272, IC IC37, analog/basic/mos_r2r_dac.hpp:31
        I(cpphdl_n646, cpphdl_n647) <+ V(cpphdl_n646, cpphdl_n647) / 1000.0;
        // device 273, IC IC43, analog/basic/inverter.hpp:11
        I(cpphdl_n634, Vdd) <+ cpphdl_channel(V(BIT_N1_5, Vdd), V(cpphdl_n634, Vdd), 0.080000000000000002, 0.69999999999999996, -1.0);
        // device 274, IC IC43, analog/basic/inverter.hpp:12
        I(cpphdl_n634, Vss) <+ cpphdl_channel(V(BIT_N1_5, Vss), V(cpphdl_n634, Vss), 0.080000000000000002, 0.69999999999999996, 1.0);
        // device 275, IC IC37, analog/basic/mos_r2r_dac.hpp:27
        I(cpphdl_n634, Vss) <+ 2.9999999999999998e-15 * ddt(V(cpphdl_n634, Vss)); // Bench initial voltage = 0.0 V.
        // device 276, IC IC37, analog/basic/mos_r2r_dac.hpp:28
        I(cpphdl_n634, cpphdl_n648) <+ V(cpphdl_n634, cpphdl_n648) / 2000.0;
        // device 277, IC IC37, analog/basic/mos_r2r_dac.hpp:29
        I(cpphdl_n648, Vss) <+ 2.9999999999999998e-15 * ddt(V(cpphdl_n648, Vss)); // Bench initial voltage = 0.0 V.
        // device 278, IC IC37, analog/basic/mos_r2r_dac.hpp:31
        I(cpphdl_n647, cpphdl_n648) <+ V(cpphdl_n647, cpphdl_n648) / 1000.0;
        // device 279, IC IC44, analog/basic/inverter.hpp:11
        I(cpphdl_n638, Vdd) <+ cpphdl_channel(V(BIT_N1_6, Vdd), V(cpphdl_n638, Vdd), 0.080000000000000002, 0.69999999999999996, -1.0);
        // device 280, IC IC44, analog/basic/inverter.hpp:12
        I(cpphdl_n638, Vss) <+ cpphdl_channel(V(BIT_N1_6, Vss), V(cpphdl_n638, Vss), 0.080000000000000002, 0.69999999999999996, 1.0);
        // device 281, IC IC37, analog/basic/mos_r2r_dac.hpp:27
        I(cpphdl_n638, Vss) <+ 2.9999999999999998e-15 * ddt(V(cpphdl_n638, Vss)); // Bench initial voltage = 0.0 V.
        // device 282, IC IC37, analog/basic/mos_r2r_dac.hpp:28
        I(cpphdl_n638, cpphdl_n649) <+ V(cpphdl_n638, cpphdl_n649) / 2000.0;
        // device 283, IC IC37, analog/basic/mos_r2r_dac.hpp:29
        I(cpphdl_n649, Vss) <+ 2.9999999999999998e-15 * ddt(V(cpphdl_n649, Vss)); // Bench initial voltage = 0.0 V.
        // device 284, IC IC37, analog/basic/mos_r2r_dac.hpp:31
        I(cpphdl_n648, cpphdl_n649) <+ V(cpphdl_n648, cpphdl_n649) / 1000.0;
        // device 285, IC IC45, analog/basic/inverter.hpp:11
        I(cpphdl_n642, Vdd) <+ cpphdl_channel(V(BIT_N1_7, Vdd), V(cpphdl_n642, Vdd), 0.080000000000000002, 0.69999999999999996, -1.0);
        // device 286, IC IC45, analog/basic/inverter.hpp:12
        I(cpphdl_n642, Vss) <+ cpphdl_channel(V(BIT_N1_7, Vss), V(cpphdl_n642, Vss), 0.080000000000000002, 0.69999999999999996, 1.0);
        // device 287, IC IC37, analog/basic/mos_r2r_dac.hpp:27
        I(cpphdl_n642, Vss) <+ 2.9999999999999998e-15 * ddt(V(cpphdl_n642, Vss)); // Bench initial voltage = 0.0 V.
        // device 288, IC IC37, analog/basic/mos_r2r_dac.hpp:28
        I(cpphdl_n642, cpphdl_n654) <+ V(cpphdl_n642, cpphdl_n654) / 2000.0;
        // device 289, IC IC37, analog/basic/mos_r2r_dac.hpp:29
        I(cpphdl_n654, Vss) <+ 2.9999999999999998e-15 * ddt(V(cpphdl_n654, Vss)); // Bench initial voltage = 0.0 V.
        // device 290, IC IC37, analog/basic/mos_r2r_dac.hpp:31
        I(cpphdl_n649, cpphdl_n654) <+ V(cpphdl_n649, cpphdl_n654) / 1000.0;
        // device 291, IC IC37, analog/basic/mos_r2r_dac.hpp:33
        I(Vss, cpphdl_n643) <+ V(Vss, cpphdl_n643) / 2000.0;
        // device 292, IC IC46, analog/basic/nmos_resistor_amplifier.hpp:23
        I(Vdd, cpphdl_n663) <+ V(Vdd, cpphdl_n663) / 500.0;
        // device 293, IC IC46, analog/basic/nmos_resistor_amplifier.hpp:24
        I(Vdd, cpphdl_n662) <+ V(Vdd, cpphdl_n662) / 500.0;
        // device 294, IC IC46, analog/basic/nmos_resistor_amplifier.hpp:25
        I(cpphdl_n663, cpphdl_n657) <+ cpphdl_channel(V(cpphdl_n653, cpphdl_n657), V(cpphdl_n663, cpphdl_n657), 0.014999999999999999, 0.69999999999999996, 1.0);
        // device 295, IC IC46, analog/basic/nmos_resistor_amplifier.hpp:26
        I(cpphdl_n662, cpphdl_n658) <+ cpphdl_channel(V(cpphdl_n654, cpphdl_n658), V(cpphdl_n662, cpphdl_n658), 0.014999999999999999, 0.69999999999999996, 1.0);
        // device 296, IC IC46, analog/basic/nmos_resistor_amplifier.hpp:27
        I(cpphdl_n659, cpphdl_n657) <+ V(cpphdl_n659, cpphdl_n657) / 50.0;
        // device 297, IC IC46, analog/basic/nmos_resistor_amplifier.hpp:28
        I(cpphdl_n659, cpphdl_n658) <+ V(cpphdl_n659, cpphdl_n658) / 50.0;
        // device 298, IC IC46, analog/basic/nmos_resistor_amplifier.hpp:29
        I(Vss, cpphdl_n659) <+ V(Vss, cpphdl_n659) / 150.0;
        // device 299, IC IC46, analog/basic/nmos_resistor_amplifier.hpp:30
        I(cpphdl_n663, Vdd) <+ 2.9999999999999998e-13 * ddt(V(cpphdl_n663, Vdd)); // Bench initial voltage = 0.0 V.
        // device 300, IC IC46, analog/basic/nmos_resistor_amplifier.hpp:31
        I(cpphdl_n662, Vdd) <+ 2.9999999999999998e-13 * ddt(V(cpphdl_n662, Vdd)); // Bench initial voltage = 0.0 V.
        // device 301, IC IC46, analog/basic/nmos_resistor_amplifier.hpp:32
        I(cpphdl_n659, Vss) <+ 4e-14 * ddt(V(cpphdl_n659, Vss)); // Bench initial voltage = 0.0 V.
        // device 302, IC IC46, analog/basic/nmos_resistor_amplifier.hpp:34
        I(cpphdl_n653, cpphdl_n657) <+ 2e-14 * ddt(V(cpphdl_n653, cpphdl_n657)); // Bench initial voltage = 1.6499999999999999 V.
        // device 303, IC IC46, analog/basic/nmos_resistor_amplifier.hpp:35
        I(cpphdl_n654, cpphdl_n658) <+ 2e-14 * ddt(V(cpphdl_n654, cpphdl_n658)); // Bench initial voltage = 0.0 V.
        // device 304, IC IC46, analog/basic/nmos_resistor_amplifier.hpp:36
        I(cpphdl_n653, cpphdl_n663) <+ 2.9999999999999998e-15 * ddt(V(cpphdl_n653, cpphdl_n663)); // Bench initial voltage = -1.6499999999999999 V.
        // device 305, IC IC46, analog/basic/nmos_resistor_amplifier.hpp:37
        I(cpphdl_n654, cpphdl_n662) <+ 2.9999999999999998e-15 * ddt(V(cpphdl_n654, cpphdl_n662)); // Bench initial voltage = -3.2999999999999998 V.
        // device 306, IC IC47, analog/basic/strongarm_comparator.hpp:28
        I(cpphdl_n667, cpphdl_n669) <+ cpphdl_channel(V(cpphdl_n662, cpphdl_n669), V(cpphdl_n667, cpphdl_n669), 0.0080000000000000002, 0.69999999999999996, 1.0);
        // device 307, IC IC47, analog/basic/strongarm_comparator.hpp:29
        I(cpphdl_n668, cpphdl_n669) <+ cpphdl_channel(V(cpphdl_n663, cpphdl_n669), V(cpphdl_n668, cpphdl_n669), 0.0080000000000000002, 0.69999999999999996, 1.0);
        // device 308, IC IC47, analog/basic/strongarm_comparator.hpp:30
        I(cpphdl_n669, Vss) <+ cpphdl_channel(V(EVALUATE, Vss), V(cpphdl_n669, Vss), 0.0080000000000000002, 0.69999999999999996, 1.0);
        // device 309, IC IC47, analog/basic/strongarm_comparator.hpp:33
        I(cpphdl_n682, cpphdl_n667) <+ cpphdl_channel(V(cpphdl_n686, cpphdl_n667), V(cpphdl_n682, cpphdl_n667), 0.0040000000000000001, 0.69999999999999996, 1.0);
        // device 310, IC IC47, analog/basic/strongarm_comparator.hpp:34
        I(cpphdl_n686, cpphdl_n668) <+ cpphdl_channel(V(cpphdl_n682, cpphdl_n668), V(cpphdl_n686, cpphdl_n668), 0.0040000000000000001, 0.69999999999999996, 1.0);
        // device 311, IC IC47, analog/basic/strongarm_comparator.hpp:35
        I(cpphdl_n686, Vdd) <+ cpphdl_channel(V(cpphdl_n682, Vdd), V(cpphdl_n686, Vdd), 0.002, 0.69999999999999996, -1.0);
        // device 312, IC IC47, analog/basic/strongarm_comparator.hpp:36
        I(cpphdl_n682, Vdd) <+ cpphdl_channel(V(cpphdl_n686, Vdd), V(cpphdl_n682, Vdd), 0.002, 0.69999999999999996, -1.0);
        // device 313, IC IC47, analog/basic/strongarm_comparator.hpp:38
        I(cpphdl_n667, Vdd) <+ cpphdl_channel(V(EVALUATE, Vdd), V(cpphdl_n667, Vdd), 0.002, 0.69999999999999996, -1.0);
        // device 314, IC IC47, analog/basic/strongarm_comparator.hpp:39
        I(cpphdl_n668, Vdd) <+ cpphdl_channel(V(EVALUATE, Vdd), V(cpphdl_n668, Vdd), 0.002, 0.69999999999999996, -1.0);
        // device 315, IC IC47, analog/basic/strongarm_comparator.hpp:40
        I(cpphdl_n686, Vdd) <+ cpphdl_channel(V(EVALUATE, Vdd), V(cpphdl_n686, Vdd), 0.002, 0.69999999999999996, -1.0);
        // device 316, IC IC47, analog/basic/strongarm_comparator.hpp:41
        I(cpphdl_n682, Vdd) <+ cpphdl_channel(V(EVALUATE, Vdd), V(cpphdl_n682, Vdd), 0.002, 0.69999999999999996, -1.0);
        // device 317, IC IC47, analog/basic/strongarm_comparator.hpp:42
        I(cpphdl_n667, Vss) <+ 2.9999999999999998e-14 * ddt(V(cpphdl_n667, Vss)); // Bench initial voltage = 0.0 V.
        // device 318, IC IC47, analog/basic/strongarm_comparator.hpp:43
        I(cpphdl_n668, Vss) <+ 2.9999999999999998e-14 * ddt(V(cpphdl_n668, Vss)); // Bench initial voltage = 0.0 V.
        // device 319, IC IC47, analog/basic/strongarm_comparator.hpp:44
        I(cpphdl_n669, Vss) <+ 2.9999999999999998e-14 * ddt(V(cpphdl_n669, Vss)); // Bench initial voltage = 0.0 V.
        // device 320, IC IC47, analog/basic/strongarm_comparator.hpp:45
        I(cpphdl_n686, Vss) <+ 5.0000000000000002e-14 * ddt(V(cpphdl_n686, Vss)); // Bench initial voltage = 0.0 V.
        // device 321, IC IC47, analog/basic/strongarm_comparator.hpp:46
        I(cpphdl_n682, Vss) <+ 5.0000000000000002e-14 * ddt(V(cpphdl_n682, Vss)); // Bench initial voltage = 0.0 V.
        // device 322, IC IC47, analog/basic/strongarm_comparator.hpp:47
        I(cpphdl_n662, cpphdl_n669) <+ 2e-14 * ddt(V(cpphdl_n662, cpphdl_n669)); // Bench initial voltage = 3.2999999999999998 V.
        // device 323, IC IC47, analog/basic/strongarm_comparator.hpp:48
        I(cpphdl_n663, cpphdl_n669) <+ 2e-14 * ddt(V(cpphdl_n663, cpphdl_n669)); // Bench initial voltage = 3.2999999999999998 V.
        // device 324, IC IC47, analog/basic/strongarm_comparator.hpp:49
        I(cpphdl_n662, cpphdl_n667) <+ 2.9999999999999998e-15 * ddt(V(cpphdl_n662, cpphdl_n667)); // Bench initial voltage = 3.2999999999999998 V.
        // device 325, IC IC47, analog/basic/strongarm_comparator.hpp:50
        I(cpphdl_n663, cpphdl_n668) <+ 2.9999999999999998e-15 * ddt(V(cpphdl_n663, cpphdl_n668)); // Bench initial voltage = 3.2999999999999998 V.
        // device 326, IC IC49, analog/basic/inverter.hpp:11
        I(cpphdl_n690, Vdd) <+ cpphdl_channel(V(cpphdl_n682, Vdd), V(cpphdl_n690, Vdd), 0.001, 0.69999999999999996, -1.0);
        // device 327, IC IC49, analog/basic/inverter.hpp:12
        I(cpphdl_n690, Vss) <+ cpphdl_channel(V(cpphdl_n682, Vss), V(cpphdl_n690, Vss), 0.001, 0.69999999999999996, 1.0);
        // device 328, IC IC51, analog/basic/inverter.hpp:11
        I(cpphdl_n704, Vdd) <+ cpphdl_channel(V(cpphdl_n690, Vdd), V(cpphdl_n704, Vdd), 0.0040000000000000001, 0.69999999999999996, -1.0);
        // device 329, IC IC51, analog/basic/inverter.hpp:12
        I(cpphdl_n704, Vss) <+ cpphdl_channel(V(cpphdl_n690, Vss), V(cpphdl_n704, Vss), 0.0040000000000000001, 0.69999999999999996, 1.0);
        // device 330, IC IC48, analog/basic/buffered_nand_latch.hpp:33
        I(cpphdl_n682, Vss) <+ 2.0000000000000002e-15 * ddt(V(cpphdl_n682, Vss)); // Bench initial voltage = 0.0 V.
        // device 331, IC IC48, analog/basic/buffered_nand_latch.hpp:34
        I(cpphdl_n682, cpphdl_n690) <+ 1.0000000000000001e-15 * ddt(V(cpphdl_n682, cpphdl_n690)); // Bench initial voltage = 0.0 V.
        // device 332, IC IC48, analog/basic/buffered_nand_latch.hpp:35
        I(cpphdl_n690, Vss) <+ 5e-15 * ddt(V(cpphdl_n690, Vss)); // Bench initial voltage = 0.0 V.
        // device 333, IC IC48, analog/basic/buffered_nand_latch.hpp:36
        I(cpphdl_n690, Vss) <+ 8.0000000000000006e-15 * ddt(V(cpphdl_n690, Vss)); // Bench initial voltage = 0.0 V.
        // device 334, IC IC48, analog/basic/buffered_nand_latch.hpp:37
        I(cpphdl_n704, Vss) <+ 1e-14 * ddt(V(cpphdl_n704, Vss)); // Bench initial voltage = 0.0 V.
        // device 335, IC IC50, analog/basic/inverter.hpp:11
        I(cpphdl_n694, Vdd) <+ cpphdl_channel(V(cpphdl_n686, Vdd), V(cpphdl_n694, Vdd), 0.001, 0.69999999999999996, -1.0);
        // device 336, IC IC50, analog/basic/inverter.hpp:12
        I(cpphdl_n694, Vss) <+ cpphdl_channel(V(cpphdl_n686, Vss), V(cpphdl_n694, Vss), 0.001, 0.69999999999999996, 1.0);
        // device 337, IC IC52, analog/basic/inverter.hpp:11
        I(cpphdl_n710, Vdd) <+ cpphdl_channel(V(cpphdl_n694, Vdd), V(cpphdl_n710, Vdd), 0.0040000000000000001, 0.69999999999999996, -1.0);
        // device 338, IC IC52, analog/basic/inverter.hpp:12
        I(cpphdl_n710, Vss) <+ cpphdl_channel(V(cpphdl_n694, Vss), V(cpphdl_n710, Vss), 0.0040000000000000001, 0.69999999999999996, 1.0);
        // device 339, IC IC48, analog/basic/buffered_nand_latch.hpp:33
        I(cpphdl_n686, Vss) <+ 2.0000000000000002e-15 * ddt(V(cpphdl_n686, Vss)); // Bench initial voltage = 0.0 V.
        // device 340, IC IC48, analog/basic/buffered_nand_latch.hpp:34
        I(cpphdl_n686, cpphdl_n694) <+ 1.0000000000000001e-15 * ddt(V(cpphdl_n686, cpphdl_n694)); // Bench initial voltage = 0.0 V.
        // device 341, IC IC48, analog/basic/buffered_nand_latch.hpp:35
        I(cpphdl_n694, Vss) <+ 5e-15 * ddt(V(cpphdl_n694, Vss)); // Bench initial voltage = 0.0 V.
        // device 342, IC IC48, analog/basic/buffered_nand_latch.hpp:36
        I(cpphdl_n694, Vss) <+ 8.0000000000000006e-15 * ddt(V(cpphdl_n694, Vss)); // Bench initial voltage = 0.0 V.
        // device 343, IC IC48, analog/basic/buffered_nand_latch.hpp:37
        I(cpphdl_n710, Vss) <+ 1e-14 * ddt(V(cpphdl_n710, Vss)); // Bench initial voltage = 0.0 V.
        // device 344, IC IC54, analog/basic/cmos_logic.hpp:15
        I(cpphdl_n2745, Vss) <+ 5.0000000000000002e-14 * ddt(V(cpphdl_n2745, Vss)); // Bench initial voltage = 0.0 V.
        // device 345, IC IC54, analog/basic/cmos_logic.hpp:16
        I(cpphdl_n2745, Vdd) <+ cpphdl_channel(V(cpphdl_n704, Vdd), V(cpphdl_n2745, Vdd), 0.01, 0.69999999999999996, -1.0);
        // device 346, IC IC54, analog/basic/cmos_logic.hpp:17
        I(cpphdl_n2745, Vdd) <+ cpphdl_channel(V(cpphdl_n712, Vdd), V(cpphdl_n2745, Vdd), 0.01, 0.69999999999999996, -1.0);
        // device 347, IC IC54, analog/basic/cmos_logic.hpp:18
        I(cpphdl_n2745, cpphdl_n707) <+ cpphdl_channel(V(cpphdl_n704, cpphdl_n707), V(cpphdl_n2745, cpphdl_n707), 0.01, 0.69999999999999996, 1.0);
        // device 348, IC IC54, analog/basic/cmos_logic.hpp:19
        I(cpphdl_n707, Vss) <+ cpphdl_channel(V(cpphdl_n712, Vss), V(cpphdl_n707, Vss), 0.01, 0.69999999999999996, 1.0);
        // device 349, IC IC54, analog/basic/cmos_logic.hpp:20
        I(cpphdl_n2745, Vss) <+ V(cpphdl_n2745, Vss) / 1000000000.0;
        // device 350, IC IC54, analog/basic/cmos_logic.hpp:21
        I(cpphdl_n707, Vss) <+ V(cpphdl_n707, Vss) / 1000000000.0;
        // device 351, IC IC55, analog/basic/cmos_logic.hpp:15
        I(cpphdl_n712, Vss) <+ 5.0000000000000002e-14 * ddt(V(cpphdl_n712, Vss)); // Bench initial voltage = 0.0 V.
        // device 352, IC IC55, analog/basic/cmos_logic.hpp:16
        I(cpphdl_n712, Vdd) <+ cpphdl_channel(V(cpphdl_n710, Vdd), V(cpphdl_n712, Vdd), 0.01, 0.69999999999999996, -1.0);
        // device 353, IC IC55, analog/basic/cmos_logic.hpp:17
        I(cpphdl_n712, Vdd) <+ cpphdl_channel(V(cpphdl_n2745, Vdd), V(cpphdl_n712, Vdd), 0.01, 0.69999999999999996, -1.0);
        // device 354, IC IC55, analog/basic/cmos_logic.hpp:18
        I(cpphdl_n712, cpphdl_n713) <+ cpphdl_channel(V(cpphdl_n710, cpphdl_n713), V(cpphdl_n712, cpphdl_n713), 0.01, 0.69999999999999996, 1.0);
        // device 355, IC IC55, analog/basic/cmos_logic.hpp:19
        I(cpphdl_n713, Vss) <+ cpphdl_channel(V(cpphdl_n2745, Vss), V(cpphdl_n713, Vss), 0.01, 0.69999999999999996, 1.0);
        // device 356, IC IC55, analog/basic/cmos_logic.hpp:20
        I(cpphdl_n712, Vss) <+ V(cpphdl_n712, Vss) / 1000000000.0;
        // device 357, IC IC55, analog/basic/cmos_logic.hpp:21
        I(cpphdl_n713, Vss) <+ V(cpphdl_n713, Vss) / 1000000000.0;
        // device 358, IC IC53, analog/basic/nand_latch.hpp:34
        I(cpphdl_n704, Vss) <+ 2.9999999999999998e-15 * ddt(V(cpphdl_n704, Vss)); // Bench initial voltage = 0.0 V.
        // device 359, IC IC53, analog/basic/nand_latch.hpp:35
        I(cpphdl_n710, Vss) <+ 2.9999999999999998e-15 * ddt(V(cpphdl_n710, Vss)); // Bench initial voltage = 0.0 V.
        // device 360, IC IC56, analog/basic/inverter.hpp:11
        I(cpphdl_n718, Vdd) <+ cpphdl_channel(V(CLEAR, Vdd), V(cpphdl_n718, Vdd), 0.01, 0.69999999999999996, -1.0);
        // device 361, IC IC56, analog/basic/inverter.hpp:12
        I(cpphdl_n718, Vss) <+ cpphdl_channel(V(CLEAR, Vss), V(cpphdl_n718, Vss), 0.01, 0.69999999999999996, 1.0);
        // device 362, IC IC53, analog/basic/nand_latch.hpp:56
        I(cpphdl_n718, Vss) <+ 2.9999999999999998e-15 * ddt(V(cpphdl_n718, Vss)); // Bench initial voltage = 0.0 V.
        // device 363, IC IC53, analog/basic/nand_latch.hpp:57
        I(cpphdl_n2745, Vss) <+ cpphdl_channel(V(CLEAR, Vss), V(cpphdl_n2745, Vss), 0.050000000000000003, 0.69999999999999996, 1.0);
        // device 364, IC IC53, analog/basic/nand_latch.hpp:58
        I(cpphdl_n712, Vdd) <+ cpphdl_channel(V(cpphdl_n718, Vdd), V(cpphdl_n712, Vdd), 0.050000000000000003, 0.69999999999999996, -1.0);
        // device 365, IC IC59, analog/basic/inverter.hpp:11
        I(cpphdl_n742, Vdd) <+ cpphdl_channel(V(TRACK2, Vdd), V(cpphdl_n742, Vdd), 0.0040000000000000001, 0.69999999999999996, -1.0);
        // device 366, IC IC59, analog/basic/inverter.hpp:12
        I(cpphdl_n742, Vss) <+ cpphdl_channel(V(TRACK2, Vss), V(cpphdl_n742, Vss), 0.0040000000000000001, 0.69999999999999996, 1.0);
        // device 367, IC IC58, analog/basic/mos_track_hold.hpp:30
        I(cpphdl_n742, Vss) <+ 2e-14 * ddt(V(cpphdl_n742, Vss)); // Bench initial voltage = 3.2999999999999998 V.
        // device 368, IC IC58, analog/basic/mos_track_hold.hpp:31
        I(cpphdl_n2595, cpphdl_n796) <+ cpphdl_channel(V(TRACK2, cpphdl_n796), V(cpphdl_n2595, cpphdl_n796), 0.02, 0.69999999999999996, 1.0);
        // device 369, IC IC58, analog/basic/mos_track_hold.hpp:32
        I(cpphdl_n796, cpphdl_n2595) <+ cpphdl_channel(V(cpphdl_n742, cpphdl_n2595), V(cpphdl_n796, cpphdl_n2595), 0.01, 0.69999999999999996, -1.0);
        // device 370, IC IC58, analog/basic/mos_track_hold.hpp:36
        I(cpphdl_n796, cpphdl_n796) <+ cpphdl_channel(V(cpphdl_n742, cpphdl_n796), V(cpphdl_n796, cpphdl_n796), 0.01, 0.69999999999999996, 1.0);
        // device 371, IC IC58, analog/basic/mos_track_hold.hpp:37
        I(cpphdl_n796, cpphdl_n796) <+ cpphdl_channel(V(TRACK2, cpphdl_n796), V(cpphdl_n796, cpphdl_n796), 0.0050000000000000001, 0.69999999999999996, -1.0);
        // device 372, IC IC58, analog/basic/mos_track_hold.hpp:38
        I(cpphdl_n796, Vss) <+ 1.5000000000000001e-12 * ddt(V(cpphdl_n796, Vss)); // Bench initial voltage = 1.6499999999999999 V.
        // device 373, IC IC58, analog/basic/mos_track_hold.hpp:39
        I(Vss, cpphdl_n796) <+ V(Vss, cpphdl_n796) / 1000000000.0;
        // device 374, IC IC58, analog/basic/mos_track_hold.hpp:40
        I(TRACK2, cpphdl_n796) <+ 2.0000000000000002e-15 * ddt(V(TRACK2, cpphdl_n796)); // Bench initial voltage = -1.6499999999999999 V.
        // device 375, IC IC58, analog/basic/mos_track_hold.hpp:41
        I(cpphdl_n742, cpphdl_n796) <+ 2.0000000000000002e-15 * ddt(V(cpphdl_n742, cpphdl_n796)); // Bench initial voltage = 1.6499999999999999 V.
        // device 376, IC IC58, analog/basic/mos_track_hold.hpp:42
        I(cpphdl_n2595, cpphdl_n796) <+ 1.0000000000000001e-15 * ddt(V(cpphdl_n2595, cpphdl_n796)); // Bench initial voltage = 0.0 V.
        // device 377, IC IC61, analog/basic/inverter.hpp:11
        I(cpphdl_n757, Vdd) <+ cpphdl_channel(V(BIT_N2_0, Vdd), V(cpphdl_n757, Vdd), 0.080000000000000002, 0.69999999999999996, -1.0);
        // device 378, IC IC61, analog/basic/inverter.hpp:12
        I(cpphdl_n757, Vss) <+ cpphdl_channel(V(BIT_N2_0, Vss), V(cpphdl_n757, Vss), 0.080000000000000002, 0.69999999999999996, 1.0);
        // device 379, IC IC60, analog/basic/mos_r2r_dac.hpp:27
        I(cpphdl_n757, Vss) <+ 2.9999999999999998e-15 * ddt(V(cpphdl_n757, Vss)); // Bench initial voltage = 0.0 V.
        // device 380, IC IC60, analog/basic/mos_r2r_dac.hpp:28
        I(cpphdl_n757, cpphdl_n786) <+ V(cpphdl_n757, cpphdl_n786) / 2000.0;
        // device 381, IC IC60, analog/basic/mos_r2r_dac.hpp:29
        I(cpphdl_n786, Vss) <+ 2.9999999999999998e-15 * ddt(V(cpphdl_n786, Vss)); // Bench initial voltage = 0.0 V.
        // device 382, IC IC62, analog/basic/inverter.hpp:11
        I(cpphdl_n761, Vdd) <+ cpphdl_channel(V(BIT_N2_1, Vdd), V(cpphdl_n761, Vdd), 0.080000000000000002, 0.69999999999999996, -1.0);
        // device 383, IC IC62, analog/basic/inverter.hpp:12
        I(cpphdl_n761, Vss) <+ cpphdl_channel(V(BIT_N2_1, Vss), V(cpphdl_n761, Vss), 0.080000000000000002, 0.69999999999999996, 1.0);
        // device 384, IC IC60, analog/basic/mos_r2r_dac.hpp:27
        I(cpphdl_n761, Vss) <+ 2.9999999999999998e-15 * ddt(V(cpphdl_n761, Vss)); // Bench initial voltage = 0.0 V.
        // device 385, IC IC60, analog/basic/mos_r2r_dac.hpp:28
        I(cpphdl_n761, cpphdl_n787) <+ V(cpphdl_n761, cpphdl_n787) / 2000.0;
        // device 386, IC IC60, analog/basic/mos_r2r_dac.hpp:29
        I(cpphdl_n787, Vss) <+ 2.9999999999999998e-15 * ddt(V(cpphdl_n787, Vss)); // Bench initial voltage = 0.0 V.
        // device 387, IC IC60, analog/basic/mos_r2r_dac.hpp:31
        I(cpphdl_n786, cpphdl_n787) <+ V(cpphdl_n786, cpphdl_n787) / 1000.0;
        // device 388, IC IC63, analog/basic/inverter.hpp:11
        I(cpphdl_n765, Vdd) <+ cpphdl_channel(V(BIT_N2_2, Vdd), V(cpphdl_n765, Vdd), 0.080000000000000002, 0.69999999999999996, -1.0);
        // device 389, IC IC63, analog/basic/inverter.hpp:12
        I(cpphdl_n765, Vss) <+ cpphdl_channel(V(BIT_N2_2, Vss), V(cpphdl_n765, Vss), 0.080000000000000002, 0.69999999999999996, 1.0);
        // device 390, IC IC60, analog/basic/mos_r2r_dac.hpp:27
        I(cpphdl_n765, Vss) <+ 2.9999999999999998e-15 * ddt(V(cpphdl_n765, Vss)); // Bench initial voltage = 0.0 V.
        // device 391, IC IC60, analog/basic/mos_r2r_dac.hpp:28
        I(cpphdl_n765, cpphdl_n788) <+ V(cpphdl_n765, cpphdl_n788) / 2000.0;
        // device 392, IC IC60, analog/basic/mos_r2r_dac.hpp:29
        I(cpphdl_n788, Vss) <+ 2.9999999999999998e-15 * ddt(V(cpphdl_n788, Vss)); // Bench initial voltage = 0.0 V.
        // device 393, IC IC60, analog/basic/mos_r2r_dac.hpp:31
        I(cpphdl_n787, cpphdl_n788) <+ V(cpphdl_n787, cpphdl_n788) / 1000.0;
        // device 394, IC IC64, analog/basic/inverter.hpp:11
        I(cpphdl_n769, Vdd) <+ cpphdl_channel(V(BIT_N2_3, Vdd), V(cpphdl_n769, Vdd), 0.080000000000000002, 0.69999999999999996, -1.0);
        // device 395, IC IC64, analog/basic/inverter.hpp:12
        I(cpphdl_n769, Vss) <+ cpphdl_channel(V(BIT_N2_3, Vss), V(cpphdl_n769, Vss), 0.080000000000000002, 0.69999999999999996, 1.0);
        // device 396, IC IC60, analog/basic/mos_r2r_dac.hpp:27
        I(cpphdl_n769, Vss) <+ 2.9999999999999998e-15 * ddt(V(cpphdl_n769, Vss)); // Bench initial voltage = 0.0 V.
        // device 397, IC IC60, analog/basic/mos_r2r_dac.hpp:28
        I(cpphdl_n769, cpphdl_n789) <+ V(cpphdl_n769, cpphdl_n789) / 2000.0;
        // device 398, IC IC60, analog/basic/mos_r2r_dac.hpp:29
        I(cpphdl_n789, Vss) <+ 2.9999999999999998e-15 * ddt(V(cpphdl_n789, Vss)); // Bench initial voltage = 0.0 V.
        // device 399, IC IC60, analog/basic/mos_r2r_dac.hpp:31
        I(cpphdl_n788, cpphdl_n789) <+ V(cpphdl_n788, cpphdl_n789) / 1000.0;
        // device 400, IC IC65, analog/basic/inverter.hpp:11
        I(cpphdl_n773, Vdd) <+ cpphdl_channel(V(BIT_N2_4, Vdd), V(cpphdl_n773, Vdd), 0.080000000000000002, 0.69999999999999996, -1.0);
        // device 401, IC IC65, analog/basic/inverter.hpp:12
        I(cpphdl_n773, Vss) <+ cpphdl_channel(V(BIT_N2_4, Vss), V(cpphdl_n773, Vss), 0.080000000000000002, 0.69999999999999996, 1.0);
        // device 402, IC IC60, analog/basic/mos_r2r_dac.hpp:27
        I(cpphdl_n773, Vss) <+ 2.9999999999999998e-15 * ddt(V(cpphdl_n773, Vss)); // Bench initial voltage = 0.0 V.
        // device 403, IC IC60, analog/basic/mos_r2r_dac.hpp:28
        I(cpphdl_n773, cpphdl_n790) <+ V(cpphdl_n773, cpphdl_n790) / 2000.0;
        // device 404, IC IC60, analog/basic/mos_r2r_dac.hpp:29
        I(cpphdl_n790, Vss) <+ 2.9999999999999998e-15 * ddt(V(cpphdl_n790, Vss)); // Bench initial voltage = 0.0 V.
        // device 405, IC IC60, analog/basic/mos_r2r_dac.hpp:31
        I(cpphdl_n789, cpphdl_n790) <+ V(cpphdl_n789, cpphdl_n790) / 1000.0;
        // device 406, IC IC66, analog/basic/inverter.hpp:11
        I(cpphdl_n777, Vdd) <+ cpphdl_channel(V(BIT_N2_5, Vdd), V(cpphdl_n777, Vdd), 0.080000000000000002, 0.69999999999999996, -1.0);
        // device 407, IC IC66, analog/basic/inverter.hpp:12
        I(cpphdl_n777, Vss) <+ cpphdl_channel(V(BIT_N2_5, Vss), V(cpphdl_n777, Vss), 0.080000000000000002, 0.69999999999999996, 1.0);
        // device 408, IC IC60, analog/basic/mos_r2r_dac.hpp:27
        I(cpphdl_n777, Vss) <+ 2.9999999999999998e-15 * ddt(V(cpphdl_n777, Vss)); // Bench initial voltage = 0.0 V.
        // device 409, IC IC60, analog/basic/mos_r2r_dac.hpp:28
        I(cpphdl_n777, cpphdl_n791) <+ V(cpphdl_n777, cpphdl_n791) / 2000.0;
        // device 410, IC IC60, analog/basic/mos_r2r_dac.hpp:29
        I(cpphdl_n791, Vss) <+ 2.9999999999999998e-15 * ddt(V(cpphdl_n791, Vss)); // Bench initial voltage = 0.0 V.
        // device 411, IC IC60, analog/basic/mos_r2r_dac.hpp:31
        I(cpphdl_n790, cpphdl_n791) <+ V(cpphdl_n790, cpphdl_n791) / 1000.0;
        // device 412, IC IC67, analog/basic/inverter.hpp:11
        I(cpphdl_n781, Vdd) <+ cpphdl_channel(V(BIT_N2_6, Vdd), V(cpphdl_n781, Vdd), 0.080000000000000002, 0.69999999999999996, -1.0);
        // device 413, IC IC67, analog/basic/inverter.hpp:12
        I(cpphdl_n781, Vss) <+ cpphdl_channel(V(BIT_N2_6, Vss), V(cpphdl_n781, Vss), 0.080000000000000002, 0.69999999999999996, 1.0);
        // device 414, IC IC60, analog/basic/mos_r2r_dac.hpp:27
        I(cpphdl_n781, Vss) <+ 2.9999999999999998e-15 * ddt(V(cpphdl_n781, Vss)); // Bench initial voltage = 0.0 V.
        // device 415, IC IC60, analog/basic/mos_r2r_dac.hpp:28
        I(cpphdl_n781, cpphdl_n792) <+ V(cpphdl_n781, cpphdl_n792) / 2000.0;
        // device 416, IC IC60, analog/basic/mos_r2r_dac.hpp:29
        I(cpphdl_n792, Vss) <+ 2.9999999999999998e-15 * ddt(V(cpphdl_n792, Vss)); // Bench initial voltage = 0.0 V.
        // device 417, IC IC60, analog/basic/mos_r2r_dac.hpp:31
        I(cpphdl_n791, cpphdl_n792) <+ V(cpphdl_n791, cpphdl_n792) / 1000.0;
        // device 418, IC IC68, analog/basic/inverter.hpp:11
        I(cpphdl_n785, Vdd) <+ cpphdl_channel(V(BIT_N2_7, Vdd), V(cpphdl_n785, Vdd), 0.080000000000000002, 0.69999999999999996, -1.0);
        // device 419, IC IC68, analog/basic/inverter.hpp:12
        I(cpphdl_n785, Vss) <+ cpphdl_channel(V(BIT_N2_7, Vss), V(cpphdl_n785, Vss), 0.080000000000000002, 0.69999999999999996, 1.0);
        // device 420, IC IC60, analog/basic/mos_r2r_dac.hpp:27
        I(cpphdl_n785, Vss) <+ 2.9999999999999998e-15 * ddt(V(cpphdl_n785, Vss)); // Bench initial voltage = 0.0 V.
        // device 421, IC IC60, analog/basic/mos_r2r_dac.hpp:28
        I(cpphdl_n785, cpphdl_n797) <+ V(cpphdl_n785, cpphdl_n797) / 2000.0;
        // device 422, IC IC60, analog/basic/mos_r2r_dac.hpp:29
        I(cpphdl_n797, Vss) <+ 2.9999999999999998e-15 * ddt(V(cpphdl_n797, Vss)); // Bench initial voltage = 0.0 V.
        // device 423, IC IC60, analog/basic/mos_r2r_dac.hpp:31
        I(cpphdl_n792, cpphdl_n797) <+ V(cpphdl_n792, cpphdl_n797) / 1000.0;
        // device 424, IC IC60, analog/basic/mos_r2r_dac.hpp:33
        I(Vss, cpphdl_n786) <+ V(Vss, cpphdl_n786) / 2000.0;
        // device 425, IC IC69, analog/basic/nmos_resistor_amplifier.hpp:23
        I(Vdd, cpphdl_n806) <+ V(Vdd, cpphdl_n806) / 500.0;
        // device 426, IC IC69, analog/basic/nmos_resistor_amplifier.hpp:24
        I(Vdd, cpphdl_n805) <+ V(Vdd, cpphdl_n805) / 500.0;
        // device 427, IC IC69, analog/basic/nmos_resistor_amplifier.hpp:25
        I(cpphdl_n806, cpphdl_n800) <+ cpphdl_channel(V(cpphdl_n796, cpphdl_n800), V(cpphdl_n806, cpphdl_n800), 0.014999999999999999, 0.69999999999999996, 1.0);
        // device 428, IC IC69, analog/basic/nmos_resistor_amplifier.hpp:26
        I(cpphdl_n805, cpphdl_n801) <+ cpphdl_channel(V(cpphdl_n797, cpphdl_n801), V(cpphdl_n805, cpphdl_n801), 0.014999999999999999, 0.69999999999999996, 1.0);
        // device 429, IC IC69, analog/basic/nmos_resistor_amplifier.hpp:27
        I(cpphdl_n802, cpphdl_n800) <+ V(cpphdl_n802, cpphdl_n800) / 50.0;
        // device 430, IC IC69, analog/basic/nmos_resistor_amplifier.hpp:28
        I(cpphdl_n802, cpphdl_n801) <+ V(cpphdl_n802, cpphdl_n801) / 50.0;
        // device 431, IC IC69, analog/basic/nmos_resistor_amplifier.hpp:29
        I(Vss, cpphdl_n802) <+ V(Vss, cpphdl_n802) / 150.0;
        // device 432, IC IC69, analog/basic/nmos_resistor_amplifier.hpp:30
        I(cpphdl_n806, Vdd) <+ 2.9999999999999998e-13 * ddt(V(cpphdl_n806, Vdd)); // Bench initial voltage = 0.0 V.
        // device 433, IC IC69, analog/basic/nmos_resistor_amplifier.hpp:31
        I(cpphdl_n805, Vdd) <+ 2.9999999999999998e-13 * ddt(V(cpphdl_n805, Vdd)); // Bench initial voltage = 0.0 V.
        // device 434, IC IC69, analog/basic/nmos_resistor_amplifier.hpp:32
        I(cpphdl_n802, Vss) <+ 4e-14 * ddt(V(cpphdl_n802, Vss)); // Bench initial voltage = 0.0 V.
        // device 435, IC IC69, analog/basic/nmos_resistor_amplifier.hpp:34
        I(cpphdl_n796, cpphdl_n800) <+ 2e-14 * ddt(V(cpphdl_n796, cpphdl_n800)); // Bench initial voltage = 1.6499999999999999 V.
        // device 436, IC IC69, analog/basic/nmos_resistor_amplifier.hpp:35
        I(cpphdl_n797, cpphdl_n801) <+ 2e-14 * ddt(V(cpphdl_n797, cpphdl_n801)); // Bench initial voltage = 0.0 V.
        // device 437, IC IC69, analog/basic/nmos_resistor_amplifier.hpp:36
        I(cpphdl_n796, cpphdl_n806) <+ 2.9999999999999998e-15 * ddt(V(cpphdl_n796, cpphdl_n806)); // Bench initial voltage = -1.6499999999999999 V.
        // device 438, IC IC69, analog/basic/nmos_resistor_amplifier.hpp:37
        I(cpphdl_n797, cpphdl_n805) <+ 2.9999999999999998e-15 * ddt(V(cpphdl_n797, cpphdl_n805)); // Bench initial voltage = -3.2999999999999998 V.
        // device 439, IC IC70, analog/basic/strongarm_comparator.hpp:28
        I(cpphdl_n810, cpphdl_n812) <+ cpphdl_channel(V(cpphdl_n805, cpphdl_n812), V(cpphdl_n810, cpphdl_n812), 0.0080000000000000002, 0.69999999999999996, 1.0);
        // device 440, IC IC70, analog/basic/strongarm_comparator.hpp:29
        I(cpphdl_n811, cpphdl_n812) <+ cpphdl_channel(V(cpphdl_n806, cpphdl_n812), V(cpphdl_n811, cpphdl_n812), 0.0080000000000000002, 0.69999999999999996, 1.0);
        // device 441, IC IC70, analog/basic/strongarm_comparator.hpp:30
        I(cpphdl_n812, Vss) <+ cpphdl_channel(V(EVALUATE, Vss), V(cpphdl_n812, Vss), 0.0080000000000000002, 0.69999999999999996, 1.0);
        // device 442, IC IC70, analog/basic/strongarm_comparator.hpp:33
        I(cpphdl_n825, cpphdl_n810) <+ cpphdl_channel(V(cpphdl_n829, cpphdl_n810), V(cpphdl_n825, cpphdl_n810), 0.0040000000000000001, 0.69999999999999996, 1.0);
        // device 443, IC IC70, analog/basic/strongarm_comparator.hpp:34
        I(cpphdl_n829, cpphdl_n811) <+ cpphdl_channel(V(cpphdl_n825, cpphdl_n811), V(cpphdl_n829, cpphdl_n811), 0.0040000000000000001, 0.69999999999999996, 1.0);
        // device 444, IC IC70, analog/basic/strongarm_comparator.hpp:35
        I(cpphdl_n829, Vdd) <+ cpphdl_channel(V(cpphdl_n825, Vdd), V(cpphdl_n829, Vdd), 0.002, 0.69999999999999996, -1.0);
        // device 445, IC IC70, analog/basic/strongarm_comparator.hpp:36
        I(cpphdl_n825, Vdd) <+ cpphdl_channel(V(cpphdl_n829, Vdd), V(cpphdl_n825, Vdd), 0.002, 0.69999999999999996, -1.0);
        // device 446, IC IC70, analog/basic/strongarm_comparator.hpp:38
        I(cpphdl_n810, Vdd) <+ cpphdl_channel(V(EVALUATE, Vdd), V(cpphdl_n810, Vdd), 0.002, 0.69999999999999996, -1.0);
        // device 447, IC IC70, analog/basic/strongarm_comparator.hpp:39
        I(cpphdl_n811, Vdd) <+ cpphdl_channel(V(EVALUATE, Vdd), V(cpphdl_n811, Vdd), 0.002, 0.69999999999999996, -1.0);
        // device 448, IC IC70, analog/basic/strongarm_comparator.hpp:40
        I(cpphdl_n829, Vdd) <+ cpphdl_channel(V(EVALUATE, Vdd), V(cpphdl_n829, Vdd), 0.002, 0.69999999999999996, -1.0);
        // device 449, IC IC70, analog/basic/strongarm_comparator.hpp:41
        I(cpphdl_n825, Vdd) <+ cpphdl_channel(V(EVALUATE, Vdd), V(cpphdl_n825, Vdd), 0.002, 0.69999999999999996, -1.0);
        // device 450, IC IC70, analog/basic/strongarm_comparator.hpp:42
        I(cpphdl_n810, Vss) <+ 2.9999999999999998e-14 * ddt(V(cpphdl_n810, Vss)); // Bench initial voltage = 0.0 V.
        // device 451, IC IC70, analog/basic/strongarm_comparator.hpp:43
        I(cpphdl_n811, Vss) <+ 2.9999999999999998e-14 * ddt(V(cpphdl_n811, Vss)); // Bench initial voltage = 0.0 V.
        // device 452, IC IC70, analog/basic/strongarm_comparator.hpp:44
        I(cpphdl_n812, Vss) <+ 2.9999999999999998e-14 * ddt(V(cpphdl_n812, Vss)); // Bench initial voltage = 0.0 V.
        // device 453, IC IC70, analog/basic/strongarm_comparator.hpp:45
        I(cpphdl_n829, Vss) <+ 5.0000000000000002e-14 * ddt(V(cpphdl_n829, Vss)); // Bench initial voltage = 0.0 V.
        // device 454, IC IC70, analog/basic/strongarm_comparator.hpp:46
        I(cpphdl_n825, Vss) <+ 5.0000000000000002e-14 * ddt(V(cpphdl_n825, Vss)); // Bench initial voltage = 0.0 V.
        // device 455, IC IC70, analog/basic/strongarm_comparator.hpp:47
        I(cpphdl_n805, cpphdl_n812) <+ 2e-14 * ddt(V(cpphdl_n805, cpphdl_n812)); // Bench initial voltage = 3.2999999999999998 V.
        // device 456, IC IC70, analog/basic/strongarm_comparator.hpp:48
        I(cpphdl_n806, cpphdl_n812) <+ 2e-14 * ddt(V(cpphdl_n806, cpphdl_n812)); // Bench initial voltage = 3.2999999999999998 V.
        // device 457, IC IC70, analog/basic/strongarm_comparator.hpp:49
        I(cpphdl_n805, cpphdl_n810) <+ 2.9999999999999998e-15 * ddt(V(cpphdl_n805, cpphdl_n810)); // Bench initial voltage = 3.2999999999999998 V.
        // device 458, IC IC70, analog/basic/strongarm_comparator.hpp:50
        I(cpphdl_n806, cpphdl_n811) <+ 2.9999999999999998e-15 * ddt(V(cpphdl_n806, cpphdl_n811)); // Bench initial voltage = 3.2999999999999998 V.
        // device 459, IC IC72, analog/basic/inverter.hpp:11
        I(cpphdl_n833, Vdd) <+ cpphdl_channel(V(cpphdl_n825, Vdd), V(cpphdl_n833, Vdd), 0.001, 0.69999999999999996, -1.0);
        // device 460, IC IC72, analog/basic/inverter.hpp:12
        I(cpphdl_n833, Vss) <+ cpphdl_channel(V(cpphdl_n825, Vss), V(cpphdl_n833, Vss), 0.001, 0.69999999999999996, 1.0);
        // device 461, IC IC74, analog/basic/inverter.hpp:11
        I(cpphdl_n847, Vdd) <+ cpphdl_channel(V(cpphdl_n833, Vdd), V(cpphdl_n847, Vdd), 0.0040000000000000001, 0.69999999999999996, -1.0);
        // device 462, IC IC74, analog/basic/inverter.hpp:12
        I(cpphdl_n847, Vss) <+ cpphdl_channel(V(cpphdl_n833, Vss), V(cpphdl_n847, Vss), 0.0040000000000000001, 0.69999999999999996, 1.0);
        // device 463, IC IC71, analog/basic/buffered_nand_latch.hpp:33
        I(cpphdl_n825, Vss) <+ 2.0000000000000002e-15 * ddt(V(cpphdl_n825, Vss)); // Bench initial voltage = 0.0 V.
        // device 464, IC IC71, analog/basic/buffered_nand_latch.hpp:34
        I(cpphdl_n825, cpphdl_n833) <+ 1.0000000000000001e-15 * ddt(V(cpphdl_n825, cpphdl_n833)); // Bench initial voltage = 0.0 V.
        // device 465, IC IC71, analog/basic/buffered_nand_latch.hpp:35
        I(cpphdl_n833, Vss) <+ 5e-15 * ddt(V(cpphdl_n833, Vss)); // Bench initial voltage = 0.0 V.
        // device 466, IC IC71, analog/basic/buffered_nand_latch.hpp:36
        I(cpphdl_n833, Vss) <+ 8.0000000000000006e-15 * ddt(V(cpphdl_n833, Vss)); // Bench initial voltage = 0.0 V.
        // device 467, IC IC71, analog/basic/buffered_nand_latch.hpp:37
        I(cpphdl_n847, Vss) <+ 1e-14 * ddt(V(cpphdl_n847, Vss)); // Bench initial voltage = 0.0 V.
        // device 468, IC IC73, analog/basic/inverter.hpp:11
        I(cpphdl_n837, Vdd) <+ cpphdl_channel(V(cpphdl_n829, Vdd), V(cpphdl_n837, Vdd), 0.001, 0.69999999999999996, -1.0);
        // device 469, IC IC73, analog/basic/inverter.hpp:12
        I(cpphdl_n837, Vss) <+ cpphdl_channel(V(cpphdl_n829, Vss), V(cpphdl_n837, Vss), 0.001, 0.69999999999999996, 1.0);
        // device 470, IC IC75, analog/basic/inverter.hpp:11
        I(cpphdl_n853, Vdd) <+ cpphdl_channel(V(cpphdl_n837, Vdd), V(cpphdl_n853, Vdd), 0.0040000000000000001, 0.69999999999999996, -1.0);
        // device 471, IC IC75, analog/basic/inverter.hpp:12
        I(cpphdl_n853, Vss) <+ cpphdl_channel(V(cpphdl_n837, Vss), V(cpphdl_n853, Vss), 0.0040000000000000001, 0.69999999999999996, 1.0);
        // device 472, IC IC71, analog/basic/buffered_nand_latch.hpp:33
        I(cpphdl_n829, Vss) <+ 2.0000000000000002e-15 * ddt(V(cpphdl_n829, Vss)); // Bench initial voltage = 0.0 V.
        // device 473, IC IC71, analog/basic/buffered_nand_latch.hpp:34
        I(cpphdl_n829, cpphdl_n837) <+ 1.0000000000000001e-15 * ddt(V(cpphdl_n829, cpphdl_n837)); // Bench initial voltage = 0.0 V.
        // device 474, IC IC71, analog/basic/buffered_nand_latch.hpp:35
        I(cpphdl_n837, Vss) <+ 5e-15 * ddt(V(cpphdl_n837, Vss)); // Bench initial voltage = 0.0 V.
        // device 475, IC IC71, analog/basic/buffered_nand_latch.hpp:36
        I(cpphdl_n837, Vss) <+ 8.0000000000000006e-15 * ddt(V(cpphdl_n837, Vss)); // Bench initial voltage = 0.0 V.
        // device 476, IC IC71, analog/basic/buffered_nand_latch.hpp:37
        I(cpphdl_n853, Vss) <+ 1e-14 * ddt(V(cpphdl_n853, Vss)); // Bench initial voltage = 0.0 V.
        // device 477, IC IC77, analog/basic/cmos_logic.hpp:15
        I(cpphdl_n2750, Vss) <+ 5.0000000000000002e-14 * ddt(V(cpphdl_n2750, Vss)); // Bench initial voltage = 0.0 V.
        // device 478, IC IC77, analog/basic/cmos_logic.hpp:16
        I(cpphdl_n2750, Vdd) <+ cpphdl_channel(V(cpphdl_n847, Vdd), V(cpphdl_n2750, Vdd), 0.01, 0.69999999999999996, -1.0);
        // device 479, IC IC77, analog/basic/cmos_logic.hpp:17
        I(cpphdl_n2750, Vdd) <+ cpphdl_channel(V(cpphdl_n855, Vdd), V(cpphdl_n2750, Vdd), 0.01, 0.69999999999999996, -1.0);
        // device 480, IC IC77, analog/basic/cmos_logic.hpp:18
        I(cpphdl_n2750, cpphdl_n850) <+ cpphdl_channel(V(cpphdl_n847, cpphdl_n850), V(cpphdl_n2750, cpphdl_n850), 0.01, 0.69999999999999996, 1.0);
        // device 481, IC IC77, analog/basic/cmos_logic.hpp:19
        I(cpphdl_n850, Vss) <+ cpphdl_channel(V(cpphdl_n855, Vss), V(cpphdl_n850, Vss), 0.01, 0.69999999999999996, 1.0);
        // device 482, IC IC77, analog/basic/cmos_logic.hpp:20
        I(cpphdl_n2750, Vss) <+ V(cpphdl_n2750, Vss) / 1000000000.0;
        // device 483, IC IC77, analog/basic/cmos_logic.hpp:21
        I(cpphdl_n850, Vss) <+ V(cpphdl_n850, Vss) / 1000000000.0;
        // device 484, IC IC78, analog/basic/cmos_logic.hpp:15
        I(cpphdl_n855, Vss) <+ 5.0000000000000002e-14 * ddt(V(cpphdl_n855, Vss)); // Bench initial voltage = 0.0 V.
        // device 485, IC IC78, analog/basic/cmos_logic.hpp:16
        I(cpphdl_n855, Vdd) <+ cpphdl_channel(V(cpphdl_n853, Vdd), V(cpphdl_n855, Vdd), 0.01, 0.69999999999999996, -1.0);
        // device 486, IC IC78, analog/basic/cmos_logic.hpp:17
        I(cpphdl_n855, Vdd) <+ cpphdl_channel(V(cpphdl_n2750, Vdd), V(cpphdl_n855, Vdd), 0.01, 0.69999999999999996, -1.0);
        // device 487, IC IC78, analog/basic/cmos_logic.hpp:18
        I(cpphdl_n855, cpphdl_n856) <+ cpphdl_channel(V(cpphdl_n853, cpphdl_n856), V(cpphdl_n855, cpphdl_n856), 0.01, 0.69999999999999996, 1.0);
        // device 488, IC IC78, analog/basic/cmos_logic.hpp:19
        I(cpphdl_n856, Vss) <+ cpphdl_channel(V(cpphdl_n2750, Vss), V(cpphdl_n856, Vss), 0.01, 0.69999999999999996, 1.0);
        // device 489, IC IC78, analog/basic/cmos_logic.hpp:20
        I(cpphdl_n855, Vss) <+ V(cpphdl_n855, Vss) / 1000000000.0;
        // device 490, IC IC78, analog/basic/cmos_logic.hpp:21
        I(cpphdl_n856, Vss) <+ V(cpphdl_n856, Vss) / 1000000000.0;
        // device 491, IC IC76, analog/basic/nand_latch.hpp:34
        I(cpphdl_n847, Vss) <+ 2.9999999999999998e-15 * ddt(V(cpphdl_n847, Vss)); // Bench initial voltage = 0.0 V.
        // device 492, IC IC76, analog/basic/nand_latch.hpp:35
        I(cpphdl_n853, Vss) <+ 2.9999999999999998e-15 * ddt(V(cpphdl_n853, Vss)); // Bench initial voltage = 0.0 V.
        // device 493, IC IC79, analog/basic/inverter.hpp:11
        I(cpphdl_n861, Vdd) <+ cpphdl_channel(V(CLEAR, Vdd), V(cpphdl_n861, Vdd), 0.01, 0.69999999999999996, -1.0);
        // device 494, IC IC79, analog/basic/inverter.hpp:12
        I(cpphdl_n861, Vss) <+ cpphdl_channel(V(CLEAR, Vss), V(cpphdl_n861, Vss), 0.01, 0.69999999999999996, 1.0);
        // device 495, IC IC76, analog/basic/nand_latch.hpp:56
        I(cpphdl_n861, Vss) <+ 2.9999999999999998e-15 * ddt(V(cpphdl_n861, Vss)); // Bench initial voltage = 0.0 V.
        // device 496, IC IC76, analog/basic/nand_latch.hpp:57
        I(cpphdl_n2750, Vss) <+ cpphdl_channel(V(CLEAR, Vss), V(cpphdl_n2750, Vss), 0.050000000000000003, 0.69999999999999996, 1.0);
        // device 497, IC IC76, analog/basic/nand_latch.hpp:58
        I(cpphdl_n855, Vdd) <+ cpphdl_channel(V(cpphdl_n861, Vdd), V(cpphdl_n855, Vdd), 0.050000000000000003, 0.69999999999999996, -1.0);
        // device 498, IC IC82, analog/basic/inverter.hpp:11
        I(cpphdl_n885, Vdd) <+ cpphdl_channel(V(TRACK3, Vdd), V(cpphdl_n885, Vdd), 0.0040000000000000001, 0.69999999999999996, -1.0);
        // device 499, IC IC82, analog/basic/inverter.hpp:12
        I(cpphdl_n885, Vss) <+ cpphdl_channel(V(TRACK3, Vss), V(cpphdl_n885, Vss), 0.0040000000000000001, 0.69999999999999996, 1.0);
        // device 500, IC IC81, analog/basic/mos_track_hold.hpp:30
        I(cpphdl_n885, Vss) <+ 2e-14 * ddt(V(cpphdl_n885, Vss)); // Bench initial voltage = 3.2999999999999998 V.
        // device 501, IC IC81, analog/basic/mos_track_hold.hpp:31
        I(cpphdl_n2595, cpphdl_n939) <+ cpphdl_channel(V(TRACK3, cpphdl_n939), V(cpphdl_n2595, cpphdl_n939), 0.02, 0.69999999999999996, 1.0);
        // device 502, IC IC81, analog/basic/mos_track_hold.hpp:32
        I(cpphdl_n939, cpphdl_n2595) <+ cpphdl_channel(V(cpphdl_n885, cpphdl_n2595), V(cpphdl_n939, cpphdl_n2595), 0.01, 0.69999999999999996, -1.0);
        // device 503, IC IC81, analog/basic/mos_track_hold.hpp:36
        I(cpphdl_n939, cpphdl_n939) <+ cpphdl_channel(V(cpphdl_n885, cpphdl_n939), V(cpphdl_n939, cpphdl_n939), 0.01, 0.69999999999999996, 1.0);
        // device 504, IC IC81, analog/basic/mos_track_hold.hpp:37
        I(cpphdl_n939, cpphdl_n939) <+ cpphdl_channel(V(TRACK3, cpphdl_n939), V(cpphdl_n939, cpphdl_n939), 0.0050000000000000001, 0.69999999999999996, -1.0);
        // device 505, IC IC81, analog/basic/mos_track_hold.hpp:38
        I(cpphdl_n939, Vss) <+ 1.5000000000000001e-12 * ddt(V(cpphdl_n939, Vss)); // Bench initial voltage = 1.6499999999999999 V.
        // device 506, IC IC81, analog/basic/mos_track_hold.hpp:39
        I(Vss, cpphdl_n939) <+ V(Vss, cpphdl_n939) / 1000000000.0;
        // device 507, IC IC81, analog/basic/mos_track_hold.hpp:40
        I(TRACK3, cpphdl_n939) <+ 2.0000000000000002e-15 * ddt(V(TRACK3, cpphdl_n939)); // Bench initial voltage = -1.6499999999999999 V.
        // device 508, IC IC81, analog/basic/mos_track_hold.hpp:41
        I(cpphdl_n885, cpphdl_n939) <+ 2.0000000000000002e-15 * ddt(V(cpphdl_n885, cpphdl_n939)); // Bench initial voltage = 1.6499999999999999 V.
        // device 509, IC IC81, analog/basic/mos_track_hold.hpp:42
        I(cpphdl_n2595, cpphdl_n939) <+ 1.0000000000000001e-15 * ddt(V(cpphdl_n2595, cpphdl_n939)); // Bench initial voltage = 0.0 V.
        // device 510, IC IC84, analog/basic/inverter.hpp:11
        I(cpphdl_n900, Vdd) <+ cpphdl_channel(V(BIT_N3_0, Vdd), V(cpphdl_n900, Vdd), 0.080000000000000002, 0.69999999999999996, -1.0);
        // device 511, IC IC84, analog/basic/inverter.hpp:12
        I(cpphdl_n900, Vss) <+ cpphdl_channel(V(BIT_N3_0, Vss), V(cpphdl_n900, Vss), 0.080000000000000002, 0.69999999999999996, 1.0);
        // device 512, IC IC83, analog/basic/mos_r2r_dac.hpp:27
        I(cpphdl_n900, Vss) <+ 2.9999999999999998e-15 * ddt(V(cpphdl_n900, Vss)); // Bench initial voltage = 0.0 V.
        // device 513, IC IC83, analog/basic/mos_r2r_dac.hpp:28
        I(cpphdl_n900, cpphdl_n929) <+ V(cpphdl_n900, cpphdl_n929) / 2000.0;
        // device 514, IC IC83, analog/basic/mos_r2r_dac.hpp:29
        I(cpphdl_n929, Vss) <+ 2.9999999999999998e-15 * ddt(V(cpphdl_n929, Vss)); // Bench initial voltage = 0.0 V.
        // device 515, IC IC85, analog/basic/inverter.hpp:11
        I(cpphdl_n904, Vdd) <+ cpphdl_channel(V(BIT_N3_1, Vdd), V(cpphdl_n904, Vdd), 0.080000000000000002, 0.69999999999999996, -1.0);
        // device 516, IC IC85, analog/basic/inverter.hpp:12
        I(cpphdl_n904, Vss) <+ cpphdl_channel(V(BIT_N3_1, Vss), V(cpphdl_n904, Vss), 0.080000000000000002, 0.69999999999999996, 1.0);
        // device 517, IC IC83, analog/basic/mos_r2r_dac.hpp:27
        I(cpphdl_n904, Vss) <+ 2.9999999999999998e-15 * ddt(V(cpphdl_n904, Vss)); // Bench initial voltage = 0.0 V.
        // device 518, IC IC83, analog/basic/mos_r2r_dac.hpp:28
        I(cpphdl_n904, cpphdl_n930) <+ V(cpphdl_n904, cpphdl_n930) / 2000.0;
        // device 519, IC IC83, analog/basic/mos_r2r_dac.hpp:29
        I(cpphdl_n930, Vss) <+ 2.9999999999999998e-15 * ddt(V(cpphdl_n930, Vss)); // Bench initial voltage = 0.0 V.
        // device 520, IC IC83, analog/basic/mos_r2r_dac.hpp:31
        I(cpphdl_n929, cpphdl_n930) <+ V(cpphdl_n929, cpphdl_n930) / 1000.0;
        // device 521, IC IC86, analog/basic/inverter.hpp:11
        I(cpphdl_n908, Vdd) <+ cpphdl_channel(V(BIT_N3_2, Vdd), V(cpphdl_n908, Vdd), 0.080000000000000002, 0.69999999999999996, -1.0);
        // device 522, IC IC86, analog/basic/inverter.hpp:12
        I(cpphdl_n908, Vss) <+ cpphdl_channel(V(BIT_N3_2, Vss), V(cpphdl_n908, Vss), 0.080000000000000002, 0.69999999999999996, 1.0);
        // device 523, IC IC83, analog/basic/mos_r2r_dac.hpp:27
        I(cpphdl_n908, Vss) <+ 2.9999999999999998e-15 * ddt(V(cpphdl_n908, Vss)); // Bench initial voltage = 0.0 V.
        // device 524, IC IC83, analog/basic/mos_r2r_dac.hpp:28
        I(cpphdl_n908, cpphdl_n931) <+ V(cpphdl_n908, cpphdl_n931) / 2000.0;
        // device 525, IC IC83, analog/basic/mos_r2r_dac.hpp:29
        I(cpphdl_n931, Vss) <+ 2.9999999999999998e-15 * ddt(V(cpphdl_n931, Vss)); // Bench initial voltage = 0.0 V.
        // device 526, IC IC83, analog/basic/mos_r2r_dac.hpp:31
        I(cpphdl_n930, cpphdl_n931) <+ V(cpphdl_n930, cpphdl_n931) / 1000.0;
        // device 527, IC IC87, analog/basic/inverter.hpp:11
        I(cpphdl_n912, Vdd) <+ cpphdl_channel(V(BIT_N3_3, Vdd), V(cpphdl_n912, Vdd), 0.080000000000000002, 0.69999999999999996, -1.0);
        // device 528, IC IC87, analog/basic/inverter.hpp:12
        I(cpphdl_n912, Vss) <+ cpphdl_channel(V(BIT_N3_3, Vss), V(cpphdl_n912, Vss), 0.080000000000000002, 0.69999999999999996, 1.0);
        // device 529, IC IC83, analog/basic/mos_r2r_dac.hpp:27
        I(cpphdl_n912, Vss) <+ 2.9999999999999998e-15 * ddt(V(cpphdl_n912, Vss)); // Bench initial voltage = 0.0 V.
        // device 530, IC IC83, analog/basic/mos_r2r_dac.hpp:28
        I(cpphdl_n912, cpphdl_n932) <+ V(cpphdl_n912, cpphdl_n932) / 2000.0;
        // device 531, IC IC83, analog/basic/mos_r2r_dac.hpp:29
        I(cpphdl_n932, Vss) <+ 2.9999999999999998e-15 * ddt(V(cpphdl_n932, Vss)); // Bench initial voltage = 0.0 V.
        // device 532, IC IC83, analog/basic/mos_r2r_dac.hpp:31
        I(cpphdl_n931, cpphdl_n932) <+ V(cpphdl_n931, cpphdl_n932) / 1000.0;
        // device 533, IC IC88, analog/basic/inverter.hpp:11
        I(cpphdl_n916, Vdd) <+ cpphdl_channel(V(BIT_N3_4, Vdd), V(cpphdl_n916, Vdd), 0.080000000000000002, 0.69999999999999996, -1.0);
        // device 534, IC IC88, analog/basic/inverter.hpp:12
        I(cpphdl_n916, Vss) <+ cpphdl_channel(V(BIT_N3_4, Vss), V(cpphdl_n916, Vss), 0.080000000000000002, 0.69999999999999996, 1.0);
        // device 535, IC IC83, analog/basic/mos_r2r_dac.hpp:27
        I(cpphdl_n916, Vss) <+ 2.9999999999999998e-15 * ddt(V(cpphdl_n916, Vss)); // Bench initial voltage = 0.0 V.
        // device 536, IC IC83, analog/basic/mos_r2r_dac.hpp:28
        I(cpphdl_n916, cpphdl_n933) <+ V(cpphdl_n916, cpphdl_n933) / 2000.0;
        // device 537, IC IC83, analog/basic/mos_r2r_dac.hpp:29
        I(cpphdl_n933, Vss) <+ 2.9999999999999998e-15 * ddt(V(cpphdl_n933, Vss)); // Bench initial voltage = 0.0 V.
        // device 538, IC IC83, analog/basic/mos_r2r_dac.hpp:31
        I(cpphdl_n932, cpphdl_n933) <+ V(cpphdl_n932, cpphdl_n933) / 1000.0;
        // device 539, IC IC89, analog/basic/inverter.hpp:11
        I(cpphdl_n920, Vdd) <+ cpphdl_channel(V(BIT_N3_5, Vdd), V(cpphdl_n920, Vdd), 0.080000000000000002, 0.69999999999999996, -1.0);
        // device 540, IC IC89, analog/basic/inverter.hpp:12
        I(cpphdl_n920, Vss) <+ cpphdl_channel(V(BIT_N3_5, Vss), V(cpphdl_n920, Vss), 0.080000000000000002, 0.69999999999999996, 1.0);
        // device 541, IC IC83, analog/basic/mos_r2r_dac.hpp:27
        I(cpphdl_n920, Vss) <+ 2.9999999999999998e-15 * ddt(V(cpphdl_n920, Vss)); // Bench initial voltage = 0.0 V.
        // device 542, IC IC83, analog/basic/mos_r2r_dac.hpp:28
        I(cpphdl_n920, cpphdl_n934) <+ V(cpphdl_n920, cpphdl_n934) / 2000.0;
        // device 543, IC IC83, analog/basic/mos_r2r_dac.hpp:29
        I(cpphdl_n934, Vss) <+ 2.9999999999999998e-15 * ddt(V(cpphdl_n934, Vss)); // Bench initial voltage = 0.0 V.
        // device 544, IC IC83, analog/basic/mos_r2r_dac.hpp:31
        I(cpphdl_n933, cpphdl_n934) <+ V(cpphdl_n933, cpphdl_n934) / 1000.0;
        // device 545, IC IC90, analog/basic/inverter.hpp:11
        I(cpphdl_n924, Vdd) <+ cpphdl_channel(V(BIT_N3_6, Vdd), V(cpphdl_n924, Vdd), 0.080000000000000002, 0.69999999999999996, -1.0);
        // device 546, IC IC90, analog/basic/inverter.hpp:12
        I(cpphdl_n924, Vss) <+ cpphdl_channel(V(BIT_N3_6, Vss), V(cpphdl_n924, Vss), 0.080000000000000002, 0.69999999999999996, 1.0);
        // device 547, IC IC83, analog/basic/mos_r2r_dac.hpp:27
        I(cpphdl_n924, Vss) <+ 2.9999999999999998e-15 * ddt(V(cpphdl_n924, Vss)); // Bench initial voltage = 0.0 V.
        // device 548, IC IC83, analog/basic/mos_r2r_dac.hpp:28
        I(cpphdl_n924, cpphdl_n935) <+ V(cpphdl_n924, cpphdl_n935) / 2000.0;
        // device 549, IC IC83, analog/basic/mos_r2r_dac.hpp:29
        I(cpphdl_n935, Vss) <+ 2.9999999999999998e-15 * ddt(V(cpphdl_n935, Vss)); // Bench initial voltage = 0.0 V.
        // device 550, IC IC83, analog/basic/mos_r2r_dac.hpp:31
        I(cpphdl_n934, cpphdl_n935) <+ V(cpphdl_n934, cpphdl_n935) / 1000.0;
        // device 551, IC IC91, analog/basic/inverter.hpp:11
        I(cpphdl_n928, Vdd) <+ cpphdl_channel(V(BIT_N3_7, Vdd), V(cpphdl_n928, Vdd), 0.080000000000000002, 0.69999999999999996, -1.0);
        // device 552, IC IC91, analog/basic/inverter.hpp:12
        I(cpphdl_n928, Vss) <+ cpphdl_channel(V(BIT_N3_7, Vss), V(cpphdl_n928, Vss), 0.080000000000000002, 0.69999999999999996, 1.0);
        // device 553, IC IC83, analog/basic/mos_r2r_dac.hpp:27
        I(cpphdl_n928, Vss) <+ 2.9999999999999998e-15 * ddt(V(cpphdl_n928, Vss)); // Bench initial voltage = 0.0 V.
        // device 554, IC IC83, analog/basic/mos_r2r_dac.hpp:28
        I(cpphdl_n928, cpphdl_n940) <+ V(cpphdl_n928, cpphdl_n940) / 2000.0;
        // device 555, IC IC83, analog/basic/mos_r2r_dac.hpp:29
        I(cpphdl_n940, Vss) <+ 2.9999999999999998e-15 * ddt(V(cpphdl_n940, Vss)); // Bench initial voltage = 0.0 V.
        // device 556, IC IC83, analog/basic/mos_r2r_dac.hpp:31
        I(cpphdl_n935, cpphdl_n940) <+ V(cpphdl_n935, cpphdl_n940) / 1000.0;
        // device 557, IC IC83, analog/basic/mos_r2r_dac.hpp:33
        I(Vss, cpphdl_n929) <+ V(Vss, cpphdl_n929) / 2000.0;
        // device 558, IC IC92, analog/basic/nmos_resistor_amplifier.hpp:23
        I(Vdd, cpphdl_n949) <+ V(Vdd, cpphdl_n949) / 500.0;
        // device 559, IC IC92, analog/basic/nmos_resistor_amplifier.hpp:24
        I(Vdd, cpphdl_n948) <+ V(Vdd, cpphdl_n948) / 500.0;
        // device 560, IC IC92, analog/basic/nmos_resistor_amplifier.hpp:25
        I(cpphdl_n949, cpphdl_n943) <+ cpphdl_channel(V(cpphdl_n939, cpphdl_n943), V(cpphdl_n949, cpphdl_n943), 0.014999999999999999, 0.69999999999999996, 1.0);
        // device 561, IC IC92, analog/basic/nmos_resistor_amplifier.hpp:26
        I(cpphdl_n948, cpphdl_n944) <+ cpphdl_channel(V(cpphdl_n940, cpphdl_n944), V(cpphdl_n948, cpphdl_n944), 0.014999999999999999, 0.69999999999999996, 1.0);
        // device 562, IC IC92, analog/basic/nmos_resistor_amplifier.hpp:27
        I(cpphdl_n945, cpphdl_n943) <+ V(cpphdl_n945, cpphdl_n943) / 50.0;
        // device 563, IC IC92, analog/basic/nmos_resistor_amplifier.hpp:28
        I(cpphdl_n945, cpphdl_n944) <+ V(cpphdl_n945, cpphdl_n944) / 50.0;
        // device 564, IC IC92, analog/basic/nmos_resistor_amplifier.hpp:29
        I(Vss, cpphdl_n945) <+ V(Vss, cpphdl_n945) / 150.0;
        // device 565, IC IC92, analog/basic/nmos_resistor_amplifier.hpp:30
        I(cpphdl_n949, Vdd) <+ 2.9999999999999998e-13 * ddt(V(cpphdl_n949, Vdd)); // Bench initial voltage = 0.0 V.
        // device 566, IC IC92, analog/basic/nmos_resistor_amplifier.hpp:31
        I(cpphdl_n948, Vdd) <+ 2.9999999999999998e-13 * ddt(V(cpphdl_n948, Vdd)); // Bench initial voltage = 0.0 V.
        // device 567, IC IC92, analog/basic/nmos_resistor_amplifier.hpp:32
        I(cpphdl_n945, Vss) <+ 4e-14 * ddt(V(cpphdl_n945, Vss)); // Bench initial voltage = 0.0 V.
        // device 568, IC IC92, analog/basic/nmos_resistor_amplifier.hpp:34
        I(cpphdl_n939, cpphdl_n943) <+ 2e-14 * ddt(V(cpphdl_n939, cpphdl_n943)); // Bench initial voltage = 1.6499999999999999 V.
        // device 569, IC IC92, analog/basic/nmos_resistor_amplifier.hpp:35
        I(cpphdl_n940, cpphdl_n944) <+ 2e-14 * ddt(V(cpphdl_n940, cpphdl_n944)); // Bench initial voltage = 0.0 V.
        // device 570, IC IC92, analog/basic/nmos_resistor_amplifier.hpp:36
        I(cpphdl_n939, cpphdl_n949) <+ 2.9999999999999998e-15 * ddt(V(cpphdl_n939, cpphdl_n949)); // Bench initial voltage = -1.6499999999999999 V.
        // device 571, IC IC92, analog/basic/nmos_resistor_amplifier.hpp:37
        I(cpphdl_n940, cpphdl_n948) <+ 2.9999999999999998e-15 * ddt(V(cpphdl_n940, cpphdl_n948)); // Bench initial voltage = -3.2999999999999998 V.
        // device 572, IC IC93, analog/basic/strongarm_comparator.hpp:28
        I(cpphdl_n953, cpphdl_n955) <+ cpphdl_channel(V(cpphdl_n948, cpphdl_n955), V(cpphdl_n953, cpphdl_n955), 0.0080000000000000002, 0.69999999999999996, 1.0);
        // device 573, IC IC93, analog/basic/strongarm_comparator.hpp:29
        I(cpphdl_n954, cpphdl_n955) <+ cpphdl_channel(V(cpphdl_n949, cpphdl_n955), V(cpphdl_n954, cpphdl_n955), 0.0080000000000000002, 0.69999999999999996, 1.0);
        // device 574, IC IC93, analog/basic/strongarm_comparator.hpp:30
        I(cpphdl_n955, Vss) <+ cpphdl_channel(V(EVALUATE, Vss), V(cpphdl_n955, Vss), 0.0080000000000000002, 0.69999999999999996, 1.0);
        // device 575, IC IC93, analog/basic/strongarm_comparator.hpp:33
        I(cpphdl_n968, cpphdl_n953) <+ cpphdl_channel(V(cpphdl_n972, cpphdl_n953), V(cpphdl_n968, cpphdl_n953), 0.0040000000000000001, 0.69999999999999996, 1.0);
        // device 576, IC IC93, analog/basic/strongarm_comparator.hpp:34
        I(cpphdl_n972, cpphdl_n954) <+ cpphdl_channel(V(cpphdl_n968, cpphdl_n954), V(cpphdl_n972, cpphdl_n954), 0.0040000000000000001, 0.69999999999999996, 1.0);
        // device 577, IC IC93, analog/basic/strongarm_comparator.hpp:35
        I(cpphdl_n972, Vdd) <+ cpphdl_channel(V(cpphdl_n968, Vdd), V(cpphdl_n972, Vdd), 0.002, 0.69999999999999996, -1.0);
        // device 578, IC IC93, analog/basic/strongarm_comparator.hpp:36
        I(cpphdl_n968, Vdd) <+ cpphdl_channel(V(cpphdl_n972, Vdd), V(cpphdl_n968, Vdd), 0.002, 0.69999999999999996, -1.0);
        // device 579, IC IC93, analog/basic/strongarm_comparator.hpp:38
        I(cpphdl_n953, Vdd) <+ cpphdl_channel(V(EVALUATE, Vdd), V(cpphdl_n953, Vdd), 0.002, 0.69999999999999996, -1.0);
        // device 580, IC IC93, analog/basic/strongarm_comparator.hpp:39
        I(cpphdl_n954, Vdd) <+ cpphdl_channel(V(EVALUATE, Vdd), V(cpphdl_n954, Vdd), 0.002, 0.69999999999999996, -1.0);
        // device 581, IC IC93, analog/basic/strongarm_comparator.hpp:40
        I(cpphdl_n972, Vdd) <+ cpphdl_channel(V(EVALUATE, Vdd), V(cpphdl_n972, Vdd), 0.002, 0.69999999999999996, -1.0);
        // device 582, IC IC93, analog/basic/strongarm_comparator.hpp:41
        I(cpphdl_n968, Vdd) <+ cpphdl_channel(V(EVALUATE, Vdd), V(cpphdl_n968, Vdd), 0.002, 0.69999999999999996, -1.0);
        // device 583, IC IC93, analog/basic/strongarm_comparator.hpp:42
        I(cpphdl_n953, Vss) <+ 2.9999999999999998e-14 * ddt(V(cpphdl_n953, Vss)); // Bench initial voltage = 0.0 V.
        // device 584, IC IC93, analog/basic/strongarm_comparator.hpp:43
        I(cpphdl_n954, Vss) <+ 2.9999999999999998e-14 * ddt(V(cpphdl_n954, Vss)); // Bench initial voltage = 0.0 V.
        // device 585, IC IC93, analog/basic/strongarm_comparator.hpp:44
        I(cpphdl_n955, Vss) <+ 2.9999999999999998e-14 * ddt(V(cpphdl_n955, Vss)); // Bench initial voltage = 0.0 V.
        // device 586, IC IC93, analog/basic/strongarm_comparator.hpp:45
        I(cpphdl_n972, Vss) <+ 5.0000000000000002e-14 * ddt(V(cpphdl_n972, Vss)); // Bench initial voltage = 0.0 V.
        // device 587, IC IC93, analog/basic/strongarm_comparator.hpp:46
        I(cpphdl_n968, Vss) <+ 5.0000000000000002e-14 * ddt(V(cpphdl_n968, Vss)); // Bench initial voltage = 0.0 V.
        // device 588, IC IC93, analog/basic/strongarm_comparator.hpp:47
        I(cpphdl_n948, cpphdl_n955) <+ 2e-14 * ddt(V(cpphdl_n948, cpphdl_n955)); // Bench initial voltage = 3.2999999999999998 V.
        // device 589, IC IC93, analog/basic/strongarm_comparator.hpp:48
        I(cpphdl_n949, cpphdl_n955) <+ 2e-14 * ddt(V(cpphdl_n949, cpphdl_n955)); // Bench initial voltage = 3.2999999999999998 V.
        // device 590, IC IC93, analog/basic/strongarm_comparator.hpp:49
        I(cpphdl_n948, cpphdl_n953) <+ 2.9999999999999998e-15 * ddt(V(cpphdl_n948, cpphdl_n953)); // Bench initial voltage = 3.2999999999999998 V.
        // device 591, IC IC93, analog/basic/strongarm_comparator.hpp:50
        I(cpphdl_n949, cpphdl_n954) <+ 2.9999999999999998e-15 * ddt(V(cpphdl_n949, cpphdl_n954)); // Bench initial voltage = 3.2999999999999998 V.
        // device 592, IC IC95, analog/basic/inverter.hpp:11
        I(cpphdl_n976, Vdd) <+ cpphdl_channel(V(cpphdl_n968, Vdd), V(cpphdl_n976, Vdd), 0.001, 0.69999999999999996, -1.0);
        // device 593, IC IC95, analog/basic/inverter.hpp:12
        I(cpphdl_n976, Vss) <+ cpphdl_channel(V(cpphdl_n968, Vss), V(cpphdl_n976, Vss), 0.001, 0.69999999999999996, 1.0);
        // device 594, IC IC97, analog/basic/inverter.hpp:11
        I(cpphdl_n990, Vdd) <+ cpphdl_channel(V(cpphdl_n976, Vdd), V(cpphdl_n990, Vdd), 0.0040000000000000001, 0.69999999999999996, -1.0);
        // device 595, IC IC97, analog/basic/inverter.hpp:12
        I(cpphdl_n990, Vss) <+ cpphdl_channel(V(cpphdl_n976, Vss), V(cpphdl_n990, Vss), 0.0040000000000000001, 0.69999999999999996, 1.0);
        // device 596, IC IC94, analog/basic/buffered_nand_latch.hpp:33
        I(cpphdl_n968, Vss) <+ 2.0000000000000002e-15 * ddt(V(cpphdl_n968, Vss)); // Bench initial voltage = 0.0 V.
        // device 597, IC IC94, analog/basic/buffered_nand_latch.hpp:34
        I(cpphdl_n968, cpphdl_n976) <+ 1.0000000000000001e-15 * ddt(V(cpphdl_n968, cpphdl_n976)); // Bench initial voltage = 0.0 V.
        // device 598, IC IC94, analog/basic/buffered_nand_latch.hpp:35
        I(cpphdl_n976, Vss) <+ 5e-15 * ddt(V(cpphdl_n976, Vss)); // Bench initial voltage = 0.0 V.
        // device 599, IC IC94, analog/basic/buffered_nand_latch.hpp:36
        I(cpphdl_n976, Vss) <+ 8.0000000000000006e-15 * ddt(V(cpphdl_n976, Vss)); // Bench initial voltage = 0.0 V.
        // device 600, IC IC94, analog/basic/buffered_nand_latch.hpp:37
        I(cpphdl_n990, Vss) <+ 1e-14 * ddt(V(cpphdl_n990, Vss)); // Bench initial voltage = 0.0 V.
        // device 601, IC IC96, analog/basic/inverter.hpp:11
        I(cpphdl_n980, Vdd) <+ cpphdl_channel(V(cpphdl_n972, Vdd), V(cpphdl_n980, Vdd), 0.001, 0.69999999999999996, -1.0);
        // device 602, IC IC96, analog/basic/inverter.hpp:12
        I(cpphdl_n980, Vss) <+ cpphdl_channel(V(cpphdl_n972, Vss), V(cpphdl_n980, Vss), 0.001, 0.69999999999999996, 1.0);
        // device 603, IC IC98, analog/basic/inverter.hpp:11
        I(cpphdl_n996, Vdd) <+ cpphdl_channel(V(cpphdl_n980, Vdd), V(cpphdl_n996, Vdd), 0.0040000000000000001, 0.69999999999999996, -1.0);
        // device 604, IC IC98, analog/basic/inverter.hpp:12
        I(cpphdl_n996, Vss) <+ cpphdl_channel(V(cpphdl_n980, Vss), V(cpphdl_n996, Vss), 0.0040000000000000001, 0.69999999999999996, 1.0);
        // device 605, IC IC94, analog/basic/buffered_nand_latch.hpp:33
        I(cpphdl_n972, Vss) <+ 2.0000000000000002e-15 * ddt(V(cpphdl_n972, Vss)); // Bench initial voltage = 0.0 V.
        // device 606, IC IC94, analog/basic/buffered_nand_latch.hpp:34
        I(cpphdl_n972, cpphdl_n980) <+ 1.0000000000000001e-15 * ddt(V(cpphdl_n972, cpphdl_n980)); // Bench initial voltage = 0.0 V.
        // device 607, IC IC94, analog/basic/buffered_nand_latch.hpp:35
        I(cpphdl_n980, Vss) <+ 5e-15 * ddt(V(cpphdl_n980, Vss)); // Bench initial voltage = 0.0 V.
        // device 608, IC IC94, analog/basic/buffered_nand_latch.hpp:36
        I(cpphdl_n980, Vss) <+ 8.0000000000000006e-15 * ddt(V(cpphdl_n980, Vss)); // Bench initial voltage = 0.0 V.
        // device 609, IC IC94, analog/basic/buffered_nand_latch.hpp:37
        I(cpphdl_n996, Vss) <+ 1e-14 * ddt(V(cpphdl_n996, Vss)); // Bench initial voltage = 0.0 V.
        // device 610, IC IC100, analog/basic/cmos_logic.hpp:15
        I(cpphdl_n2755, Vss) <+ 5.0000000000000002e-14 * ddt(V(cpphdl_n2755, Vss)); // Bench initial voltage = 0.0 V.
        // device 611, IC IC100, analog/basic/cmos_logic.hpp:16
        I(cpphdl_n2755, Vdd) <+ cpphdl_channel(V(cpphdl_n990, Vdd), V(cpphdl_n2755, Vdd), 0.01, 0.69999999999999996, -1.0);
        // device 612, IC IC100, analog/basic/cmos_logic.hpp:17
        I(cpphdl_n2755, Vdd) <+ cpphdl_channel(V(cpphdl_n998, Vdd), V(cpphdl_n2755, Vdd), 0.01, 0.69999999999999996, -1.0);
        // device 613, IC IC100, analog/basic/cmos_logic.hpp:18
        I(cpphdl_n2755, cpphdl_n993) <+ cpphdl_channel(V(cpphdl_n990, cpphdl_n993), V(cpphdl_n2755, cpphdl_n993), 0.01, 0.69999999999999996, 1.0);
        // device 614, IC IC100, analog/basic/cmos_logic.hpp:19
        I(cpphdl_n993, Vss) <+ cpphdl_channel(V(cpphdl_n998, Vss), V(cpphdl_n993, Vss), 0.01, 0.69999999999999996, 1.0);
        // device 615, IC IC100, analog/basic/cmos_logic.hpp:20
        I(cpphdl_n2755, Vss) <+ V(cpphdl_n2755, Vss) / 1000000000.0;
        // device 616, IC IC100, analog/basic/cmos_logic.hpp:21
        I(cpphdl_n993, Vss) <+ V(cpphdl_n993, Vss) / 1000000000.0;
        // device 617, IC IC101, analog/basic/cmos_logic.hpp:15
        I(cpphdl_n998, Vss) <+ 5.0000000000000002e-14 * ddt(V(cpphdl_n998, Vss)); // Bench initial voltage = 0.0 V.
        // device 618, IC IC101, analog/basic/cmos_logic.hpp:16
        I(cpphdl_n998, Vdd) <+ cpphdl_channel(V(cpphdl_n996, Vdd), V(cpphdl_n998, Vdd), 0.01, 0.69999999999999996, -1.0);
        // device 619, IC IC101, analog/basic/cmos_logic.hpp:17
        I(cpphdl_n998, Vdd) <+ cpphdl_channel(V(cpphdl_n2755, Vdd), V(cpphdl_n998, Vdd), 0.01, 0.69999999999999996, -1.0);
        // device 620, IC IC101, analog/basic/cmos_logic.hpp:18
        I(cpphdl_n998, cpphdl_n999) <+ cpphdl_channel(V(cpphdl_n996, cpphdl_n999), V(cpphdl_n998, cpphdl_n999), 0.01, 0.69999999999999996, 1.0);
        // device 621, IC IC101, analog/basic/cmos_logic.hpp:19
        I(cpphdl_n999, Vss) <+ cpphdl_channel(V(cpphdl_n2755, Vss), V(cpphdl_n999, Vss), 0.01, 0.69999999999999996, 1.0);
        // device 622, IC IC101, analog/basic/cmos_logic.hpp:20
        I(cpphdl_n998, Vss) <+ V(cpphdl_n998, Vss) / 1000000000.0;
        // device 623, IC IC101, analog/basic/cmos_logic.hpp:21
        I(cpphdl_n999, Vss) <+ V(cpphdl_n999, Vss) / 1000000000.0;
        // device 624, IC IC99, analog/basic/nand_latch.hpp:34
        I(cpphdl_n990, Vss) <+ 2.9999999999999998e-15 * ddt(V(cpphdl_n990, Vss)); // Bench initial voltage = 0.0 V.
        // device 625, IC IC99, analog/basic/nand_latch.hpp:35
        I(cpphdl_n996, Vss) <+ 2.9999999999999998e-15 * ddt(V(cpphdl_n996, Vss)); // Bench initial voltage = 0.0 V.
        // device 626, IC IC102, analog/basic/inverter.hpp:11
        I(cpphdl_n1004, Vdd) <+ cpphdl_channel(V(CLEAR, Vdd), V(cpphdl_n1004, Vdd), 0.01, 0.69999999999999996, -1.0);
        // device 627, IC IC102, analog/basic/inverter.hpp:12
        I(cpphdl_n1004, Vss) <+ cpphdl_channel(V(CLEAR, Vss), V(cpphdl_n1004, Vss), 0.01, 0.69999999999999996, 1.0);
        // device 628, IC IC99, analog/basic/nand_latch.hpp:56
        I(cpphdl_n1004, Vss) <+ 2.9999999999999998e-15 * ddt(V(cpphdl_n1004, Vss)); // Bench initial voltage = 0.0 V.
        // device 629, IC IC99, analog/basic/nand_latch.hpp:57
        I(cpphdl_n2755, Vss) <+ cpphdl_channel(V(CLEAR, Vss), V(cpphdl_n2755, Vss), 0.050000000000000003, 0.69999999999999996, 1.0);
        // device 630, IC IC99, analog/basic/nand_latch.hpp:58
        I(cpphdl_n998, Vdd) <+ cpphdl_channel(V(cpphdl_n1004, Vdd), V(cpphdl_n998, Vdd), 0.050000000000000003, 0.69999999999999996, -1.0);
        // device 631, IC IC105, analog/basic/inverter.hpp:11
        I(cpphdl_n1028, Vdd) <+ cpphdl_channel(V(TRACK4, Vdd), V(cpphdl_n1028, Vdd), 0.0040000000000000001, 0.69999999999999996, -1.0);
        // device 632, IC IC105, analog/basic/inverter.hpp:12
        I(cpphdl_n1028, Vss) <+ cpphdl_channel(V(TRACK4, Vss), V(cpphdl_n1028, Vss), 0.0040000000000000001, 0.69999999999999996, 1.0);
        // device 633, IC IC104, analog/basic/mos_track_hold.hpp:30
        I(cpphdl_n1028, Vss) <+ 2e-14 * ddt(V(cpphdl_n1028, Vss)); // Bench initial voltage = 3.2999999999999998 V.
        // device 634, IC IC104, analog/basic/mos_track_hold.hpp:31
        I(cpphdl_n2595, cpphdl_n1082) <+ cpphdl_channel(V(TRACK4, cpphdl_n1082), V(cpphdl_n2595, cpphdl_n1082), 0.02, 0.69999999999999996, 1.0);
        // device 635, IC IC104, analog/basic/mos_track_hold.hpp:32
        I(cpphdl_n1082, cpphdl_n2595) <+ cpphdl_channel(V(cpphdl_n1028, cpphdl_n2595), V(cpphdl_n1082, cpphdl_n2595), 0.01, 0.69999999999999996, -1.0);
        // device 636, IC IC104, analog/basic/mos_track_hold.hpp:36
        I(cpphdl_n1082, cpphdl_n1082) <+ cpphdl_channel(V(cpphdl_n1028, cpphdl_n1082), V(cpphdl_n1082, cpphdl_n1082), 0.01, 0.69999999999999996, 1.0);
        // device 637, IC IC104, analog/basic/mos_track_hold.hpp:37
        I(cpphdl_n1082, cpphdl_n1082) <+ cpphdl_channel(V(TRACK4, cpphdl_n1082), V(cpphdl_n1082, cpphdl_n1082), 0.0050000000000000001, 0.69999999999999996, -1.0);
        // device 638, IC IC104, analog/basic/mos_track_hold.hpp:38
        I(cpphdl_n1082, Vss) <+ 1.5000000000000001e-12 * ddt(V(cpphdl_n1082, Vss)); // Bench initial voltage = 1.6499999999999999 V.
        // device 639, IC IC104, analog/basic/mos_track_hold.hpp:39
        I(Vss, cpphdl_n1082) <+ V(Vss, cpphdl_n1082) / 1000000000.0;
        // device 640, IC IC104, analog/basic/mos_track_hold.hpp:40
        I(TRACK4, cpphdl_n1082) <+ 2.0000000000000002e-15 * ddt(V(TRACK4, cpphdl_n1082)); // Bench initial voltage = -1.6499999999999999 V.
        // device 641, IC IC104, analog/basic/mos_track_hold.hpp:41
        I(cpphdl_n1028, cpphdl_n1082) <+ 2.0000000000000002e-15 * ddt(V(cpphdl_n1028, cpphdl_n1082)); // Bench initial voltage = 1.6499999999999999 V.
        // device 642, IC IC104, analog/basic/mos_track_hold.hpp:42
        I(cpphdl_n2595, cpphdl_n1082) <+ 1.0000000000000001e-15 * ddt(V(cpphdl_n2595, cpphdl_n1082)); // Bench initial voltage = 0.0 V.
        // device 643, IC IC107, analog/basic/inverter.hpp:11
        I(cpphdl_n1043, Vdd) <+ cpphdl_channel(V(BIT_N4_0, Vdd), V(cpphdl_n1043, Vdd), 0.080000000000000002, 0.69999999999999996, -1.0);
        // device 644, IC IC107, analog/basic/inverter.hpp:12
        I(cpphdl_n1043, Vss) <+ cpphdl_channel(V(BIT_N4_0, Vss), V(cpphdl_n1043, Vss), 0.080000000000000002, 0.69999999999999996, 1.0);
        // device 645, IC IC106, analog/basic/mos_r2r_dac.hpp:27
        I(cpphdl_n1043, Vss) <+ 2.9999999999999998e-15 * ddt(V(cpphdl_n1043, Vss)); // Bench initial voltage = 0.0 V.
        // device 646, IC IC106, analog/basic/mos_r2r_dac.hpp:28
        I(cpphdl_n1043, cpphdl_n1072) <+ V(cpphdl_n1043, cpphdl_n1072) / 2000.0;
        // device 647, IC IC106, analog/basic/mos_r2r_dac.hpp:29
        I(cpphdl_n1072, Vss) <+ 2.9999999999999998e-15 * ddt(V(cpphdl_n1072, Vss)); // Bench initial voltage = 0.0 V.
        // device 648, IC IC108, analog/basic/inverter.hpp:11
        I(cpphdl_n1047, Vdd) <+ cpphdl_channel(V(BIT_N4_1, Vdd), V(cpphdl_n1047, Vdd), 0.080000000000000002, 0.69999999999999996, -1.0);
        // device 649, IC IC108, analog/basic/inverter.hpp:12
        I(cpphdl_n1047, Vss) <+ cpphdl_channel(V(BIT_N4_1, Vss), V(cpphdl_n1047, Vss), 0.080000000000000002, 0.69999999999999996, 1.0);
        // device 650, IC IC106, analog/basic/mos_r2r_dac.hpp:27
        I(cpphdl_n1047, Vss) <+ 2.9999999999999998e-15 * ddt(V(cpphdl_n1047, Vss)); // Bench initial voltage = 0.0 V.
        // device 651, IC IC106, analog/basic/mos_r2r_dac.hpp:28
        I(cpphdl_n1047, cpphdl_n1073) <+ V(cpphdl_n1047, cpphdl_n1073) / 2000.0;
        // device 652, IC IC106, analog/basic/mos_r2r_dac.hpp:29
        I(cpphdl_n1073, Vss) <+ 2.9999999999999998e-15 * ddt(V(cpphdl_n1073, Vss)); // Bench initial voltage = 0.0 V.
        // device 653, IC IC106, analog/basic/mos_r2r_dac.hpp:31
        I(cpphdl_n1072, cpphdl_n1073) <+ V(cpphdl_n1072, cpphdl_n1073) / 1000.0;
        // device 654, IC IC109, analog/basic/inverter.hpp:11
        I(cpphdl_n1051, Vdd) <+ cpphdl_channel(V(BIT_N4_2, Vdd), V(cpphdl_n1051, Vdd), 0.080000000000000002, 0.69999999999999996, -1.0);
        // device 655, IC IC109, analog/basic/inverter.hpp:12
        I(cpphdl_n1051, Vss) <+ cpphdl_channel(V(BIT_N4_2, Vss), V(cpphdl_n1051, Vss), 0.080000000000000002, 0.69999999999999996, 1.0);
        // device 656, IC IC106, analog/basic/mos_r2r_dac.hpp:27
        I(cpphdl_n1051, Vss) <+ 2.9999999999999998e-15 * ddt(V(cpphdl_n1051, Vss)); // Bench initial voltage = 0.0 V.
        // device 657, IC IC106, analog/basic/mos_r2r_dac.hpp:28
        I(cpphdl_n1051, cpphdl_n1074) <+ V(cpphdl_n1051, cpphdl_n1074) / 2000.0;
        // device 658, IC IC106, analog/basic/mos_r2r_dac.hpp:29
        I(cpphdl_n1074, Vss) <+ 2.9999999999999998e-15 * ddt(V(cpphdl_n1074, Vss)); // Bench initial voltage = 0.0 V.
        // device 659, IC IC106, analog/basic/mos_r2r_dac.hpp:31
        I(cpphdl_n1073, cpphdl_n1074) <+ V(cpphdl_n1073, cpphdl_n1074) / 1000.0;
        // device 660, IC IC110, analog/basic/inverter.hpp:11
        I(cpphdl_n1055, Vdd) <+ cpphdl_channel(V(BIT_N4_3, Vdd), V(cpphdl_n1055, Vdd), 0.080000000000000002, 0.69999999999999996, -1.0);
        // device 661, IC IC110, analog/basic/inverter.hpp:12
        I(cpphdl_n1055, Vss) <+ cpphdl_channel(V(BIT_N4_3, Vss), V(cpphdl_n1055, Vss), 0.080000000000000002, 0.69999999999999996, 1.0);
        // device 662, IC IC106, analog/basic/mos_r2r_dac.hpp:27
        I(cpphdl_n1055, Vss) <+ 2.9999999999999998e-15 * ddt(V(cpphdl_n1055, Vss)); // Bench initial voltage = 0.0 V.
        // device 663, IC IC106, analog/basic/mos_r2r_dac.hpp:28
        I(cpphdl_n1055, cpphdl_n1075) <+ V(cpphdl_n1055, cpphdl_n1075) / 2000.0;
        // device 664, IC IC106, analog/basic/mos_r2r_dac.hpp:29
        I(cpphdl_n1075, Vss) <+ 2.9999999999999998e-15 * ddt(V(cpphdl_n1075, Vss)); // Bench initial voltage = 0.0 V.
        // device 665, IC IC106, analog/basic/mos_r2r_dac.hpp:31
        I(cpphdl_n1074, cpphdl_n1075) <+ V(cpphdl_n1074, cpphdl_n1075) / 1000.0;
        // device 666, IC IC111, analog/basic/inverter.hpp:11
        I(cpphdl_n1059, Vdd) <+ cpphdl_channel(V(BIT_N4_4, Vdd), V(cpphdl_n1059, Vdd), 0.080000000000000002, 0.69999999999999996, -1.0);
        // device 667, IC IC111, analog/basic/inverter.hpp:12
        I(cpphdl_n1059, Vss) <+ cpphdl_channel(V(BIT_N4_4, Vss), V(cpphdl_n1059, Vss), 0.080000000000000002, 0.69999999999999996, 1.0);
        // device 668, IC IC106, analog/basic/mos_r2r_dac.hpp:27
        I(cpphdl_n1059, Vss) <+ 2.9999999999999998e-15 * ddt(V(cpphdl_n1059, Vss)); // Bench initial voltage = 0.0 V.
        // device 669, IC IC106, analog/basic/mos_r2r_dac.hpp:28
        I(cpphdl_n1059, cpphdl_n1076) <+ V(cpphdl_n1059, cpphdl_n1076) / 2000.0;
        // device 670, IC IC106, analog/basic/mos_r2r_dac.hpp:29
        I(cpphdl_n1076, Vss) <+ 2.9999999999999998e-15 * ddt(V(cpphdl_n1076, Vss)); // Bench initial voltage = 0.0 V.
        // device 671, IC IC106, analog/basic/mos_r2r_dac.hpp:31
        I(cpphdl_n1075, cpphdl_n1076) <+ V(cpphdl_n1075, cpphdl_n1076) / 1000.0;
        // device 672, IC IC112, analog/basic/inverter.hpp:11
        I(cpphdl_n1063, Vdd) <+ cpphdl_channel(V(BIT_N4_5, Vdd), V(cpphdl_n1063, Vdd), 0.080000000000000002, 0.69999999999999996, -1.0);
        // device 673, IC IC112, analog/basic/inverter.hpp:12
        I(cpphdl_n1063, Vss) <+ cpphdl_channel(V(BIT_N4_5, Vss), V(cpphdl_n1063, Vss), 0.080000000000000002, 0.69999999999999996, 1.0);
        // device 674, IC IC106, analog/basic/mos_r2r_dac.hpp:27
        I(cpphdl_n1063, Vss) <+ 2.9999999999999998e-15 * ddt(V(cpphdl_n1063, Vss)); // Bench initial voltage = 0.0 V.
        // device 675, IC IC106, analog/basic/mos_r2r_dac.hpp:28
        I(cpphdl_n1063, cpphdl_n1077) <+ V(cpphdl_n1063, cpphdl_n1077) / 2000.0;
        // device 676, IC IC106, analog/basic/mos_r2r_dac.hpp:29
        I(cpphdl_n1077, Vss) <+ 2.9999999999999998e-15 * ddt(V(cpphdl_n1077, Vss)); // Bench initial voltage = 0.0 V.
        // device 677, IC IC106, analog/basic/mos_r2r_dac.hpp:31
        I(cpphdl_n1076, cpphdl_n1077) <+ V(cpphdl_n1076, cpphdl_n1077) / 1000.0;
        // device 678, IC IC113, analog/basic/inverter.hpp:11
        I(cpphdl_n1067, Vdd) <+ cpphdl_channel(V(BIT_N4_6, Vdd), V(cpphdl_n1067, Vdd), 0.080000000000000002, 0.69999999999999996, -1.0);
        // device 679, IC IC113, analog/basic/inverter.hpp:12
        I(cpphdl_n1067, Vss) <+ cpphdl_channel(V(BIT_N4_6, Vss), V(cpphdl_n1067, Vss), 0.080000000000000002, 0.69999999999999996, 1.0);
        // device 680, IC IC106, analog/basic/mos_r2r_dac.hpp:27
        I(cpphdl_n1067, Vss) <+ 2.9999999999999998e-15 * ddt(V(cpphdl_n1067, Vss)); // Bench initial voltage = 0.0 V.
        // device 681, IC IC106, analog/basic/mos_r2r_dac.hpp:28
        I(cpphdl_n1067, cpphdl_n1078) <+ V(cpphdl_n1067, cpphdl_n1078) / 2000.0;
        // device 682, IC IC106, analog/basic/mos_r2r_dac.hpp:29
        I(cpphdl_n1078, Vss) <+ 2.9999999999999998e-15 * ddt(V(cpphdl_n1078, Vss)); // Bench initial voltage = 0.0 V.
        // device 683, IC IC106, analog/basic/mos_r2r_dac.hpp:31
        I(cpphdl_n1077, cpphdl_n1078) <+ V(cpphdl_n1077, cpphdl_n1078) / 1000.0;
        // device 684, IC IC114, analog/basic/inverter.hpp:11
        I(cpphdl_n1071, Vdd) <+ cpphdl_channel(V(BIT_N4_7, Vdd), V(cpphdl_n1071, Vdd), 0.080000000000000002, 0.69999999999999996, -1.0);
        // device 685, IC IC114, analog/basic/inverter.hpp:12
        I(cpphdl_n1071, Vss) <+ cpphdl_channel(V(BIT_N4_7, Vss), V(cpphdl_n1071, Vss), 0.080000000000000002, 0.69999999999999996, 1.0);
        // device 686, IC IC106, analog/basic/mos_r2r_dac.hpp:27
        I(cpphdl_n1071, Vss) <+ 2.9999999999999998e-15 * ddt(V(cpphdl_n1071, Vss)); // Bench initial voltage = 0.0 V.
        // device 687, IC IC106, analog/basic/mos_r2r_dac.hpp:28
        I(cpphdl_n1071, cpphdl_n1083) <+ V(cpphdl_n1071, cpphdl_n1083) / 2000.0;
        // device 688, IC IC106, analog/basic/mos_r2r_dac.hpp:29
        I(cpphdl_n1083, Vss) <+ 2.9999999999999998e-15 * ddt(V(cpphdl_n1083, Vss)); // Bench initial voltage = 0.0 V.
        // device 689, IC IC106, analog/basic/mos_r2r_dac.hpp:31
        I(cpphdl_n1078, cpphdl_n1083) <+ V(cpphdl_n1078, cpphdl_n1083) / 1000.0;
        // device 690, IC IC106, analog/basic/mos_r2r_dac.hpp:33
        I(Vss, cpphdl_n1072) <+ V(Vss, cpphdl_n1072) / 2000.0;
        // device 691, IC IC115, analog/basic/nmos_resistor_amplifier.hpp:23
        I(Vdd, cpphdl_n1092) <+ V(Vdd, cpphdl_n1092) / 500.0;
        // device 692, IC IC115, analog/basic/nmos_resistor_amplifier.hpp:24
        I(Vdd, cpphdl_n1091) <+ V(Vdd, cpphdl_n1091) / 500.0;
        // device 693, IC IC115, analog/basic/nmos_resistor_amplifier.hpp:25
        I(cpphdl_n1092, cpphdl_n1086) <+ cpphdl_channel(V(cpphdl_n1082, cpphdl_n1086), V(cpphdl_n1092, cpphdl_n1086), 0.014999999999999999, 0.69999999999999996, 1.0);
        // device 694, IC IC115, analog/basic/nmos_resistor_amplifier.hpp:26
        I(cpphdl_n1091, cpphdl_n1087) <+ cpphdl_channel(V(cpphdl_n1083, cpphdl_n1087), V(cpphdl_n1091, cpphdl_n1087), 0.014999999999999999, 0.69999999999999996, 1.0);
        // device 695, IC IC115, analog/basic/nmos_resistor_amplifier.hpp:27
        I(cpphdl_n1088, cpphdl_n1086) <+ V(cpphdl_n1088, cpphdl_n1086) / 50.0;
        // device 696, IC IC115, analog/basic/nmos_resistor_amplifier.hpp:28
        I(cpphdl_n1088, cpphdl_n1087) <+ V(cpphdl_n1088, cpphdl_n1087) / 50.0;
        // device 697, IC IC115, analog/basic/nmos_resistor_amplifier.hpp:29
        I(Vss, cpphdl_n1088) <+ V(Vss, cpphdl_n1088) / 150.0;
        // device 698, IC IC115, analog/basic/nmos_resistor_amplifier.hpp:30
        I(cpphdl_n1092, Vdd) <+ 2.9999999999999998e-13 * ddt(V(cpphdl_n1092, Vdd)); // Bench initial voltage = 0.0 V.
        // device 699, IC IC115, analog/basic/nmos_resistor_amplifier.hpp:31
        I(cpphdl_n1091, Vdd) <+ 2.9999999999999998e-13 * ddt(V(cpphdl_n1091, Vdd)); // Bench initial voltage = 0.0 V.
        // device 700, IC IC115, analog/basic/nmos_resistor_amplifier.hpp:32
        I(cpphdl_n1088, Vss) <+ 4e-14 * ddt(V(cpphdl_n1088, Vss)); // Bench initial voltage = 0.0 V.
        // device 701, IC IC115, analog/basic/nmos_resistor_amplifier.hpp:34
        I(cpphdl_n1082, cpphdl_n1086) <+ 2e-14 * ddt(V(cpphdl_n1082, cpphdl_n1086)); // Bench initial voltage = 1.6499999999999999 V.
        // device 702, IC IC115, analog/basic/nmos_resistor_amplifier.hpp:35
        I(cpphdl_n1083, cpphdl_n1087) <+ 2e-14 * ddt(V(cpphdl_n1083, cpphdl_n1087)); // Bench initial voltage = 0.0 V.
        // device 703, IC IC115, analog/basic/nmos_resistor_amplifier.hpp:36
        I(cpphdl_n1082, cpphdl_n1092) <+ 2.9999999999999998e-15 * ddt(V(cpphdl_n1082, cpphdl_n1092)); // Bench initial voltage = -1.6499999999999999 V.
        // device 704, IC IC115, analog/basic/nmos_resistor_amplifier.hpp:37
        I(cpphdl_n1083, cpphdl_n1091) <+ 2.9999999999999998e-15 * ddt(V(cpphdl_n1083, cpphdl_n1091)); // Bench initial voltage = -3.2999999999999998 V.
        // device 705, IC IC116, analog/basic/strongarm_comparator.hpp:28
        I(cpphdl_n1096, cpphdl_n1098) <+ cpphdl_channel(V(cpphdl_n1091, cpphdl_n1098), V(cpphdl_n1096, cpphdl_n1098), 0.0080000000000000002, 0.69999999999999996, 1.0);
        // device 706, IC IC116, analog/basic/strongarm_comparator.hpp:29
        I(cpphdl_n1097, cpphdl_n1098) <+ cpphdl_channel(V(cpphdl_n1092, cpphdl_n1098), V(cpphdl_n1097, cpphdl_n1098), 0.0080000000000000002, 0.69999999999999996, 1.0);
        // device 707, IC IC116, analog/basic/strongarm_comparator.hpp:30
        I(cpphdl_n1098, Vss) <+ cpphdl_channel(V(EVALUATE, Vss), V(cpphdl_n1098, Vss), 0.0080000000000000002, 0.69999999999999996, 1.0);
        // device 708, IC IC116, analog/basic/strongarm_comparator.hpp:33
        I(cpphdl_n1111, cpphdl_n1096) <+ cpphdl_channel(V(cpphdl_n1115, cpphdl_n1096), V(cpphdl_n1111, cpphdl_n1096), 0.0040000000000000001, 0.69999999999999996, 1.0);
        // device 709, IC IC116, analog/basic/strongarm_comparator.hpp:34
        I(cpphdl_n1115, cpphdl_n1097) <+ cpphdl_channel(V(cpphdl_n1111, cpphdl_n1097), V(cpphdl_n1115, cpphdl_n1097), 0.0040000000000000001, 0.69999999999999996, 1.0);
        // device 710, IC IC116, analog/basic/strongarm_comparator.hpp:35
        I(cpphdl_n1115, Vdd) <+ cpphdl_channel(V(cpphdl_n1111, Vdd), V(cpphdl_n1115, Vdd), 0.002, 0.69999999999999996, -1.0);
        // device 711, IC IC116, analog/basic/strongarm_comparator.hpp:36
        I(cpphdl_n1111, Vdd) <+ cpphdl_channel(V(cpphdl_n1115, Vdd), V(cpphdl_n1111, Vdd), 0.002, 0.69999999999999996, -1.0);
        // device 712, IC IC116, analog/basic/strongarm_comparator.hpp:38
        I(cpphdl_n1096, Vdd) <+ cpphdl_channel(V(EVALUATE, Vdd), V(cpphdl_n1096, Vdd), 0.002, 0.69999999999999996, -1.0);
        // device 713, IC IC116, analog/basic/strongarm_comparator.hpp:39
        I(cpphdl_n1097, Vdd) <+ cpphdl_channel(V(EVALUATE, Vdd), V(cpphdl_n1097, Vdd), 0.002, 0.69999999999999996, -1.0);
        // device 714, IC IC116, analog/basic/strongarm_comparator.hpp:40
        I(cpphdl_n1115, Vdd) <+ cpphdl_channel(V(EVALUATE, Vdd), V(cpphdl_n1115, Vdd), 0.002, 0.69999999999999996, -1.0);
        // device 715, IC IC116, analog/basic/strongarm_comparator.hpp:41
        I(cpphdl_n1111, Vdd) <+ cpphdl_channel(V(EVALUATE, Vdd), V(cpphdl_n1111, Vdd), 0.002, 0.69999999999999996, -1.0);
        // device 716, IC IC116, analog/basic/strongarm_comparator.hpp:42
        I(cpphdl_n1096, Vss) <+ 2.9999999999999998e-14 * ddt(V(cpphdl_n1096, Vss)); // Bench initial voltage = 0.0 V.
        // device 717, IC IC116, analog/basic/strongarm_comparator.hpp:43
        I(cpphdl_n1097, Vss) <+ 2.9999999999999998e-14 * ddt(V(cpphdl_n1097, Vss)); // Bench initial voltage = 0.0 V.
        // device 718, IC IC116, analog/basic/strongarm_comparator.hpp:44
        I(cpphdl_n1098, Vss) <+ 2.9999999999999998e-14 * ddt(V(cpphdl_n1098, Vss)); // Bench initial voltage = 0.0 V.
        // device 719, IC IC116, analog/basic/strongarm_comparator.hpp:45
        I(cpphdl_n1115, Vss) <+ 5.0000000000000002e-14 * ddt(V(cpphdl_n1115, Vss)); // Bench initial voltage = 0.0 V.
        // device 720, IC IC116, analog/basic/strongarm_comparator.hpp:46
        I(cpphdl_n1111, Vss) <+ 5.0000000000000002e-14 * ddt(V(cpphdl_n1111, Vss)); // Bench initial voltage = 0.0 V.
        // device 721, IC IC116, analog/basic/strongarm_comparator.hpp:47
        I(cpphdl_n1091, cpphdl_n1098) <+ 2e-14 * ddt(V(cpphdl_n1091, cpphdl_n1098)); // Bench initial voltage = 3.2999999999999998 V.
        // device 722, IC IC116, analog/basic/strongarm_comparator.hpp:48
        I(cpphdl_n1092, cpphdl_n1098) <+ 2e-14 * ddt(V(cpphdl_n1092, cpphdl_n1098)); // Bench initial voltage = 3.2999999999999998 V.
        // device 723, IC IC116, analog/basic/strongarm_comparator.hpp:49
        I(cpphdl_n1091, cpphdl_n1096) <+ 2.9999999999999998e-15 * ddt(V(cpphdl_n1091, cpphdl_n1096)); // Bench initial voltage = 3.2999999999999998 V.
        // device 724, IC IC116, analog/basic/strongarm_comparator.hpp:50
        I(cpphdl_n1092, cpphdl_n1097) <+ 2.9999999999999998e-15 * ddt(V(cpphdl_n1092, cpphdl_n1097)); // Bench initial voltage = 3.2999999999999998 V.
        // device 725, IC IC118, analog/basic/inverter.hpp:11
        I(cpphdl_n1119, Vdd) <+ cpphdl_channel(V(cpphdl_n1111, Vdd), V(cpphdl_n1119, Vdd), 0.001, 0.69999999999999996, -1.0);
        // device 726, IC IC118, analog/basic/inverter.hpp:12
        I(cpphdl_n1119, Vss) <+ cpphdl_channel(V(cpphdl_n1111, Vss), V(cpphdl_n1119, Vss), 0.001, 0.69999999999999996, 1.0);
        // device 727, IC IC120, analog/basic/inverter.hpp:11
        I(cpphdl_n1133, Vdd) <+ cpphdl_channel(V(cpphdl_n1119, Vdd), V(cpphdl_n1133, Vdd), 0.0040000000000000001, 0.69999999999999996, -1.0);
        // device 728, IC IC120, analog/basic/inverter.hpp:12
        I(cpphdl_n1133, Vss) <+ cpphdl_channel(V(cpphdl_n1119, Vss), V(cpphdl_n1133, Vss), 0.0040000000000000001, 0.69999999999999996, 1.0);
        // device 729, IC IC117, analog/basic/buffered_nand_latch.hpp:33
        I(cpphdl_n1111, Vss) <+ 2.0000000000000002e-15 * ddt(V(cpphdl_n1111, Vss)); // Bench initial voltage = 0.0 V.
        // device 730, IC IC117, analog/basic/buffered_nand_latch.hpp:34
        I(cpphdl_n1111, cpphdl_n1119) <+ 1.0000000000000001e-15 * ddt(V(cpphdl_n1111, cpphdl_n1119)); // Bench initial voltage = 0.0 V.
        // device 731, IC IC117, analog/basic/buffered_nand_latch.hpp:35
        I(cpphdl_n1119, Vss) <+ 5e-15 * ddt(V(cpphdl_n1119, Vss)); // Bench initial voltage = 0.0 V.
        // device 732, IC IC117, analog/basic/buffered_nand_latch.hpp:36
        I(cpphdl_n1119, Vss) <+ 8.0000000000000006e-15 * ddt(V(cpphdl_n1119, Vss)); // Bench initial voltage = 0.0 V.
        // device 733, IC IC117, analog/basic/buffered_nand_latch.hpp:37
        I(cpphdl_n1133, Vss) <+ 1e-14 * ddt(V(cpphdl_n1133, Vss)); // Bench initial voltage = 0.0 V.
        // device 734, IC IC119, analog/basic/inverter.hpp:11
        I(cpphdl_n1123, Vdd) <+ cpphdl_channel(V(cpphdl_n1115, Vdd), V(cpphdl_n1123, Vdd), 0.001, 0.69999999999999996, -1.0);
        // device 735, IC IC119, analog/basic/inverter.hpp:12
        I(cpphdl_n1123, Vss) <+ cpphdl_channel(V(cpphdl_n1115, Vss), V(cpphdl_n1123, Vss), 0.001, 0.69999999999999996, 1.0);
        // device 736, IC IC121, analog/basic/inverter.hpp:11
        I(cpphdl_n1139, Vdd) <+ cpphdl_channel(V(cpphdl_n1123, Vdd), V(cpphdl_n1139, Vdd), 0.0040000000000000001, 0.69999999999999996, -1.0);
        // device 737, IC IC121, analog/basic/inverter.hpp:12
        I(cpphdl_n1139, Vss) <+ cpphdl_channel(V(cpphdl_n1123, Vss), V(cpphdl_n1139, Vss), 0.0040000000000000001, 0.69999999999999996, 1.0);
        // device 738, IC IC117, analog/basic/buffered_nand_latch.hpp:33
        I(cpphdl_n1115, Vss) <+ 2.0000000000000002e-15 * ddt(V(cpphdl_n1115, Vss)); // Bench initial voltage = 0.0 V.
        // device 739, IC IC117, analog/basic/buffered_nand_latch.hpp:34
        I(cpphdl_n1115, cpphdl_n1123) <+ 1.0000000000000001e-15 * ddt(V(cpphdl_n1115, cpphdl_n1123)); // Bench initial voltage = 0.0 V.
        // device 740, IC IC117, analog/basic/buffered_nand_latch.hpp:35
        I(cpphdl_n1123, Vss) <+ 5e-15 * ddt(V(cpphdl_n1123, Vss)); // Bench initial voltage = 0.0 V.
        // device 741, IC IC117, analog/basic/buffered_nand_latch.hpp:36
        I(cpphdl_n1123, Vss) <+ 8.0000000000000006e-15 * ddt(V(cpphdl_n1123, Vss)); // Bench initial voltage = 0.0 V.
        // device 742, IC IC117, analog/basic/buffered_nand_latch.hpp:37
        I(cpphdl_n1139, Vss) <+ 1e-14 * ddt(V(cpphdl_n1139, Vss)); // Bench initial voltage = 0.0 V.
        // device 743, IC IC123, analog/basic/cmos_logic.hpp:15
        I(cpphdl_n2760, Vss) <+ 5.0000000000000002e-14 * ddt(V(cpphdl_n2760, Vss)); // Bench initial voltage = 0.0 V.
        // device 744, IC IC123, analog/basic/cmos_logic.hpp:16
        I(cpphdl_n2760, Vdd) <+ cpphdl_channel(V(cpphdl_n1133, Vdd), V(cpphdl_n2760, Vdd), 0.01, 0.69999999999999996, -1.0);
        // device 745, IC IC123, analog/basic/cmos_logic.hpp:17
        I(cpphdl_n2760, Vdd) <+ cpphdl_channel(V(cpphdl_n1141, Vdd), V(cpphdl_n2760, Vdd), 0.01, 0.69999999999999996, -1.0);
        // device 746, IC IC123, analog/basic/cmos_logic.hpp:18
        I(cpphdl_n2760, cpphdl_n1136) <+ cpphdl_channel(V(cpphdl_n1133, cpphdl_n1136), V(cpphdl_n2760, cpphdl_n1136), 0.01, 0.69999999999999996, 1.0);
        // device 747, IC IC123, analog/basic/cmos_logic.hpp:19
        I(cpphdl_n1136, Vss) <+ cpphdl_channel(V(cpphdl_n1141, Vss), V(cpphdl_n1136, Vss), 0.01, 0.69999999999999996, 1.0);
        // device 748, IC IC123, analog/basic/cmos_logic.hpp:20
        I(cpphdl_n2760, Vss) <+ V(cpphdl_n2760, Vss) / 1000000000.0;
        // device 749, IC IC123, analog/basic/cmos_logic.hpp:21
        I(cpphdl_n1136, Vss) <+ V(cpphdl_n1136, Vss) / 1000000000.0;
        // device 750, IC IC124, analog/basic/cmos_logic.hpp:15
        I(cpphdl_n1141, Vss) <+ 5.0000000000000002e-14 * ddt(V(cpphdl_n1141, Vss)); // Bench initial voltage = 0.0 V.
        // device 751, IC IC124, analog/basic/cmos_logic.hpp:16
        I(cpphdl_n1141, Vdd) <+ cpphdl_channel(V(cpphdl_n1139, Vdd), V(cpphdl_n1141, Vdd), 0.01, 0.69999999999999996, -1.0);
        // device 752, IC IC124, analog/basic/cmos_logic.hpp:17
        I(cpphdl_n1141, Vdd) <+ cpphdl_channel(V(cpphdl_n2760, Vdd), V(cpphdl_n1141, Vdd), 0.01, 0.69999999999999996, -1.0);
        // device 753, IC IC124, analog/basic/cmos_logic.hpp:18
        I(cpphdl_n1141, cpphdl_n1142) <+ cpphdl_channel(V(cpphdl_n1139, cpphdl_n1142), V(cpphdl_n1141, cpphdl_n1142), 0.01, 0.69999999999999996, 1.0);
        // device 754, IC IC124, analog/basic/cmos_logic.hpp:19
        I(cpphdl_n1142, Vss) <+ cpphdl_channel(V(cpphdl_n2760, Vss), V(cpphdl_n1142, Vss), 0.01, 0.69999999999999996, 1.0);
        // device 755, IC IC124, analog/basic/cmos_logic.hpp:20
        I(cpphdl_n1141, Vss) <+ V(cpphdl_n1141, Vss) / 1000000000.0;
        // device 756, IC IC124, analog/basic/cmos_logic.hpp:21
        I(cpphdl_n1142, Vss) <+ V(cpphdl_n1142, Vss) / 1000000000.0;
        // device 757, IC IC122, analog/basic/nand_latch.hpp:34
        I(cpphdl_n1133, Vss) <+ 2.9999999999999998e-15 * ddt(V(cpphdl_n1133, Vss)); // Bench initial voltage = 0.0 V.
        // device 758, IC IC122, analog/basic/nand_latch.hpp:35
        I(cpphdl_n1139, Vss) <+ 2.9999999999999998e-15 * ddt(V(cpphdl_n1139, Vss)); // Bench initial voltage = 0.0 V.
        // device 759, IC IC125, analog/basic/inverter.hpp:11
        I(cpphdl_n1147, Vdd) <+ cpphdl_channel(V(CLEAR, Vdd), V(cpphdl_n1147, Vdd), 0.01, 0.69999999999999996, -1.0);
        // device 760, IC IC125, analog/basic/inverter.hpp:12
        I(cpphdl_n1147, Vss) <+ cpphdl_channel(V(CLEAR, Vss), V(cpphdl_n1147, Vss), 0.01, 0.69999999999999996, 1.0);
        // device 761, IC IC122, analog/basic/nand_latch.hpp:56
        I(cpphdl_n1147, Vss) <+ 2.9999999999999998e-15 * ddt(V(cpphdl_n1147, Vss)); // Bench initial voltage = 0.0 V.
        // device 762, IC IC122, analog/basic/nand_latch.hpp:57
        I(cpphdl_n2760, Vss) <+ cpphdl_channel(V(CLEAR, Vss), V(cpphdl_n2760, Vss), 0.050000000000000003, 0.69999999999999996, 1.0);
        // device 763, IC IC122, analog/basic/nand_latch.hpp:58
        I(cpphdl_n1141, Vdd) <+ cpphdl_channel(V(cpphdl_n1147, Vdd), V(cpphdl_n1141, Vdd), 0.050000000000000003, 0.69999999999999996, -1.0);
        // device 764, IC IC128, analog/basic/inverter.hpp:11
        I(cpphdl_n1171, Vdd) <+ cpphdl_channel(V(TRACK5, Vdd), V(cpphdl_n1171, Vdd), 0.0040000000000000001, 0.69999999999999996, -1.0);
        // device 765, IC IC128, analog/basic/inverter.hpp:12
        I(cpphdl_n1171, Vss) <+ cpphdl_channel(V(TRACK5, Vss), V(cpphdl_n1171, Vss), 0.0040000000000000001, 0.69999999999999996, 1.0);
        // device 766, IC IC127, analog/basic/mos_track_hold.hpp:30
        I(cpphdl_n1171, Vss) <+ 2e-14 * ddt(V(cpphdl_n1171, Vss)); // Bench initial voltage = 3.2999999999999998 V.
        // device 767, IC IC127, analog/basic/mos_track_hold.hpp:31
        I(cpphdl_n2595, cpphdl_n1225) <+ cpphdl_channel(V(TRACK5, cpphdl_n1225), V(cpphdl_n2595, cpphdl_n1225), 0.02, 0.69999999999999996, 1.0);
        // device 768, IC IC127, analog/basic/mos_track_hold.hpp:32
        I(cpphdl_n1225, cpphdl_n2595) <+ cpphdl_channel(V(cpphdl_n1171, cpphdl_n2595), V(cpphdl_n1225, cpphdl_n2595), 0.01, 0.69999999999999996, -1.0);
        // device 769, IC IC127, analog/basic/mos_track_hold.hpp:36
        I(cpphdl_n1225, cpphdl_n1225) <+ cpphdl_channel(V(cpphdl_n1171, cpphdl_n1225), V(cpphdl_n1225, cpphdl_n1225), 0.01, 0.69999999999999996, 1.0);
        // device 770, IC IC127, analog/basic/mos_track_hold.hpp:37
        I(cpphdl_n1225, cpphdl_n1225) <+ cpphdl_channel(V(TRACK5, cpphdl_n1225), V(cpphdl_n1225, cpphdl_n1225), 0.0050000000000000001, 0.69999999999999996, -1.0);
        // device 771, IC IC127, analog/basic/mos_track_hold.hpp:38
        I(cpphdl_n1225, Vss) <+ 1.5000000000000001e-12 * ddt(V(cpphdl_n1225, Vss)); // Bench initial voltage = 1.6499999999999999 V.
        // device 772, IC IC127, analog/basic/mos_track_hold.hpp:39
        I(Vss, cpphdl_n1225) <+ V(Vss, cpphdl_n1225) / 1000000000.0;
        // device 773, IC IC127, analog/basic/mos_track_hold.hpp:40
        I(TRACK5, cpphdl_n1225) <+ 2.0000000000000002e-15 * ddt(V(TRACK5, cpphdl_n1225)); // Bench initial voltage = -1.6499999999999999 V.
        // device 774, IC IC127, analog/basic/mos_track_hold.hpp:41
        I(cpphdl_n1171, cpphdl_n1225) <+ 2.0000000000000002e-15 * ddt(V(cpphdl_n1171, cpphdl_n1225)); // Bench initial voltage = 1.6499999999999999 V.
        // device 775, IC IC127, analog/basic/mos_track_hold.hpp:42
        I(cpphdl_n2595, cpphdl_n1225) <+ 1.0000000000000001e-15 * ddt(V(cpphdl_n2595, cpphdl_n1225)); // Bench initial voltage = 0.0 V.
        // device 776, IC IC130, analog/basic/inverter.hpp:11
        I(cpphdl_n1186, Vdd) <+ cpphdl_channel(V(BIT_N5_0, Vdd), V(cpphdl_n1186, Vdd), 0.080000000000000002, 0.69999999999999996, -1.0);
        // device 777, IC IC130, analog/basic/inverter.hpp:12
        I(cpphdl_n1186, Vss) <+ cpphdl_channel(V(BIT_N5_0, Vss), V(cpphdl_n1186, Vss), 0.080000000000000002, 0.69999999999999996, 1.0);
        // device 778, IC IC129, analog/basic/mos_r2r_dac.hpp:27
        I(cpphdl_n1186, Vss) <+ 2.9999999999999998e-15 * ddt(V(cpphdl_n1186, Vss)); // Bench initial voltage = 0.0 V.
        // device 779, IC IC129, analog/basic/mos_r2r_dac.hpp:28
        I(cpphdl_n1186, cpphdl_n1215) <+ V(cpphdl_n1186, cpphdl_n1215) / 2000.0;
        // device 780, IC IC129, analog/basic/mos_r2r_dac.hpp:29
        I(cpphdl_n1215, Vss) <+ 2.9999999999999998e-15 * ddt(V(cpphdl_n1215, Vss)); // Bench initial voltage = 0.0 V.
        // device 781, IC IC131, analog/basic/inverter.hpp:11
        I(cpphdl_n1190, Vdd) <+ cpphdl_channel(V(BIT_N5_1, Vdd), V(cpphdl_n1190, Vdd), 0.080000000000000002, 0.69999999999999996, -1.0);
        // device 782, IC IC131, analog/basic/inverter.hpp:12
        I(cpphdl_n1190, Vss) <+ cpphdl_channel(V(BIT_N5_1, Vss), V(cpphdl_n1190, Vss), 0.080000000000000002, 0.69999999999999996, 1.0);
        // device 783, IC IC129, analog/basic/mos_r2r_dac.hpp:27
        I(cpphdl_n1190, Vss) <+ 2.9999999999999998e-15 * ddt(V(cpphdl_n1190, Vss)); // Bench initial voltage = 0.0 V.
        // device 784, IC IC129, analog/basic/mos_r2r_dac.hpp:28
        I(cpphdl_n1190, cpphdl_n1216) <+ V(cpphdl_n1190, cpphdl_n1216) / 2000.0;
        // device 785, IC IC129, analog/basic/mos_r2r_dac.hpp:29
        I(cpphdl_n1216, Vss) <+ 2.9999999999999998e-15 * ddt(V(cpphdl_n1216, Vss)); // Bench initial voltage = 0.0 V.
        // device 786, IC IC129, analog/basic/mos_r2r_dac.hpp:31
        I(cpphdl_n1215, cpphdl_n1216) <+ V(cpphdl_n1215, cpphdl_n1216) / 1000.0;
        // device 787, IC IC132, analog/basic/inverter.hpp:11
        I(cpphdl_n1194, Vdd) <+ cpphdl_channel(V(BIT_N5_2, Vdd), V(cpphdl_n1194, Vdd), 0.080000000000000002, 0.69999999999999996, -1.0);
        // device 788, IC IC132, analog/basic/inverter.hpp:12
        I(cpphdl_n1194, Vss) <+ cpphdl_channel(V(BIT_N5_2, Vss), V(cpphdl_n1194, Vss), 0.080000000000000002, 0.69999999999999996, 1.0);
        // device 789, IC IC129, analog/basic/mos_r2r_dac.hpp:27
        I(cpphdl_n1194, Vss) <+ 2.9999999999999998e-15 * ddt(V(cpphdl_n1194, Vss)); // Bench initial voltage = 0.0 V.
        // device 790, IC IC129, analog/basic/mos_r2r_dac.hpp:28
        I(cpphdl_n1194, cpphdl_n1217) <+ V(cpphdl_n1194, cpphdl_n1217) / 2000.0;
        // device 791, IC IC129, analog/basic/mos_r2r_dac.hpp:29
        I(cpphdl_n1217, Vss) <+ 2.9999999999999998e-15 * ddt(V(cpphdl_n1217, Vss)); // Bench initial voltage = 0.0 V.
        // device 792, IC IC129, analog/basic/mos_r2r_dac.hpp:31
        I(cpphdl_n1216, cpphdl_n1217) <+ V(cpphdl_n1216, cpphdl_n1217) / 1000.0;
        // device 793, IC IC133, analog/basic/inverter.hpp:11
        I(cpphdl_n1198, Vdd) <+ cpphdl_channel(V(BIT_N5_3, Vdd), V(cpphdl_n1198, Vdd), 0.080000000000000002, 0.69999999999999996, -1.0);
        // device 794, IC IC133, analog/basic/inverter.hpp:12
        I(cpphdl_n1198, Vss) <+ cpphdl_channel(V(BIT_N5_3, Vss), V(cpphdl_n1198, Vss), 0.080000000000000002, 0.69999999999999996, 1.0);
        // device 795, IC IC129, analog/basic/mos_r2r_dac.hpp:27
        I(cpphdl_n1198, Vss) <+ 2.9999999999999998e-15 * ddt(V(cpphdl_n1198, Vss)); // Bench initial voltage = 0.0 V.
        // device 796, IC IC129, analog/basic/mos_r2r_dac.hpp:28
        I(cpphdl_n1198, cpphdl_n1218) <+ V(cpphdl_n1198, cpphdl_n1218) / 2000.0;
        // device 797, IC IC129, analog/basic/mos_r2r_dac.hpp:29
        I(cpphdl_n1218, Vss) <+ 2.9999999999999998e-15 * ddt(V(cpphdl_n1218, Vss)); // Bench initial voltage = 0.0 V.
        // device 798, IC IC129, analog/basic/mos_r2r_dac.hpp:31
        I(cpphdl_n1217, cpphdl_n1218) <+ V(cpphdl_n1217, cpphdl_n1218) / 1000.0;
        // device 799, IC IC134, analog/basic/inverter.hpp:11
        I(cpphdl_n1202, Vdd) <+ cpphdl_channel(V(BIT_N5_4, Vdd), V(cpphdl_n1202, Vdd), 0.080000000000000002, 0.69999999999999996, -1.0);
        // device 800, IC IC134, analog/basic/inverter.hpp:12
        I(cpphdl_n1202, Vss) <+ cpphdl_channel(V(BIT_N5_4, Vss), V(cpphdl_n1202, Vss), 0.080000000000000002, 0.69999999999999996, 1.0);
        // device 801, IC IC129, analog/basic/mos_r2r_dac.hpp:27
        I(cpphdl_n1202, Vss) <+ 2.9999999999999998e-15 * ddt(V(cpphdl_n1202, Vss)); // Bench initial voltage = 0.0 V.
        // device 802, IC IC129, analog/basic/mos_r2r_dac.hpp:28
        I(cpphdl_n1202, cpphdl_n1219) <+ V(cpphdl_n1202, cpphdl_n1219) / 2000.0;
        // device 803, IC IC129, analog/basic/mos_r2r_dac.hpp:29
        I(cpphdl_n1219, Vss) <+ 2.9999999999999998e-15 * ddt(V(cpphdl_n1219, Vss)); // Bench initial voltage = 0.0 V.
        // device 804, IC IC129, analog/basic/mos_r2r_dac.hpp:31
        I(cpphdl_n1218, cpphdl_n1219) <+ V(cpphdl_n1218, cpphdl_n1219) / 1000.0;
        // device 805, IC IC135, analog/basic/inverter.hpp:11
        I(cpphdl_n1206, Vdd) <+ cpphdl_channel(V(BIT_N5_5, Vdd), V(cpphdl_n1206, Vdd), 0.080000000000000002, 0.69999999999999996, -1.0);
        // device 806, IC IC135, analog/basic/inverter.hpp:12
        I(cpphdl_n1206, Vss) <+ cpphdl_channel(V(BIT_N5_5, Vss), V(cpphdl_n1206, Vss), 0.080000000000000002, 0.69999999999999996, 1.0);
        // device 807, IC IC129, analog/basic/mos_r2r_dac.hpp:27
        I(cpphdl_n1206, Vss) <+ 2.9999999999999998e-15 * ddt(V(cpphdl_n1206, Vss)); // Bench initial voltage = 0.0 V.
        // device 808, IC IC129, analog/basic/mos_r2r_dac.hpp:28
        I(cpphdl_n1206, cpphdl_n1220) <+ V(cpphdl_n1206, cpphdl_n1220) / 2000.0;
        // device 809, IC IC129, analog/basic/mos_r2r_dac.hpp:29
        I(cpphdl_n1220, Vss) <+ 2.9999999999999998e-15 * ddt(V(cpphdl_n1220, Vss)); // Bench initial voltage = 0.0 V.
        // device 810, IC IC129, analog/basic/mos_r2r_dac.hpp:31
        I(cpphdl_n1219, cpphdl_n1220) <+ V(cpphdl_n1219, cpphdl_n1220) / 1000.0;
        // device 811, IC IC136, analog/basic/inverter.hpp:11
        I(cpphdl_n1210, Vdd) <+ cpphdl_channel(V(BIT_N5_6, Vdd), V(cpphdl_n1210, Vdd), 0.080000000000000002, 0.69999999999999996, -1.0);
        // device 812, IC IC136, analog/basic/inverter.hpp:12
        I(cpphdl_n1210, Vss) <+ cpphdl_channel(V(BIT_N5_6, Vss), V(cpphdl_n1210, Vss), 0.080000000000000002, 0.69999999999999996, 1.0);
        // device 813, IC IC129, analog/basic/mos_r2r_dac.hpp:27
        I(cpphdl_n1210, Vss) <+ 2.9999999999999998e-15 * ddt(V(cpphdl_n1210, Vss)); // Bench initial voltage = 0.0 V.
        // device 814, IC IC129, analog/basic/mos_r2r_dac.hpp:28
        I(cpphdl_n1210, cpphdl_n1221) <+ V(cpphdl_n1210, cpphdl_n1221) / 2000.0;
        // device 815, IC IC129, analog/basic/mos_r2r_dac.hpp:29
        I(cpphdl_n1221, Vss) <+ 2.9999999999999998e-15 * ddt(V(cpphdl_n1221, Vss)); // Bench initial voltage = 0.0 V.
        // device 816, IC IC129, analog/basic/mos_r2r_dac.hpp:31
        I(cpphdl_n1220, cpphdl_n1221) <+ V(cpphdl_n1220, cpphdl_n1221) / 1000.0;
        // device 817, IC IC137, analog/basic/inverter.hpp:11
        I(cpphdl_n1214, Vdd) <+ cpphdl_channel(V(BIT_N5_7, Vdd), V(cpphdl_n1214, Vdd), 0.080000000000000002, 0.69999999999999996, -1.0);
        // device 818, IC IC137, analog/basic/inverter.hpp:12
        I(cpphdl_n1214, Vss) <+ cpphdl_channel(V(BIT_N5_7, Vss), V(cpphdl_n1214, Vss), 0.080000000000000002, 0.69999999999999996, 1.0);
        // device 819, IC IC129, analog/basic/mos_r2r_dac.hpp:27
        I(cpphdl_n1214, Vss) <+ 2.9999999999999998e-15 * ddt(V(cpphdl_n1214, Vss)); // Bench initial voltage = 0.0 V.
        // device 820, IC IC129, analog/basic/mos_r2r_dac.hpp:28
        I(cpphdl_n1214, cpphdl_n1226) <+ V(cpphdl_n1214, cpphdl_n1226) / 2000.0;
        // device 821, IC IC129, analog/basic/mos_r2r_dac.hpp:29
        I(cpphdl_n1226, Vss) <+ 2.9999999999999998e-15 * ddt(V(cpphdl_n1226, Vss)); // Bench initial voltage = 0.0 V.
        // device 822, IC IC129, analog/basic/mos_r2r_dac.hpp:31
        I(cpphdl_n1221, cpphdl_n1226) <+ V(cpphdl_n1221, cpphdl_n1226) / 1000.0;
        // device 823, IC IC129, analog/basic/mos_r2r_dac.hpp:33
        I(Vss, cpphdl_n1215) <+ V(Vss, cpphdl_n1215) / 2000.0;
        // device 824, IC IC138, analog/basic/nmos_resistor_amplifier.hpp:23
        I(Vdd, cpphdl_n1235) <+ V(Vdd, cpphdl_n1235) / 500.0;
        // device 825, IC IC138, analog/basic/nmos_resistor_amplifier.hpp:24
        I(Vdd, cpphdl_n1234) <+ V(Vdd, cpphdl_n1234) / 500.0;
        // device 826, IC IC138, analog/basic/nmos_resistor_amplifier.hpp:25
        I(cpphdl_n1235, cpphdl_n1229) <+ cpphdl_channel(V(cpphdl_n1225, cpphdl_n1229), V(cpphdl_n1235, cpphdl_n1229), 0.014999999999999999, 0.69999999999999996, 1.0);
        // device 827, IC IC138, analog/basic/nmos_resistor_amplifier.hpp:26
        I(cpphdl_n1234, cpphdl_n1230) <+ cpphdl_channel(V(cpphdl_n1226, cpphdl_n1230), V(cpphdl_n1234, cpphdl_n1230), 0.014999999999999999, 0.69999999999999996, 1.0);
        // device 828, IC IC138, analog/basic/nmos_resistor_amplifier.hpp:27
        I(cpphdl_n1231, cpphdl_n1229) <+ V(cpphdl_n1231, cpphdl_n1229) / 50.0;
        // device 829, IC IC138, analog/basic/nmos_resistor_amplifier.hpp:28
        I(cpphdl_n1231, cpphdl_n1230) <+ V(cpphdl_n1231, cpphdl_n1230) / 50.0;
        // device 830, IC IC138, analog/basic/nmos_resistor_amplifier.hpp:29
        I(Vss, cpphdl_n1231) <+ V(Vss, cpphdl_n1231) / 150.0;
        // device 831, IC IC138, analog/basic/nmos_resistor_amplifier.hpp:30
        I(cpphdl_n1235, Vdd) <+ 2.9999999999999998e-13 * ddt(V(cpphdl_n1235, Vdd)); // Bench initial voltage = 0.0 V.
        // device 832, IC IC138, analog/basic/nmos_resistor_amplifier.hpp:31
        I(cpphdl_n1234, Vdd) <+ 2.9999999999999998e-13 * ddt(V(cpphdl_n1234, Vdd)); // Bench initial voltage = 0.0 V.
        // device 833, IC IC138, analog/basic/nmos_resistor_amplifier.hpp:32
        I(cpphdl_n1231, Vss) <+ 4e-14 * ddt(V(cpphdl_n1231, Vss)); // Bench initial voltage = 0.0 V.
        // device 834, IC IC138, analog/basic/nmos_resistor_amplifier.hpp:34
        I(cpphdl_n1225, cpphdl_n1229) <+ 2e-14 * ddt(V(cpphdl_n1225, cpphdl_n1229)); // Bench initial voltage = 1.6499999999999999 V.
        // device 835, IC IC138, analog/basic/nmos_resistor_amplifier.hpp:35
        I(cpphdl_n1226, cpphdl_n1230) <+ 2e-14 * ddt(V(cpphdl_n1226, cpphdl_n1230)); // Bench initial voltage = 0.0 V.
        // device 836, IC IC138, analog/basic/nmos_resistor_amplifier.hpp:36
        I(cpphdl_n1225, cpphdl_n1235) <+ 2.9999999999999998e-15 * ddt(V(cpphdl_n1225, cpphdl_n1235)); // Bench initial voltage = -1.6499999999999999 V.
        // device 837, IC IC138, analog/basic/nmos_resistor_amplifier.hpp:37
        I(cpphdl_n1226, cpphdl_n1234) <+ 2.9999999999999998e-15 * ddt(V(cpphdl_n1226, cpphdl_n1234)); // Bench initial voltage = -3.2999999999999998 V.
        // device 838, IC IC139, analog/basic/strongarm_comparator.hpp:28
        I(cpphdl_n1239, cpphdl_n1241) <+ cpphdl_channel(V(cpphdl_n1234, cpphdl_n1241), V(cpphdl_n1239, cpphdl_n1241), 0.0080000000000000002, 0.69999999999999996, 1.0);
        // device 839, IC IC139, analog/basic/strongarm_comparator.hpp:29
        I(cpphdl_n1240, cpphdl_n1241) <+ cpphdl_channel(V(cpphdl_n1235, cpphdl_n1241), V(cpphdl_n1240, cpphdl_n1241), 0.0080000000000000002, 0.69999999999999996, 1.0);
        // device 840, IC IC139, analog/basic/strongarm_comparator.hpp:30
        I(cpphdl_n1241, Vss) <+ cpphdl_channel(V(EVALUATE, Vss), V(cpphdl_n1241, Vss), 0.0080000000000000002, 0.69999999999999996, 1.0);
        // device 841, IC IC139, analog/basic/strongarm_comparator.hpp:33
        I(cpphdl_n1254, cpphdl_n1239) <+ cpphdl_channel(V(cpphdl_n1258, cpphdl_n1239), V(cpphdl_n1254, cpphdl_n1239), 0.0040000000000000001, 0.69999999999999996, 1.0);
        // device 842, IC IC139, analog/basic/strongarm_comparator.hpp:34
        I(cpphdl_n1258, cpphdl_n1240) <+ cpphdl_channel(V(cpphdl_n1254, cpphdl_n1240), V(cpphdl_n1258, cpphdl_n1240), 0.0040000000000000001, 0.69999999999999996, 1.0);
        // device 843, IC IC139, analog/basic/strongarm_comparator.hpp:35
        I(cpphdl_n1258, Vdd) <+ cpphdl_channel(V(cpphdl_n1254, Vdd), V(cpphdl_n1258, Vdd), 0.002, 0.69999999999999996, -1.0);
        // device 844, IC IC139, analog/basic/strongarm_comparator.hpp:36
        I(cpphdl_n1254, Vdd) <+ cpphdl_channel(V(cpphdl_n1258, Vdd), V(cpphdl_n1254, Vdd), 0.002, 0.69999999999999996, -1.0);
        // device 845, IC IC139, analog/basic/strongarm_comparator.hpp:38
        I(cpphdl_n1239, Vdd) <+ cpphdl_channel(V(EVALUATE, Vdd), V(cpphdl_n1239, Vdd), 0.002, 0.69999999999999996, -1.0);
        // device 846, IC IC139, analog/basic/strongarm_comparator.hpp:39
        I(cpphdl_n1240, Vdd) <+ cpphdl_channel(V(EVALUATE, Vdd), V(cpphdl_n1240, Vdd), 0.002, 0.69999999999999996, -1.0);
        // device 847, IC IC139, analog/basic/strongarm_comparator.hpp:40
        I(cpphdl_n1258, Vdd) <+ cpphdl_channel(V(EVALUATE, Vdd), V(cpphdl_n1258, Vdd), 0.002, 0.69999999999999996, -1.0);
        // device 848, IC IC139, analog/basic/strongarm_comparator.hpp:41
        I(cpphdl_n1254, Vdd) <+ cpphdl_channel(V(EVALUATE, Vdd), V(cpphdl_n1254, Vdd), 0.002, 0.69999999999999996, -1.0);
        // device 849, IC IC139, analog/basic/strongarm_comparator.hpp:42
        I(cpphdl_n1239, Vss) <+ 2.9999999999999998e-14 * ddt(V(cpphdl_n1239, Vss)); // Bench initial voltage = 0.0 V.
        // device 850, IC IC139, analog/basic/strongarm_comparator.hpp:43
        I(cpphdl_n1240, Vss) <+ 2.9999999999999998e-14 * ddt(V(cpphdl_n1240, Vss)); // Bench initial voltage = 0.0 V.
        // device 851, IC IC139, analog/basic/strongarm_comparator.hpp:44
        I(cpphdl_n1241, Vss) <+ 2.9999999999999998e-14 * ddt(V(cpphdl_n1241, Vss)); // Bench initial voltage = 0.0 V.
        // device 852, IC IC139, analog/basic/strongarm_comparator.hpp:45
        I(cpphdl_n1258, Vss) <+ 5.0000000000000002e-14 * ddt(V(cpphdl_n1258, Vss)); // Bench initial voltage = 0.0 V.
        // device 853, IC IC139, analog/basic/strongarm_comparator.hpp:46
        I(cpphdl_n1254, Vss) <+ 5.0000000000000002e-14 * ddt(V(cpphdl_n1254, Vss)); // Bench initial voltage = 0.0 V.
        // device 854, IC IC139, analog/basic/strongarm_comparator.hpp:47
        I(cpphdl_n1234, cpphdl_n1241) <+ 2e-14 * ddt(V(cpphdl_n1234, cpphdl_n1241)); // Bench initial voltage = 3.2999999999999998 V.
        // device 855, IC IC139, analog/basic/strongarm_comparator.hpp:48
        I(cpphdl_n1235, cpphdl_n1241) <+ 2e-14 * ddt(V(cpphdl_n1235, cpphdl_n1241)); // Bench initial voltage = 3.2999999999999998 V.
        // device 856, IC IC139, analog/basic/strongarm_comparator.hpp:49
        I(cpphdl_n1234, cpphdl_n1239) <+ 2.9999999999999998e-15 * ddt(V(cpphdl_n1234, cpphdl_n1239)); // Bench initial voltage = 3.2999999999999998 V.
        // device 857, IC IC139, analog/basic/strongarm_comparator.hpp:50
        I(cpphdl_n1235, cpphdl_n1240) <+ 2.9999999999999998e-15 * ddt(V(cpphdl_n1235, cpphdl_n1240)); // Bench initial voltage = 3.2999999999999998 V.
        // device 858, IC IC141, analog/basic/inverter.hpp:11
        I(cpphdl_n1262, Vdd) <+ cpphdl_channel(V(cpphdl_n1254, Vdd), V(cpphdl_n1262, Vdd), 0.001, 0.69999999999999996, -1.0);
        // device 859, IC IC141, analog/basic/inverter.hpp:12
        I(cpphdl_n1262, Vss) <+ cpphdl_channel(V(cpphdl_n1254, Vss), V(cpphdl_n1262, Vss), 0.001, 0.69999999999999996, 1.0);
        // device 860, IC IC143, analog/basic/inverter.hpp:11
        I(cpphdl_n1276, Vdd) <+ cpphdl_channel(V(cpphdl_n1262, Vdd), V(cpphdl_n1276, Vdd), 0.0040000000000000001, 0.69999999999999996, -1.0);
        // device 861, IC IC143, analog/basic/inverter.hpp:12
        I(cpphdl_n1276, Vss) <+ cpphdl_channel(V(cpphdl_n1262, Vss), V(cpphdl_n1276, Vss), 0.0040000000000000001, 0.69999999999999996, 1.0);
        // device 862, IC IC140, analog/basic/buffered_nand_latch.hpp:33
        I(cpphdl_n1254, Vss) <+ 2.0000000000000002e-15 * ddt(V(cpphdl_n1254, Vss)); // Bench initial voltage = 0.0 V.
        // device 863, IC IC140, analog/basic/buffered_nand_latch.hpp:34
        I(cpphdl_n1254, cpphdl_n1262) <+ 1.0000000000000001e-15 * ddt(V(cpphdl_n1254, cpphdl_n1262)); // Bench initial voltage = 0.0 V.
        // device 864, IC IC140, analog/basic/buffered_nand_latch.hpp:35
        I(cpphdl_n1262, Vss) <+ 5e-15 * ddt(V(cpphdl_n1262, Vss)); // Bench initial voltage = 0.0 V.
        // device 865, IC IC140, analog/basic/buffered_nand_latch.hpp:36
        I(cpphdl_n1262, Vss) <+ 8.0000000000000006e-15 * ddt(V(cpphdl_n1262, Vss)); // Bench initial voltage = 0.0 V.
        // device 866, IC IC140, analog/basic/buffered_nand_latch.hpp:37
        I(cpphdl_n1276, Vss) <+ 1e-14 * ddt(V(cpphdl_n1276, Vss)); // Bench initial voltage = 0.0 V.
        // device 867, IC IC142, analog/basic/inverter.hpp:11
        I(cpphdl_n1266, Vdd) <+ cpphdl_channel(V(cpphdl_n1258, Vdd), V(cpphdl_n1266, Vdd), 0.001, 0.69999999999999996, -1.0);
        // device 868, IC IC142, analog/basic/inverter.hpp:12
        I(cpphdl_n1266, Vss) <+ cpphdl_channel(V(cpphdl_n1258, Vss), V(cpphdl_n1266, Vss), 0.001, 0.69999999999999996, 1.0);
        // device 869, IC IC144, analog/basic/inverter.hpp:11
        I(cpphdl_n1282, Vdd) <+ cpphdl_channel(V(cpphdl_n1266, Vdd), V(cpphdl_n1282, Vdd), 0.0040000000000000001, 0.69999999999999996, -1.0);
        // device 870, IC IC144, analog/basic/inverter.hpp:12
        I(cpphdl_n1282, Vss) <+ cpphdl_channel(V(cpphdl_n1266, Vss), V(cpphdl_n1282, Vss), 0.0040000000000000001, 0.69999999999999996, 1.0);
        // device 871, IC IC140, analog/basic/buffered_nand_latch.hpp:33
        I(cpphdl_n1258, Vss) <+ 2.0000000000000002e-15 * ddt(V(cpphdl_n1258, Vss)); // Bench initial voltage = 0.0 V.
        // device 872, IC IC140, analog/basic/buffered_nand_latch.hpp:34
        I(cpphdl_n1258, cpphdl_n1266) <+ 1.0000000000000001e-15 * ddt(V(cpphdl_n1258, cpphdl_n1266)); // Bench initial voltage = 0.0 V.
        // device 873, IC IC140, analog/basic/buffered_nand_latch.hpp:35
        I(cpphdl_n1266, Vss) <+ 5e-15 * ddt(V(cpphdl_n1266, Vss)); // Bench initial voltage = 0.0 V.
        // device 874, IC IC140, analog/basic/buffered_nand_latch.hpp:36
        I(cpphdl_n1266, Vss) <+ 8.0000000000000006e-15 * ddt(V(cpphdl_n1266, Vss)); // Bench initial voltage = 0.0 V.
        // device 875, IC IC140, analog/basic/buffered_nand_latch.hpp:37
        I(cpphdl_n1282, Vss) <+ 1e-14 * ddt(V(cpphdl_n1282, Vss)); // Bench initial voltage = 0.0 V.
        // device 876, IC IC146, analog/basic/cmos_logic.hpp:15
        I(cpphdl_n2765, Vss) <+ 5.0000000000000002e-14 * ddt(V(cpphdl_n2765, Vss)); // Bench initial voltage = 0.0 V.
        // device 877, IC IC146, analog/basic/cmos_logic.hpp:16
        I(cpphdl_n2765, Vdd) <+ cpphdl_channel(V(cpphdl_n1276, Vdd), V(cpphdl_n2765, Vdd), 0.01, 0.69999999999999996, -1.0);
        // device 878, IC IC146, analog/basic/cmos_logic.hpp:17
        I(cpphdl_n2765, Vdd) <+ cpphdl_channel(V(cpphdl_n1284, Vdd), V(cpphdl_n2765, Vdd), 0.01, 0.69999999999999996, -1.0);
        // device 879, IC IC146, analog/basic/cmos_logic.hpp:18
        I(cpphdl_n2765, cpphdl_n1279) <+ cpphdl_channel(V(cpphdl_n1276, cpphdl_n1279), V(cpphdl_n2765, cpphdl_n1279), 0.01, 0.69999999999999996, 1.0);
        // device 880, IC IC146, analog/basic/cmos_logic.hpp:19
        I(cpphdl_n1279, Vss) <+ cpphdl_channel(V(cpphdl_n1284, Vss), V(cpphdl_n1279, Vss), 0.01, 0.69999999999999996, 1.0);
        // device 881, IC IC146, analog/basic/cmos_logic.hpp:20
        I(cpphdl_n2765, Vss) <+ V(cpphdl_n2765, Vss) / 1000000000.0;
        // device 882, IC IC146, analog/basic/cmos_logic.hpp:21
        I(cpphdl_n1279, Vss) <+ V(cpphdl_n1279, Vss) / 1000000000.0;
        // device 883, IC IC147, analog/basic/cmos_logic.hpp:15
        I(cpphdl_n1284, Vss) <+ 5.0000000000000002e-14 * ddt(V(cpphdl_n1284, Vss)); // Bench initial voltage = 0.0 V.
        // device 884, IC IC147, analog/basic/cmos_logic.hpp:16
        I(cpphdl_n1284, Vdd) <+ cpphdl_channel(V(cpphdl_n1282, Vdd), V(cpphdl_n1284, Vdd), 0.01, 0.69999999999999996, -1.0);
        // device 885, IC IC147, analog/basic/cmos_logic.hpp:17
        I(cpphdl_n1284, Vdd) <+ cpphdl_channel(V(cpphdl_n2765, Vdd), V(cpphdl_n1284, Vdd), 0.01, 0.69999999999999996, -1.0);
        // device 886, IC IC147, analog/basic/cmos_logic.hpp:18
        I(cpphdl_n1284, cpphdl_n1285) <+ cpphdl_channel(V(cpphdl_n1282, cpphdl_n1285), V(cpphdl_n1284, cpphdl_n1285), 0.01, 0.69999999999999996, 1.0);
        // device 887, IC IC147, analog/basic/cmos_logic.hpp:19
        I(cpphdl_n1285, Vss) <+ cpphdl_channel(V(cpphdl_n2765, Vss), V(cpphdl_n1285, Vss), 0.01, 0.69999999999999996, 1.0);
        // device 888, IC IC147, analog/basic/cmos_logic.hpp:20
        I(cpphdl_n1284, Vss) <+ V(cpphdl_n1284, Vss) / 1000000000.0;
        // device 889, IC IC147, analog/basic/cmos_logic.hpp:21
        I(cpphdl_n1285, Vss) <+ V(cpphdl_n1285, Vss) / 1000000000.0;
        // device 890, IC IC145, analog/basic/nand_latch.hpp:34
        I(cpphdl_n1276, Vss) <+ 2.9999999999999998e-15 * ddt(V(cpphdl_n1276, Vss)); // Bench initial voltage = 0.0 V.
        // device 891, IC IC145, analog/basic/nand_latch.hpp:35
        I(cpphdl_n1282, Vss) <+ 2.9999999999999998e-15 * ddt(V(cpphdl_n1282, Vss)); // Bench initial voltage = 0.0 V.
        // device 892, IC IC148, analog/basic/inverter.hpp:11
        I(cpphdl_n1290, Vdd) <+ cpphdl_channel(V(CLEAR, Vdd), V(cpphdl_n1290, Vdd), 0.01, 0.69999999999999996, -1.0);
        // device 893, IC IC148, analog/basic/inverter.hpp:12
        I(cpphdl_n1290, Vss) <+ cpphdl_channel(V(CLEAR, Vss), V(cpphdl_n1290, Vss), 0.01, 0.69999999999999996, 1.0);
        // device 894, IC IC145, analog/basic/nand_latch.hpp:56
        I(cpphdl_n1290, Vss) <+ 2.9999999999999998e-15 * ddt(V(cpphdl_n1290, Vss)); // Bench initial voltage = 0.0 V.
        // device 895, IC IC145, analog/basic/nand_latch.hpp:57
        I(cpphdl_n2765, Vss) <+ cpphdl_channel(V(CLEAR, Vss), V(cpphdl_n2765, Vss), 0.050000000000000003, 0.69999999999999996, 1.0);
        // device 896, IC IC145, analog/basic/nand_latch.hpp:58
        I(cpphdl_n1284, Vdd) <+ cpphdl_channel(V(cpphdl_n1290, Vdd), V(cpphdl_n1284, Vdd), 0.050000000000000003, 0.69999999999999996, -1.0);
        // device 897, IC IC151, analog/basic/inverter.hpp:11
        I(cpphdl_n1314, Vdd) <+ cpphdl_channel(V(TRACK6, Vdd), V(cpphdl_n1314, Vdd), 0.0040000000000000001, 0.69999999999999996, -1.0);
        // device 898, IC IC151, analog/basic/inverter.hpp:12
        I(cpphdl_n1314, Vss) <+ cpphdl_channel(V(TRACK6, Vss), V(cpphdl_n1314, Vss), 0.0040000000000000001, 0.69999999999999996, 1.0);
        // device 899, IC IC150, analog/basic/mos_track_hold.hpp:30
        I(cpphdl_n1314, Vss) <+ 2e-14 * ddt(V(cpphdl_n1314, Vss)); // Bench initial voltage = 3.2999999999999998 V.
        // device 900, IC IC150, analog/basic/mos_track_hold.hpp:31
        I(cpphdl_n2595, cpphdl_n1368) <+ cpphdl_channel(V(TRACK6, cpphdl_n1368), V(cpphdl_n2595, cpphdl_n1368), 0.02, 0.69999999999999996, 1.0);
        // device 901, IC IC150, analog/basic/mos_track_hold.hpp:32
        I(cpphdl_n1368, cpphdl_n2595) <+ cpphdl_channel(V(cpphdl_n1314, cpphdl_n2595), V(cpphdl_n1368, cpphdl_n2595), 0.01, 0.69999999999999996, -1.0);
        // device 902, IC IC150, analog/basic/mos_track_hold.hpp:36
        I(cpphdl_n1368, cpphdl_n1368) <+ cpphdl_channel(V(cpphdl_n1314, cpphdl_n1368), V(cpphdl_n1368, cpphdl_n1368), 0.01, 0.69999999999999996, 1.0);
        // device 903, IC IC150, analog/basic/mos_track_hold.hpp:37
        I(cpphdl_n1368, cpphdl_n1368) <+ cpphdl_channel(V(TRACK6, cpphdl_n1368), V(cpphdl_n1368, cpphdl_n1368), 0.0050000000000000001, 0.69999999999999996, -1.0);
        // device 904, IC IC150, analog/basic/mos_track_hold.hpp:38
        I(cpphdl_n1368, Vss) <+ 1.5000000000000001e-12 * ddt(V(cpphdl_n1368, Vss)); // Bench initial voltage = 1.6499999999999999 V.
        // device 905, IC IC150, analog/basic/mos_track_hold.hpp:39
        I(Vss, cpphdl_n1368) <+ V(Vss, cpphdl_n1368) / 1000000000.0;
        // device 906, IC IC150, analog/basic/mos_track_hold.hpp:40
        I(TRACK6, cpphdl_n1368) <+ 2.0000000000000002e-15 * ddt(V(TRACK6, cpphdl_n1368)); // Bench initial voltage = -1.6499999999999999 V.
        // device 907, IC IC150, analog/basic/mos_track_hold.hpp:41
        I(cpphdl_n1314, cpphdl_n1368) <+ 2.0000000000000002e-15 * ddt(V(cpphdl_n1314, cpphdl_n1368)); // Bench initial voltage = 1.6499999999999999 V.
        // device 908, IC IC150, analog/basic/mos_track_hold.hpp:42
        I(cpphdl_n2595, cpphdl_n1368) <+ 1.0000000000000001e-15 * ddt(V(cpphdl_n2595, cpphdl_n1368)); // Bench initial voltage = 0.0 V.
        // device 909, IC IC153, analog/basic/inverter.hpp:11
        I(cpphdl_n1329, Vdd) <+ cpphdl_channel(V(BIT_N6_0, Vdd), V(cpphdl_n1329, Vdd), 0.080000000000000002, 0.69999999999999996, -1.0);
        // device 910, IC IC153, analog/basic/inverter.hpp:12
        I(cpphdl_n1329, Vss) <+ cpphdl_channel(V(BIT_N6_0, Vss), V(cpphdl_n1329, Vss), 0.080000000000000002, 0.69999999999999996, 1.0);
        // device 911, IC IC152, analog/basic/mos_r2r_dac.hpp:27
        I(cpphdl_n1329, Vss) <+ 2.9999999999999998e-15 * ddt(V(cpphdl_n1329, Vss)); // Bench initial voltage = 0.0 V.
        // device 912, IC IC152, analog/basic/mos_r2r_dac.hpp:28
        I(cpphdl_n1329, cpphdl_n1358) <+ V(cpphdl_n1329, cpphdl_n1358) / 2000.0;
        // device 913, IC IC152, analog/basic/mos_r2r_dac.hpp:29
        I(cpphdl_n1358, Vss) <+ 2.9999999999999998e-15 * ddt(V(cpphdl_n1358, Vss)); // Bench initial voltage = 0.0 V.
        // device 914, IC IC154, analog/basic/inverter.hpp:11
        I(cpphdl_n1333, Vdd) <+ cpphdl_channel(V(BIT_N6_1, Vdd), V(cpphdl_n1333, Vdd), 0.080000000000000002, 0.69999999999999996, -1.0);
        // device 915, IC IC154, analog/basic/inverter.hpp:12
        I(cpphdl_n1333, Vss) <+ cpphdl_channel(V(BIT_N6_1, Vss), V(cpphdl_n1333, Vss), 0.080000000000000002, 0.69999999999999996, 1.0);
        // device 916, IC IC152, analog/basic/mos_r2r_dac.hpp:27
        I(cpphdl_n1333, Vss) <+ 2.9999999999999998e-15 * ddt(V(cpphdl_n1333, Vss)); // Bench initial voltage = 0.0 V.
        // device 917, IC IC152, analog/basic/mos_r2r_dac.hpp:28
        I(cpphdl_n1333, cpphdl_n1359) <+ V(cpphdl_n1333, cpphdl_n1359) / 2000.0;
        // device 918, IC IC152, analog/basic/mos_r2r_dac.hpp:29
        I(cpphdl_n1359, Vss) <+ 2.9999999999999998e-15 * ddt(V(cpphdl_n1359, Vss)); // Bench initial voltage = 0.0 V.
        // device 919, IC IC152, analog/basic/mos_r2r_dac.hpp:31
        I(cpphdl_n1358, cpphdl_n1359) <+ V(cpphdl_n1358, cpphdl_n1359) / 1000.0;
        // device 920, IC IC155, analog/basic/inverter.hpp:11
        I(cpphdl_n1337, Vdd) <+ cpphdl_channel(V(BIT_N6_2, Vdd), V(cpphdl_n1337, Vdd), 0.080000000000000002, 0.69999999999999996, -1.0);
        // device 921, IC IC155, analog/basic/inverter.hpp:12
        I(cpphdl_n1337, Vss) <+ cpphdl_channel(V(BIT_N6_2, Vss), V(cpphdl_n1337, Vss), 0.080000000000000002, 0.69999999999999996, 1.0);
        // device 922, IC IC152, analog/basic/mos_r2r_dac.hpp:27
        I(cpphdl_n1337, Vss) <+ 2.9999999999999998e-15 * ddt(V(cpphdl_n1337, Vss)); // Bench initial voltage = 0.0 V.
        // device 923, IC IC152, analog/basic/mos_r2r_dac.hpp:28
        I(cpphdl_n1337, cpphdl_n1360) <+ V(cpphdl_n1337, cpphdl_n1360) / 2000.0;
        // device 924, IC IC152, analog/basic/mos_r2r_dac.hpp:29
        I(cpphdl_n1360, Vss) <+ 2.9999999999999998e-15 * ddt(V(cpphdl_n1360, Vss)); // Bench initial voltage = 0.0 V.
        // device 925, IC IC152, analog/basic/mos_r2r_dac.hpp:31
        I(cpphdl_n1359, cpphdl_n1360) <+ V(cpphdl_n1359, cpphdl_n1360) / 1000.0;
        // device 926, IC IC156, analog/basic/inverter.hpp:11
        I(cpphdl_n1341, Vdd) <+ cpphdl_channel(V(BIT_N6_3, Vdd), V(cpphdl_n1341, Vdd), 0.080000000000000002, 0.69999999999999996, -1.0);
        // device 927, IC IC156, analog/basic/inverter.hpp:12
        I(cpphdl_n1341, Vss) <+ cpphdl_channel(V(BIT_N6_3, Vss), V(cpphdl_n1341, Vss), 0.080000000000000002, 0.69999999999999996, 1.0);
        // device 928, IC IC152, analog/basic/mos_r2r_dac.hpp:27
        I(cpphdl_n1341, Vss) <+ 2.9999999999999998e-15 * ddt(V(cpphdl_n1341, Vss)); // Bench initial voltage = 0.0 V.
        // device 929, IC IC152, analog/basic/mos_r2r_dac.hpp:28
        I(cpphdl_n1341, cpphdl_n1361) <+ V(cpphdl_n1341, cpphdl_n1361) / 2000.0;
        // device 930, IC IC152, analog/basic/mos_r2r_dac.hpp:29
        I(cpphdl_n1361, Vss) <+ 2.9999999999999998e-15 * ddt(V(cpphdl_n1361, Vss)); // Bench initial voltage = 0.0 V.
        // device 931, IC IC152, analog/basic/mos_r2r_dac.hpp:31
        I(cpphdl_n1360, cpphdl_n1361) <+ V(cpphdl_n1360, cpphdl_n1361) / 1000.0;
        // device 932, IC IC157, analog/basic/inverter.hpp:11
        I(cpphdl_n1345, Vdd) <+ cpphdl_channel(V(BIT_N6_4, Vdd), V(cpphdl_n1345, Vdd), 0.080000000000000002, 0.69999999999999996, -1.0);
        // device 933, IC IC157, analog/basic/inverter.hpp:12
        I(cpphdl_n1345, Vss) <+ cpphdl_channel(V(BIT_N6_4, Vss), V(cpphdl_n1345, Vss), 0.080000000000000002, 0.69999999999999996, 1.0);
        // device 934, IC IC152, analog/basic/mos_r2r_dac.hpp:27
        I(cpphdl_n1345, Vss) <+ 2.9999999999999998e-15 * ddt(V(cpphdl_n1345, Vss)); // Bench initial voltage = 0.0 V.
        // device 935, IC IC152, analog/basic/mos_r2r_dac.hpp:28
        I(cpphdl_n1345, cpphdl_n1362) <+ V(cpphdl_n1345, cpphdl_n1362) / 2000.0;
        // device 936, IC IC152, analog/basic/mos_r2r_dac.hpp:29
        I(cpphdl_n1362, Vss) <+ 2.9999999999999998e-15 * ddt(V(cpphdl_n1362, Vss)); // Bench initial voltage = 0.0 V.
        // device 937, IC IC152, analog/basic/mos_r2r_dac.hpp:31
        I(cpphdl_n1361, cpphdl_n1362) <+ V(cpphdl_n1361, cpphdl_n1362) / 1000.0;
        // device 938, IC IC158, analog/basic/inverter.hpp:11
        I(cpphdl_n1349, Vdd) <+ cpphdl_channel(V(BIT_N6_5, Vdd), V(cpphdl_n1349, Vdd), 0.080000000000000002, 0.69999999999999996, -1.0);
        // device 939, IC IC158, analog/basic/inverter.hpp:12
        I(cpphdl_n1349, Vss) <+ cpphdl_channel(V(BIT_N6_5, Vss), V(cpphdl_n1349, Vss), 0.080000000000000002, 0.69999999999999996, 1.0);
        // device 940, IC IC152, analog/basic/mos_r2r_dac.hpp:27
        I(cpphdl_n1349, Vss) <+ 2.9999999999999998e-15 * ddt(V(cpphdl_n1349, Vss)); // Bench initial voltage = 0.0 V.
        // device 941, IC IC152, analog/basic/mos_r2r_dac.hpp:28
        I(cpphdl_n1349, cpphdl_n1363) <+ V(cpphdl_n1349, cpphdl_n1363) / 2000.0;
        // device 942, IC IC152, analog/basic/mos_r2r_dac.hpp:29
        I(cpphdl_n1363, Vss) <+ 2.9999999999999998e-15 * ddt(V(cpphdl_n1363, Vss)); // Bench initial voltage = 0.0 V.
        // device 943, IC IC152, analog/basic/mos_r2r_dac.hpp:31
        I(cpphdl_n1362, cpphdl_n1363) <+ V(cpphdl_n1362, cpphdl_n1363) / 1000.0;
        // device 944, IC IC159, analog/basic/inverter.hpp:11
        I(cpphdl_n1353, Vdd) <+ cpphdl_channel(V(BIT_N6_6, Vdd), V(cpphdl_n1353, Vdd), 0.080000000000000002, 0.69999999999999996, -1.0);
        // device 945, IC IC159, analog/basic/inverter.hpp:12
        I(cpphdl_n1353, Vss) <+ cpphdl_channel(V(BIT_N6_6, Vss), V(cpphdl_n1353, Vss), 0.080000000000000002, 0.69999999999999996, 1.0);
        // device 946, IC IC152, analog/basic/mos_r2r_dac.hpp:27
        I(cpphdl_n1353, Vss) <+ 2.9999999999999998e-15 * ddt(V(cpphdl_n1353, Vss)); // Bench initial voltage = 0.0 V.
        // device 947, IC IC152, analog/basic/mos_r2r_dac.hpp:28
        I(cpphdl_n1353, cpphdl_n1364) <+ V(cpphdl_n1353, cpphdl_n1364) / 2000.0;
        // device 948, IC IC152, analog/basic/mos_r2r_dac.hpp:29
        I(cpphdl_n1364, Vss) <+ 2.9999999999999998e-15 * ddt(V(cpphdl_n1364, Vss)); // Bench initial voltage = 0.0 V.
        // device 949, IC IC152, analog/basic/mos_r2r_dac.hpp:31
        I(cpphdl_n1363, cpphdl_n1364) <+ V(cpphdl_n1363, cpphdl_n1364) / 1000.0;
        // device 950, IC IC160, analog/basic/inverter.hpp:11
        I(cpphdl_n1357, Vdd) <+ cpphdl_channel(V(BIT_N6_7, Vdd), V(cpphdl_n1357, Vdd), 0.080000000000000002, 0.69999999999999996, -1.0);
        // device 951, IC IC160, analog/basic/inverter.hpp:12
        I(cpphdl_n1357, Vss) <+ cpphdl_channel(V(BIT_N6_7, Vss), V(cpphdl_n1357, Vss), 0.080000000000000002, 0.69999999999999996, 1.0);
        // device 952, IC IC152, analog/basic/mos_r2r_dac.hpp:27
        I(cpphdl_n1357, Vss) <+ 2.9999999999999998e-15 * ddt(V(cpphdl_n1357, Vss)); // Bench initial voltage = 0.0 V.
        // device 953, IC IC152, analog/basic/mos_r2r_dac.hpp:28
        I(cpphdl_n1357, cpphdl_n1369) <+ V(cpphdl_n1357, cpphdl_n1369) / 2000.0;
        // device 954, IC IC152, analog/basic/mos_r2r_dac.hpp:29
        I(cpphdl_n1369, Vss) <+ 2.9999999999999998e-15 * ddt(V(cpphdl_n1369, Vss)); // Bench initial voltage = 0.0 V.
        // device 955, IC IC152, analog/basic/mos_r2r_dac.hpp:31
        I(cpphdl_n1364, cpphdl_n1369) <+ V(cpphdl_n1364, cpphdl_n1369) / 1000.0;
        // device 956, IC IC152, analog/basic/mos_r2r_dac.hpp:33
        I(Vss, cpphdl_n1358) <+ V(Vss, cpphdl_n1358) / 2000.0;
        // device 957, IC IC161, analog/basic/nmos_resistor_amplifier.hpp:23
        I(Vdd, cpphdl_n1378) <+ V(Vdd, cpphdl_n1378) / 500.0;
        // device 958, IC IC161, analog/basic/nmos_resistor_amplifier.hpp:24
        I(Vdd, cpphdl_n1377) <+ V(Vdd, cpphdl_n1377) / 500.0;
        // device 959, IC IC161, analog/basic/nmos_resistor_amplifier.hpp:25
        I(cpphdl_n1378, cpphdl_n1372) <+ cpphdl_channel(V(cpphdl_n1368, cpphdl_n1372), V(cpphdl_n1378, cpphdl_n1372), 0.014999999999999999, 0.69999999999999996, 1.0);
        // device 960, IC IC161, analog/basic/nmos_resistor_amplifier.hpp:26
        I(cpphdl_n1377, cpphdl_n1373) <+ cpphdl_channel(V(cpphdl_n1369, cpphdl_n1373), V(cpphdl_n1377, cpphdl_n1373), 0.014999999999999999, 0.69999999999999996, 1.0);
        // device 961, IC IC161, analog/basic/nmos_resistor_amplifier.hpp:27
        I(cpphdl_n1374, cpphdl_n1372) <+ V(cpphdl_n1374, cpphdl_n1372) / 50.0;
        // device 962, IC IC161, analog/basic/nmos_resistor_amplifier.hpp:28
        I(cpphdl_n1374, cpphdl_n1373) <+ V(cpphdl_n1374, cpphdl_n1373) / 50.0;
        // device 963, IC IC161, analog/basic/nmos_resistor_amplifier.hpp:29
        I(Vss, cpphdl_n1374) <+ V(Vss, cpphdl_n1374) / 150.0;
        // device 964, IC IC161, analog/basic/nmos_resistor_amplifier.hpp:30
        I(cpphdl_n1378, Vdd) <+ 2.9999999999999998e-13 * ddt(V(cpphdl_n1378, Vdd)); // Bench initial voltage = 0.0 V.
        // device 965, IC IC161, analog/basic/nmos_resistor_amplifier.hpp:31
        I(cpphdl_n1377, Vdd) <+ 2.9999999999999998e-13 * ddt(V(cpphdl_n1377, Vdd)); // Bench initial voltage = 0.0 V.
        // device 966, IC IC161, analog/basic/nmos_resistor_amplifier.hpp:32
        I(cpphdl_n1374, Vss) <+ 4e-14 * ddt(V(cpphdl_n1374, Vss)); // Bench initial voltage = 0.0 V.
        // device 967, IC IC161, analog/basic/nmos_resistor_amplifier.hpp:34
        I(cpphdl_n1368, cpphdl_n1372) <+ 2e-14 * ddt(V(cpphdl_n1368, cpphdl_n1372)); // Bench initial voltage = 1.6499999999999999 V.
        // device 968, IC IC161, analog/basic/nmos_resistor_amplifier.hpp:35
        I(cpphdl_n1369, cpphdl_n1373) <+ 2e-14 * ddt(V(cpphdl_n1369, cpphdl_n1373)); // Bench initial voltage = 0.0 V.
        // device 969, IC IC161, analog/basic/nmos_resistor_amplifier.hpp:36
        I(cpphdl_n1368, cpphdl_n1378) <+ 2.9999999999999998e-15 * ddt(V(cpphdl_n1368, cpphdl_n1378)); // Bench initial voltage = -1.6499999999999999 V.
        // device 970, IC IC161, analog/basic/nmos_resistor_amplifier.hpp:37
        I(cpphdl_n1369, cpphdl_n1377) <+ 2.9999999999999998e-15 * ddt(V(cpphdl_n1369, cpphdl_n1377)); // Bench initial voltage = -3.2999999999999998 V.
        // device 971, IC IC162, analog/basic/strongarm_comparator.hpp:28
        I(cpphdl_n1382, cpphdl_n1384) <+ cpphdl_channel(V(cpphdl_n1377, cpphdl_n1384), V(cpphdl_n1382, cpphdl_n1384), 0.0080000000000000002, 0.69999999999999996, 1.0);
        // device 972, IC IC162, analog/basic/strongarm_comparator.hpp:29
        I(cpphdl_n1383, cpphdl_n1384) <+ cpphdl_channel(V(cpphdl_n1378, cpphdl_n1384), V(cpphdl_n1383, cpphdl_n1384), 0.0080000000000000002, 0.69999999999999996, 1.0);
        // device 973, IC IC162, analog/basic/strongarm_comparator.hpp:30
        I(cpphdl_n1384, Vss) <+ cpphdl_channel(V(EVALUATE, Vss), V(cpphdl_n1384, Vss), 0.0080000000000000002, 0.69999999999999996, 1.0);
        // device 974, IC IC162, analog/basic/strongarm_comparator.hpp:33
        I(cpphdl_n1397, cpphdl_n1382) <+ cpphdl_channel(V(cpphdl_n1401, cpphdl_n1382), V(cpphdl_n1397, cpphdl_n1382), 0.0040000000000000001, 0.69999999999999996, 1.0);
        // device 975, IC IC162, analog/basic/strongarm_comparator.hpp:34
        I(cpphdl_n1401, cpphdl_n1383) <+ cpphdl_channel(V(cpphdl_n1397, cpphdl_n1383), V(cpphdl_n1401, cpphdl_n1383), 0.0040000000000000001, 0.69999999999999996, 1.0);
        // device 976, IC IC162, analog/basic/strongarm_comparator.hpp:35
        I(cpphdl_n1401, Vdd) <+ cpphdl_channel(V(cpphdl_n1397, Vdd), V(cpphdl_n1401, Vdd), 0.002, 0.69999999999999996, -1.0);
        // device 977, IC IC162, analog/basic/strongarm_comparator.hpp:36
        I(cpphdl_n1397, Vdd) <+ cpphdl_channel(V(cpphdl_n1401, Vdd), V(cpphdl_n1397, Vdd), 0.002, 0.69999999999999996, -1.0);
        // device 978, IC IC162, analog/basic/strongarm_comparator.hpp:38
        I(cpphdl_n1382, Vdd) <+ cpphdl_channel(V(EVALUATE, Vdd), V(cpphdl_n1382, Vdd), 0.002, 0.69999999999999996, -1.0);
        // device 979, IC IC162, analog/basic/strongarm_comparator.hpp:39
        I(cpphdl_n1383, Vdd) <+ cpphdl_channel(V(EVALUATE, Vdd), V(cpphdl_n1383, Vdd), 0.002, 0.69999999999999996, -1.0);
        // device 980, IC IC162, analog/basic/strongarm_comparator.hpp:40
        I(cpphdl_n1401, Vdd) <+ cpphdl_channel(V(EVALUATE, Vdd), V(cpphdl_n1401, Vdd), 0.002, 0.69999999999999996, -1.0);
        // device 981, IC IC162, analog/basic/strongarm_comparator.hpp:41
        I(cpphdl_n1397, Vdd) <+ cpphdl_channel(V(EVALUATE, Vdd), V(cpphdl_n1397, Vdd), 0.002, 0.69999999999999996, -1.0);
        // device 982, IC IC162, analog/basic/strongarm_comparator.hpp:42
        I(cpphdl_n1382, Vss) <+ 2.9999999999999998e-14 * ddt(V(cpphdl_n1382, Vss)); // Bench initial voltage = 0.0 V.
        // device 983, IC IC162, analog/basic/strongarm_comparator.hpp:43
        I(cpphdl_n1383, Vss) <+ 2.9999999999999998e-14 * ddt(V(cpphdl_n1383, Vss)); // Bench initial voltage = 0.0 V.
        // device 984, IC IC162, analog/basic/strongarm_comparator.hpp:44
        I(cpphdl_n1384, Vss) <+ 2.9999999999999998e-14 * ddt(V(cpphdl_n1384, Vss)); // Bench initial voltage = 0.0 V.
        // device 985, IC IC162, analog/basic/strongarm_comparator.hpp:45
        I(cpphdl_n1401, Vss) <+ 5.0000000000000002e-14 * ddt(V(cpphdl_n1401, Vss)); // Bench initial voltage = 0.0 V.
        // device 986, IC IC162, analog/basic/strongarm_comparator.hpp:46
        I(cpphdl_n1397, Vss) <+ 5.0000000000000002e-14 * ddt(V(cpphdl_n1397, Vss)); // Bench initial voltage = 0.0 V.
        // device 987, IC IC162, analog/basic/strongarm_comparator.hpp:47
        I(cpphdl_n1377, cpphdl_n1384) <+ 2e-14 * ddt(V(cpphdl_n1377, cpphdl_n1384)); // Bench initial voltage = 3.2999999999999998 V.
        // device 988, IC IC162, analog/basic/strongarm_comparator.hpp:48
        I(cpphdl_n1378, cpphdl_n1384) <+ 2e-14 * ddt(V(cpphdl_n1378, cpphdl_n1384)); // Bench initial voltage = 3.2999999999999998 V.
        // device 989, IC IC162, analog/basic/strongarm_comparator.hpp:49
        I(cpphdl_n1377, cpphdl_n1382) <+ 2.9999999999999998e-15 * ddt(V(cpphdl_n1377, cpphdl_n1382)); // Bench initial voltage = 3.2999999999999998 V.
        // device 990, IC IC162, analog/basic/strongarm_comparator.hpp:50
        I(cpphdl_n1378, cpphdl_n1383) <+ 2.9999999999999998e-15 * ddt(V(cpphdl_n1378, cpphdl_n1383)); // Bench initial voltage = 3.2999999999999998 V.
        // device 991, IC IC164, analog/basic/inverter.hpp:11
        I(cpphdl_n1405, Vdd) <+ cpphdl_channel(V(cpphdl_n1397, Vdd), V(cpphdl_n1405, Vdd), 0.001, 0.69999999999999996, -1.0);
        // device 992, IC IC164, analog/basic/inverter.hpp:12
        I(cpphdl_n1405, Vss) <+ cpphdl_channel(V(cpphdl_n1397, Vss), V(cpphdl_n1405, Vss), 0.001, 0.69999999999999996, 1.0);
        // device 993, IC IC166, analog/basic/inverter.hpp:11
        I(cpphdl_n1419, Vdd) <+ cpphdl_channel(V(cpphdl_n1405, Vdd), V(cpphdl_n1419, Vdd), 0.0040000000000000001, 0.69999999999999996, -1.0);
        // device 994, IC IC166, analog/basic/inverter.hpp:12
        I(cpphdl_n1419, Vss) <+ cpphdl_channel(V(cpphdl_n1405, Vss), V(cpphdl_n1419, Vss), 0.0040000000000000001, 0.69999999999999996, 1.0);
        // device 995, IC IC163, analog/basic/buffered_nand_latch.hpp:33
        I(cpphdl_n1397, Vss) <+ 2.0000000000000002e-15 * ddt(V(cpphdl_n1397, Vss)); // Bench initial voltage = 0.0 V.
        // device 996, IC IC163, analog/basic/buffered_nand_latch.hpp:34
        I(cpphdl_n1397, cpphdl_n1405) <+ 1.0000000000000001e-15 * ddt(V(cpphdl_n1397, cpphdl_n1405)); // Bench initial voltage = 0.0 V.
        // device 997, IC IC163, analog/basic/buffered_nand_latch.hpp:35
        I(cpphdl_n1405, Vss) <+ 5e-15 * ddt(V(cpphdl_n1405, Vss)); // Bench initial voltage = 0.0 V.
        // device 998, IC IC163, analog/basic/buffered_nand_latch.hpp:36
        I(cpphdl_n1405, Vss) <+ 8.0000000000000006e-15 * ddt(V(cpphdl_n1405, Vss)); // Bench initial voltage = 0.0 V.
        // device 999, IC IC163, analog/basic/buffered_nand_latch.hpp:37
        I(cpphdl_n1419, Vss) <+ 1e-14 * ddt(V(cpphdl_n1419, Vss)); // Bench initial voltage = 0.0 V.
        // device 1000, IC IC165, analog/basic/inverter.hpp:11
        I(cpphdl_n1409, Vdd) <+ cpphdl_channel(V(cpphdl_n1401, Vdd), V(cpphdl_n1409, Vdd), 0.001, 0.69999999999999996, -1.0);
        // device 1001, IC IC165, analog/basic/inverter.hpp:12
        I(cpphdl_n1409, Vss) <+ cpphdl_channel(V(cpphdl_n1401, Vss), V(cpphdl_n1409, Vss), 0.001, 0.69999999999999996, 1.0);
        // device 1002, IC IC167, analog/basic/inverter.hpp:11
        I(cpphdl_n1425, Vdd) <+ cpphdl_channel(V(cpphdl_n1409, Vdd), V(cpphdl_n1425, Vdd), 0.0040000000000000001, 0.69999999999999996, -1.0);
        // device 1003, IC IC167, analog/basic/inverter.hpp:12
        I(cpphdl_n1425, Vss) <+ cpphdl_channel(V(cpphdl_n1409, Vss), V(cpphdl_n1425, Vss), 0.0040000000000000001, 0.69999999999999996, 1.0);
        // device 1004, IC IC163, analog/basic/buffered_nand_latch.hpp:33
        I(cpphdl_n1401, Vss) <+ 2.0000000000000002e-15 * ddt(V(cpphdl_n1401, Vss)); // Bench initial voltage = 0.0 V.
        // device 1005, IC IC163, analog/basic/buffered_nand_latch.hpp:34
        I(cpphdl_n1401, cpphdl_n1409) <+ 1.0000000000000001e-15 * ddt(V(cpphdl_n1401, cpphdl_n1409)); // Bench initial voltage = 0.0 V.
        // device 1006, IC IC163, analog/basic/buffered_nand_latch.hpp:35
        I(cpphdl_n1409, Vss) <+ 5e-15 * ddt(V(cpphdl_n1409, Vss)); // Bench initial voltage = 0.0 V.
        // device 1007, IC IC163, analog/basic/buffered_nand_latch.hpp:36
        I(cpphdl_n1409, Vss) <+ 8.0000000000000006e-15 * ddt(V(cpphdl_n1409, Vss)); // Bench initial voltage = 0.0 V.
        // device 1008, IC IC163, analog/basic/buffered_nand_latch.hpp:37
        I(cpphdl_n1425, Vss) <+ 1e-14 * ddt(V(cpphdl_n1425, Vss)); // Bench initial voltage = 0.0 V.
        // device 1009, IC IC169, analog/basic/cmos_logic.hpp:15
        I(cpphdl_n2770, Vss) <+ 5.0000000000000002e-14 * ddt(V(cpphdl_n2770, Vss)); // Bench initial voltage = 0.0 V.
        // device 1010, IC IC169, analog/basic/cmos_logic.hpp:16
        I(cpphdl_n2770, Vdd) <+ cpphdl_channel(V(cpphdl_n1419, Vdd), V(cpphdl_n2770, Vdd), 0.01, 0.69999999999999996, -1.0);
        // device 1011, IC IC169, analog/basic/cmos_logic.hpp:17
        I(cpphdl_n2770, Vdd) <+ cpphdl_channel(V(cpphdl_n1427, Vdd), V(cpphdl_n2770, Vdd), 0.01, 0.69999999999999996, -1.0);
        // device 1012, IC IC169, analog/basic/cmos_logic.hpp:18
        I(cpphdl_n2770, cpphdl_n1422) <+ cpphdl_channel(V(cpphdl_n1419, cpphdl_n1422), V(cpphdl_n2770, cpphdl_n1422), 0.01, 0.69999999999999996, 1.0);
        // device 1013, IC IC169, analog/basic/cmos_logic.hpp:19
        I(cpphdl_n1422, Vss) <+ cpphdl_channel(V(cpphdl_n1427, Vss), V(cpphdl_n1422, Vss), 0.01, 0.69999999999999996, 1.0);
        // device 1014, IC IC169, analog/basic/cmos_logic.hpp:20
        I(cpphdl_n2770, Vss) <+ V(cpphdl_n2770, Vss) / 1000000000.0;
        // device 1015, IC IC169, analog/basic/cmos_logic.hpp:21
        I(cpphdl_n1422, Vss) <+ V(cpphdl_n1422, Vss) / 1000000000.0;
        // device 1016, IC IC170, analog/basic/cmos_logic.hpp:15
        I(cpphdl_n1427, Vss) <+ 5.0000000000000002e-14 * ddt(V(cpphdl_n1427, Vss)); // Bench initial voltage = 0.0 V.
        // device 1017, IC IC170, analog/basic/cmos_logic.hpp:16
        I(cpphdl_n1427, Vdd) <+ cpphdl_channel(V(cpphdl_n1425, Vdd), V(cpphdl_n1427, Vdd), 0.01, 0.69999999999999996, -1.0);
        // device 1018, IC IC170, analog/basic/cmos_logic.hpp:17
        I(cpphdl_n1427, Vdd) <+ cpphdl_channel(V(cpphdl_n2770, Vdd), V(cpphdl_n1427, Vdd), 0.01, 0.69999999999999996, -1.0);
        // device 1019, IC IC170, analog/basic/cmos_logic.hpp:18
        I(cpphdl_n1427, cpphdl_n1428) <+ cpphdl_channel(V(cpphdl_n1425, cpphdl_n1428), V(cpphdl_n1427, cpphdl_n1428), 0.01, 0.69999999999999996, 1.0);
        // device 1020, IC IC170, analog/basic/cmos_logic.hpp:19
        I(cpphdl_n1428, Vss) <+ cpphdl_channel(V(cpphdl_n2770, Vss), V(cpphdl_n1428, Vss), 0.01, 0.69999999999999996, 1.0);
        // device 1021, IC IC170, analog/basic/cmos_logic.hpp:20
        I(cpphdl_n1427, Vss) <+ V(cpphdl_n1427, Vss) / 1000000000.0;
        // device 1022, IC IC170, analog/basic/cmos_logic.hpp:21
        I(cpphdl_n1428, Vss) <+ V(cpphdl_n1428, Vss) / 1000000000.0;
        // device 1023, IC IC168, analog/basic/nand_latch.hpp:34
        I(cpphdl_n1419, Vss) <+ 2.9999999999999998e-15 * ddt(V(cpphdl_n1419, Vss)); // Bench initial voltage = 0.0 V.
        // device 1024, IC IC168, analog/basic/nand_latch.hpp:35
        I(cpphdl_n1425, Vss) <+ 2.9999999999999998e-15 * ddt(V(cpphdl_n1425, Vss)); // Bench initial voltage = 0.0 V.
        // device 1025, IC IC171, analog/basic/inverter.hpp:11
        I(cpphdl_n1433, Vdd) <+ cpphdl_channel(V(CLEAR, Vdd), V(cpphdl_n1433, Vdd), 0.01, 0.69999999999999996, -1.0);
        // device 1026, IC IC171, analog/basic/inverter.hpp:12
        I(cpphdl_n1433, Vss) <+ cpphdl_channel(V(CLEAR, Vss), V(cpphdl_n1433, Vss), 0.01, 0.69999999999999996, 1.0);
        // device 1027, IC IC168, analog/basic/nand_latch.hpp:56
        I(cpphdl_n1433, Vss) <+ 2.9999999999999998e-15 * ddt(V(cpphdl_n1433, Vss)); // Bench initial voltage = 0.0 V.
        // device 1028, IC IC168, analog/basic/nand_latch.hpp:57
        I(cpphdl_n2770, Vss) <+ cpphdl_channel(V(CLEAR, Vss), V(cpphdl_n2770, Vss), 0.050000000000000003, 0.69999999999999996, 1.0);
        // device 1029, IC IC168, analog/basic/nand_latch.hpp:58
        I(cpphdl_n1427, Vdd) <+ cpphdl_channel(V(cpphdl_n1433, Vdd), V(cpphdl_n1427, Vdd), 0.050000000000000003, 0.69999999999999996, -1.0);
        // device 1030, IC IC174, analog/basic/inverter.hpp:11
        I(cpphdl_n1457, Vdd) <+ cpphdl_channel(V(TRACK7, Vdd), V(cpphdl_n1457, Vdd), 0.0040000000000000001, 0.69999999999999996, -1.0);
        // device 1031, IC IC174, analog/basic/inverter.hpp:12
        I(cpphdl_n1457, Vss) <+ cpphdl_channel(V(TRACK7, Vss), V(cpphdl_n1457, Vss), 0.0040000000000000001, 0.69999999999999996, 1.0);
        // device 1032, IC IC173, analog/basic/mos_track_hold.hpp:30
        I(cpphdl_n1457, Vss) <+ 2e-14 * ddt(V(cpphdl_n1457, Vss)); // Bench initial voltage = 3.2999999999999998 V.
        // device 1033, IC IC173, analog/basic/mos_track_hold.hpp:31
        I(cpphdl_n2595, cpphdl_n1511) <+ cpphdl_channel(V(TRACK7, cpphdl_n1511), V(cpphdl_n2595, cpphdl_n1511), 0.02, 0.69999999999999996, 1.0);
        // device 1034, IC IC173, analog/basic/mos_track_hold.hpp:32
        I(cpphdl_n1511, cpphdl_n2595) <+ cpphdl_channel(V(cpphdl_n1457, cpphdl_n2595), V(cpphdl_n1511, cpphdl_n2595), 0.01, 0.69999999999999996, -1.0);
        // device 1035, IC IC173, analog/basic/mos_track_hold.hpp:36
        I(cpphdl_n1511, cpphdl_n1511) <+ cpphdl_channel(V(cpphdl_n1457, cpphdl_n1511), V(cpphdl_n1511, cpphdl_n1511), 0.01, 0.69999999999999996, 1.0);
        // device 1036, IC IC173, analog/basic/mos_track_hold.hpp:37
        I(cpphdl_n1511, cpphdl_n1511) <+ cpphdl_channel(V(TRACK7, cpphdl_n1511), V(cpphdl_n1511, cpphdl_n1511), 0.0050000000000000001, 0.69999999999999996, -1.0);
        // device 1037, IC IC173, analog/basic/mos_track_hold.hpp:38
        I(cpphdl_n1511, Vss) <+ 1.5000000000000001e-12 * ddt(V(cpphdl_n1511, Vss)); // Bench initial voltage = 1.6499999999999999 V.
        // device 1038, IC IC173, analog/basic/mos_track_hold.hpp:39
        I(Vss, cpphdl_n1511) <+ V(Vss, cpphdl_n1511) / 1000000000.0;
        // device 1039, IC IC173, analog/basic/mos_track_hold.hpp:40
        I(TRACK7, cpphdl_n1511) <+ 2.0000000000000002e-15 * ddt(V(TRACK7, cpphdl_n1511)); // Bench initial voltage = -1.6499999999999999 V.
        // device 1040, IC IC173, analog/basic/mos_track_hold.hpp:41
        I(cpphdl_n1457, cpphdl_n1511) <+ 2.0000000000000002e-15 * ddt(V(cpphdl_n1457, cpphdl_n1511)); // Bench initial voltage = 1.6499999999999999 V.
        // device 1041, IC IC173, analog/basic/mos_track_hold.hpp:42
        I(cpphdl_n2595, cpphdl_n1511) <+ 1.0000000000000001e-15 * ddt(V(cpphdl_n2595, cpphdl_n1511)); // Bench initial voltage = 0.0 V.
        // device 1042, IC IC176, analog/basic/inverter.hpp:11
        I(cpphdl_n1472, Vdd) <+ cpphdl_channel(V(BIT_N7_0, Vdd), V(cpphdl_n1472, Vdd), 0.080000000000000002, 0.69999999999999996, -1.0);
        // device 1043, IC IC176, analog/basic/inverter.hpp:12
        I(cpphdl_n1472, Vss) <+ cpphdl_channel(V(BIT_N7_0, Vss), V(cpphdl_n1472, Vss), 0.080000000000000002, 0.69999999999999996, 1.0);
        // device 1044, IC IC175, analog/basic/mos_r2r_dac.hpp:27
        I(cpphdl_n1472, Vss) <+ 2.9999999999999998e-15 * ddt(V(cpphdl_n1472, Vss)); // Bench initial voltage = 0.0 V.
        // device 1045, IC IC175, analog/basic/mos_r2r_dac.hpp:28
        I(cpphdl_n1472, cpphdl_n1501) <+ V(cpphdl_n1472, cpphdl_n1501) / 2000.0;
        // device 1046, IC IC175, analog/basic/mos_r2r_dac.hpp:29
        I(cpphdl_n1501, Vss) <+ 2.9999999999999998e-15 * ddt(V(cpphdl_n1501, Vss)); // Bench initial voltage = 0.0 V.
        // device 1047, IC IC177, analog/basic/inverter.hpp:11
        I(cpphdl_n1476, Vdd) <+ cpphdl_channel(V(BIT_N7_1, Vdd), V(cpphdl_n1476, Vdd), 0.080000000000000002, 0.69999999999999996, -1.0);
        // device 1048, IC IC177, analog/basic/inverter.hpp:12
        I(cpphdl_n1476, Vss) <+ cpphdl_channel(V(BIT_N7_1, Vss), V(cpphdl_n1476, Vss), 0.080000000000000002, 0.69999999999999996, 1.0);
        // device 1049, IC IC175, analog/basic/mos_r2r_dac.hpp:27
        I(cpphdl_n1476, Vss) <+ 2.9999999999999998e-15 * ddt(V(cpphdl_n1476, Vss)); // Bench initial voltage = 0.0 V.
        // device 1050, IC IC175, analog/basic/mos_r2r_dac.hpp:28
        I(cpphdl_n1476, cpphdl_n1502) <+ V(cpphdl_n1476, cpphdl_n1502) / 2000.0;
        // device 1051, IC IC175, analog/basic/mos_r2r_dac.hpp:29
        I(cpphdl_n1502, Vss) <+ 2.9999999999999998e-15 * ddt(V(cpphdl_n1502, Vss)); // Bench initial voltage = 0.0 V.
        // device 1052, IC IC175, analog/basic/mos_r2r_dac.hpp:31
        I(cpphdl_n1501, cpphdl_n1502) <+ V(cpphdl_n1501, cpphdl_n1502) / 1000.0;
        // device 1053, IC IC178, analog/basic/inverter.hpp:11
        I(cpphdl_n1480, Vdd) <+ cpphdl_channel(V(BIT_N7_2, Vdd), V(cpphdl_n1480, Vdd), 0.080000000000000002, 0.69999999999999996, -1.0);
        // device 1054, IC IC178, analog/basic/inverter.hpp:12
        I(cpphdl_n1480, Vss) <+ cpphdl_channel(V(BIT_N7_2, Vss), V(cpphdl_n1480, Vss), 0.080000000000000002, 0.69999999999999996, 1.0);
        // device 1055, IC IC175, analog/basic/mos_r2r_dac.hpp:27
        I(cpphdl_n1480, Vss) <+ 2.9999999999999998e-15 * ddt(V(cpphdl_n1480, Vss)); // Bench initial voltage = 0.0 V.
        // device 1056, IC IC175, analog/basic/mos_r2r_dac.hpp:28
        I(cpphdl_n1480, cpphdl_n1503) <+ V(cpphdl_n1480, cpphdl_n1503) / 2000.0;
        // device 1057, IC IC175, analog/basic/mos_r2r_dac.hpp:29
        I(cpphdl_n1503, Vss) <+ 2.9999999999999998e-15 * ddt(V(cpphdl_n1503, Vss)); // Bench initial voltage = 0.0 V.
        // device 1058, IC IC175, analog/basic/mos_r2r_dac.hpp:31
        I(cpphdl_n1502, cpphdl_n1503) <+ V(cpphdl_n1502, cpphdl_n1503) / 1000.0;
        // device 1059, IC IC179, analog/basic/inverter.hpp:11
        I(cpphdl_n1484, Vdd) <+ cpphdl_channel(V(BIT_N7_3, Vdd), V(cpphdl_n1484, Vdd), 0.080000000000000002, 0.69999999999999996, -1.0);
        // device 1060, IC IC179, analog/basic/inverter.hpp:12
        I(cpphdl_n1484, Vss) <+ cpphdl_channel(V(BIT_N7_3, Vss), V(cpphdl_n1484, Vss), 0.080000000000000002, 0.69999999999999996, 1.0);
        // device 1061, IC IC175, analog/basic/mos_r2r_dac.hpp:27
        I(cpphdl_n1484, Vss) <+ 2.9999999999999998e-15 * ddt(V(cpphdl_n1484, Vss)); // Bench initial voltage = 0.0 V.
        // device 1062, IC IC175, analog/basic/mos_r2r_dac.hpp:28
        I(cpphdl_n1484, cpphdl_n1504) <+ V(cpphdl_n1484, cpphdl_n1504) / 2000.0;
        // device 1063, IC IC175, analog/basic/mos_r2r_dac.hpp:29
        I(cpphdl_n1504, Vss) <+ 2.9999999999999998e-15 * ddt(V(cpphdl_n1504, Vss)); // Bench initial voltage = 0.0 V.
        // device 1064, IC IC175, analog/basic/mos_r2r_dac.hpp:31
        I(cpphdl_n1503, cpphdl_n1504) <+ V(cpphdl_n1503, cpphdl_n1504) / 1000.0;
        // device 1065, IC IC180, analog/basic/inverter.hpp:11
        I(cpphdl_n1488, Vdd) <+ cpphdl_channel(V(BIT_N7_4, Vdd), V(cpphdl_n1488, Vdd), 0.080000000000000002, 0.69999999999999996, -1.0);
        // device 1066, IC IC180, analog/basic/inverter.hpp:12
        I(cpphdl_n1488, Vss) <+ cpphdl_channel(V(BIT_N7_4, Vss), V(cpphdl_n1488, Vss), 0.080000000000000002, 0.69999999999999996, 1.0);
        // device 1067, IC IC175, analog/basic/mos_r2r_dac.hpp:27
        I(cpphdl_n1488, Vss) <+ 2.9999999999999998e-15 * ddt(V(cpphdl_n1488, Vss)); // Bench initial voltage = 0.0 V.
        // device 1068, IC IC175, analog/basic/mos_r2r_dac.hpp:28
        I(cpphdl_n1488, cpphdl_n1505) <+ V(cpphdl_n1488, cpphdl_n1505) / 2000.0;
        // device 1069, IC IC175, analog/basic/mos_r2r_dac.hpp:29
        I(cpphdl_n1505, Vss) <+ 2.9999999999999998e-15 * ddt(V(cpphdl_n1505, Vss)); // Bench initial voltage = 0.0 V.
        // device 1070, IC IC175, analog/basic/mos_r2r_dac.hpp:31
        I(cpphdl_n1504, cpphdl_n1505) <+ V(cpphdl_n1504, cpphdl_n1505) / 1000.0;
        // device 1071, IC IC181, analog/basic/inverter.hpp:11
        I(cpphdl_n1492, Vdd) <+ cpphdl_channel(V(BIT_N7_5, Vdd), V(cpphdl_n1492, Vdd), 0.080000000000000002, 0.69999999999999996, -1.0);
        // device 1072, IC IC181, analog/basic/inverter.hpp:12
        I(cpphdl_n1492, Vss) <+ cpphdl_channel(V(BIT_N7_5, Vss), V(cpphdl_n1492, Vss), 0.080000000000000002, 0.69999999999999996, 1.0);
        // device 1073, IC IC175, analog/basic/mos_r2r_dac.hpp:27
        I(cpphdl_n1492, Vss) <+ 2.9999999999999998e-15 * ddt(V(cpphdl_n1492, Vss)); // Bench initial voltage = 0.0 V.
        // device 1074, IC IC175, analog/basic/mos_r2r_dac.hpp:28
        I(cpphdl_n1492, cpphdl_n1506) <+ V(cpphdl_n1492, cpphdl_n1506) / 2000.0;
        // device 1075, IC IC175, analog/basic/mos_r2r_dac.hpp:29
        I(cpphdl_n1506, Vss) <+ 2.9999999999999998e-15 * ddt(V(cpphdl_n1506, Vss)); // Bench initial voltage = 0.0 V.
        // device 1076, IC IC175, analog/basic/mos_r2r_dac.hpp:31
        I(cpphdl_n1505, cpphdl_n1506) <+ V(cpphdl_n1505, cpphdl_n1506) / 1000.0;
        // device 1077, IC IC182, analog/basic/inverter.hpp:11
        I(cpphdl_n1496, Vdd) <+ cpphdl_channel(V(BIT_N7_6, Vdd), V(cpphdl_n1496, Vdd), 0.080000000000000002, 0.69999999999999996, -1.0);
        // device 1078, IC IC182, analog/basic/inverter.hpp:12
        I(cpphdl_n1496, Vss) <+ cpphdl_channel(V(BIT_N7_6, Vss), V(cpphdl_n1496, Vss), 0.080000000000000002, 0.69999999999999996, 1.0);
        // device 1079, IC IC175, analog/basic/mos_r2r_dac.hpp:27
        I(cpphdl_n1496, Vss) <+ 2.9999999999999998e-15 * ddt(V(cpphdl_n1496, Vss)); // Bench initial voltage = 0.0 V.
        // device 1080, IC IC175, analog/basic/mos_r2r_dac.hpp:28
        I(cpphdl_n1496, cpphdl_n1507) <+ V(cpphdl_n1496, cpphdl_n1507) / 2000.0;
        // device 1081, IC IC175, analog/basic/mos_r2r_dac.hpp:29
        I(cpphdl_n1507, Vss) <+ 2.9999999999999998e-15 * ddt(V(cpphdl_n1507, Vss)); // Bench initial voltage = 0.0 V.
        // device 1082, IC IC175, analog/basic/mos_r2r_dac.hpp:31
        I(cpphdl_n1506, cpphdl_n1507) <+ V(cpphdl_n1506, cpphdl_n1507) / 1000.0;
        // device 1083, IC IC183, analog/basic/inverter.hpp:11
        I(cpphdl_n1500, Vdd) <+ cpphdl_channel(V(BIT_N7_7, Vdd), V(cpphdl_n1500, Vdd), 0.080000000000000002, 0.69999999999999996, -1.0);
        // device 1084, IC IC183, analog/basic/inverter.hpp:12
        I(cpphdl_n1500, Vss) <+ cpphdl_channel(V(BIT_N7_7, Vss), V(cpphdl_n1500, Vss), 0.080000000000000002, 0.69999999999999996, 1.0);
        // device 1085, IC IC175, analog/basic/mos_r2r_dac.hpp:27
        I(cpphdl_n1500, Vss) <+ 2.9999999999999998e-15 * ddt(V(cpphdl_n1500, Vss)); // Bench initial voltage = 0.0 V.
        // device 1086, IC IC175, analog/basic/mos_r2r_dac.hpp:28
        I(cpphdl_n1500, cpphdl_n1512) <+ V(cpphdl_n1500, cpphdl_n1512) / 2000.0;
        // device 1087, IC IC175, analog/basic/mos_r2r_dac.hpp:29
        I(cpphdl_n1512, Vss) <+ 2.9999999999999998e-15 * ddt(V(cpphdl_n1512, Vss)); // Bench initial voltage = 0.0 V.
        // device 1088, IC IC175, analog/basic/mos_r2r_dac.hpp:31
        I(cpphdl_n1507, cpphdl_n1512) <+ V(cpphdl_n1507, cpphdl_n1512) / 1000.0;
        // device 1089, IC IC175, analog/basic/mos_r2r_dac.hpp:33
        I(Vss, cpphdl_n1501) <+ V(Vss, cpphdl_n1501) / 2000.0;
        // device 1090, IC IC184, analog/basic/nmos_resistor_amplifier.hpp:23
        I(Vdd, cpphdl_n1521) <+ V(Vdd, cpphdl_n1521) / 500.0;
        // device 1091, IC IC184, analog/basic/nmos_resistor_amplifier.hpp:24
        I(Vdd, cpphdl_n1520) <+ V(Vdd, cpphdl_n1520) / 500.0;
        // device 1092, IC IC184, analog/basic/nmos_resistor_amplifier.hpp:25
        I(cpphdl_n1521, cpphdl_n1515) <+ cpphdl_channel(V(cpphdl_n1511, cpphdl_n1515), V(cpphdl_n1521, cpphdl_n1515), 0.014999999999999999, 0.69999999999999996, 1.0);
        // device 1093, IC IC184, analog/basic/nmos_resistor_amplifier.hpp:26
        I(cpphdl_n1520, cpphdl_n1516) <+ cpphdl_channel(V(cpphdl_n1512, cpphdl_n1516), V(cpphdl_n1520, cpphdl_n1516), 0.014999999999999999, 0.69999999999999996, 1.0);
        // device 1094, IC IC184, analog/basic/nmos_resistor_amplifier.hpp:27
        I(cpphdl_n1517, cpphdl_n1515) <+ V(cpphdl_n1517, cpphdl_n1515) / 50.0;
        // device 1095, IC IC184, analog/basic/nmos_resistor_amplifier.hpp:28
        I(cpphdl_n1517, cpphdl_n1516) <+ V(cpphdl_n1517, cpphdl_n1516) / 50.0;
        // device 1096, IC IC184, analog/basic/nmos_resistor_amplifier.hpp:29
        I(Vss, cpphdl_n1517) <+ V(Vss, cpphdl_n1517) / 150.0;
        // device 1097, IC IC184, analog/basic/nmos_resistor_amplifier.hpp:30
        I(cpphdl_n1521, Vdd) <+ 2.9999999999999998e-13 * ddt(V(cpphdl_n1521, Vdd)); // Bench initial voltage = 0.0 V.
        // device 1098, IC IC184, analog/basic/nmos_resistor_amplifier.hpp:31
        I(cpphdl_n1520, Vdd) <+ 2.9999999999999998e-13 * ddt(V(cpphdl_n1520, Vdd)); // Bench initial voltage = 0.0 V.
        // device 1099, IC IC184, analog/basic/nmos_resistor_amplifier.hpp:32
        I(cpphdl_n1517, Vss) <+ 4e-14 * ddt(V(cpphdl_n1517, Vss)); // Bench initial voltage = 0.0 V.
        // device 1100, IC IC184, analog/basic/nmos_resistor_amplifier.hpp:34
        I(cpphdl_n1511, cpphdl_n1515) <+ 2e-14 * ddt(V(cpphdl_n1511, cpphdl_n1515)); // Bench initial voltage = 1.6499999999999999 V.
        // device 1101, IC IC184, analog/basic/nmos_resistor_amplifier.hpp:35
        I(cpphdl_n1512, cpphdl_n1516) <+ 2e-14 * ddt(V(cpphdl_n1512, cpphdl_n1516)); // Bench initial voltage = 0.0 V.
        // device 1102, IC IC184, analog/basic/nmos_resistor_amplifier.hpp:36
        I(cpphdl_n1511, cpphdl_n1521) <+ 2.9999999999999998e-15 * ddt(V(cpphdl_n1511, cpphdl_n1521)); // Bench initial voltage = -1.6499999999999999 V.
        // device 1103, IC IC184, analog/basic/nmos_resistor_amplifier.hpp:37
        I(cpphdl_n1512, cpphdl_n1520) <+ 2.9999999999999998e-15 * ddt(V(cpphdl_n1512, cpphdl_n1520)); // Bench initial voltage = -3.2999999999999998 V.
        // device 1104, IC IC185, analog/basic/strongarm_comparator.hpp:28
        I(cpphdl_n1525, cpphdl_n1527) <+ cpphdl_channel(V(cpphdl_n1520, cpphdl_n1527), V(cpphdl_n1525, cpphdl_n1527), 0.0080000000000000002, 0.69999999999999996, 1.0);
        // device 1105, IC IC185, analog/basic/strongarm_comparator.hpp:29
        I(cpphdl_n1526, cpphdl_n1527) <+ cpphdl_channel(V(cpphdl_n1521, cpphdl_n1527), V(cpphdl_n1526, cpphdl_n1527), 0.0080000000000000002, 0.69999999999999996, 1.0);
        // device 1106, IC IC185, analog/basic/strongarm_comparator.hpp:30
        I(cpphdl_n1527, Vss) <+ cpphdl_channel(V(EVALUATE, Vss), V(cpphdl_n1527, Vss), 0.0080000000000000002, 0.69999999999999996, 1.0);
        // device 1107, IC IC185, analog/basic/strongarm_comparator.hpp:33
        I(cpphdl_n1540, cpphdl_n1525) <+ cpphdl_channel(V(cpphdl_n1544, cpphdl_n1525), V(cpphdl_n1540, cpphdl_n1525), 0.0040000000000000001, 0.69999999999999996, 1.0);
        // device 1108, IC IC185, analog/basic/strongarm_comparator.hpp:34
        I(cpphdl_n1544, cpphdl_n1526) <+ cpphdl_channel(V(cpphdl_n1540, cpphdl_n1526), V(cpphdl_n1544, cpphdl_n1526), 0.0040000000000000001, 0.69999999999999996, 1.0);
        // device 1109, IC IC185, analog/basic/strongarm_comparator.hpp:35
        I(cpphdl_n1544, Vdd) <+ cpphdl_channel(V(cpphdl_n1540, Vdd), V(cpphdl_n1544, Vdd), 0.002, 0.69999999999999996, -1.0);
        // device 1110, IC IC185, analog/basic/strongarm_comparator.hpp:36
        I(cpphdl_n1540, Vdd) <+ cpphdl_channel(V(cpphdl_n1544, Vdd), V(cpphdl_n1540, Vdd), 0.002, 0.69999999999999996, -1.0);
        // device 1111, IC IC185, analog/basic/strongarm_comparator.hpp:38
        I(cpphdl_n1525, Vdd) <+ cpphdl_channel(V(EVALUATE, Vdd), V(cpphdl_n1525, Vdd), 0.002, 0.69999999999999996, -1.0);
        // device 1112, IC IC185, analog/basic/strongarm_comparator.hpp:39
        I(cpphdl_n1526, Vdd) <+ cpphdl_channel(V(EVALUATE, Vdd), V(cpphdl_n1526, Vdd), 0.002, 0.69999999999999996, -1.0);
        // device 1113, IC IC185, analog/basic/strongarm_comparator.hpp:40
        I(cpphdl_n1544, Vdd) <+ cpphdl_channel(V(EVALUATE, Vdd), V(cpphdl_n1544, Vdd), 0.002, 0.69999999999999996, -1.0);
        // device 1114, IC IC185, analog/basic/strongarm_comparator.hpp:41
        I(cpphdl_n1540, Vdd) <+ cpphdl_channel(V(EVALUATE, Vdd), V(cpphdl_n1540, Vdd), 0.002, 0.69999999999999996, -1.0);
        // device 1115, IC IC185, analog/basic/strongarm_comparator.hpp:42
        I(cpphdl_n1525, Vss) <+ 2.9999999999999998e-14 * ddt(V(cpphdl_n1525, Vss)); // Bench initial voltage = 0.0 V.
        // device 1116, IC IC185, analog/basic/strongarm_comparator.hpp:43
        I(cpphdl_n1526, Vss) <+ 2.9999999999999998e-14 * ddt(V(cpphdl_n1526, Vss)); // Bench initial voltage = 0.0 V.
        // device 1117, IC IC185, analog/basic/strongarm_comparator.hpp:44
        I(cpphdl_n1527, Vss) <+ 2.9999999999999998e-14 * ddt(V(cpphdl_n1527, Vss)); // Bench initial voltage = 0.0 V.
        // device 1118, IC IC185, analog/basic/strongarm_comparator.hpp:45
        I(cpphdl_n1544, Vss) <+ 5.0000000000000002e-14 * ddt(V(cpphdl_n1544, Vss)); // Bench initial voltage = 0.0 V.
        // device 1119, IC IC185, analog/basic/strongarm_comparator.hpp:46
        I(cpphdl_n1540, Vss) <+ 5.0000000000000002e-14 * ddt(V(cpphdl_n1540, Vss)); // Bench initial voltage = 0.0 V.
        // device 1120, IC IC185, analog/basic/strongarm_comparator.hpp:47
        I(cpphdl_n1520, cpphdl_n1527) <+ 2e-14 * ddt(V(cpphdl_n1520, cpphdl_n1527)); // Bench initial voltage = 3.2999999999999998 V.
        // device 1121, IC IC185, analog/basic/strongarm_comparator.hpp:48
        I(cpphdl_n1521, cpphdl_n1527) <+ 2e-14 * ddt(V(cpphdl_n1521, cpphdl_n1527)); // Bench initial voltage = 3.2999999999999998 V.
        // device 1122, IC IC185, analog/basic/strongarm_comparator.hpp:49
        I(cpphdl_n1520, cpphdl_n1525) <+ 2.9999999999999998e-15 * ddt(V(cpphdl_n1520, cpphdl_n1525)); // Bench initial voltage = 3.2999999999999998 V.
        // device 1123, IC IC185, analog/basic/strongarm_comparator.hpp:50
        I(cpphdl_n1521, cpphdl_n1526) <+ 2.9999999999999998e-15 * ddt(V(cpphdl_n1521, cpphdl_n1526)); // Bench initial voltage = 3.2999999999999998 V.
        // device 1124, IC IC187, analog/basic/inverter.hpp:11
        I(cpphdl_n1548, Vdd) <+ cpphdl_channel(V(cpphdl_n1540, Vdd), V(cpphdl_n1548, Vdd), 0.001, 0.69999999999999996, -1.0);
        // device 1125, IC IC187, analog/basic/inverter.hpp:12
        I(cpphdl_n1548, Vss) <+ cpphdl_channel(V(cpphdl_n1540, Vss), V(cpphdl_n1548, Vss), 0.001, 0.69999999999999996, 1.0);
        // device 1126, IC IC189, analog/basic/inverter.hpp:11
        I(cpphdl_n1562, Vdd) <+ cpphdl_channel(V(cpphdl_n1548, Vdd), V(cpphdl_n1562, Vdd), 0.0040000000000000001, 0.69999999999999996, -1.0);
        // device 1127, IC IC189, analog/basic/inverter.hpp:12
        I(cpphdl_n1562, Vss) <+ cpphdl_channel(V(cpphdl_n1548, Vss), V(cpphdl_n1562, Vss), 0.0040000000000000001, 0.69999999999999996, 1.0);
        // device 1128, IC IC186, analog/basic/buffered_nand_latch.hpp:33
        I(cpphdl_n1540, Vss) <+ 2.0000000000000002e-15 * ddt(V(cpphdl_n1540, Vss)); // Bench initial voltage = 0.0 V.
        // device 1129, IC IC186, analog/basic/buffered_nand_latch.hpp:34
        I(cpphdl_n1540, cpphdl_n1548) <+ 1.0000000000000001e-15 * ddt(V(cpphdl_n1540, cpphdl_n1548)); // Bench initial voltage = 0.0 V.
        // device 1130, IC IC186, analog/basic/buffered_nand_latch.hpp:35
        I(cpphdl_n1548, Vss) <+ 5e-15 * ddt(V(cpphdl_n1548, Vss)); // Bench initial voltage = 0.0 V.
        // device 1131, IC IC186, analog/basic/buffered_nand_latch.hpp:36
        I(cpphdl_n1548, Vss) <+ 8.0000000000000006e-15 * ddt(V(cpphdl_n1548, Vss)); // Bench initial voltage = 0.0 V.
        // device 1132, IC IC186, analog/basic/buffered_nand_latch.hpp:37
        I(cpphdl_n1562, Vss) <+ 1e-14 * ddt(V(cpphdl_n1562, Vss)); // Bench initial voltage = 0.0 V.
        // device 1133, IC IC188, analog/basic/inverter.hpp:11
        I(cpphdl_n1552, Vdd) <+ cpphdl_channel(V(cpphdl_n1544, Vdd), V(cpphdl_n1552, Vdd), 0.001, 0.69999999999999996, -1.0);
        // device 1134, IC IC188, analog/basic/inverter.hpp:12
        I(cpphdl_n1552, Vss) <+ cpphdl_channel(V(cpphdl_n1544, Vss), V(cpphdl_n1552, Vss), 0.001, 0.69999999999999996, 1.0);
        // device 1135, IC IC190, analog/basic/inverter.hpp:11
        I(cpphdl_n1568, Vdd) <+ cpphdl_channel(V(cpphdl_n1552, Vdd), V(cpphdl_n1568, Vdd), 0.0040000000000000001, 0.69999999999999996, -1.0);
        // device 1136, IC IC190, analog/basic/inverter.hpp:12
        I(cpphdl_n1568, Vss) <+ cpphdl_channel(V(cpphdl_n1552, Vss), V(cpphdl_n1568, Vss), 0.0040000000000000001, 0.69999999999999996, 1.0);
        // device 1137, IC IC186, analog/basic/buffered_nand_latch.hpp:33
        I(cpphdl_n1544, Vss) <+ 2.0000000000000002e-15 * ddt(V(cpphdl_n1544, Vss)); // Bench initial voltage = 0.0 V.
        // device 1138, IC IC186, analog/basic/buffered_nand_latch.hpp:34
        I(cpphdl_n1544, cpphdl_n1552) <+ 1.0000000000000001e-15 * ddt(V(cpphdl_n1544, cpphdl_n1552)); // Bench initial voltage = 0.0 V.
        // device 1139, IC IC186, analog/basic/buffered_nand_latch.hpp:35
        I(cpphdl_n1552, Vss) <+ 5e-15 * ddt(V(cpphdl_n1552, Vss)); // Bench initial voltage = 0.0 V.
        // device 1140, IC IC186, analog/basic/buffered_nand_latch.hpp:36
        I(cpphdl_n1552, Vss) <+ 8.0000000000000006e-15 * ddt(V(cpphdl_n1552, Vss)); // Bench initial voltage = 0.0 V.
        // device 1141, IC IC186, analog/basic/buffered_nand_latch.hpp:37
        I(cpphdl_n1568, Vss) <+ 1e-14 * ddt(V(cpphdl_n1568, Vss)); // Bench initial voltage = 0.0 V.
        // device 1142, IC IC192, analog/basic/cmos_logic.hpp:15
        I(cpphdl_n2775, Vss) <+ 5.0000000000000002e-14 * ddt(V(cpphdl_n2775, Vss)); // Bench initial voltage = 0.0 V.
        // device 1143, IC IC192, analog/basic/cmos_logic.hpp:16
        I(cpphdl_n2775, Vdd) <+ cpphdl_channel(V(cpphdl_n1562, Vdd), V(cpphdl_n2775, Vdd), 0.01, 0.69999999999999996, -1.0);
        // device 1144, IC IC192, analog/basic/cmos_logic.hpp:17
        I(cpphdl_n2775, Vdd) <+ cpphdl_channel(V(cpphdl_n1570, Vdd), V(cpphdl_n2775, Vdd), 0.01, 0.69999999999999996, -1.0);
        // device 1145, IC IC192, analog/basic/cmos_logic.hpp:18
        I(cpphdl_n2775, cpphdl_n1565) <+ cpphdl_channel(V(cpphdl_n1562, cpphdl_n1565), V(cpphdl_n2775, cpphdl_n1565), 0.01, 0.69999999999999996, 1.0);
        // device 1146, IC IC192, analog/basic/cmos_logic.hpp:19
        I(cpphdl_n1565, Vss) <+ cpphdl_channel(V(cpphdl_n1570, Vss), V(cpphdl_n1565, Vss), 0.01, 0.69999999999999996, 1.0);
        // device 1147, IC IC192, analog/basic/cmos_logic.hpp:20
        I(cpphdl_n2775, Vss) <+ V(cpphdl_n2775, Vss) / 1000000000.0;
        // device 1148, IC IC192, analog/basic/cmos_logic.hpp:21
        I(cpphdl_n1565, Vss) <+ V(cpphdl_n1565, Vss) / 1000000000.0;
        // device 1149, IC IC193, analog/basic/cmos_logic.hpp:15
        I(cpphdl_n1570, Vss) <+ 5.0000000000000002e-14 * ddt(V(cpphdl_n1570, Vss)); // Bench initial voltage = 0.0 V.
        // device 1150, IC IC193, analog/basic/cmos_logic.hpp:16
        I(cpphdl_n1570, Vdd) <+ cpphdl_channel(V(cpphdl_n1568, Vdd), V(cpphdl_n1570, Vdd), 0.01, 0.69999999999999996, -1.0);
        // device 1151, IC IC193, analog/basic/cmos_logic.hpp:17
        I(cpphdl_n1570, Vdd) <+ cpphdl_channel(V(cpphdl_n2775, Vdd), V(cpphdl_n1570, Vdd), 0.01, 0.69999999999999996, -1.0);
        // device 1152, IC IC193, analog/basic/cmos_logic.hpp:18
        I(cpphdl_n1570, cpphdl_n1571) <+ cpphdl_channel(V(cpphdl_n1568, cpphdl_n1571), V(cpphdl_n1570, cpphdl_n1571), 0.01, 0.69999999999999996, 1.0);
        // device 1153, IC IC193, analog/basic/cmos_logic.hpp:19
        I(cpphdl_n1571, Vss) <+ cpphdl_channel(V(cpphdl_n2775, Vss), V(cpphdl_n1571, Vss), 0.01, 0.69999999999999996, 1.0);
        // device 1154, IC IC193, analog/basic/cmos_logic.hpp:20
        I(cpphdl_n1570, Vss) <+ V(cpphdl_n1570, Vss) / 1000000000.0;
        // device 1155, IC IC193, analog/basic/cmos_logic.hpp:21
        I(cpphdl_n1571, Vss) <+ V(cpphdl_n1571, Vss) / 1000000000.0;
        // device 1156, IC IC191, analog/basic/nand_latch.hpp:34
        I(cpphdl_n1562, Vss) <+ 2.9999999999999998e-15 * ddt(V(cpphdl_n1562, Vss)); // Bench initial voltage = 0.0 V.
        // device 1157, IC IC191, analog/basic/nand_latch.hpp:35
        I(cpphdl_n1568, Vss) <+ 2.9999999999999998e-15 * ddt(V(cpphdl_n1568, Vss)); // Bench initial voltage = 0.0 V.
        // device 1158, IC IC194, analog/basic/inverter.hpp:11
        I(cpphdl_n1576, Vdd) <+ cpphdl_channel(V(CLEAR, Vdd), V(cpphdl_n1576, Vdd), 0.01, 0.69999999999999996, -1.0);
        // device 1159, IC IC194, analog/basic/inverter.hpp:12
        I(cpphdl_n1576, Vss) <+ cpphdl_channel(V(CLEAR, Vss), V(cpphdl_n1576, Vss), 0.01, 0.69999999999999996, 1.0);
        // device 1160, IC IC191, analog/basic/nand_latch.hpp:56
        I(cpphdl_n1576, Vss) <+ 2.9999999999999998e-15 * ddt(V(cpphdl_n1576, Vss)); // Bench initial voltage = 0.0 V.
        // device 1161, IC IC191, analog/basic/nand_latch.hpp:57
        I(cpphdl_n2775, Vss) <+ cpphdl_channel(V(CLEAR, Vss), V(cpphdl_n2775, Vss), 0.050000000000000003, 0.69999999999999996, 1.0);
        // device 1162, IC IC191, analog/basic/nand_latch.hpp:58
        I(cpphdl_n1570, Vdd) <+ cpphdl_channel(V(cpphdl_n1576, Vdd), V(cpphdl_n1570, Vdd), 0.050000000000000003, 0.69999999999999996, -1.0);
        // device 1163, IC IC197, analog/basic/inverter.hpp:11
        I(cpphdl_n1600, Vdd) <+ cpphdl_channel(V(TRACK8, Vdd), V(cpphdl_n1600, Vdd), 0.0040000000000000001, 0.69999999999999996, -1.0);
        // device 1164, IC IC197, analog/basic/inverter.hpp:12
        I(cpphdl_n1600, Vss) <+ cpphdl_channel(V(TRACK8, Vss), V(cpphdl_n1600, Vss), 0.0040000000000000001, 0.69999999999999996, 1.0);
        // device 1165, IC IC196, analog/basic/mos_track_hold.hpp:30
        I(cpphdl_n1600, Vss) <+ 2e-14 * ddt(V(cpphdl_n1600, Vss)); // Bench initial voltage = 3.2999999999999998 V.
        // device 1166, IC IC196, analog/basic/mos_track_hold.hpp:31
        I(cpphdl_n2595, cpphdl_n1654) <+ cpphdl_channel(V(TRACK8, cpphdl_n1654), V(cpphdl_n2595, cpphdl_n1654), 0.02, 0.69999999999999996, 1.0);
        // device 1167, IC IC196, analog/basic/mos_track_hold.hpp:32
        I(cpphdl_n1654, cpphdl_n2595) <+ cpphdl_channel(V(cpphdl_n1600, cpphdl_n2595), V(cpphdl_n1654, cpphdl_n2595), 0.01, 0.69999999999999996, -1.0);
        // device 1168, IC IC196, analog/basic/mos_track_hold.hpp:36
        I(cpphdl_n1654, cpphdl_n1654) <+ cpphdl_channel(V(cpphdl_n1600, cpphdl_n1654), V(cpphdl_n1654, cpphdl_n1654), 0.01, 0.69999999999999996, 1.0);
        // device 1169, IC IC196, analog/basic/mos_track_hold.hpp:37
        I(cpphdl_n1654, cpphdl_n1654) <+ cpphdl_channel(V(TRACK8, cpphdl_n1654), V(cpphdl_n1654, cpphdl_n1654), 0.0050000000000000001, 0.69999999999999996, -1.0);
        // device 1170, IC IC196, analog/basic/mos_track_hold.hpp:38
        I(cpphdl_n1654, Vss) <+ 1.5000000000000001e-12 * ddt(V(cpphdl_n1654, Vss)); // Bench initial voltage = 1.6499999999999999 V.
        // device 1171, IC IC196, analog/basic/mos_track_hold.hpp:39
        I(Vss, cpphdl_n1654) <+ V(Vss, cpphdl_n1654) / 1000000000.0;
        // device 1172, IC IC196, analog/basic/mos_track_hold.hpp:40
        I(TRACK8, cpphdl_n1654) <+ 2.0000000000000002e-15 * ddt(V(TRACK8, cpphdl_n1654)); // Bench initial voltage = -1.6499999999999999 V.
        // device 1173, IC IC196, analog/basic/mos_track_hold.hpp:41
        I(cpphdl_n1600, cpphdl_n1654) <+ 2.0000000000000002e-15 * ddt(V(cpphdl_n1600, cpphdl_n1654)); // Bench initial voltage = 1.6499999999999999 V.
        // device 1174, IC IC196, analog/basic/mos_track_hold.hpp:42
        I(cpphdl_n2595, cpphdl_n1654) <+ 1.0000000000000001e-15 * ddt(V(cpphdl_n2595, cpphdl_n1654)); // Bench initial voltage = 0.0 V.
        // device 1175, IC IC199, analog/basic/inverter.hpp:11
        I(cpphdl_n1615, Vdd) <+ cpphdl_channel(V(BIT_N8_0, Vdd), V(cpphdl_n1615, Vdd), 0.080000000000000002, 0.69999999999999996, -1.0);
        // device 1176, IC IC199, analog/basic/inverter.hpp:12
        I(cpphdl_n1615, Vss) <+ cpphdl_channel(V(BIT_N8_0, Vss), V(cpphdl_n1615, Vss), 0.080000000000000002, 0.69999999999999996, 1.0);
        // device 1177, IC IC198, analog/basic/mos_r2r_dac.hpp:27
        I(cpphdl_n1615, Vss) <+ 2.9999999999999998e-15 * ddt(V(cpphdl_n1615, Vss)); // Bench initial voltage = 0.0 V.
        // device 1178, IC IC198, analog/basic/mos_r2r_dac.hpp:28
        I(cpphdl_n1615, cpphdl_n1644) <+ V(cpphdl_n1615, cpphdl_n1644) / 2000.0;
        // device 1179, IC IC198, analog/basic/mos_r2r_dac.hpp:29
        I(cpphdl_n1644, Vss) <+ 2.9999999999999998e-15 * ddt(V(cpphdl_n1644, Vss)); // Bench initial voltage = 0.0 V.
        // device 1180, IC IC200, analog/basic/inverter.hpp:11
        I(cpphdl_n1619, Vdd) <+ cpphdl_channel(V(BIT_N8_1, Vdd), V(cpphdl_n1619, Vdd), 0.080000000000000002, 0.69999999999999996, -1.0);
        // device 1181, IC IC200, analog/basic/inverter.hpp:12
        I(cpphdl_n1619, Vss) <+ cpphdl_channel(V(BIT_N8_1, Vss), V(cpphdl_n1619, Vss), 0.080000000000000002, 0.69999999999999996, 1.0);
        // device 1182, IC IC198, analog/basic/mos_r2r_dac.hpp:27
        I(cpphdl_n1619, Vss) <+ 2.9999999999999998e-15 * ddt(V(cpphdl_n1619, Vss)); // Bench initial voltage = 0.0 V.
        // device 1183, IC IC198, analog/basic/mos_r2r_dac.hpp:28
        I(cpphdl_n1619, cpphdl_n1645) <+ V(cpphdl_n1619, cpphdl_n1645) / 2000.0;
        // device 1184, IC IC198, analog/basic/mos_r2r_dac.hpp:29
        I(cpphdl_n1645, Vss) <+ 2.9999999999999998e-15 * ddt(V(cpphdl_n1645, Vss)); // Bench initial voltage = 0.0 V.
        // device 1185, IC IC198, analog/basic/mos_r2r_dac.hpp:31
        I(cpphdl_n1644, cpphdl_n1645) <+ V(cpphdl_n1644, cpphdl_n1645) / 1000.0;
        // device 1186, IC IC201, analog/basic/inverter.hpp:11
        I(cpphdl_n1623, Vdd) <+ cpphdl_channel(V(BIT_N8_2, Vdd), V(cpphdl_n1623, Vdd), 0.080000000000000002, 0.69999999999999996, -1.0);
        // device 1187, IC IC201, analog/basic/inverter.hpp:12
        I(cpphdl_n1623, Vss) <+ cpphdl_channel(V(BIT_N8_2, Vss), V(cpphdl_n1623, Vss), 0.080000000000000002, 0.69999999999999996, 1.0);
        // device 1188, IC IC198, analog/basic/mos_r2r_dac.hpp:27
        I(cpphdl_n1623, Vss) <+ 2.9999999999999998e-15 * ddt(V(cpphdl_n1623, Vss)); // Bench initial voltage = 0.0 V.
        // device 1189, IC IC198, analog/basic/mos_r2r_dac.hpp:28
        I(cpphdl_n1623, cpphdl_n1646) <+ V(cpphdl_n1623, cpphdl_n1646) / 2000.0;
        // device 1190, IC IC198, analog/basic/mos_r2r_dac.hpp:29
        I(cpphdl_n1646, Vss) <+ 2.9999999999999998e-15 * ddt(V(cpphdl_n1646, Vss)); // Bench initial voltage = 0.0 V.
        // device 1191, IC IC198, analog/basic/mos_r2r_dac.hpp:31
        I(cpphdl_n1645, cpphdl_n1646) <+ V(cpphdl_n1645, cpphdl_n1646) / 1000.0;
        // device 1192, IC IC202, analog/basic/inverter.hpp:11
        I(cpphdl_n1627, Vdd) <+ cpphdl_channel(V(BIT_N8_3, Vdd), V(cpphdl_n1627, Vdd), 0.080000000000000002, 0.69999999999999996, -1.0);
        // device 1193, IC IC202, analog/basic/inverter.hpp:12
        I(cpphdl_n1627, Vss) <+ cpphdl_channel(V(BIT_N8_3, Vss), V(cpphdl_n1627, Vss), 0.080000000000000002, 0.69999999999999996, 1.0);
        // device 1194, IC IC198, analog/basic/mos_r2r_dac.hpp:27
        I(cpphdl_n1627, Vss) <+ 2.9999999999999998e-15 * ddt(V(cpphdl_n1627, Vss)); // Bench initial voltage = 0.0 V.
        // device 1195, IC IC198, analog/basic/mos_r2r_dac.hpp:28
        I(cpphdl_n1627, cpphdl_n1647) <+ V(cpphdl_n1627, cpphdl_n1647) / 2000.0;
        // device 1196, IC IC198, analog/basic/mos_r2r_dac.hpp:29
        I(cpphdl_n1647, Vss) <+ 2.9999999999999998e-15 * ddt(V(cpphdl_n1647, Vss)); // Bench initial voltage = 0.0 V.
        // device 1197, IC IC198, analog/basic/mos_r2r_dac.hpp:31
        I(cpphdl_n1646, cpphdl_n1647) <+ V(cpphdl_n1646, cpphdl_n1647) / 1000.0;
        // device 1198, IC IC203, analog/basic/inverter.hpp:11
        I(cpphdl_n1631, Vdd) <+ cpphdl_channel(V(BIT_N8_4, Vdd), V(cpphdl_n1631, Vdd), 0.080000000000000002, 0.69999999999999996, -1.0);
        // device 1199, IC IC203, analog/basic/inverter.hpp:12
        I(cpphdl_n1631, Vss) <+ cpphdl_channel(V(BIT_N8_4, Vss), V(cpphdl_n1631, Vss), 0.080000000000000002, 0.69999999999999996, 1.0);
        // device 1200, IC IC198, analog/basic/mos_r2r_dac.hpp:27
        I(cpphdl_n1631, Vss) <+ 2.9999999999999998e-15 * ddt(V(cpphdl_n1631, Vss)); // Bench initial voltage = 0.0 V.
        // device 1201, IC IC198, analog/basic/mos_r2r_dac.hpp:28
        I(cpphdl_n1631, cpphdl_n1648) <+ V(cpphdl_n1631, cpphdl_n1648) / 2000.0;
        // device 1202, IC IC198, analog/basic/mos_r2r_dac.hpp:29
        I(cpphdl_n1648, Vss) <+ 2.9999999999999998e-15 * ddt(V(cpphdl_n1648, Vss)); // Bench initial voltage = 0.0 V.
        // device 1203, IC IC198, analog/basic/mos_r2r_dac.hpp:31
        I(cpphdl_n1647, cpphdl_n1648) <+ V(cpphdl_n1647, cpphdl_n1648) / 1000.0;
        // device 1204, IC IC204, analog/basic/inverter.hpp:11
        I(cpphdl_n1635, Vdd) <+ cpphdl_channel(V(BIT_N8_5, Vdd), V(cpphdl_n1635, Vdd), 0.080000000000000002, 0.69999999999999996, -1.0);
        // device 1205, IC IC204, analog/basic/inverter.hpp:12
        I(cpphdl_n1635, Vss) <+ cpphdl_channel(V(BIT_N8_5, Vss), V(cpphdl_n1635, Vss), 0.080000000000000002, 0.69999999999999996, 1.0);
        // device 1206, IC IC198, analog/basic/mos_r2r_dac.hpp:27
        I(cpphdl_n1635, Vss) <+ 2.9999999999999998e-15 * ddt(V(cpphdl_n1635, Vss)); // Bench initial voltage = 0.0 V.
        // device 1207, IC IC198, analog/basic/mos_r2r_dac.hpp:28
        I(cpphdl_n1635, cpphdl_n1649) <+ V(cpphdl_n1635, cpphdl_n1649) / 2000.0;
        // device 1208, IC IC198, analog/basic/mos_r2r_dac.hpp:29
        I(cpphdl_n1649, Vss) <+ 2.9999999999999998e-15 * ddt(V(cpphdl_n1649, Vss)); // Bench initial voltage = 0.0 V.
        // device 1209, IC IC198, analog/basic/mos_r2r_dac.hpp:31
        I(cpphdl_n1648, cpphdl_n1649) <+ V(cpphdl_n1648, cpphdl_n1649) / 1000.0;
        // device 1210, IC IC205, analog/basic/inverter.hpp:11
        I(cpphdl_n1639, Vdd) <+ cpphdl_channel(V(BIT_N8_6, Vdd), V(cpphdl_n1639, Vdd), 0.080000000000000002, 0.69999999999999996, -1.0);
        // device 1211, IC IC205, analog/basic/inverter.hpp:12
        I(cpphdl_n1639, Vss) <+ cpphdl_channel(V(BIT_N8_6, Vss), V(cpphdl_n1639, Vss), 0.080000000000000002, 0.69999999999999996, 1.0);
        // device 1212, IC IC198, analog/basic/mos_r2r_dac.hpp:27
        I(cpphdl_n1639, Vss) <+ 2.9999999999999998e-15 * ddt(V(cpphdl_n1639, Vss)); // Bench initial voltage = 0.0 V.
        // device 1213, IC IC198, analog/basic/mos_r2r_dac.hpp:28
        I(cpphdl_n1639, cpphdl_n1650) <+ V(cpphdl_n1639, cpphdl_n1650) / 2000.0;
        // device 1214, IC IC198, analog/basic/mos_r2r_dac.hpp:29
        I(cpphdl_n1650, Vss) <+ 2.9999999999999998e-15 * ddt(V(cpphdl_n1650, Vss)); // Bench initial voltage = 0.0 V.
        // device 1215, IC IC198, analog/basic/mos_r2r_dac.hpp:31
        I(cpphdl_n1649, cpphdl_n1650) <+ V(cpphdl_n1649, cpphdl_n1650) / 1000.0;
        // device 1216, IC IC206, analog/basic/inverter.hpp:11
        I(cpphdl_n1643, Vdd) <+ cpphdl_channel(V(BIT_N8_7, Vdd), V(cpphdl_n1643, Vdd), 0.080000000000000002, 0.69999999999999996, -1.0);
        // device 1217, IC IC206, analog/basic/inverter.hpp:12
        I(cpphdl_n1643, Vss) <+ cpphdl_channel(V(BIT_N8_7, Vss), V(cpphdl_n1643, Vss), 0.080000000000000002, 0.69999999999999996, 1.0);
        // device 1218, IC IC198, analog/basic/mos_r2r_dac.hpp:27
        I(cpphdl_n1643, Vss) <+ 2.9999999999999998e-15 * ddt(V(cpphdl_n1643, Vss)); // Bench initial voltage = 0.0 V.
        // device 1219, IC IC198, analog/basic/mos_r2r_dac.hpp:28
        I(cpphdl_n1643, cpphdl_n1655) <+ V(cpphdl_n1643, cpphdl_n1655) / 2000.0;
        // device 1220, IC IC198, analog/basic/mos_r2r_dac.hpp:29
        I(cpphdl_n1655, Vss) <+ 2.9999999999999998e-15 * ddt(V(cpphdl_n1655, Vss)); // Bench initial voltage = 0.0 V.
        // device 1221, IC IC198, analog/basic/mos_r2r_dac.hpp:31
        I(cpphdl_n1650, cpphdl_n1655) <+ V(cpphdl_n1650, cpphdl_n1655) / 1000.0;
        // device 1222, IC IC198, analog/basic/mos_r2r_dac.hpp:33
        I(Vss, cpphdl_n1644) <+ V(Vss, cpphdl_n1644) / 2000.0;
        // device 1223, IC IC207, analog/basic/nmos_resistor_amplifier.hpp:23
        I(Vdd, cpphdl_n1664) <+ V(Vdd, cpphdl_n1664) / 500.0;
        // device 1224, IC IC207, analog/basic/nmos_resistor_amplifier.hpp:24
        I(Vdd, cpphdl_n1663) <+ V(Vdd, cpphdl_n1663) / 500.0;
        // device 1225, IC IC207, analog/basic/nmos_resistor_amplifier.hpp:25
        I(cpphdl_n1664, cpphdl_n1658) <+ cpphdl_channel(V(cpphdl_n1654, cpphdl_n1658), V(cpphdl_n1664, cpphdl_n1658), 0.014999999999999999, 0.69999999999999996, 1.0);
        // device 1226, IC IC207, analog/basic/nmos_resistor_amplifier.hpp:26
        I(cpphdl_n1663, cpphdl_n1659) <+ cpphdl_channel(V(cpphdl_n1655, cpphdl_n1659), V(cpphdl_n1663, cpphdl_n1659), 0.014999999999999999, 0.69999999999999996, 1.0);
        // device 1227, IC IC207, analog/basic/nmos_resistor_amplifier.hpp:27
        I(cpphdl_n1660, cpphdl_n1658) <+ V(cpphdl_n1660, cpphdl_n1658) / 50.0;
        // device 1228, IC IC207, analog/basic/nmos_resistor_amplifier.hpp:28
        I(cpphdl_n1660, cpphdl_n1659) <+ V(cpphdl_n1660, cpphdl_n1659) / 50.0;
        // device 1229, IC IC207, analog/basic/nmos_resistor_amplifier.hpp:29
        I(Vss, cpphdl_n1660) <+ V(Vss, cpphdl_n1660) / 150.0;
        // device 1230, IC IC207, analog/basic/nmos_resistor_amplifier.hpp:30
        I(cpphdl_n1664, Vdd) <+ 2.9999999999999998e-13 * ddt(V(cpphdl_n1664, Vdd)); // Bench initial voltage = 0.0 V.
        // device 1231, IC IC207, analog/basic/nmos_resistor_amplifier.hpp:31
        I(cpphdl_n1663, Vdd) <+ 2.9999999999999998e-13 * ddt(V(cpphdl_n1663, Vdd)); // Bench initial voltage = 0.0 V.
        // device 1232, IC IC207, analog/basic/nmos_resistor_amplifier.hpp:32
        I(cpphdl_n1660, Vss) <+ 4e-14 * ddt(V(cpphdl_n1660, Vss)); // Bench initial voltage = 0.0 V.
        // device 1233, IC IC207, analog/basic/nmos_resistor_amplifier.hpp:34
        I(cpphdl_n1654, cpphdl_n1658) <+ 2e-14 * ddt(V(cpphdl_n1654, cpphdl_n1658)); // Bench initial voltage = 1.6499999999999999 V.
        // device 1234, IC IC207, analog/basic/nmos_resistor_amplifier.hpp:35
        I(cpphdl_n1655, cpphdl_n1659) <+ 2e-14 * ddt(V(cpphdl_n1655, cpphdl_n1659)); // Bench initial voltage = 0.0 V.
        // device 1235, IC IC207, analog/basic/nmos_resistor_amplifier.hpp:36
        I(cpphdl_n1654, cpphdl_n1664) <+ 2.9999999999999998e-15 * ddt(V(cpphdl_n1654, cpphdl_n1664)); // Bench initial voltage = -1.6499999999999999 V.
        // device 1236, IC IC207, analog/basic/nmos_resistor_amplifier.hpp:37
        I(cpphdl_n1655, cpphdl_n1663) <+ 2.9999999999999998e-15 * ddt(V(cpphdl_n1655, cpphdl_n1663)); // Bench initial voltage = -3.2999999999999998 V.
        // device 1237, IC IC208, analog/basic/strongarm_comparator.hpp:28
        I(cpphdl_n1668, cpphdl_n1670) <+ cpphdl_channel(V(cpphdl_n1663, cpphdl_n1670), V(cpphdl_n1668, cpphdl_n1670), 0.0080000000000000002, 0.69999999999999996, 1.0);
        // device 1238, IC IC208, analog/basic/strongarm_comparator.hpp:29
        I(cpphdl_n1669, cpphdl_n1670) <+ cpphdl_channel(V(cpphdl_n1664, cpphdl_n1670), V(cpphdl_n1669, cpphdl_n1670), 0.0080000000000000002, 0.69999999999999996, 1.0);
        // device 1239, IC IC208, analog/basic/strongarm_comparator.hpp:30
        I(cpphdl_n1670, Vss) <+ cpphdl_channel(V(EVALUATE, Vss), V(cpphdl_n1670, Vss), 0.0080000000000000002, 0.69999999999999996, 1.0);
        // device 1240, IC IC208, analog/basic/strongarm_comparator.hpp:33
        I(cpphdl_n1683, cpphdl_n1668) <+ cpphdl_channel(V(cpphdl_n1687, cpphdl_n1668), V(cpphdl_n1683, cpphdl_n1668), 0.0040000000000000001, 0.69999999999999996, 1.0);
        // device 1241, IC IC208, analog/basic/strongarm_comparator.hpp:34
        I(cpphdl_n1687, cpphdl_n1669) <+ cpphdl_channel(V(cpphdl_n1683, cpphdl_n1669), V(cpphdl_n1687, cpphdl_n1669), 0.0040000000000000001, 0.69999999999999996, 1.0);
        // device 1242, IC IC208, analog/basic/strongarm_comparator.hpp:35
        I(cpphdl_n1687, Vdd) <+ cpphdl_channel(V(cpphdl_n1683, Vdd), V(cpphdl_n1687, Vdd), 0.002, 0.69999999999999996, -1.0);
        // device 1243, IC IC208, analog/basic/strongarm_comparator.hpp:36
        I(cpphdl_n1683, Vdd) <+ cpphdl_channel(V(cpphdl_n1687, Vdd), V(cpphdl_n1683, Vdd), 0.002, 0.69999999999999996, -1.0);
        // device 1244, IC IC208, analog/basic/strongarm_comparator.hpp:38
        I(cpphdl_n1668, Vdd) <+ cpphdl_channel(V(EVALUATE, Vdd), V(cpphdl_n1668, Vdd), 0.002, 0.69999999999999996, -1.0);
        // device 1245, IC IC208, analog/basic/strongarm_comparator.hpp:39
        I(cpphdl_n1669, Vdd) <+ cpphdl_channel(V(EVALUATE, Vdd), V(cpphdl_n1669, Vdd), 0.002, 0.69999999999999996, -1.0);
        // device 1246, IC IC208, analog/basic/strongarm_comparator.hpp:40
        I(cpphdl_n1687, Vdd) <+ cpphdl_channel(V(EVALUATE, Vdd), V(cpphdl_n1687, Vdd), 0.002, 0.69999999999999996, -1.0);
        // device 1247, IC IC208, analog/basic/strongarm_comparator.hpp:41
        I(cpphdl_n1683, Vdd) <+ cpphdl_channel(V(EVALUATE, Vdd), V(cpphdl_n1683, Vdd), 0.002, 0.69999999999999996, -1.0);
        // device 1248, IC IC208, analog/basic/strongarm_comparator.hpp:42
        I(cpphdl_n1668, Vss) <+ 2.9999999999999998e-14 * ddt(V(cpphdl_n1668, Vss)); // Bench initial voltage = 0.0 V.
        // device 1249, IC IC208, analog/basic/strongarm_comparator.hpp:43
        I(cpphdl_n1669, Vss) <+ 2.9999999999999998e-14 * ddt(V(cpphdl_n1669, Vss)); // Bench initial voltage = 0.0 V.
        // device 1250, IC IC208, analog/basic/strongarm_comparator.hpp:44
        I(cpphdl_n1670, Vss) <+ 2.9999999999999998e-14 * ddt(V(cpphdl_n1670, Vss)); // Bench initial voltage = 0.0 V.
        // device 1251, IC IC208, analog/basic/strongarm_comparator.hpp:45
        I(cpphdl_n1687, Vss) <+ 5.0000000000000002e-14 * ddt(V(cpphdl_n1687, Vss)); // Bench initial voltage = 0.0 V.
        // device 1252, IC IC208, analog/basic/strongarm_comparator.hpp:46
        I(cpphdl_n1683, Vss) <+ 5.0000000000000002e-14 * ddt(V(cpphdl_n1683, Vss)); // Bench initial voltage = 0.0 V.
        // device 1253, IC IC208, analog/basic/strongarm_comparator.hpp:47
        I(cpphdl_n1663, cpphdl_n1670) <+ 2e-14 * ddt(V(cpphdl_n1663, cpphdl_n1670)); // Bench initial voltage = 3.2999999999999998 V.
        // device 1254, IC IC208, analog/basic/strongarm_comparator.hpp:48
        I(cpphdl_n1664, cpphdl_n1670) <+ 2e-14 * ddt(V(cpphdl_n1664, cpphdl_n1670)); // Bench initial voltage = 3.2999999999999998 V.
        // device 1255, IC IC208, analog/basic/strongarm_comparator.hpp:49
        I(cpphdl_n1663, cpphdl_n1668) <+ 2.9999999999999998e-15 * ddt(V(cpphdl_n1663, cpphdl_n1668)); // Bench initial voltage = 3.2999999999999998 V.
        // device 1256, IC IC208, analog/basic/strongarm_comparator.hpp:50
        I(cpphdl_n1664, cpphdl_n1669) <+ 2.9999999999999998e-15 * ddt(V(cpphdl_n1664, cpphdl_n1669)); // Bench initial voltage = 3.2999999999999998 V.
        // device 1257, IC IC210, analog/basic/inverter.hpp:11
        I(cpphdl_n1691, Vdd) <+ cpphdl_channel(V(cpphdl_n1683, Vdd), V(cpphdl_n1691, Vdd), 0.001, 0.69999999999999996, -1.0);
        // device 1258, IC IC210, analog/basic/inverter.hpp:12
        I(cpphdl_n1691, Vss) <+ cpphdl_channel(V(cpphdl_n1683, Vss), V(cpphdl_n1691, Vss), 0.001, 0.69999999999999996, 1.0);
        // device 1259, IC IC212, analog/basic/inverter.hpp:11
        I(cpphdl_n1705, Vdd) <+ cpphdl_channel(V(cpphdl_n1691, Vdd), V(cpphdl_n1705, Vdd), 0.0040000000000000001, 0.69999999999999996, -1.0);
        // device 1260, IC IC212, analog/basic/inverter.hpp:12
        I(cpphdl_n1705, Vss) <+ cpphdl_channel(V(cpphdl_n1691, Vss), V(cpphdl_n1705, Vss), 0.0040000000000000001, 0.69999999999999996, 1.0);
        // device 1261, IC IC209, analog/basic/buffered_nand_latch.hpp:33
        I(cpphdl_n1683, Vss) <+ 2.0000000000000002e-15 * ddt(V(cpphdl_n1683, Vss)); // Bench initial voltage = 0.0 V.
        // device 1262, IC IC209, analog/basic/buffered_nand_latch.hpp:34
        I(cpphdl_n1683, cpphdl_n1691) <+ 1.0000000000000001e-15 * ddt(V(cpphdl_n1683, cpphdl_n1691)); // Bench initial voltage = 0.0 V.
        // device 1263, IC IC209, analog/basic/buffered_nand_latch.hpp:35
        I(cpphdl_n1691, Vss) <+ 5e-15 * ddt(V(cpphdl_n1691, Vss)); // Bench initial voltage = 0.0 V.
        // device 1264, IC IC209, analog/basic/buffered_nand_latch.hpp:36
        I(cpphdl_n1691, Vss) <+ 8.0000000000000006e-15 * ddt(V(cpphdl_n1691, Vss)); // Bench initial voltage = 0.0 V.
        // device 1265, IC IC209, analog/basic/buffered_nand_latch.hpp:37
        I(cpphdl_n1705, Vss) <+ 1e-14 * ddt(V(cpphdl_n1705, Vss)); // Bench initial voltage = 0.0 V.
        // device 1266, IC IC211, analog/basic/inverter.hpp:11
        I(cpphdl_n1695, Vdd) <+ cpphdl_channel(V(cpphdl_n1687, Vdd), V(cpphdl_n1695, Vdd), 0.001, 0.69999999999999996, -1.0);
        // device 1267, IC IC211, analog/basic/inverter.hpp:12
        I(cpphdl_n1695, Vss) <+ cpphdl_channel(V(cpphdl_n1687, Vss), V(cpphdl_n1695, Vss), 0.001, 0.69999999999999996, 1.0);
        // device 1268, IC IC213, analog/basic/inverter.hpp:11
        I(cpphdl_n1711, Vdd) <+ cpphdl_channel(V(cpphdl_n1695, Vdd), V(cpphdl_n1711, Vdd), 0.0040000000000000001, 0.69999999999999996, -1.0);
        // device 1269, IC IC213, analog/basic/inverter.hpp:12
        I(cpphdl_n1711, Vss) <+ cpphdl_channel(V(cpphdl_n1695, Vss), V(cpphdl_n1711, Vss), 0.0040000000000000001, 0.69999999999999996, 1.0);
        // device 1270, IC IC209, analog/basic/buffered_nand_latch.hpp:33
        I(cpphdl_n1687, Vss) <+ 2.0000000000000002e-15 * ddt(V(cpphdl_n1687, Vss)); // Bench initial voltage = 0.0 V.
        // device 1271, IC IC209, analog/basic/buffered_nand_latch.hpp:34
        I(cpphdl_n1687, cpphdl_n1695) <+ 1.0000000000000001e-15 * ddt(V(cpphdl_n1687, cpphdl_n1695)); // Bench initial voltage = 0.0 V.
        // device 1272, IC IC209, analog/basic/buffered_nand_latch.hpp:35
        I(cpphdl_n1695, Vss) <+ 5e-15 * ddt(V(cpphdl_n1695, Vss)); // Bench initial voltage = 0.0 V.
        // device 1273, IC IC209, analog/basic/buffered_nand_latch.hpp:36
        I(cpphdl_n1695, Vss) <+ 8.0000000000000006e-15 * ddt(V(cpphdl_n1695, Vss)); // Bench initial voltage = 0.0 V.
        // device 1274, IC IC209, analog/basic/buffered_nand_latch.hpp:37
        I(cpphdl_n1711, Vss) <+ 1e-14 * ddt(V(cpphdl_n1711, Vss)); // Bench initial voltage = 0.0 V.
        // device 1275, IC IC215, analog/basic/cmos_logic.hpp:15
        I(cpphdl_n2780, Vss) <+ 5.0000000000000002e-14 * ddt(V(cpphdl_n2780, Vss)); // Bench initial voltage = 0.0 V.
        // device 1276, IC IC215, analog/basic/cmos_logic.hpp:16
        I(cpphdl_n2780, Vdd) <+ cpphdl_channel(V(cpphdl_n1705, Vdd), V(cpphdl_n2780, Vdd), 0.01, 0.69999999999999996, -1.0);
        // device 1277, IC IC215, analog/basic/cmos_logic.hpp:17
        I(cpphdl_n2780, Vdd) <+ cpphdl_channel(V(cpphdl_n1713, Vdd), V(cpphdl_n2780, Vdd), 0.01, 0.69999999999999996, -1.0);
        // device 1278, IC IC215, analog/basic/cmos_logic.hpp:18
        I(cpphdl_n2780, cpphdl_n1708) <+ cpphdl_channel(V(cpphdl_n1705, cpphdl_n1708), V(cpphdl_n2780, cpphdl_n1708), 0.01, 0.69999999999999996, 1.0);
        // device 1279, IC IC215, analog/basic/cmos_logic.hpp:19
        I(cpphdl_n1708, Vss) <+ cpphdl_channel(V(cpphdl_n1713, Vss), V(cpphdl_n1708, Vss), 0.01, 0.69999999999999996, 1.0);
        // device 1280, IC IC215, analog/basic/cmos_logic.hpp:20
        I(cpphdl_n2780, Vss) <+ V(cpphdl_n2780, Vss) / 1000000000.0;
        // device 1281, IC IC215, analog/basic/cmos_logic.hpp:21
        I(cpphdl_n1708, Vss) <+ V(cpphdl_n1708, Vss) / 1000000000.0;
        // device 1282, IC IC216, analog/basic/cmos_logic.hpp:15
        I(cpphdl_n1713, Vss) <+ 5.0000000000000002e-14 * ddt(V(cpphdl_n1713, Vss)); // Bench initial voltage = 0.0 V.
        // device 1283, IC IC216, analog/basic/cmos_logic.hpp:16
        I(cpphdl_n1713, Vdd) <+ cpphdl_channel(V(cpphdl_n1711, Vdd), V(cpphdl_n1713, Vdd), 0.01, 0.69999999999999996, -1.0);
        // device 1284, IC IC216, analog/basic/cmos_logic.hpp:17
        I(cpphdl_n1713, Vdd) <+ cpphdl_channel(V(cpphdl_n2780, Vdd), V(cpphdl_n1713, Vdd), 0.01, 0.69999999999999996, -1.0);
        // device 1285, IC IC216, analog/basic/cmos_logic.hpp:18
        I(cpphdl_n1713, cpphdl_n1714) <+ cpphdl_channel(V(cpphdl_n1711, cpphdl_n1714), V(cpphdl_n1713, cpphdl_n1714), 0.01, 0.69999999999999996, 1.0);
        // device 1286, IC IC216, analog/basic/cmos_logic.hpp:19
        I(cpphdl_n1714, Vss) <+ cpphdl_channel(V(cpphdl_n2780, Vss), V(cpphdl_n1714, Vss), 0.01, 0.69999999999999996, 1.0);
        // device 1287, IC IC216, analog/basic/cmos_logic.hpp:20
        I(cpphdl_n1713, Vss) <+ V(cpphdl_n1713, Vss) / 1000000000.0;
        // device 1288, IC IC216, analog/basic/cmos_logic.hpp:21
        I(cpphdl_n1714, Vss) <+ V(cpphdl_n1714, Vss) / 1000000000.0;
        // device 1289, IC IC214, analog/basic/nand_latch.hpp:34
        I(cpphdl_n1705, Vss) <+ 2.9999999999999998e-15 * ddt(V(cpphdl_n1705, Vss)); // Bench initial voltage = 0.0 V.
        // device 1290, IC IC214, analog/basic/nand_latch.hpp:35
        I(cpphdl_n1711, Vss) <+ 2.9999999999999998e-15 * ddt(V(cpphdl_n1711, Vss)); // Bench initial voltage = 0.0 V.
        // device 1291, IC IC217, analog/basic/inverter.hpp:11
        I(cpphdl_n1719, Vdd) <+ cpphdl_channel(V(CLEAR, Vdd), V(cpphdl_n1719, Vdd), 0.01, 0.69999999999999996, -1.0);
        // device 1292, IC IC217, analog/basic/inverter.hpp:12
        I(cpphdl_n1719, Vss) <+ cpphdl_channel(V(CLEAR, Vss), V(cpphdl_n1719, Vss), 0.01, 0.69999999999999996, 1.0);
        // device 1293, IC IC214, analog/basic/nand_latch.hpp:56
        I(cpphdl_n1719, Vss) <+ 2.9999999999999998e-15 * ddt(V(cpphdl_n1719, Vss)); // Bench initial voltage = 0.0 V.
        // device 1294, IC IC214, analog/basic/nand_latch.hpp:57
        I(cpphdl_n2780, Vss) <+ cpphdl_channel(V(CLEAR, Vss), V(cpphdl_n2780, Vss), 0.050000000000000003, 0.69999999999999996, 1.0);
        // device 1295, IC IC214, analog/basic/nand_latch.hpp:58
        I(cpphdl_n1713, Vdd) <+ cpphdl_channel(V(cpphdl_n1719, Vdd), V(cpphdl_n1713, Vdd), 0.050000000000000003, 0.69999999999999996, -1.0);
        // device 1296, IC IC220, analog/basic/inverter.hpp:11
        I(cpphdl_n1743, Vdd) <+ cpphdl_channel(V(TRACK9, Vdd), V(cpphdl_n1743, Vdd), 0.0040000000000000001, 0.69999999999999996, -1.0);
        // device 1297, IC IC220, analog/basic/inverter.hpp:12
        I(cpphdl_n1743, Vss) <+ cpphdl_channel(V(TRACK9, Vss), V(cpphdl_n1743, Vss), 0.0040000000000000001, 0.69999999999999996, 1.0);
        // device 1298, IC IC219, analog/basic/mos_track_hold.hpp:30
        I(cpphdl_n1743, Vss) <+ 2e-14 * ddt(V(cpphdl_n1743, Vss)); // Bench initial voltage = 3.2999999999999998 V.
        // device 1299, IC IC219, analog/basic/mos_track_hold.hpp:31
        I(cpphdl_n2595, cpphdl_n1797) <+ cpphdl_channel(V(TRACK9, cpphdl_n1797), V(cpphdl_n2595, cpphdl_n1797), 0.02, 0.69999999999999996, 1.0);
        // device 1300, IC IC219, analog/basic/mos_track_hold.hpp:32
        I(cpphdl_n1797, cpphdl_n2595) <+ cpphdl_channel(V(cpphdl_n1743, cpphdl_n2595), V(cpphdl_n1797, cpphdl_n2595), 0.01, 0.69999999999999996, -1.0);
        // device 1301, IC IC219, analog/basic/mos_track_hold.hpp:36
        I(cpphdl_n1797, cpphdl_n1797) <+ cpphdl_channel(V(cpphdl_n1743, cpphdl_n1797), V(cpphdl_n1797, cpphdl_n1797), 0.01, 0.69999999999999996, 1.0);
        // device 1302, IC IC219, analog/basic/mos_track_hold.hpp:37
        I(cpphdl_n1797, cpphdl_n1797) <+ cpphdl_channel(V(TRACK9, cpphdl_n1797), V(cpphdl_n1797, cpphdl_n1797), 0.0050000000000000001, 0.69999999999999996, -1.0);
        // device 1303, IC IC219, analog/basic/mos_track_hold.hpp:38
        I(cpphdl_n1797, Vss) <+ 1.5000000000000001e-12 * ddt(V(cpphdl_n1797, Vss)); // Bench initial voltage = 1.6499999999999999 V.
        // device 1304, IC IC219, analog/basic/mos_track_hold.hpp:39
        I(Vss, cpphdl_n1797) <+ V(Vss, cpphdl_n1797) / 1000000000.0;
        // device 1305, IC IC219, analog/basic/mos_track_hold.hpp:40
        I(TRACK9, cpphdl_n1797) <+ 2.0000000000000002e-15 * ddt(V(TRACK9, cpphdl_n1797)); // Bench initial voltage = -1.6499999999999999 V.
        // device 1306, IC IC219, analog/basic/mos_track_hold.hpp:41
        I(cpphdl_n1743, cpphdl_n1797) <+ 2.0000000000000002e-15 * ddt(V(cpphdl_n1743, cpphdl_n1797)); // Bench initial voltage = 1.6499999999999999 V.
        // device 1307, IC IC219, analog/basic/mos_track_hold.hpp:42
        I(cpphdl_n2595, cpphdl_n1797) <+ 1.0000000000000001e-15 * ddt(V(cpphdl_n2595, cpphdl_n1797)); // Bench initial voltage = 0.0 V.
        // device 1308, IC IC222, analog/basic/inverter.hpp:11
        I(cpphdl_n1758, Vdd) <+ cpphdl_channel(V(BIT_N9_0, Vdd), V(cpphdl_n1758, Vdd), 0.080000000000000002, 0.69999999999999996, -1.0);
        // device 1309, IC IC222, analog/basic/inverter.hpp:12
        I(cpphdl_n1758, Vss) <+ cpphdl_channel(V(BIT_N9_0, Vss), V(cpphdl_n1758, Vss), 0.080000000000000002, 0.69999999999999996, 1.0);
        // device 1310, IC IC221, analog/basic/mos_r2r_dac.hpp:27
        I(cpphdl_n1758, Vss) <+ 2.9999999999999998e-15 * ddt(V(cpphdl_n1758, Vss)); // Bench initial voltage = 0.0 V.
        // device 1311, IC IC221, analog/basic/mos_r2r_dac.hpp:28
        I(cpphdl_n1758, cpphdl_n1787) <+ V(cpphdl_n1758, cpphdl_n1787) / 2000.0;
        // device 1312, IC IC221, analog/basic/mos_r2r_dac.hpp:29
        I(cpphdl_n1787, Vss) <+ 2.9999999999999998e-15 * ddt(V(cpphdl_n1787, Vss)); // Bench initial voltage = 0.0 V.
        // device 1313, IC IC223, analog/basic/inverter.hpp:11
        I(cpphdl_n1762, Vdd) <+ cpphdl_channel(V(BIT_N9_1, Vdd), V(cpphdl_n1762, Vdd), 0.080000000000000002, 0.69999999999999996, -1.0);
        // device 1314, IC IC223, analog/basic/inverter.hpp:12
        I(cpphdl_n1762, Vss) <+ cpphdl_channel(V(BIT_N9_1, Vss), V(cpphdl_n1762, Vss), 0.080000000000000002, 0.69999999999999996, 1.0);
        // device 1315, IC IC221, analog/basic/mos_r2r_dac.hpp:27
        I(cpphdl_n1762, Vss) <+ 2.9999999999999998e-15 * ddt(V(cpphdl_n1762, Vss)); // Bench initial voltage = 0.0 V.
        // device 1316, IC IC221, analog/basic/mos_r2r_dac.hpp:28
        I(cpphdl_n1762, cpphdl_n1788) <+ V(cpphdl_n1762, cpphdl_n1788) / 2000.0;
        // device 1317, IC IC221, analog/basic/mos_r2r_dac.hpp:29
        I(cpphdl_n1788, Vss) <+ 2.9999999999999998e-15 * ddt(V(cpphdl_n1788, Vss)); // Bench initial voltage = 0.0 V.
        // device 1318, IC IC221, analog/basic/mos_r2r_dac.hpp:31
        I(cpphdl_n1787, cpphdl_n1788) <+ V(cpphdl_n1787, cpphdl_n1788) / 1000.0;
        // device 1319, IC IC224, analog/basic/inverter.hpp:11
        I(cpphdl_n1766, Vdd) <+ cpphdl_channel(V(BIT_N9_2, Vdd), V(cpphdl_n1766, Vdd), 0.080000000000000002, 0.69999999999999996, -1.0);
        // device 1320, IC IC224, analog/basic/inverter.hpp:12
        I(cpphdl_n1766, Vss) <+ cpphdl_channel(V(BIT_N9_2, Vss), V(cpphdl_n1766, Vss), 0.080000000000000002, 0.69999999999999996, 1.0);
        // device 1321, IC IC221, analog/basic/mos_r2r_dac.hpp:27
        I(cpphdl_n1766, Vss) <+ 2.9999999999999998e-15 * ddt(V(cpphdl_n1766, Vss)); // Bench initial voltage = 0.0 V.
        // device 1322, IC IC221, analog/basic/mos_r2r_dac.hpp:28
        I(cpphdl_n1766, cpphdl_n1789) <+ V(cpphdl_n1766, cpphdl_n1789) / 2000.0;
        // device 1323, IC IC221, analog/basic/mos_r2r_dac.hpp:29
        I(cpphdl_n1789, Vss) <+ 2.9999999999999998e-15 * ddt(V(cpphdl_n1789, Vss)); // Bench initial voltage = 0.0 V.
        // device 1324, IC IC221, analog/basic/mos_r2r_dac.hpp:31
        I(cpphdl_n1788, cpphdl_n1789) <+ V(cpphdl_n1788, cpphdl_n1789) / 1000.0;
        // device 1325, IC IC225, analog/basic/inverter.hpp:11
        I(cpphdl_n1770, Vdd) <+ cpphdl_channel(V(BIT_N9_3, Vdd), V(cpphdl_n1770, Vdd), 0.080000000000000002, 0.69999999999999996, -1.0);
        // device 1326, IC IC225, analog/basic/inverter.hpp:12
        I(cpphdl_n1770, Vss) <+ cpphdl_channel(V(BIT_N9_3, Vss), V(cpphdl_n1770, Vss), 0.080000000000000002, 0.69999999999999996, 1.0);
        // device 1327, IC IC221, analog/basic/mos_r2r_dac.hpp:27
        I(cpphdl_n1770, Vss) <+ 2.9999999999999998e-15 * ddt(V(cpphdl_n1770, Vss)); // Bench initial voltage = 0.0 V.
        // device 1328, IC IC221, analog/basic/mos_r2r_dac.hpp:28
        I(cpphdl_n1770, cpphdl_n1790) <+ V(cpphdl_n1770, cpphdl_n1790) / 2000.0;
        // device 1329, IC IC221, analog/basic/mos_r2r_dac.hpp:29
        I(cpphdl_n1790, Vss) <+ 2.9999999999999998e-15 * ddt(V(cpphdl_n1790, Vss)); // Bench initial voltage = 0.0 V.
        // device 1330, IC IC221, analog/basic/mos_r2r_dac.hpp:31
        I(cpphdl_n1789, cpphdl_n1790) <+ V(cpphdl_n1789, cpphdl_n1790) / 1000.0;
        // device 1331, IC IC226, analog/basic/inverter.hpp:11
        I(cpphdl_n1774, Vdd) <+ cpphdl_channel(V(BIT_N9_4, Vdd), V(cpphdl_n1774, Vdd), 0.080000000000000002, 0.69999999999999996, -1.0);
        // device 1332, IC IC226, analog/basic/inverter.hpp:12
        I(cpphdl_n1774, Vss) <+ cpphdl_channel(V(BIT_N9_4, Vss), V(cpphdl_n1774, Vss), 0.080000000000000002, 0.69999999999999996, 1.0);
        // device 1333, IC IC221, analog/basic/mos_r2r_dac.hpp:27
        I(cpphdl_n1774, Vss) <+ 2.9999999999999998e-15 * ddt(V(cpphdl_n1774, Vss)); // Bench initial voltage = 0.0 V.
        // device 1334, IC IC221, analog/basic/mos_r2r_dac.hpp:28
        I(cpphdl_n1774, cpphdl_n1791) <+ V(cpphdl_n1774, cpphdl_n1791) / 2000.0;
        // device 1335, IC IC221, analog/basic/mos_r2r_dac.hpp:29
        I(cpphdl_n1791, Vss) <+ 2.9999999999999998e-15 * ddt(V(cpphdl_n1791, Vss)); // Bench initial voltage = 0.0 V.
        // device 1336, IC IC221, analog/basic/mos_r2r_dac.hpp:31
        I(cpphdl_n1790, cpphdl_n1791) <+ V(cpphdl_n1790, cpphdl_n1791) / 1000.0;
        // device 1337, IC IC227, analog/basic/inverter.hpp:11
        I(cpphdl_n1778, Vdd) <+ cpphdl_channel(V(BIT_N9_5, Vdd), V(cpphdl_n1778, Vdd), 0.080000000000000002, 0.69999999999999996, -1.0);
        // device 1338, IC IC227, analog/basic/inverter.hpp:12
        I(cpphdl_n1778, Vss) <+ cpphdl_channel(V(BIT_N9_5, Vss), V(cpphdl_n1778, Vss), 0.080000000000000002, 0.69999999999999996, 1.0);
        // device 1339, IC IC221, analog/basic/mos_r2r_dac.hpp:27
        I(cpphdl_n1778, Vss) <+ 2.9999999999999998e-15 * ddt(V(cpphdl_n1778, Vss)); // Bench initial voltage = 0.0 V.
        // device 1340, IC IC221, analog/basic/mos_r2r_dac.hpp:28
        I(cpphdl_n1778, cpphdl_n1792) <+ V(cpphdl_n1778, cpphdl_n1792) / 2000.0;
        // device 1341, IC IC221, analog/basic/mos_r2r_dac.hpp:29
        I(cpphdl_n1792, Vss) <+ 2.9999999999999998e-15 * ddt(V(cpphdl_n1792, Vss)); // Bench initial voltage = 0.0 V.
        // device 1342, IC IC221, analog/basic/mos_r2r_dac.hpp:31
        I(cpphdl_n1791, cpphdl_n1792) <+ V(cpphdl_n1791, cpphdl_n1792) / 1000.0;
        // device 1343, IC IC228, analog/basic/inverter.hpp:11
        I(cpphdl_n1782, Vdd) <+ cpphdl_channel(V(BIT_N9_6, Vdd), V(cpphdl_n1782, Vdd), 0.080000000000000002, 0.69999999999999996, -1.0);
        // device 1344, IC IC228, analog/basic/inverter.hpp:12
        I(cpphdl_n1782, Vss) <+ cpphdl_channel(V(BIT_N9_6, Vss), V(cpphdl_n1782, Vss), 0.080000000000000002, 0.69999999999999996, 1.0);
        // device 1345, IC IC221, analog/basic/mos_r2r_dac.hpp:27
        I(cpphdl_n1782, Vss) <+ 2.9999999999999998e-15 * ddt(V(cpphdl_n1782, Vss)); // Bench initial voltage = 0.0 V.
        // device 1346, IC IC221, analog/basic/mos_r2r_dac.hpp:28
        I(cpphdl_n1782, cpphdl_n1793) <+ V(cpphdl_n1782, cpphdl_n1793) / 2000.0;
        // device 1347, IC IC221, analog/basic/mos_r2r_dac.hpp:29
        I(cpphdl_n1793, Vss) <+ 2.9999999999999998e-15 * ddt(V(cpphdl_n1793, Vss)); // Bench initial voltage = 0.0 V.
        // device 1348, IC IC221, analog/basic/mos_r2r_dac.hpp:31
        I(cpphdl_n1792, cpphdl_n1793) <+ V(cpphdl_n1792, cpphdl_n1793) / 1000.0;
        // device 1349, IC IC229, analog/basic/inverter.hpp:11
        I(cpphdl_n1786, Vdd) <+ cpphdl_channel(V(BIT_N9_7, Vdd), V(cpphdl_n1786, Vdd), 0.080000000000000002, 0.69999999999999996, -1.0);
        // device 1350, IC IC229, analog/basic/inverter.hpp:12
        I(cpphdl_n1786, Vss) <+ cpphdl_channel(V(BIT_N9_7, Vss), V(cpphdl_n1786, Vss), 0.080000000000000002, 0.69999999999999996, 1.0);
        // device 1351, IC IC221, analog/basic/mos_r2r_dac.hpp:27
        I(cpphdl_n1786, Vss) <+ 2.9999999999999998e-15 * ddt(V(cpphdl_n1786, Vss)); // Bench initial voltage = 0.0 V.
        // device 1352, IC IC221, analog/basic/mos_r2r_dac.hpp:28
        I(cpphdl_n1786, cpphdl_n1798) <+ V(cpphdl_n1786, cpphdl_n1798) / 2000.0;
        // device 1353, IC IC221, analog/basic/mos_r2r_dac.hpp:29
        I(cpphdl_n1798, Vss) <+ 2.9999999999999998e-15 * ddt(V(cpphdl_n1798, Vss)); // Bench initial voltage = 0.0 V.
        // device 1354, IC IC221, analog/basic/mos_r2r_dac.hpp:31
        I(cpphdl_n1793, cpphdl_n1798) <+ V(cpphdl_n1793, cpphdl_n1798) / 1000.0;
        // device 1355, IC IC221, analog/basic/mos_r2r_dac.hpp:33
        I(Vss, cpphdl_n1787) <+ V(Vss, cpphdl_n1787) / 2000.0;
        // device 1356, IC IC230, analog/basic/nmos_resistor_amplifier.hpp:23
        I(Vdd, cpphdl_n1807) <+ V(Vdd, cpphdl_n1807) / 500.0;
        // device 1357, IC IC230, analog/basic/nmos_resistor_amplifier.hpp:24
        I(Vdd, cpphdl_n1806) <+ V(Vdd, cpphdl_n1806) / 500.0;
        // device 1358, IC IC230, analog/basic/nmos_resistor_amplifier.hpp:25
        I(cpphdl_n1807, cpphdl_n1801) <+ cpphdl_channel(V(cpphdl_n1797, cpphdl_n1801), V(cpphdl_n1807, cpphdl_n1801), 0.014999999999999999, 0.69999999999999996, 1.0);
        // device 1359, IC IC230, analog/basic/nmos_resistor_amplifier.hpp:26
        I(cpphdl_n1806, cpphdl_n1802) <+ cpphdl_channel(V(cpphdl_n1798, cpphdl_n1802), V(cpphdl_n1806, cpphdl_n1802), 0.014999999999999999, 0.69999999999999996, 1.0);
        // device 1360, IC IC230, analog/basic/nmos_resistor_amplifier.hpp:27
        I(cpphdl_n1803, cpphdl_n1801) <+ V(cpphdl_n1803, cpphdl_n1801) / 50.0;
        // device 1361, IC IC230, analog/basic/nmos_resistor_amplifier.hpp:28
        I(cpphdl_n1803, cpphdl_n1802) <+ V(cpphdl_n1803, cpphdl_n1802) / 50.0;
        // device 1362, IC IC230, analog/basic/nmos_resistor_amplifier.hpp:29
        I(Vss, cpphdl_n1803) <+ V(Vss, cpphdl_n1803) / 150.0;
        // device 1363, IC IC230, analog/basic/nmos_resistor_amplifier.hpp:30
        I(cpphdl_n1807, Vdd) <+ 2.9999999999999998e-13 * ddt(V(cpphdl_n1807, Vdd)); // Bench initial voltage = 0.0 V.
        // device 1364, IC IC230, analog/basic/nmos_resistor_amplifier.hpp:31
        I(cpphdl_n1806, Vdd) <+ 2.9999999999999998e-13 * ddt(V(cpphdl_n1806, Vdd)); // Bench initial voltage = 0.0 V.
        // device 1365, IC IC230, analog/basic/nmos_resistor_amplifier.hpp:32
        I(cpphdl_n1803, Vss) <+ 4e-14 * ddt(V(cpphdl_n1803, Vss)); // Bench initial voltage = 0.0 V.
        // device 1366, IC IC230, analog/basic/nmos_resistor_amplifier.hpp:34
        I(cpphdl_n1797, cpphdl_n1801) <+ 2e-14 * ddt(V(cpphdl_n1797, cpphdl_n1801)); // Bench initial voltage = 1.6499999999999999 V.
        // device 1367, IC IC230, analog/basic/nmos_resistor_amplifier.hpp:35
        I(cpphdl_n1798, cpphdl_n1802) <+ 2e-14 * ddt(V(cpphdl_n1798, cpphdl_n1802)); // Bench initial voltage = 0.0 V.
        // device 1368, IC IC230, analog/basic/nmos_resistor_amplifier.hpp:36
        I(cpphdl_n1797, cpphdl_n1807) <+ 2.9999999999999998e-15 * ddt(V(cpphdl_n1797, cpphdl_n1807)); // Bench initial voltage = -1.6499999999999999 V.
        // device 1369, IC IC230, analog/basic/nmos_resistor_amplifier.hpp:37
        I(cpphdl_n1798, cpphdl_n1806) <+ 2.9999999999999998e-15 * ddt(V(cpphdl_n1798, cpphdl_n1806)); // Bench initial voltage = -3.2999999999999998 V.
        // device 1370, IC IC231, analog/basic/strongarm_comparator.hpp:28
        I(cpphdl_n1811, cpphdl_n1813) <+ cpphdl_channel(V(cpphdl_n1806, cpphdl_n1813), V(cpphdl_n1811, cpphdl_n1813), 0.0080000000000000002, 0.69999999999999996, 1.0);
        // device 1371, IC IC231, analog/basic/strongarm_comparator.hpp:29
        I(cpphdl_n1812, cpphdl_n1813) <+ cpphdl_channel(V(cpphdl_n1807, cpphdl_n1813), V(cpphdl_n1812, cpphdl_n1813), 0.0080000000000000002, 0.69999999999999996, 1.0);
        // device 1372, IC IC231, analog/basic/strongarm_comparator.hpp:30
        I(cpphdl_n1813, Vss) <+ cpphdl_channel(V(EVALUATE, Vss), V(cpphdl_n1813, Vss), 0.0080000000000000002, 0.69999999999999996, 1.0);
        // device 1373, IC IC231, analog/basic/strongarm_comparator.hpp:33
        I(cpphdl_n1826, cpphdl_n1811) <+ cpphdl_channel(V(cpphdl_n1830, cpphdl_n1811), V(cpphdl_n1826, cpphdl_n1811), 0.0040000000000000001, 0.69999999999999996, 1.0);
        // device 1374, IC IC231, analog/basic/strongarm_comparator.hpp:34
        I(cpphdl_n1830, cpphdl_n1812) <+ cpphdl_channel(V(cpphdl_n1826, cpphdl_n1812), V(cpphdl_n1830, cpphdl_n1812), 0.0040000000000000001, 0.69999999999999996, 1.0);
        // device 1375, IC IC231, analog/basic/strongarm_comparator.hpp:35
        I(cpphdl_n1830, Vdd) <+ cpphdl_channel(V(cpphdl_n1826, Vdd), V(cpphdl_n1830, Vdd), 0.002, 0.69999999999999996, -1.0);
        // device 1376, IC IC231, analog/basic/strongarm_comparator.hpp:36
        I(cpphdl_n1826, Vdd) <+ cpphdl_channel(V(cpphdl_n1830, Vdd), V(cpphdl_n1826, Vdd), 0.002, 0.69999999999999996, -1.0);
        // device 1377, IC IC231, analog/basic/strongarm_comparator.hpp:38
        I(cpphdl_n1811, Vdd) <+ cpphdl_channel(V(EVALUATE, Vdd), V(cpphdl_n1811, Vdd), 0.002, 0.69999999999999996, -1.0);
        // device 1378, IC IC231, analog/basic/strongarm_comparator.hpp:39
        I(cpphdl_n1812, Vdd) <+ cpphdl_channel(V(EVALUATE, Vdd), V(cpphdl_n1812, Vdd), 0.002, 0.69999999999999996, -1.0);
        // device 1379, IC IC231, analog/basic/strongarm_comparator.hpp:40
        I(cpphdl_n1830, Vdd) <+ cpphdl_channel(V(EVALUATE, Vdd), V(cpphdl_n1830, Vdd), 0.002, 0.69999999999999996, -1.0);
        // device 1380, IC IC231, analog/basic/strongarm_comparator.hpp:41
        I(cpphdl_n1826, Vdd) <+ cpphdl_channel(V(EVALUATE, Vdd), V(cpphdl_n1826, Vdd), 0.002, 0.69999999999999996, -1.0);
        // device 1381, IC IC231, analog/basic/strongarm_comparator.hpp:42
        I(cpphdl_n1811, Vss) <+ 2.9999999999999998e-14 * ddt(V(cpphdl_n1811, Vss)); // Bench initial voltage = 0.0 V.
        // device 1382, IC IC231, analog/basic/strongarm_comparator.hpp:43
        I(cpphdl_n1812, Vss) <+ 2.9999999999999998e-14 * ddt(V(cpphdl_n1812, Vss)); // Bench initial voltage = 0.0 V.
        // device 1383, IC IC231, analog/basic/strongarm_comparator.hpp:44
        I(cpphdl_n1813, Vss) <+ 2.9999999999999998e-14 * ddt(V(cpphdl_n1813, Vss)); // Bench initial voltage = 0.0 V.
        // device 1384, IC IC231, analog/basic/strongarm_comparator.hpp:45
        I(cpphdl_n1830, Vss) <+ 5.0000000000000002e-14 * ddt(V(cpphdl_n1830, Vss)); // Bench initial voltage = 0.0 V.
        // device 1385, IC IC231, analog/basic/strongarm_comparator.hpp:46
        I(cpphdl_n1826, Vss) <+ 5.0000000000000002e-14 * ddt(V(cpphdl_n1826, Vss)); // Bench initial voltage = 0.0 V.
        // device 1386, IC IC231, analog/basic/strongarm_comparator.hpp:47
        I(cpphdl_n1806, cpphdl_n1813) <+ 2e-14 * ddt(V(cpphdl_n1806, cpphdl_n1813)); // Bench initial voltage = 3.2999999999999998 V.
        // device 1387, IC IC231, analog/basic/strongarm_comparator.hpp:48
        I(cpphdl_n1807, cpphdl_n1813) <+ 2e-14 * ddt(V(cpphdl_n1807, cpphdl_n1813)); // Bench initial voltage = 3.2999999999999998 V.
        // device 1388, IC IC231, analog/basic/strongarm_comparator.hpp:49
        I(cpphdl_n1806, cpphdl_n1811) <+ 2.9999999999999998e-15 * ddt(V(cpphdl_n1806, cpphdl_n1811)); // Bench initial voltage = 3.2999999999999998 V.
        // device 1389, IC IC231, analog/basic/strongarm_comparator.hpp:50
        I(cpphdl_n1807, cpphdl_n1812) <+ 2.9999999999999998e-15 * ddt(V(cpphdl_n1807, cpphdl_n1812)); // Bench initial voltage = 3.2999999999999998 V.
        // device 1390, IC IC233, analog/basic/inverter.hpp:11
        I(cpphdl_n1834, Vdd) <+ cpphdl_channel(V(cpphdl_n1826, Vdd), V(cpphdl_n1834, Vdd), 0.001, 0.69999999999999996, -1.0);
        // device 1391, IC IC233, analog/basic/inverter.hpp:12
        I(cpphdl_n1834, Vss) <+ cpphdl_channel(V(cpphdl_n1826, Vss), V(cpphdl_n1834, Vss), 0.001, 0.69999999999999996, 1.0);
        // device 1392, IC IC235, analog/basic/inverter.hpp:11
        I(cpphdl_n1848, Vdd) <+ cpphdl_channel(V(cpphdl_n1834, Vdd), V(cpphdl_n1848, Vdd), 0.0040000000000000001, 0.69999999999999996, -1.0);
        // device 1393, IC IC235, analog/basic/inverter.hpp:12
        I(cpphdl_n1848, Vss) <+ cpphdl_channel(V(cpphdl_n1834, Vss), V(cpphdl_n1848, Vss), 0.0040000000000000001, 0.69999999999999996, 1.0);
        // device 1394, IC IC232, analog/basic/buffered_nand_latch.hpp:33
        I(cpphdl_n1826, Vss) <+ 2.0000000000000002e-15 * ddt(V(cpphdl_n1826, Vss)); // Bench initial voltage = 0.0 V.
        // device 1395, IC IC232, analog/basic/buffered_nand_latch.hpp:34
        I(cpphdl_n1826, cpphdl_n1834) <+ 1.0000000000000001e-15 * ddt(V(cpphdl_n1826, cpphdl_n1834)); // Bench initial voltage = 0.0 V.
        // device 1396, IC IC232, analog/basic/buffered_nand_latch.hpp:35
        I(cpphdl_n1834, Vss) <+ 5e-15 * ddt(V(cpphdl_n1834, Vss)); // Bench initial voltage = 0.0 V.
        // device 1397, IC IC232, analog/basic/buffered_nand_latch.hpp:36
        I(cpphdl_n1834, Vss) <+ 8.0000000000000006e-15 * ddt(V(cpphdl_n1834, Vss)); // Bench initial voltage = 0.0 V.
        // device 1398, IC IC232, analog/basic/buffered_nand_latch.hpp:37
        I(cpphdl_n1848, Vss) <+ 1e-14 * ddt(V(cpphdl_n1848, Vss)); // Bench initial voltage = 0.0 V.
        // device 1399, IC IC234, analog/basic/inverter.hpp:11
        I(cpphdl_n1838, Vdd) <+ cpphdl_channel(V(cpphdl_n1830, Vdd), V(cpphdl_n1838, Vdd), 0.001, 0.69999999999999996, -1.0);
        // device 1400, IC IC234, analog/basic/inverter.hpp:12
        I(cpphdl_n1838, Vss) <+ cpphdl_channel(V(cpphdl_n1830, Vss), V(cpphdl_n1838, Vss), 0.001, 0.69999999999999996, 1.0);
        // device 1401, IC IC236, analog/basic/inverter.hpp:11
        I(cpphdl_n1854, Vdd) <+ cpphdl_channel(V(cpphdl_n1838, Vdd), V(cpphdl_n1854, Vdd), 0.0040000000000000001, 0.69999999999999996, -1.0);
        // device 1402, IC IC236, analog/basic/inverter.hpp:12
        I(cpphdl_n1854, Vss) <+ cpphdl_channel(V(cpphdl_n1838, Vss), V(cpphdl_n1854, Vss), 0.0040000000000000001, 0.69999999999999996, 1.0);
        // device 1403, IC IC232, analog/basic/buffered_nand_latch.hpp:33
        I(cpphdl_n1830, Vss) <+ 2.0000000000000002e-15 * ddt(V(cpphdl_n1830, Vss)); // Bench initial voltage = 0.0 V.
        // device 1404, IC IC232, analog/basic/buffered_nand_latch.hpp:34
        I(cpphdl_n1830, cpphdl_n1838) <+ 1.0000000000000001e-15 * ddt(V(cpphdl_n1830, cpphdl_n1838)); // Bench initial voltage = 0.0 V.
        // device 1405, IC IC232, analog/basic/buffered_nand_latch.hpp:35
        I(cpphdl_n1838, Vss) <+ 5e-15 * ddt(V(cpphdl_n1838, Vss)); // Bench initial voltage = 0.0 V.
        // device 1406, IC IC232, analog/basic/buffered_nand_latch.hpp:36
        I(cpphdl_n1838, Vss) <+ 8.0000000000000006e-15 * ddt(V(cpphdl_n1838, Vss)); // Bench initial voltage = 0.0 V.
        // device 1407, IC IC232, analog/basic/buffered_nand_latch.hpp:37
        I(cpphdl_n1854, Vss) <+ 1e-14 * ddt(V(cpphdl_n1854, Vss)); // Bench initial voltage = 0.0 V.
        // device 1408, IC IC238, analog/basic/cmos_logic.hpp:15
        I(cpphdl_n2785, Vss) <+ 5.0000000000000002e-14 * ddt(V(cpphdl_n2785, Vss)); // Bench initial voltage = 0.0 V.
        // device 1409, IC IC238, analog/basic/cmos_logic.hpp:16
        I(cpphdl_n2785, Vdd) <+ cpphdl_channel(V(cpphdl_n1848, Vdd), V(cpphdl_n2785, Vdd), 0.01, 0.69999999999999996, -1.0);
        // device 1410, IC IC238, analog/basic/cmos_logic.hpp:17
        I(cpphdl_n2785, Vdd) <+ cpphdl_channel(V(cpphdl_n1856, Vdd), V(cpphdl_n2785, Vdd), 0.01, 0.69999999999999996, -1.0);
        // device 1411, IC IC238, analog/basic/cmos_logic.hpp:18
        I(cpphdl_n2785, cpphdl_n1851) <+ cpphdl_channel(V(cpphdl_n1848, cpphdl_n1851), V(cpphdl_n2785, cpphdl_n1851), 0.01, 0.69999999999999996, 1.0);
        // device 1412, IC IC238, analog/basic/cmos_logic.hpp:19
        I(cpphdl_n1851, Vss) <+ cpphdl_channel(V(cpphdl_n1856, Vss), V(cpphdl_n1851, Vss), 0.01, 0.69999999999999996, 1.0);
        // device 1413, IC IC238, analog/basic/cmos_logic.hpp:20
        I(cpphdl_n2785, Vss) <+ V(cpphdl_n2785, Vss) / 1000000000.0;
        // device 1414, IC IC238, analog/basic/cmos_logic.hpp:21
        I(cpphdl_n1851, Vss) <+ V(cpphdl_n1851, Vss) / 1000000000.0;
        // device 1415, IC IC239, analog/basic/cmos_logic.hpp:15
        I(cpphdl_n1856, Vss) <+ 5.0000000000000002e-14 * ddt(V(cpphdl_n1856, Vss)); // Bench initial voltage = 0.0 V.
        // device 1416, IC IC239, analog/basic/cmos_logic.hpp:16
        I(cpphdl_n1856, Vdd) <+ cpphdl_channel(V(cpphdl_n1854, Vdd), V(cpphdl_n1856, Vdd), 0.01, 0.69999999999999996, -1.0);
        // device 1417, IC IC239, analog/basic/cmos_logic.hpp:17
        I(cpphdl_n1856, Vdd) <+ cpphdl_channel(V(cpphdl_n2785, Vdd), V(cpphdl_n1856, Vdd), 0.01, 0.69999999999999996, -1.0);
        // device 1418, IC IC239, analog/basic/cmos_logic.hpp:18
        I(cpphdl_n1856, cpphdl_n1857) <+ cpphdl_channel(V(cpphdl_n1854, cpphdl_n1857), V(cpphdl_n1856, cpphdl_n1857), 0.01, 0.69999999999999996, 1.0);
        // device 1419, IC IC239, analog/basic/cmos_logic.hpp:19
        I(cpphdl_n1857, Vss) <+ cpphdl_channel(V(cpphdl_n2785, Vss), V(cpphdl_n1857, Vss), 0.01, 0.69999999999999996, 1.0);
        // device 1420, IC IC239, analog/basic/cmos_logic.hpp:20
        I(cpphdl_n1856, Vss) <+ V(cpphdl_n1856, Vss) / 1000000000.0;
        // device 1421, IC IC239, analog/basic/cmos_logic.hpp:21
        I(cpphdl_n1857, Vss) <+ V(cpphdl_n1857, Vss) / 1000000000.0;
        // device 1422, IC IC237, analog/basic/nand_latch.hpp:34
        I(cpphdl_n1848, Vss) <+ 2.9999999999999998e-15 * ddt(V(cpphdl_n1848, Vss)); // Bench initial voltage = 0.0 V.
        // device 1423, IC IC237, analog/basic/nand_latch.hpp:35
        I(cpphdl_n1854, Vss) <+ 2.9999999999999998e-15 * ddt(V(cpphdl_n1854, Vss)); // Bench initial voltage = 0.0 V.
        // device 1424, IC IC240, analog/basic/inverter.hpp:11
        I(cpphdl_n1862, Vdd) <+ cpphdl_channel(V(CLEAR, Vdd), V(cpphdl_n1862, Vdd), 0.01, 0.69999999999999996, -1.0);
        // device 1425, IC IC240, analog/basic/inverter.hpp:12
        I(cpphdl_n1862, Vss) <+ cpphdl_channel(V(CLEAR, Vss), V(cpphdl_n1862, Vss), 0.01, 0.69999999999999996, 1.0);
        // device 1426, IC IC237, analog/basic/nand_latch.hpp:56
        I(cpphdl_n1862, Vss) <+ 2.9999999999999998e-15 * ddt(V(cpphdl_n1862, Vss)); // Bench initial voltage = 0.0 V.
        // device 1427, IC IC237, analog/basic/nand_latch.hpp:57
        I(cpphdl_n2785, Vss) <+ cpphdl_channel(V(CLEAR, Vss), V(cpphdl_n2785, Vss), 0.050000000000000003, 0.69999999999999996, 1.0);
        // device 1428, IC IC237, analog/basic/nand_latch.hpp:58
        I(cpphdl_n1856, Vdd) <+ cpphdl_channel(V(cpphdl_n1862, Vdd), V(cpphdl_n1856, Vdd), 0.050000000000000003, 0.69999999999999996, -1.0);
        // device 1429, IC IC243, analog/basic/inverter.hpp:11
        I(cpphdl_n1886, Vdd) <+ cpphdl_channel(V(TRACK10, Vdd), V(cpphdl_n1886, Vdd), 0.0040000000000000001, 0.69999999999999996, -1.0);
        // device 1430, IC IC243, analog/basic/inverter.hpp:12
        I(cpphdl_n1886, Vss) <+ cpphdl_channel(V(TRACK10, Vss), V(cpphdl_n1886, Vss), 0.0040000000000000001, 0.69999999999999996, 1.0);
        // device 1431, IC IC242, analog/basic/mos_track_hold.hpp:30
        I(cpphdl_n1886, Vss) <+ 2e-14 * ddt(V(cpphdl_n1886, Vss)); // Bench initial voltage = 3.2999999999999998 V.
        // device 1432, IC IC242, analog/basic/mos_track_hold.hpp:31
        I(cpphdl_n2595, cpphdl_n1940) <+ cpphdl_channel(V(TRACK10, cpphdl_n1940), V(cpphdl_n2595, cpphdl_n1940), 0.02, 0.69999999999999996, 1.0);
        // device 1433, IC IC242, analog/basic/mos_track_hold.hpp:32
        I(cpphdl_n1940, cpphdl_n2595) <+ cpphdl_channel(V(cpphdl_n1886, cpphdl_n2595), V(cpphdl_n1940, cpphdl_n2595), 0.01, 0.69999999999999996, -1.0);
        // device 1434, IC IC242, analog/basic/mos_track_hold.hpp:36
        I(cpphdl_n1940, cpphdl_n1940) <+ cpphdl_channel(V(cpphdl_n1886, cpphdl_n1940), V(cpphdl_n1940, cpphdl_n1940), 0.01, 0.69999999999999996, 1.0);
        // device 1435, IC IC242, analog/basic/mos_track_hold.hpp:37
        I(cpphdl_n1940, cpphdl_n1940) <+ cpphdl_channel(V(TRACK10, cpphdl_n1940), V(cpphdl_n1940, cpphdl_n1940), 0.0050000000000000001, 0.69999999999999996, -1.0);
        // device 1436, IC IC242, analog/basic/mos_track_hold.hpp:38
        I(cpphdl_n1940, Vss) <+ 1.5000000000000001e-12 * ddt(V(cpphdl_n1940, Vss)); // Bench initial voltage = 1.6499999999999999 V.
        // device 1437, IC IC242, analog/basic/mos_track_hold.hpp:39
        I(Vss, cpphdl_n1940) <+ V(Vss, cpphdl_n1940) / 1000000000.0;
        // device 1438, IC IC242, analog/basic/mos_track_hold.hpp:40
        I(TRACK10, cpphdl_n1940) <+ 2.0000000000000002e-15 * ddt(V(TRACK10, cpphdl_n1940)); // Bench initial voltage = -1.6499999999999999 V.
        // device 1439, IC IC242, analog/basic/mos_track_hold.hpp:41
        I(cpphdl_n1886, cpphdl_n1940) <+ 2.0000000000000002e-15 * ddt(V(cpphdl_n1886, cpphdl_n1940)); // Bench initial voltage = 1.6499999999999999 V.
        // device 1440, IC IC242, analog/basic/mos_track_hold.hpp:42
        I(cpphdl_n2595, cpphdl_n1940) <+ 1.0000000000000001e-15 * ddt(V(cpphdl_n2595, cpphdl_n1940)); // Bench initial voltage = 0.0 V.
        // device 1441, IC IC245, analog/basic/inverter.hpp:11
        I(cpphdl_n1901, Vdd) <+ cpphdl_channel(V(BIT_N10_0, Vdd), V(cpphdl_n1901, Vdd), 0.080000000000000002, 0.69999999999999996, -1.0);
        // device 1442, IC IC245, analog/basic/inverter.hpp:12
        I(cpphdl_n1901, Vss) <+ cpphdl_channel(V(BIT_N10_0, Vss), V(cpphdl_n1901, Vss), 0.080000000000000002, 0.69999999999999996, 1.0);
        // device 1443, IC IC244, analog/basic/mos_r2r_dac.hpp:27
        I(cpphdl_n1901, Vss) <+ 2.9999999999999998e-15 * ddt(V(cpphdl_n1901, Vss)); // Bench initial voltage = 0.0 V.
        // device 1444, IC IC244, analog/basic/mos_r2r_dac.hpp:28
        I(cpphdl_n1901, cpphdl_n1930) <+ V(cpphdl_n1901, cpphdl_n1930) / 2000.0;
        // device 1445, IC IC244, analog/basic/mos_r2r_dac.hpp:29
        I(cpphdl_n1930, Vss) <+ 2.9999999999999998e-15 * ddt(V(cpphdl_n1930, Vss)); // Bench initial voltage = 0.0 V.
        // device 1446, IC IC246, analog/basic/inverter.hpp:11
        I(cpphdl_n1905, Vdd) <+ cpphdl_channel(V(BIT_N10_1, Vdd), V(cpphdl_n1905, Vdd), 0.080000000000000002, 0.69999999999999996, -1.0);
        // device 1447, IC IC246, analog/basic/inverter.hpp:12
        I(cpphdl_n1905, Vss) <+ cpphdl_channel(V(BIT_N10_1, Vss), V(cpphdl_n1905, Vss), 0.080000000000000002, 0.69999999999999996, 1.0);
        // device 1448, IC IC244, analog/basic/mos_r2r_dac.hpp:27
        I(cpphdl_n1905, Vss) <+ 2.9999999999999998e-15 * ddt(V(cpphdl_n1905, Vss)); // Bench initial voltage = 0.0 V.
        // device 1449, IC IC244, analog/basic/mos_r2r_dac.hpp:28
        I(cpphdl_n1905, cpphdl_n1931) <+ V(cpphdl_n1905, cpphdl_n1931) / 2000.0;
        // device 1450, IC IC244, analog/basic/mos_r2r_dac.hpp:29
        I(cpphdl_n1931, Vss) <+ 2.9999999999999998e-15 * ddt(V(cpphdl_n1931, Vss)); // Bench initial voltage = 0.0 V.
        // device 1451, IC IC244, analog/basic/mos_r2r_dac.hpp:31
        I(cpphdl_n1930, cpphdl_n1931) <+ V(cpphdl_n1930, cpphdl_n1931) / 1000.0;
        // device 1452, IC IC247, analog/basic/inverter.hpp:11
        I(cpphdl_n1909, Vdd) <+ cpphdl_channel(V(BIT_N10_2, Vdd), V(cpphdl_n1909, Vdd), 0.080000000000000002, 0.69999999999999996, -1.0);
        // device 1453, IC IC247, analog/basic/inverter.hpp:12
        I(cpphdl_n1909, Vss) <+ cpphdl_channel(V(BIT_N10_2, Vss), V(cpphdl_n1909, Vss), 0.080000000000000002, 0.69999999999999996, 1.0);
        // device 1454, IC IC244, analog/basic/mos_r2r_dac.hpp:27
        I(cpphdl_n1909, Vss) <+ 2.9999999999999998e-15 * ddt(V(cpphdl_n1909, Vss)); // Bench initial voltage = 0.0 V.
        // device 1455, IC IC244, analog/basic/mos_r2r_dac.hpp:28
        I(cpphdl_n1909, cpphdl_n1932) <+ V(cpphdl_n1909, cpphdl_n1932) / 2000.0;
        // device 1456, IC IC244, analog/basic/mos_r2r_dac.hpp:29
        I(cpphdl_n1932, Vss) <+ 2.9999999999999998e-15 * ddt(V(cpphdl_n1932, Vss)); // Bench initial voltage = 0.0 V.
        // device 1457, IC IC244, analog/basic/mos_r2r_dac.hpp:31
        I(cpphdl_n1931, cpphdl_n1932) <+ V(cpphdl_n1931, cpphdl_n1932) / 1000.0;
        // device 1458, IC IC248, analog/basic/inverter.hpp:11
        I(cpphdl_n1913, Vdd) <+ cpphdl_channel(V(BIT_N10_3, Vdd), V(cpphdl_n1913, Vdd), 0.080000000000000002, 0.69999999999999996, -1.0);
        // device 1459, IC IC248, analog/basic/inverter.hpp:12
        I(cpphdl_n1913, Vss) <+ cpphdl_channel(V(BIT_N10_3, Vss), V(cpphdl_n1913, Vss), 0.080000000000000002, 0.69999999999999996, 1.0);
        // device 1460, IC IC244, analog/basic/mos_r2r_dac.hpp:27
        I(cpphdl_n1913, Vss) <+ 2.9999999999999998e-15 * ddt(V(cpphdl_n1913, Vss)); // Bench initial voltage = 0.0 V.
        // device 1461, IC IC244, analog/basic/mos_r2r_dac.hpp:28
        I(cpphdl_n1913, cpphdl_n1933) <+ V(cpphdl_n1913, cpphdl_n1933) / 2000.0;
        // device 1462, IC IC244, analog/basic/mos_r2r_dac.hpp:29
        I(cpphdl_n1933, Vss) <+ 2.9999999999999998e-15 * ddt(V(cpphdl_n1933, Vss)); // Bench initial voltage = 0.0 V.
        // device 1463, IC IC244, analog/basic/mos_r2r_dac.hpp:31
        I(cpphdl_n1932, cpphdl_n1933) <+ V(cpphdl_n1932, cpphdl_n1933) / 1000.0;
        // device 1464, IC IC249, analog/basic/inverter.hpp:11
        I(cpphdl_n1917, Vdd) <+ cpphdl_channel(V(BIT_N10_4, Vdd), V(cpphdl_n1917, Vdd), 0.080000000000000002, 0.69999999999999996, -1.0);
        // device 1465, IC IC249, analog/basic/inverter.hpp:12
        I(cpphdl_n1917, Vss) <+ cpphdl_channel(V(BIT_N10_4, Vss), V(cpphdl_n1917, Vss), 0.080000000000000002, 0.69999999999999996, 1.0);
        // device 1466, IC IC244, analog/basic/mos_r2r_dac.hpp:27
        I(cpphdl_n1917, Vss) <+ 2.9999999999999998e-15 * ddt(V(cpphdl_n1917, Vss)); // Bench initial voltage = 0.0 V.
        // device 1467, IC IC244, analog/basic/mos_r2r_dac.hpp:28
        I(cpphdl_n1917, cpphdl_n1934) <+ V(cpphdl_n1917, cpphdl_n1934) / 2000.0;
        // device 1468, IC IC244, analog/basic/mos_r2r_dac.hpp:29
        I(cpphdl_n1934, Vss) <+ 2.9999999999999998e-15 * ddt(V(cpphdl_n1934, Vss)); // Bench initial voltage = 0.0 V.
        // device 1469, IC IC244, analog/basic/mos_r2r_dac.hpp:31
        I(cpphdl_n1933, cpphdl_n1934) <+ V(cpphdl_n1933, cpphdl_n1934) / 1000.0;
        // device 1470, IC IC250, analog/basic/inverter.hpp:11
        I(cpphdl_n1921, Vdd) <+ cpphdl_channel(V(BIT_N10_5, Vdd), V(cpphdl_n1921, Vdd), 0.080000000000000002, 0.69999999999999996, -1.0);
        // device 1471, IC IC250, analog/basic/inverter.hpp:12
        I(cpphdl_n1921, Vss) <+ cpphdl_channel(V(BIT_N10_5, Vss), V(cpphdl_n1921, Vss), 0.080000000000000002, 0.69999999999999996, 1.0);
        // device 1472, IC IC244, analog/basic/mos_r2r_dac.hpp:27
        I(cpphdl_n1921, Vss) <+ 2.9999999999999998e-15 * ddt(V(cpphdl_n1921, Vss)); // Bench initial voltage = 0.0 V.
        // device 1473, IC IC244, analog/basic/mos_r2r_dac.hpp:28
        I(cpphdl_n1921, cpphdl_n1935) <+ V(cpphdl_n1921, cpphdl_n1935) / 2000.0;
        // device 1474, IC IC244, analog/basic/mos_r2r_dac.hpp:29
        I(cpphdl_n1935, Vss) <+ 2.9999999999999998e-15 * ddt(V(cpphdl_n1935, Vss)); // Bench initial voltage = 0.0 V.
        // device 1475, IC IC244, analog/basic/mos_r2r_dac.hpp:31
        I(cpphdl_n1934, cpphdl_n1935) <+ V(cpphdl_n1934, cpphdl_n1935) / 1000.0;
        // device 1476, IC IC251, analog/basic/inverter.hpp:11
        I(cpphdl_n1925, Vdd) <+ cpphdl_channel(V(BIT_N10_6, Vdd), V(cpphdl_n1925, Vdd), 0.080000000000000002, 0.69999999999999996, -1.0);
        // device 1477, IC IC251, analog/basic/inverter.hpp:12
        I(cpphdl_n1925, Vss) <+ cpphdl_channel(V(BIT_N10_6, Vss), V(cpphdl_n1925, Vss), 0.080000000000000002, 0.69999999999999996, 1.0);
        // device 1478, IC IC244, analog/basic/mos_r2r_dac.hpp:27
        I(cpphdl_n1925, Vss) <+ 2.9999999999999998e-15 * ddt(V(cpphdl_n1925, Vss)); // Bench initial voltage = 0.0 V.
        // device 1479, IC IC244, analog/basic/mos_r2r_dac.hpp:28
        I(cpphdl_n1925, cpphdl_n1936) <+ V(cpphdl_n1925, cpphdl_n1936) / 2000.0;
        // device 1480, IC IC244, analog/basic/mos_r2r_dac.hpp:29
        I(cpphdl_n1936, Vss) <+ 2.9999999999999998e-15 * ddt(V(cpphdl_n1936, Vss)); // Bench initial voltage = 0.0 V.
        // device 1481, IC IC244, analog/basic/mos_r2r_dac.hpp:31
        I(cpphdl_n1935, cpphdl_n1936) <+ V(cpphdl_n1935, cpphdl_n1936) / 1000.0;
        // device 1482, IC IC252, analog/basic/inverter.hpp:11
        I(cpphdl_n1929, Vdd) <+ cpphdl_channel(V(BIT_N10_7, Vdd), V(cpphdl_n1929, Vdd), 0.080000000000000002, 0.69999999999999996, -1.0);
        // device 1483, IC IC252, analog/basic/inverter.hpp:12
        I(cpphdl_n1929, Vss) <+ cpphdl_channel(V(BIT_N10_7, Vss), V(cpphdl_n1929, Vss), 0.080000000000000002, 0.69999999999999996, 1.0);
        // device 1484, IC IC244, analog/basic/mos_r2r_dac.hpp:27
        I(cpphdl_n1929, Vss) <+ 2.9999999999999998e-15 * ddt(V(cpphdl_n1929, Vss)); // Bench initial voltage = 0.0 V.
        // device 1485, IC IC244, analog/basic/mos_r2r_dac.hpp:28
        I(cpphdl_n1929, cpphdl_n1941) <+ V(cpphdl_n1929, cpphdl_n1941) / 2000.0;
        // device 1486, IC IC244, analog/basic/mos_r2r_dac.hpp:29
        I(cpphdl_n1941, Vss) <+ 2.9999999999999998e-15 * ddt(V(cpphdl_n1941, Vss)); // Bench initial voltage = 0.0 V.
        // device 1487, IC IC244, analog/basic/mos_r2r_dac.hpp:31
        I(cpphdl_n1936, cpphdl_n1941) <+ V(cpphdl_n1936, cpphdl_n1941) / 1000.0;
        // device 1488, IC IC244, analog/basic/mos_r2r_dac.hpp:33
        I(Vss, cpphdl_n1930) <+ V(Vss, cpphdl_n1930) / 2000.0;
        // device 1489, IC IC253, analog/basic/nmos_resistor_amplifier.hpp:23
        I(Vdd, cpphdl_n1950) <+ V(Vdd, cpphdl_n1950) / 500.0;
        // device 1490, IC IC253, analog/basic/nmos_resistor_amplifier.hpp:24
        I(Vdd, cpphdl_n1949) <+ V(Vdd, cpphdl_n1949) / 500.0;
        // device 1491, IC IC253, analog/basic/nmos_resistor_amplifier.hpp:25
        I(cpphdl_n1950, cpphdl_n1944) <+ cpphdl_channel(V(cpphdl_n1940, cpphdl_n1944), V(cpphdl_n1950, cpphdl_n1944), 0.014999999999999999, 0.69999999999999996, 1.0);
        // device 1492, IC IC253, analog/basic/nmos_resistor_amplifier.hpp:26
        I(cpphdl_n1949, cpphdl_n1945) <+ cpphdl_channel(V(cpphdl_n1941, cpphdl_n1945), V(cpphdl_n1949, cpphdl_n1945), 0.014999999999999999, 0.69999999999999996, 1.0);
        // device 1493, IC IC253, analog/basic/nmos_resistor_amplifier.hpp:27
        I(cpphdl_n1946, cpphdl_n1944) <+ V(cpphdl_n1946, cpphdl_n1944) / 50.0;
        // device 1494, IC IC253, analog/basic/nmos_resistor_amplifier.hpp:28
        I(cpphdl_n1946, cpphdl_n1945) <+ V(cpphdl_n1946, cpphdl_n1945) / 50.0;
        // device 1495, IC IC253, analog/basic/nmos_resistor_amplifier.hpp:29
        I(Vss, cpphdl_n1946) <+ V(Vss, cpphdl_n1946) / 150.0;
        // device 1496, IC IC253, analog/basic/nmos_resistor_amplifier.hpp:30
        I(cpphdl_n1950, Vdd) <+ 2.9999999999999998e-13 * ddt(V(cpphdl_n1950, Vdd)); // Bench initial voltage = 0.0 V.
        // device 1497, IC IC253, analog/basic/nmos_resistor_amplifier.hpp:31
        I(cpphdl_n1949, Vdd) <+ 2.9999999999999998e-13 * ddt(V(cpphdl_n1949, Vdd)); // Bench initial voltage = 0.0 V.
        // device 1498, IC IC253, analog/basic/nmos_resistor_amplifier.hpp:32
        I(cpphdl_n1946, Vss) <+ 4e-14 * ddt(V(cpphdl_n1946, Vss)); // Bench initial voltage = 0.0 V.
        // device 1499, IC IC253, analog/basic/nmos_resistor_amplifier.hpp:34
        I(cpphdl_n1940, cpphdl_n1944) <+ 2e-14 * ddt(V(cpphdl_n1940, cpphdl_n1944)); // Bench initial voltage = 1.6499999999999999 V.
        // device 1500, IC IC253, analog/basic/nmos_resistor_amplifier.hpp:35
        I(cpphdl_n1941, cpphdl_n1945) <+ 2e-14 * ddt(V(cpphdl_n1941, cpphdl_n1945)); // Bench initial voltage = 0.0 V.
        // device 1501, IC IC253, analog/basic/nmos_resistor_amplifier.hpp:36
        I(cpphdl_n1940, cpphdl_n1950) <+ 2.9999999999999998e-15 * ddt(V(cpphdl_n1940, cpphdl_n1950)); // Bench initial voltage = -1.6499999999999999 V.
        // device 1502, IC IC253, analog/basic/nmos_resistor_amplifier.hpp:37
        I(cpphdl_n1941, cpphdl_n1949) <+ 2.9999999999999998e-15 * ddt(V(cpphdl_n1941, cpphdl_n1949)); // Bench initial voltage = -3.2999999999999998 V.
        // device 1503, IC IC254, analog/basic/strongarm_comparator.hpp:28
        I(cpphdl_n1954, cpphdl_n1956) <+ cpphdl_channel(V(cpphdl_n1949, cpphdl_n1956), V(cpphdl_n1954, cpphdl_n1956), 0.0080000000000000002, 0.69999999999999996, 1.0);
        // device 1504, IC IC254, analog/basic/strongarm_comparator.hpp:29
        I(cpphdl_n1955, cpphdl_n1956) <+ cpphdl_channel(V(cpphdl_n1950, cpphdl_n1956), V(cpphdl_n1955, cpphdl_n1956), 0.0080000000000000002, 0.69999999999999996, 1.0);
        // device 1505, IC IC254, analog/basic/strongarm_comparator.hpp:30
        I(cpphdl_n1956, Vss) <+ cpphdl_channel(V(EVALUATE, Vss), V(cpphdl_n1956, Vss), 0.0080000000000000002, 0.69999999999999996, 1.0);
        // device 1506, IC IC254, analog/basic/strongarm_comparator.hpp:33
        I(cpphdl_n1969, cpphdl_n1954) <+ cpphdl_channel(V(cpphdl_n1973, cpphdl_n1954), V(cpphdl_n1969, cpphdl_n1954), 0.0040000000000000001, 0.69999999999999996, 1.0);
        // device 1507, IC IC254, analog/basic/strongarm_comparator.hpp:34
        I(cpphdl_n1973, cpphdl_n1955) <+ cpphdl_channel(V(cpphdl_n1969, cpphdl_n1955), V(cpphdl_n1973, cpphdl_n1955), 0.0040000000000000001, 0.69999999999999996, 1.0);
        // device 1508, IC IC254, analog/basic/strongarm_comparator.hpp:35
        I(cpphdl_n1973, Vdd) <+ cpphdl_channel(V(cpphdl_n1969, Vdd), V(cpphdl_n1973, Vdd), 0.002, 0.69999999999999996, -1.0);
        // device 1509, IC IC254, analog/basic/strongarm_comparator.hpp:36
        I(cpphdl_n1969, Vdd) <+ cpphdl_channel(V(cpphdl_n1973, Vdd), V(cpphdl_n1969, Vdd), 0.002, 0.69999999999999996, -1.0);
        // device 1510, IC IC254, analog/basic/strongarm_comparator.hpp:38
        I(cpphdl_n1954, Vdd) <+ cpphdl_channel(V(EVALUATE, Vdd), V(cpphdl_n1954, Vdd), 0.002, 0.69999999999999996, -1.0);
        // device 1511, IC IC254, analog/basic/strongarm_comparator.hpp:39
        I(cpphdl_n1955, Vdd) <+ cpphdl_channel(V(EVALUATE, Vdd), V(cpphdl_n1955, Vdd), 0.002, 0.69999999999999996, -1.0);
        // device 1512, IC IC254, analog/basic/strongarm_comparator.hpp:40
        I(cpphdl_n1973, Vdd) <+ cpphdl_channel(V(EVALUATE, Vdd), V(cpphdl_n1973, Vdd), 0.002, 0.69999999999999996, -1.0);
        // device 1513, IC IC254, analog/basic/strongarm_comparator.hpp:41
        I(cpphdl_n1969, Vdd) <+ cpphdl_channel(V(EVALUATE, Vdd), V(cpphdl_n1969, Vdd), 0.002, 0.69999999999999996, -1.0);
        // device 1514, IC IC254, analog/basic/strongarm_comparator.hpp:42
        I(cpphdl_n1954, Vss) <+ 2.9999999999999998e-14 * ddt(V(cpphdl_n1954, Vss)); // Bench initial voltage = 0.0 V.
        // device 1515, IC IC254, analog/basic/strongarm_comparator.hpp:43
        I(cpphdl_n1955, Vss) <+ 2.9999999999999998e-14 * ddt(V(cpphdl_n1955, Vss)); // Bench initial voltage = 0.0 V.
        // device 1516, IC IC254, analog/basic/strongarm_comparator.hpp:44
        I(cpphdl_n1956, Vss) <+ 2.9999999999999998e-14 * ddt(V(cpphdl_n1956, Vss)); // Bench initial voltage = 0.0 V.
        // device 1517, IC IC254, analog/basic/strongarm_comparator.hpp:45
        I(cpphdl_n1973, Vss) <+ 5.0000000000000002e-14 * ddt(V(cpphdl_n1973, Vss)); // Bench initial voltage = 0.0 V.
        // device 1518, IC IC254, analog/basic/strongarm_comparator.hpp:46
        I(cpphdl_n1969, Vss) <+ 5.0000000000000002e-14 * ddt(V(cpphdl_n1969, Vss)); // Bench initial voltage = 0.0 V.
        // device 1519, IC IC254, analog/basic/strongarm_comparator.hpp:47
        I(cpphdl_n1949, cpphdl_n1956) <+ 2e-14 * ddt(V(cpphdl_n1949, cpphdl_n1956)); // Bench initial voltage = 3.2999999999999998 V.
        // device 1520, IC IC254, analog/basic/strongarm_comparator.hpp:48
        I(cpphdl_n1950, cpphdl_n1956) <+ 2e-14 * ddt(V(cpphdl_n1950, cpphdl_n1956)); // Bench initial voltage = 3.2999999999999998 V.
        // device 1521, IC IC254, analog/basic/strongarm_comparator.hpp:49
        I(cpphdl_n1949, cpphdl_n1954) <+ 2.9999999999999998e-15 * ddt(V(cpphdl_n1949, cpphdl_n1954)); // Bench initial voltage = 3.2999999999999998 V.
        // device 1522, IC IC254, analog/basic/strongarm_comparator.hpp:50
        I(cpphdl_n1950, cpphdl_n1955) <+ 2.9999999999999998e-15 * ddt(V(cpphdl_n1950, cpphdl_n1955)); // Bench initial voltage = 3.2999999999999998 V.
        // device 1523, IC IC256, analog/basic/inverter.hpp:11
        I(cpphdl_n1977, Vdd) <+ cpphdl_channel(V(cpphdl_n1969, Vdd), V(cpphdl_n1977, Vdd), 0.001, 0.69999999999999996, -1.0);
        // device 1524, IC IC256, analog/basic/inverter.hpp:12
        I(cpphdl_n1977, Vss) <+ cpphdl_channel(V(cpphdl_n1969, Vss), V(cpphdl_n1977, Vss), 0.001, 0.69999999999999996, 1.0);
        // device 1525, IC IC258, analog/basic/inverter.hpp:11
        I(cpphdl_n1991, Vdd) <+ cpphdl_channel(V(cpphdl_n1977, Vdd), V(cpphdl_n1991, Vdd), 0.0040000000000000001, 0.69999999999999996, -1.0);
        // device 1526, IC IC258, analog/basic/inverter.hpp:12
        I(cpphdl_n1991, Vss) <+ cpphdl_channel(V(cpphdl_n1977, Vss), V(cpphdl_n1991, Vss), 0.0040000000000000001, 0.69999999999999996, 1.0);
        // device 1527, IC IC255, analog/basic/buffered_nand_latch.hpp:33
        I(cpphdl_n1969, Vss) <+ 2.0000000000000002e-15 * ddt(V(cpphdl_n1969, Vss)); // Bench initial voltage = 0.0 V.
        // device 1528, IC IC255, analog/basic/buffered_nand_latch.hpp:34
        I(cpphdl_n1969, cpphdl_n1977) <+ 1.0000000000000001e-15 * ddt(V(cpphdl_n1969, cpphdl_n1977)); // Bench initial voltage = 0.0 V.
        // device 1529, IC IC255, analog/basic/buffered_nand_latch.hpp:35
        I(cpphdl_n1977, Vss) <+ 5e-15 * ddt(V(cpphdl_n1977, Vss)); // Bench initial voltage = 0.0 V.
        // device 1530, IC IC255, analog/basic/buffered_nand_latch.hpp:36
        I(cpphdl_n1977, Vss) <+ 8.0000000000000006e-15 * ddt(V(cpphdl_n1977, Vss)); // Bench initial voltage = 0.0 V.
        // device 1531, IC IC255, analog/basic/buffered_nand_latch.hpp:37
        I(cpphdl_n1991, Vss) <+ 1e-14 * ddt(V(cpphdl_n1991, Vss)); // Bench initial voltage = 0.0 V.
        // device 1532, IC IC257, analog/basic/inverter.hpp:11
        I(cpphdl_n1981, Vdd) <+ cpphdl_channel(V(cpphdl_n1973, Vdd), V(cpphdl_n1981, Vdd), 0.001, 0.69999999999999996, -1.0);
        // device 1533, IC IC257, analog/basic/inverter.hpp:12
        I(cpphdl_n1981, Vss) <+ cpphdl_channel(V(cpphdl_n1973, Vss), V(cpphdl_n1981, Vss), 0.001, 0.69999999999999996, 1.0);
        // device 1534, IC IC259, analog/basic/inverter.hpp:11
        I(cpphdl_n1997, Vdd) <+ cpphdl_channel(V(cpphdl_n1981, Vdd), V(cpphdl_n1997, Vdd), 0.0040000000000000001, 0.69999999999999996, -1.0);
        // device 1535, IC IC259, analog/basic/inverter.hpp:12
        I(cpphdl_n1997, Vss) <+ cpphdl_channel(V(cpphdl_n1981, Vss), V(cpphdl_n1997, Vss), 0.0040000000000000001, 0.69999999999999996, 1.0);
        // device 1536, IC IC255, analog/basic/buffered_nand_latch.hpp:33
        I(cpphdl_n1973, Vss) <+ 2.0000000000000002e-15 * ddt(V(cpphdl_n1973, Vss)); // Bench initial voltage = 0.0 V.
        // device 1537, IC IC255, analog/basic/buffered_nand_latch.hpp:34
        I(cpphdl_n1973, cpphdl_n1981) <+ 1.0000000000000001e-15 * ddt(V(cpphdl_n1973, cpphdl_n1981)); // Bench initial voltage = 0.0 V.
        // device 1538, IC IC255, analog/basic/buffered_nand_latch.hpp:35
        I(cpphdl_n1981, Vss) <+ 5e-15 * ddt(V(cpphdl_n1981, Vss)); // Bench initial voltage = 0.0 V.
        // device 1539, IC IC255, analog/basic/buffered_nand_latch.hpp:36
        I(cpphdl_n1981, Vss) <+ 8.0000000000000006e-15 * ddt(V(cpphdl_n1981, Vss)); // Bench initial voltage = 0.0 V.
        // device 1540, IC IC255, analog/basic/buffered_nand_latch.hpp:37
        I(cpphdl_n1997, Vss) <+ 1e-14 * ddt(V(cpphdl_n1997, Vss)); // Bench initial voltage = 0.0 V.
        // device 1541, IC IC261, analog/basic/cmos_logic.hpp:15
        I(cpphdl_n2790, Vss) <+ 5.0000000000000002e-14 * ddt(V(cpphdl_n2790, Vss)); // Bench initial voltage = 0.0 V.
        // device 1542, IC IC261, analog/basic/cmos_logic.hpp:16
        I(cpphdl_n2790, Vdd) <+ cpphdl_channel(V(cpphdl_n1991, Vdd), V(cpphdl_n2790, Vdd), 0.01, 0.69999999999999996, -1.0);
        // device 1543, IC IC261, analog/basic/cmos_logic.hpp:17
        I(cpphdl_n2790, Vdd) <+ cpphdl_channel(V(cpphdl_n1999, Vdd), V(cpphdl_n2790, Vdd), 0.01, 0.69999999999999996, -1.0);
        // device 1544, IC IC261, analog/basic/cmos_logic.hpp:18
        I(cpphdl_n2790, cpphdl_n1994) <+ cpphdl_channel(V(cpphdl_n1991, cpphdl_n1994), V(cpphdl_n2790, cpphdl_n1994), 0.01, 0.69999999999999996, 1.0);
        // device 1545, IC IC261, analog/basic/cmos_logic.hpp:19
        I(cpphdl_n1994, Vss) <+ cpphdl_channel(V(cpphdl_n1999, Vss), V(cpphdl_n1994, Vss), 0.01, 0.69999999999999996, 1.0);
        // device 1546, IC IC261, analog/basic/cmos_logic.hpp:20
        I(cpphdl_n2790, Vss) <+ V(cpphdl_n2790, Vss) / 1000000000.0;
        // device 1547, IC IC261, analog/basic/cmos_logic.hpp:21
        I(cpphdl_n1994, Vss) <+ V(cpphdl_n1994, Vss) / 1000000000.0;
        // device 1548, IC IC262, analog/basic/cmos_logic.hpp:15
        I(cpphdl_n1999, Vss) <+ 5.0000000000000002e-14 * ddt(V(cpphdl_n1999, Vss)); // Bench initial voltage = 0.0 V.
        // device 1549, IC IC262, analog/basic/cmos_logic.hpp:16
        I(cpphdl_n1999, Vdd) <+ cpphdl_channel(V(cpphdl_n1997, Vdd), V(cpphdl_n1999, Vdd), 0.01, 0.69999999999999996, -1.0);
        // device 1550, IC IC262, analog/basic/cmos_logic.hpp:17
        I(cpphdl_n1999, Vdd) <+ cpphdl_channel(V(cpphdl_n2790, Vdd), V(cpphdl_n1999, Vdd), 0.01, 0.69999999999999996, -1.0);
        // device 1551, IC IC262, analog/basic/cmos_logic.hpp:18
        I(cpphdl_n1999, cpphdl_n2000) <+ cpphdl_channel(V(cpphdl_n1997, cpphdl_n2000), V(cpphdl_n1999, cpphdl_n2000), 0.01, 0.69999999999999996, 1.0);
        // device 1552, IC IC262, analog/basic/cmos_logic.hpp:19
        I(cpphdl_n2000, Vss) <+ cpphdl_channel(V(cpphdl_n2790, Vss), V(cpphdl_n2000, Vss), 0.01, 0.69999999999999996, 1.0);
        // device 1553, IC IC262, analog/basic/cmos_logic.hpp:20
        I(cpphdl_n1999, Vss) <+ V(cpphdl_n1999, Vss) / 1000000000.0;
        // device 1554, IC IC262, analog/basic/cmos_logic.hpp:21
        I(cpphdl_n2000, Vss) <+ V(cpphdl_n2000, Vss) / 1000000000.0;
        // device 1555, IC IC260, analog/basic/nand_latch.hpp:34
        I(cpphdl_n1991, Vss) <+ 2.9999999999999998e-15 * ddt(V(cpphdl_n1991, Vss)); // Bench initial voltage = 0.0 V.
        // device 1556, IC IC260, analog/basic/nand_latch.hpp:35
        I(cpphdl_n1997, Vss) <+ 2.9999999999999998e-15 * ddt(V(cpphdl_n1997, Vss)); // Bench initial voltage = 0.0 V.
        // device 1557, IC IC263, analog/basic/inverter.hpp:11
        I(cpphdl_n2005, Vdd) <+ cpphdl_channel(V(CLEAR, Vdd), V(cpphdl_n2005, Vdd), 0.01, 0.69999999999999996, -1.0);
        // device 1558, IC IC263, analog/basic/inverter.hpp:12
        I(cpphdl_n2005, Vss) <+ cpphdl_channel(V(CLEAR, Vss), V(cpphdl_n2005, Vss), 0.01, 0.69999999999999996, 1.0);
        // device 1559, IC IC260, analog/basic/nand_latch.hpp:56
        I(cpphdl_n2005, Vss) <+ 2.9999999999999998e-15 * ddt(V(cpphdl_n2005, Vss)); // Bench initial voltage = 0.0 V.
        // device 1560, IC IC260, analog/basic/nand_latch.hpp:57
        I(cpphdl_n2790, Vss) <+ cpphdl_channel(V(CLEAR, Vss), V(cpphdl_n2790, Vss), 0.050000000000000003, 0.69999999999999996, 1.0);
        // device 1561, IC IC260, analog/basic/nand_latch.hpp:58
        I(cpphdl_n1999, Vdd) <+ cpphdl_channel(V(cpphdl_n2005, Vdd), V(cpphdl_n1999, Vdd), 0.050000000000000003, 0.69999999999999996, -1.0);
        // device 1562, IC IC266, analog/basic/inverter.hpp:11
        I(cpphdl_n2029, Vdd) <+ cpphdl_channel(V(TRACK11, Vdd), V(cpphdl_n2029, Vdd), 0.0040000000000000001, 0.69999999999999996, -1.0);
        // device 1563, IC IC266, analog/basic/inverter.hpp:12
        I(cpphdl_n2029, Vss) <+ cpphdl_channel(V(TRACK11, Vss), V(cpphdl_n2029, Vss), 0.0040000000000000001, 0.69999999999999996, 1.0);
        // device 1564, IC IC265, analog/basic/mos_track_hold.hpp:30
        I(cpphdl_n2029, Vss) <+ 2e-14 * ddt(V(cpphdl_n2029, Vss)); // Bench initial voltage = 3.2999999999999998 V.
        // device 1565, IC IC265, analog/basic/mos_track_hold.hpp:31
        I(cpphdl_n2595, cpphdl_n2083) <+ cpphdl_channel(V(TRACK11, cpphdl_n2083), V(cpphdl_n2595, cpphdl_n2083), 0.02, 0.69999999999999996, 1.0);
        // device 1566, IC IC265, analog/basic/mos_track_hold.hpp:32
        I(cpphdl_n2083, cpphdl_n2595) <+ cpphdl_channel(V(cpphdl_n2029, cpphdl_n2595), V(cpphdl_n2083, cpphdl_n2595), 0.01, 0.69999999999999996, -1.0);
        // device 1567, IC IC265, analog/basic/mos_track_hold.hpp:36
        I(cpphdl_n2083, cpphdl_n2083) <+ cpphdl_channel(V(cpphdl_n2029, cpphdl_n2083), V(cpphdl_n2083, cpphdl_n2083), 0.01, 0.69999999999999996, 1.0);
        // device 1568, IC IC265, analog/basic/mos_track_hold.hpp:37
        I(cpphdl_n2083, cpphdl_n2083) <+ cpphdl_channel(V(TRACK11, cpphdl_n2083), V(cpphdl_n2083, cpphdl_n2083), 0.0050000000000000001, 0.69999999999999996, -1.0);
        // device 1569, IC IC265, analog/basic/mos_track_hold.hpp:38
        I(cpphdl_n2083, Vss) <+ 1.5000000000000001e-12 * ddt(V(cpphdl_n2083, Vss)); // Bench initial voltage = 1.6499999999999999 V.
        // device 1570, IC IC265, analog/basic/mos_track_hold.hpp:39
        I(Vss, cpphdl_n2083) <+ V(Vss, cpphdl_n2083) / 1000000000.0;
        // device 1571, IC IC265, analog/basic/mos_track_hold.hpp:40
        I(TRACK11, cpphdl_n2083) <+ 2.0000000000000002e-15 * ddt(V(TRACK11, cpphdl_n2083)); // Bench initial voltage = -1.6499999999999999 V.
        // device 1572, IC IC265, analog/basic/mos_track_hold.hpp:41
        I(cpphdl_n2029, cpphdl_n2083) <+ 2.0000000000000002e-15 * ddt(V(cpphdl_n2029, cpphdl_n2083)); // Bench initial voltage = 1.6499999999999999 V.
        // device 1573, IC IC265, analog/basic/mos_track_hold.hpp:42
        I(cpphdl_n2595, cpphdl_n2083) <+ 1.0000000000000001e-15 * ddt(V(cpphdl_n2595, cpphdl_n2083)); // Bench initial voltage = 0.0 V.
        // device 1574, IC IC268, analog/basic/inverter.hpp:11
        I(cpphdl_n2044, Vdd) <+ cpphdl_channel(V(BIT_N11_0, Vdd), V(cpphdl_n2044, Vdd), 0.080000000000000002, 0.69999999999999996, -1.0);
        // device 1575, IC IC268, analog/basic/inverter.hpp:12
        I(cpphdl_n2044, Vss) <+ cpphdl_channel(V(BIT_N11_0, Vss), V(cpphdl_n2044, Vss), 0.080000000000000002, 0.69999999999999996, 1.0);
        // device 1576, IC IC267, analog/basic/mos_r2r_dac.hpp:27
        I(cpphdl_n2044, Vss) <+ 2.9999999999999998e-15 * ddt(V(cpphdl_n2044, Vss)); // Bench initial voltage = 0.0 V.
        // device 1577, IC IC267, analog/basic/mos_r2r_dac.hpp:28
        I(cpphdl_n2044, cpphdl_n2073) <+ V(cpphdl_n2044, cpphdl_n2073) / 2000.0;
        // device 1578, IC IC267, analog/basic/mos_r2r_dac.hpp:29
        I(cpphdl_n2073, Vss) <+ 2.9999999999999998e-15 * ddt(V(cpphdl_n2073, Vss)); // Bench initial voltage = 0.0 V.
        // device 1579, IC IC269, analog/basic/inverter.hpp:11
        I(cpphdl_n2048, Vdd) <+ cpphdl_channel(V(BIT_N11_1, Vdd), V(cpphdl_n2048, Vdd), 0.080000000000000002, 0.69999999999999996, -1.0);
        // device 1580, IC IC269, analog/basic/inverter.hpp:12
        I(cpphdl_n2048, Vss) <+ cpphdl_channel(V(BIT_N11_1, Vss), V(cpphdl_n2048, Vss), 0.080000000000000002, 0.69999999999999996, 1.0);
        // device 1581, IC IC267, analog/basic/mos_r2r_dac.hpp:27
        I(cpphdl_n2048, Vss) <+ 2.9999999999999998e-15 * ddt(V(cpphdl_n2048, Vss)); // Bench initial voltage = 0.0 V.
        // device 1582, IC IC267, analog/basic/mos_r2r_dac.hpp:28
        I(cpphdl_n2048, cpphdl_n2074) <+ V(cpphdl_n2048, cpphdl_n2074) / 2000.0;
        // device 1583, IC IC267, analog/basic/mos_r2r_dac.hpp:29
        I(cpphdl_n2074, Vss) <+ 2.9999999999999998e-15 * ddt(V(cpphdl_n2074, Vss)); // Bench initial voltage = 0.0 V.
        // device 1584, IC IC267, analog/basic/mos_r2r_dac.hpp:31
        I(cpphdl_n2073, cpphdl_n2074) <+ V(cpphdl_n2073, cpphdl_n2074) / 1000.0;
        // device 1585, IC IC270, analog/basic/inverter.hpp:11
        I(cpphdl_n2052, Vdd) <+ cpphdl_channel(V(BIT_N11_2, Vdd), V(cpphdl_n2052, Vdd), 0.080000000000000002, 0.69999999999999996, -1.0);
        // device 1586, IC IC270, analog/basic/inverter.hpp:12
        I(cpphdl_n2052, Vss) <+ cpphdl_channel(V(BIT_N11_2, Vss), V(cpphdl_n2052, Vss), 0.080000000000000002, 0.69999999999999996, 1.0);
        // device 1587, IC IC267, analog/basic/mos_r2r_dac.hpp:27
        I(cpphdl_n2052, Vss) <+ 2.9999999999999998e-15 * ddt(V(cpphdl_n2052, Vss)); // Bench initial voltage = 0.0 V.
        // device 1588, IC IC267, analog/basic/mos_r2r_dac.hpp:28
        I(cpphdl_n2052, cpphdl_n2075) <+ V(cpphdl_n2052, cpphdl_n2075) / 2000.0;
        // device 1589, IC IC267, analog/basic/mos_r2r_dac.hpp:29
        I(cpphdl_n2075, Vss) <+ 2.9999999999999998e-15 * ddt(V(cpphdl_n2075, Vss)); // Bench initial voltage = 0.0 V.
        // device 1590, IC IC267, analog/basic/mos_r2r_dac.hpp:31
        I(cpphdl_n2074, cpphdl_n2075) <+ V(cpphdl_n2074, cpphdl_n2075) / 1000.0;
        // device 1591, IC IC271, analog/basic/inverter.hpp:11
        I(cpphdl_n2056, Vdd) <+ cpphdl_channel(V(BIT_N11_3, Vdd), V(cpphdl_n2056, Vdd), 0.080000000000000002, 0.69999999999999996, -1.0);
        // device 1592, IC IC271, analog/basic/inverter.hpp:12
        I(cpphdl_n2056, Vss) <+ cpphdl_channel(V(BIT_N11_3, Vss), V(cpphdl_n2056, Vss), 0.080000000000000002, 0.69999999999999996, 1.0);
        // device 1593, IC IC267, analog/basic/mos_r2r_dac.hpp:27
        I(cpphdl_n2056, Vss) <+ 2.9999999999999998e-15 * ddt(V(cpphdl_n2056, Vss)); // Bench initial voltage = 0.0 V.
        // device 1594, IC IC267, analog/basic/mos_r2r_dac.hpp:28
        I(cpphdl_n2056, cpphdl_n2076) <+ V(cpphdl_n2056, cpphdl_n2076) / 2000.0;
        // device 1595, IC IC267, analog/basic/mos_r2r_dac.hpp:29
        I(cpphdl_n2076, Vss) <+ 2.9999999999999998e-15 * ddt(V(cpphdl_n2076, Vss)); // Bench initial voltage = 0.0 V.
        // device 1596, IC IC267, analog/basic/mos_r2r_dac.hpp:31
        I(cpphdl_n2075, cpphdl_n2076) <+ V(cpphdl_n2075, cpphdl_n2076) / 1000.0;
        // device 1597, IC IC272, analog/basic/inverter.hpp:11
        I(cpphdl_n2060, Vdd) <+ cpphdl_channel(V(BIT_N11_4, Vdd), V(cpphdl_n2060, Vdd), 0.080000000000000002, 0.69999999999999996, -1.0);
        // device 1598, IC IC272, analog/basic/inverter.hpp:12
        I(cpphdl_n2060, Vss) <+ cpphdl_channel(V(BIT_N11_4, Vss), V(cpphdl_n2060, Vss), 0.080000000000000002, 0.69999999999999996, 1.0);
        // device 1599, IC IC267, analog/basic/mos_r2r_dac.hpp:27
        I(cpphdl_n2060, Vss) <+ 2.9999999999999998e-15 * ddt(V(cpphdl_n2060, Vss)); // Bench initial voltage = 0.0 V.
        // device 1600, IC IC267, analog/basic/mos_r2r_dac.hpp:28
        I(cpphdl_n2060, cpphdl_n2077) <+ V(cpphdl_n2060, cpphdl_n2077) / 2000.0;
        // device 1601, IC IC267, analog/basic/mos_r2r_dac.hpp:29
        I(cpphdl_n2077, Vss) <+ 2.9999999999999998e-15 * ddt(V(cpphdl_n2077, Vss)); // Bench initial voltage = 0.0 V.
        // device 1602, IC IC267, analog/basic/mos_r2r_dac.hpp:31
        I(cpphdl_n2076, cpphdl_n2077) <+ V(cpphdl_n2076, cpphdl_n2077) / 1000.0;
        // device 1603, IC IC273, analog/basic/inverter.hpp:11
        I(cpphdl_n2064, Vdd) <+ cpphdl_channel(V(BIT_N11_5, Vdd), V(cpphdl_n2064, Vdd), 0.080000000000000002, 0.69999999999999996, -1.0);
        // device 1604, IC IC273, analog/basic/inverter.hpp:12
        I(cpphdl_n2064, Vss) <+ cpphdl_channel(V(BIT_N11_5, Vss), V(cpphdl_n2064, Vss), 0.080000000000000002, 0.69999999999999996, 1.0);
        // device 1605, IC IC267, analog/basic/mos_r2r_dac.hpp:27
        I(cpphdl_n2064, Vss) <+ 2.9999999999999998e-15 * ddt(V(cpphdl_n2064, Vss)); // Bench initial voltage = 0.0 V.
        // device 1606, IC IC267, analog/basic/mos_r2r_dac.hpp:28
        I(cpphdl_n2064, cpphdl_n2078) <+ V(cpphdl_n2064, cpphdl_n2078) / 2000.0;
        // device 1607, IC IC267, analog/basic/mos_r2r_dac.hpp:29
        I(cpphdl_n2078, Vss) <+ 2.9999999999999998e-15 * ddt(V(cpphdl_n2078, Vss)); // Bench initial voltage = 0.0 V.
        // device 1608, IC IC267, analog/basic/mos_r2r_dac.hpp:31
        I(cpphdl_n2077, cpphdl_n2078) <+ V(cpphdl_n2077, cpphdl_n2078) / 1000.0;
        // device 1609, IC IC274, analog/basic/inverter.hpp:11
        I(cpphdl_n2068, Vdd) <+ cpphdl_channel(V(BIT_N11_6, Vdd), V(cpphdl_n2068, Vdd), 0.080000000000000002, 0.69999999999999996, -1.0);
        // device 1610, IC IC274, analog/basic/inverter.hpp:12
        I(cpphdl_n2068, Vss) <+ cpphdl_channel(V(BIT_N11_6, Vss), V(cpphdl_n2068, Vss), 0.080000000000000002, 0.69999999999999996, 1.0);
        // device 1611, IC IC267, analog/basic/mos_r2r_dac.hpp:27
        I(cpphdl_n2068, Vss) <+ 2.9999999999999998e-15 * ddt(V(cpphdl_n2068, Vss)); // Bench initial voltage = 0.0 V.
        // device 1612, IC IC267, analog/basic/mos_r2r_dac.hpp:28
        I(cpphdl_n2068, cpphdl_n2079) <+ V(cpphdl_n2068, cpphdl_n2079) / 2000.0;
        // device 1613, IC IC267, analog/basic/mos_r2r_dac.hpp:29
        I(cpphdl_n2079, Vss) <+ 2.9999999999999998e-15 * ddt(V(cpphdl_n2079, Vss)); // Bench initial voltage = 0.0 V.
        // device 1614, IC IC267, analog/basic/mos_r2r_dac.hpp:31
        I(cpphdl_n2078, cpphdl_n2079) <+ V(cpphdl_n2078, cpphdl_n2079) / 1000.0;
        // device 1615, IC IC275, analog/basic/inverter.hpp:11
        I(cpphdl_n2072, Vdd) <+ cpphdl_channel(V(BIT_N11_7, Vdd), V(cpphdl_n2072, Vdd), 0.080000000000000002, 0.69999999999999996, -1.0);
        // device 1616, IC IC275, analog/basic/inverter.hpp:12
        I(cpphdl_n2072, Vss) <+ cpphdl_channel(V(BIT_N11_7, Vss), V(cpphdl_n2072, Vss), 0.080000000000000002, 0.69999999999999996, 1.0);
        // device 1617, IC IC267, analog/basic/mos_r2r_dac.hpp:27
        I(cpphdl_n2072, Vss) <+ 2.9999999999999998e-15 * ddt(V(cpphdl_n2072, Vss)); // Bench initial voltage = 0.0 V.
        // device 1618, IC IC267, analog/basic/mos_r2r_dac.hpp:28
        I(cpphdl_n2072, cpphdl_n2084) <+ V(cpphdl_n2072, cpphdl_n2084) / 2000.0;
        // device 1619, IC IC267, analog/basic/mos_r2r_dac.hpp:29
        I(cpphdl_n2084, Vss) <+ 2.9999999999999998e-15 * ddt(V(cpphdl_n2084, Vss)); // Bench initial voltage = 0.0 V.
        // device 1620, IC IC267, analog/basic/mos_r2r_dac.hpp:31
        I(cpphdl_n2079, cpphdl_n2084) <+ V(cpphdl_n2079, cpphdl_n2084) / 1000.0;
        // device 1621, IC IC267, analog/basic/mos_r2r_dac.hpp:33
        I(Vss, cpphdl_n2073) <+ V(Vss, cpphdl_n2073) / 2000.0;
        // device 1622, IC IC276, analog/basic/nmos_resistor_amplifier.hpp:23
        I(Vdd, cpphdl_n2093) <+ V(Vdd, cpphdl_n2093) / 500.0;
        // device 1623, IC IC276, analog/basic/nmos_resistor_amplifier.hpp:24
        I(Vdd, cpphdl_n2092) <+ V(Vdd, cpphdl_n2092) / 500.0;
        // device 1624, IC IC276, analog/basic/nmos_resistor_amplifier.hpp:25
        I(cpphdl_n2093, cpphdl_n2087) <+ cpphdl_channel(V(cpphdl_n2083, cpphdl_n2087), V(cpphdl_n2093, cpphdl_n2087), 0.014999999999999999, 0.69999999999999996, 1.0);
        // device 1625, IC IC276, analog/basic/nmos_resistor_amplifier.hpp:26
        I(cpphdl_n2092, cpphdl_n2088) <+ cpphdl_channel(V(cpphdl_n2084, cpphdl_n2088), V(cpphdl_n2092, cpphdl_n2088), 0.014999999999999999, 0.69999999999999996, 1.0);
        // device 1626, IC IC276, analog/basic/nmos_resistor_amplifier.hpp:27
        I(cpphdl_n2089, cpphdl_n2087) <+ V(cpphdl_n2089, cpphdl_n2087) / 50.0;
        // device 1627, IC IC276, analog/basic/nmos_resistor_amplifier.hpp:28
        I(cpphdl_n2089, cpphdl_n2088) <+ V(cpphdl_n2089, cpphdl_n2088) / 50.0;
        // device 1628, IC IC276, analog/basic/nmos_resistor_amplifier.hpp:29
        I(Vss, cpphdl_n2089) <+ V(Vss, cpphdl_n2089) / 150.0;
        // device 1629, IC IC276, analog/basic/nmos_resistor_amplifier.hpp:30
        I(cpphdl_n2093, Vdd) <+ 2.9999999999999998e-13 * ddt(V(cpphdl_n2093, Vdd)); // Bench initial voltage = 0.0 V.
        // device 1630, IC IC276, analog/basic/nmos_resistor_amplifier.hpp:31
        I(cpphdl_n2092, Vdd) <+ 2.9999999999999998e-13 * ddt(V(cpphdl_n2092, Vdd)); // Bench initial voltage = 0.0 V.
        // device 1631, IC IC276, analog/basic/nmos_resistor_amplifier.hpp:32
        I(cpphdl_n2089, Vss) <+ 4e-14 * ddt(V(cpphdl_n2089, Vss)); // Bench initial voltage = 0.0 V.
        // device 1632, IC IC276, analog/basic/nmos_resistor_amplifier.hpp:34
        I(cpphdl_n2083, cpphdl_n2087) <+ 2e-14 * ddt(V(cpphdl_n2083, cpphdl_n2087)); // Bench initial voltage = 1.6499999999999999 V.
        // device 1633, IC IC276, analog/basic/nmos_resistor_amplifier.hpp:35
        I(cpphdl_n2084, cpphdl_n2088) <+ 2e-14 * ddt(V(cpphdl_n2084, cpphdl_n2088)); // Bench initial voltage = 0.0 V.
        // device 1634, IC IC276, analog/basic/nmos_resistor_amplifier.hpp:36
        I(cpphdl_n2083, cpphdl_n2093) <+ 2.9999999999999998e-15 * ddt(V(cpphdl_n2083, cpphdl_n2093)); // Bench initial voltage = -1.6499999999999999 V.
        // device 1635, IC IC276, analog/basic/nmos_resistor_amplifier.hpp:37
        I(cpphdl_n2084, cpphdl_n2092) <+ 2.9999999999999998e-15 * ddt(V(cpphdl_n2084, cpphdl_n2092)); // Bench initial voltage = -3.2999999999999998 V.
        // device 1636, IC IC277, analog/basic/strongarm_comparator.hpp:28
        I(cpphdl_n2097, cpphdl_n2099) <+ cpphdl_channel(V(cpphdl_n2092, cpphdl_n2099), V(cpphdl_n2097, cpphdl_n2099), 0.0080000000000000002, 0.69999999999999996, 1.0);
        // device 1637, IC IC277, analog/basic/strongarm_comparator.hpp:29
        I(cpphdl_n2098, cpphdl_n2099) <+ cpphdl_channel(V(cpphdl_n2093, cpphdl_n2099), V(cpphdl_n2098, cpphdl_n2099), 0.0080000000000000002, 0.69999999999999996, 1.0);
        // device 1638, IC IC277, analog/basic/strongarm_comparator.hpp:30
        I(cpphdl_n2099, Vss) <+ cpphdl_channel(V(EVALUATE, Vss), V(cpphdl_n2099, Vss), 0.0080000000000000002, 0.69999999999999996, 1.0);
        // device 1639, IC IC277, analog/basic/strongarm_comparator.hpp:33
        I(cpphdl_n2112, cpphdl_n2097) <+ cpphdl_channel(V(cpphdl_n2116, cpphdl_n2097), V(cpphdl_n2112, cpphdl_n2097), 0.0040000000000000001, 0.69999999999999996, 1.0);
        // device 1640, IC IC277, analog/basic/strongarm_comparator.hpp:34
        I(cpphdl_n2116, cpphdl_n2098) <+ cpphdl_channel(V(cpphdl_n2112, cpphdl_n2098), V(cpphdl_n2116, cpphdl_n2098), 0.0040000000000000001, 0.69999999999999996, 1.0);
        // device 1641, IC IC277, analog/basic/strongarm_comparator.hpp:35
        I(cpphdl_n2116, Vdd) <+ cpphdl_channel(V(cpphdl_n2112, Vdd), V(cpphdl_n2116, Vdd), 0.002, 0.69999999999999996, -1.0);
        // device 1642, IC IC277, analog/basic/strongarm_comparator.hpp:36
        I(cpphdl_n2112, Vdd) <+ cpphdl_channel(V(cpphdl_n2116, Vdd), V(cpphdl_n2112, Vdd), 0.002, 0.69999999999999996, -1.0);
        // device 1643, IC IC277, analog/basic/strongarm_comparator.hpp:38
        I(cpphdl_n2097, Vdd) <+ cpphdl_channel(V(EVALUATE, Vdd), V(cpphdl_n2097, Vdd), 0.002, 0.69999999999999996, -1.0);
        // device 1644, IC IC277, analog/basic/strongarm_comparator.hpp:39
        I(cpphdl_n2098, Vdd) <+ cpphdl_channel(V(EVALUATE, Vdd), V(cpphdl_n2098, Vdd), 0.002, 0.69999999999999996, -1.0);
        // device 1645, IC IC277, analog/basic/strongarm_comparator.hpp:40
        I(cpphdl_n2116, Vdd) <+ cpphdl_channel(V(EVALUATE, Vdd), V(cpphdl_n2116, Vdd), 0.002, 0.69999999999999996, -1.0);
        // device 1646, IC IC277, analog/basic/strongarm_comparator.hpp:41
        I(cpphdl_n2112, Vdd) <+ cpphdl_channel(V(EVALUATE, Vdd), V(cpphdl_n2112, Vdd), 0.002, 0.69999999999999996, -1.0);
        // device 1647, IC IC277, analog/basic/strongarm_comparator.hpp:42
        I(cpphdl_n2097, Vss) <+ 2.9999999999999998e-14 * ddt(V(cpphdl_n2097, Vss)); // Bench initial voltage = 0.0 V.
        // device 1648, IC IC277, analog/basic/strongarm_comparator.hpp:43
        I(cpphdl_n2098, Vss) <+ 2.9999999999999998e-14 * ddt(V(cpphdl_n2098, Vss)); // Bench initial voltage = 0.0 V.
        // device 1649, IC IC277, analog/basic/strongarm_comparator.hpp:44
        I(cpphdl_n2099, Vss) <+ 2.9999999999999998e-14 * ddt(V(cpphdl_n2099, Vss)); // Bench initial voltage = 0.0 V.
        // device 1650, IC IC277, analog/basic/strongarm_comparator.hpp:45
        I(cpphdl_n2116, Vss) <+ 5.0000000000000002e-14 * ddt(V(cpphdl_n2116, Vss)); // Bench initial voltage = 0.0 V.
        // device 1651, IC IC277, analog/basic/strongarm_comparator.hpp:46
        I(cpphdl_n2112, Vss) <+ 5.0000000000000002e-14 * ddt(V(cpphdl_n2112, Vss)); // Bench initial voltage = 0.0 V.
        // device 1652, IC IC277, analog/basic/strongarm_comparator.hpp:47
        I(cpphdl_n2092, cpphdl_n2099) <+ 2e-14 * ddt(V(cpphdl_n2092, cpphdl_n2099)); // Bench initial voltage = 3.2999999999999998 V.
        // device 1653, IC IC277, analog/basic/strongarm_comparator.hpp:48
        I(cpphdl_n2093, cpphdl_n2099) <+ 2e-14 * ddt(V(cpphdl_n2093, cpphdl_n2099)); // Bench initial voltage = 3.2999999999999998 V.
        // device 1654, IC IC277, analog/basic/strongarm_comparator.hpp:49
        I(cpphdl_n2092, cpphdl_n2097) <+ 2.9999999999999998e-15 * ddt(V(cpphdl_n2092, cpphdl_n2097)); // Bench initial voltage = 3.2999999999999998 V.
        // device 1655, IC IC277, analog/basic/strongarm_comparator.hpp:50
        I(cpphdl_n2093, cpphdl_n2098) <+ 2.9999999999999998e-15 * ddt(V(cpphdl_n2093, cpphdl_n2098)); // Bench initial voltage = 3.2999999999999998 V.
        // device 1656, IC IC279, analog/basic/inverter.hpp:11
        I(cpphdl_n2120, Vdd) <+ cpphdl_channel(V(cpphdl_n2112, Vdd), V(cpphdl_n2120, Vdd), 0.001, 0.69999999999999996, -1.0);
        // device 1657, IC IC279, analog/basic/inverter.hpp:12
        I(cpphdl_n2120, Vss) <+ cpphdl_channel(V(cpphdl_n2112, Vss), V(cpphdl_n2120, Vss), 0.001, 0.69999999999999996, 1.0);
        // device 1658, IC IC281, analog/basic/inverter.hpp:11
        I(cpphdl_n2134, Vdd) <+ cpphdl_channel(V(cpphdl_n2120, Vdd), V(cpphdl_n2134, Vdd), 0.0040000000000000001, 0.69999999999999996, -1.0);
        // device 1659, IC IC281, analog/basic/inverter.hpp:12
        I(cpphdl_n2134, Vss) <+ cpphdl_channel(V(cpphdl_n2120, Vss), V(cpphdl_n2134, Vss), 0.0040000000000000001, 0.69999999999999996, 1.0);
        // device 1660, IC IC278, analog/basic/buffered_nand_latch.hpp:33
        I(cpphdl_n2112, Vss) <+ 2.0000000000000002e-15 * ddt(V(cpphdl_n2112, Vss)); // Bench initial voltage = 0.0 V.
        // device 1661, IC IC278, analog/basic/buffered_nand_latch.hpp:34
        I(cpphdl_n2112, cpphdl_n2120) <+ 1.0000000000000001e-15 * ddt(V(cpphdl_n2112, cpphdl_n2120)); // Bench initial voltage = 0.0 V.
        // device 1662, IC IC278, analog/basic/buffered_nand_latch.hpp:35
        I(cpphdl_n2120, Vss) <+ 5e-15 * ddt(V(cpphdl_n2120, Vss)); // Bench initial voltage = 0.0 V.
        // device 1663, IC IC278, analog/basic/buffered_nand_latch.hpp:36
        I(cpphdl_n2120, Vss) <+ 8.0000000000000006e-15 * ddt(V(cpphdl_n2120, Vss)); // Bench initial voltage = 0.0 V.
        // device 1664, IC IC278, analog/basic/buffered_nand_latch.hpp:37
        I(cpphdl_n2134, Vss) <+ 1e-14 * ddt(V(cpphdl_n2134, Vss)); // Bench initial voltage = 0.0 V.
        // device 1665, IC IC280, analog/basic/inverter.hpp:11
        I(cpphdl_n2124, Vdd) <+ cpphdl_channel(V(cpphdl_n2116, Vdd), V(cpphdl_n2124, Vdd), 0.001, 0.69999999999999996, -1.0);
        // device 1666, IC IC280, analog/basic/inverter.hpp:12
        I(cpphdl_n2124, Vss) <+ cpphdl_channel(V(cpphdl_n2116, Vss), V(cpphdl_n2124, Vss), 0.001, 0.69999999999999996, 1.0);
        // device 1667, IC IC282, analog/basic/inverter.hpp:11
        I(cpphdl_n2140, Vdd) <+ cpphdl_channel(V(cpphdl_n2124, Vdd), V(cpphdl_n2140, Vdd), 0.0040000000000000001, 0.69999999999999996, -1.0);
        // device 1668, IC IC282, analog/basic/inverter.hpp:12
        I(cpphdl_n2140, Vss) <+ cpphdl_channel(V(cpphdl_n2124, Vss), V(cpphdl_n2140, Vss), 0.0040000000000000001, 0.69999999999999996, 1.0);
        // device 1669, IC IC278, analog/basic/buffered_nand_latch.hpp:33
        I(cpphdl_n2116, Vss) <+ 2.0000000000000002e-15 * ddt(V(cpphdl_n2116, Vss)); // Bench initial voltage = 0.0 V.
        // device 1670, IC IC278, analog/basic/buffered_nand_latch.hpp:34
        I(cpphdl_n2116, cpphdl_n2124) <+ 1.0000000000000001e-15 * ddt(V(cpphdl_n2116, cpphdl_n2124)); // Bench initial voltage = 0.0 V.
        // device 1671, IC IC278, analog/basic/buffered_nand_latch.hpp:35
        I(cpphdl_n2124, Vss) <+ 5e-15 * ddt(V(cpphdl_n2124, Vss)); // Bench initial voltage = 0.0 V.
        // device 1672, IC IC278, analog/basic/buffered_nand_latch.hpp:36
        I(cpphdl_n2124, Vss) <+ 8.0000000000000006e-15 * ddt(V(cpphdl_n2124, Vss)); // Bench initial voltage = 0.0 V.
        // device 1673, IC IC278, analog/basic/buffered_nand_latch.hpp:37
        I(cpphdl_n2140, Vss) <+ 1e-14 * ddt(V(cpphdl_n2140, Vss)); // Bench initial voltage = 0.0 V.
        // device 1674, IC IC284, analog/basic/cmos_logic.hpp:15
        I(cpphdl_n2795, Vss) <+ 5.0000000000000002e-14 * ddt(V(cpphdl_n2795, Vss)); // Bench initial voltage = 0.0 V.
        // device 1675, IC IC284, analog/basic/cmos_logic.hpp:16
        I(cpphdl_n2795, Vdd) <+ cpphdl_channel(V(cpphdl_n2134, Vdd), V(cpphdl_n2795, Vdd), 0.01, 0.69999999999999996, -1.0);
        // device 1676, IC IC284, analog/basic/cmos_logic.hpp:17
        I(cpphdl_n2795, Vdd) <+ cpphdl_channel(V(cpphdl_n2142, Vdd), V(cpphdl_n2795, Vdd), 0.01, 0.69999999999999996, -1.0);
        // device 1677, IC IC284, analog/basic/cmos_logic.hpp:18
        I(cpphdl_n2795, cpphdl_n2137) <+ cpphdl_channel(V(cpphdl_n2134, cpphdl_n2137), V(cpphdl_n2795, cpphdl_n2137), 0.01, 0.69999999999999996, 1.0);
        // device 1678, IC IC284, analog/basic/cmos_logic.hpp:19
        I(cpphdl_n2137, Vss) <+ cpphdl_channel(V(cpphdl_n2142, Vss), V(cpphdl_n2137, Vss), 0.01, 0.69999999999999996, 1.0);
        // device 1679, IC IC284, analog/basic/cmos_logic.hpp:20
        I(cpphdl_n2795, Vss) <+ V(cpphdl_n2795, Vss) / 1000000000.0;
        // device 1680, IC IC284, analog/basic/cmos_logic.hpp:21
        I(cpphdl_n2137, Vss) <+ V(cpphdl_n2137, Vss) / 1000000000.0;
        // device 1681, IC IC285, analog/basic/cmos_logic.hpp:15
        I(cpphdl_n2142, Vss) <+ 5.0000000000000002e-14 * ddt(V(cpphdl_n2142, Vss)); // Bench initial voltage = 0.0 V.
        // device 1682, IC IC285, analog/basic/cmos_logic.hpp:16
        I(cpphdl_n2142, Vdd) <+ cpphdl_channel(V(cpphdl_n2140, Vdd), V(cpphdl_n2142, Vdd), 0.01, 0.69999999999999996, -1.0);
        // device 1683, IC IC285, analog/basic/cmos_logic.hpp:17
        I(cpphdl_n2142, Vdd) <+ cpphdl_channel(V(cpphdl_n2795, Vdd), V(cpphdl_n2142, Vdd), 0.01, 0.69999999999999996, -1.0);
        // device 1684, IC IC285, analog/basic/cmos_logic.hpp:18
        I(cpphdl_n2142, cpphdl_n2143) <+ cpphdl_channel(V(cpphdl_n2140, cpphdl_n2143), V(cpphdl_n2142, cpphdl_n2143), 0.01, 0.69999999999999996, 1.0);
        // device 1685, IC IC285, analog/basic/cmos_logic.hpp:19
        I(cpphdl_n2143, Vss) <+ cpphdl_channel(V(cpphdl_n2795, Vss), V(cpphdl_n2143, Vss), 0.01, 0.69999999999999996, 1.0);
        // device 1686, IC IC285, analog/basic/cmos_logic.hpp:20
        I(cpphdl_n2142, Vss) <+ V(cpphdl_n2142, Vss) / 1000000000.0;
        // device 1687, IC IC285, analog/basic/cmos_logic.hpp:21
        I(cpphdl_n2143, Vss) <+ V(cpphdl_n2143, Vss) / 1000000000.0;
        // device 1688, IC IC283, analog/basic/nand_latch.hpp:34
        I(cpphdl_n2134, Vss) <+ 2.9999999999999998e-15 * ddt(V(cpphdl_n2134, Vss)); // Bench initial voltage = 0.0 V.
        // device 1689, IC IC283, analog/basic/nand_latch.hpp:35
        I(cpphdl_n2140, Vss) <+ 2.9999999999999998e-15 * ddt(V(cpphdl_n2140, Vss)); // Bench initial voltage = 0.0 V.
        // device 1690, IC IC286, analog/basic/inverter.hpp:11
        I(cpphdl_n2148, Vdd) <+ cpphdl_channel(V(CLEAR, Vdd), V(cpphdl_n2148, Vdd), 0.01, 0.69999999999999996, -1.0);
        // device 1691, IC IC286, analog/basic/inverter.hpp:12
        I(cpphdl_n2148, Vss) <+ cpphdl_channel(V(CLEAR, Vss), V(cpphdl_n2148, Vss), 0.01, 0.69999999999999996, 1.0);
        // device 1692, IC IC283, analog/basic/nand_latch.hpp:56
        I(cpphdl_n2148, Vss) <+ 2.9999999999999998e-15 * ddt(V(cpphdl_n2148, Vss)); // Bench initial voltage = 0.0 V.
        // device 1693, IC IC283, analog/basic/nand_latch.hpp:57
        I(cpphdl_n2795, Vss) <+ cpphdl_channel(V(CLEAR, Vss), V(cpphdl_n2795, Vss), 0.050000000000000003, 0.69999999999999996, 1.0);
        // device 1694, IC IC283, analog/basic/nand_latch.hpp:58
        I(cpphdl_n2142, Vdd) <+ cpphdl_channel(V(cpphdl_n2148, Vdd), V(cpphdl_n2142, Vdd), 0.050000000000000003, 0.69999999999999996, -1.0);
        // device 1695, IC IC289, analog/basic/inverter.hpp:11
        I(cpphdl_n2172, Vdd) <+ cpphdl_channel(V(TRACK12, Vdd), V(cpphdl_n2172, Vdd), 0.0040000000000000001, 0.69999999999999996, -1.0);
        // device 1696, IC IC289, analog/basic/inverter.hpp:12
        I(cpphdl_n2172, Vss) <+ cpphdl_channel(V(TRACK12, Vss), V(cpphdl_n2172, Vss), 0.0040000000000000001, 0.69999999999999996, 1.0);
        // device 1697, IC IC288, analog/basic/mos_track_hold.hpp:30
        I(cpphdl_n2172, Vss) <+ 2e-14 * ddt(V(cpphdl_n2172, Vss)); // Bench initial voltage = 3.2999999999999998 V.
        // device 1698, IC IC288, analog/basic/mos_track_hold.hpp:31
        I(cpphdl_n2595, cpphdl_n2226) <+ cpphdl_channel(V(TRACK12, cpphdl_n2226), V(cpphdl_n2595, cpphdl_n2226), 0.02, 0.69999999999999996, 1.0);
        // device 1699, IC IC288, analog/basic/mos_track_hold.hpp:32
        I(cpphdl_n2226, cpphdl_n2595) <+ cpphdl_channel(V(cpphdl_n2172, cpphdl_n2595), V(cpphdl_n2226, cpphdl_n2595), 0.01, 0.69999999999999996, -1.0);
        // device 1700, IC IC288, analog/basic/mos_track_hold.hpp:36
        I(cpphdl_n2226, cpphdl_n2226) <+ cpphdl_channel(V(cpphdl_n2172, cpphdl_n2226), V(cpphdl_n2226, cpphdl_n2226), 0.01, 0.69999999999999996, 1.0);
        // device 1701, IC IC288, analog/basic/mos_track_hold.hpp:37
        I(cpphdl_n2226, cpphdl_n2226) <+ cpphdl_channel(V(TRACK12, cpphdl_n2226), V(cpphdl_n2226, cpphdl_n2226), 0.0050000000000000001, 0.69999999999999996, -1.0);
        // device 1702, IC IC288, analog/basic/mos_track_hold.hpp:38
        I(cpphdl_n2226, Vss) <+ 1.5000000000000001e-12 * ddt(V(cpphdl_n2226, Vss)); // Bench initial voltage = 1.6499999999999999 V.
        // device 1703, IC IC288, analog/basic/mos_track_hold.hpp:39
        I(Vss, cpphdl_n2226) <+ V(Vss, cpphdl_n2226) / 1000000000.0;
        // device 1704, IC IC288, analog/basic/mos_track_hold.hpp:40
        I(TRACK12, cpphdl_n2226) <+ 2.0000000000000002e-15 * ddt(V(TRACK12, cpphdl_n2226)); // Bench initial voltage = -1.6499999999999999 V.
        // device 1705, IC IC288, analog/basic/mos_track_hold.hpp:41
        I(cpphdl_n2172, cpphdl_n2226) <+ 2.0000000000000002e-15 * ddt(V(cpphdl_n2172, cpphdl_n2226)); // Bench initial voltage = 1.6499999999999999 V.
        // device 1706, IC IC288, analog/basic/mos_track_hold.hpp:42
        I(cpphdl_n2595, cpphdl_n2226) <+ 1.0000000000000001e-15 * ddt(V(cpphdl_n2595, cpphdl_n2226)); // Bench initial voltage = 0.0 V.
        // device 1707, IC IC291, analog/basic/inverter.hpp:11
        I(cpphdl_n2187, Vdd) <+ cpphdl_channel(V(BIT_N12_0, Vdd), V(cpphdl_n2187, Vdd), 0.080000000000000002, 0.69999999999999996, -1.0);
        // device 1708, IC IC291, analog/basic/inverter.hpp:12
        I(cpphdl_n2187, Vss) <+ cpphdl_channel(V(BIT_N12_0, Vss), V(cpphdl_n2187, Vss), 0.080000000000000002, 0.69999999999999996, 1.0);
        // device 1709, IC IC290, analog/basic/mos_r2r_dac.hpp:27
        I(cpphdl_n2187, Vss) <+ 2.9999999999999998e-15 * ddt(V(cpphdl_n2187, Vss)); // Bench initial voltage = 0.0 V.
        // device 1710, IC IC290, analog/basic/mos_r2r_dac.hpp:28
        I(cpphdl_n2187, cpphdl_n2216) <+ V(cpphdl_n2187, cpphdl_n2216) / 2000.0;
        // device 1711, IC IC290, analog/basic/mos_r2r_dac.hpp:29
        I(cpphdl_n2216, Vss) <+ 2.9999999999999998e-15 * ddt(V(cpphdl_n2216, Vss)); // Bench initial voltage = 0.0 V.
        // device 1712, IC IC292, analog/basic/inverter.hpp:11
        I(cpphdl_n2191, Vdd) <+ cpphdl_channel(V(BIT_N12_1, Vdd), V(cpphdl_n2191, Vdd), 0.080000000000000002, 0.69999999999999996, -1.0);
        // device 1713, IC IC292, analog/basic/inverter.hpp:12
        I(cpphdl_n2191, Vss) <+ cpphdl_channel(V(BIT_N12_1, Vss), V(cpphdl_n2191, Vss), 0.080000000000000002, 0.69999999999999996, 1.0);
        // device 1714, IC IC290, analog/basic/mos_r2r_dac.hpp:27
        I(cpphdl_n2191, Vss) <+ 2.9999999999999998e-15 * ddt(V(cpphdl_n2191, Vss)); // Bench initial voltage = 0.0 V.
        // device 1715, IC IC290, analog/basic/mos_r2r_dac.hpp:28
        I(cpphdl_n2191, cpphdl_n2217) <+ V(cpphdl_n2191, cpphdl_n2217) / 2000.0;
        // device 1716, IC IC290, analog/basic/mos_r2r_dac.hpp:29
        I(cpphdl_n2217, Vss) <+ 2.9999999999999998e-15 * ddt(V(cpphdl_n2217, Vss)); // Bench initial voltage = 0.0 V.
        // device 1717, IC IC290, analog/basic/mos_r2r_dac.hpp:31
        I(cpphdl_n2216, cpphdl_n2217) <+ V(cpphdl_n2216, cpphdl_n2217) / 1000.0;
        // device 1718, IC IC293, analog/basic/inverter.hpp:11
        I(cpphdl_n2195, Vdd) <+ cpphdl_channel(V(BIT_N12_2, Vdd), V(cpphdl_n2195, Vdd), 0.080000000000000002, 0.69999999999999996, -1.0);
        // device 1719, IC IC293, analog/basic/inverter.hpp:12
        I(cpphdl_n2195, Vss) <+ cpphdl_channel(V(BIT_N12_2, Vss), V(cpphdl_n2195, Vss), 0.080000000000000002, 0.69999999999999996, 1.0);
        // device 1720, IC IC290, analog/basic/mos_r2r_dac.hpp:27
        I(cpphdl_n2195, Vss) <+ 2.9999999999999998e-15 * ddt(V(cpphdl_n2195, Vss)); // Bench initial voltage = 0.0 V.
        // device 1721, IC IC290, analog/basic/mos_r2r_dac.hpp:28
        I(cpphdl_n2195, cpphdl_n2218) <+ V(cpphdl_n2195, cpphdl_n2218) / 2000.0;
        // device 1722, IC IC290, analog/basic/mos_r2r_dac.hpp:29
        I(cpphdl_n2218, Vss) <+ 2.9999999999999998e-15 * ddt(V(cpphdl_n2218, Vss)); // Bench initial voltage = 0.0 V.
        // device 1723, IC IC290, analog/basic/mos_r2r_dac.hpp:31
        I(cpphdl_n2217, cpphdl_n2218) <+ V(cpphdl_n2217, cpphdl_n2218) / 1000.0;
        // device 1724, IC IC294, analog/basic/inverter.hpp:11
        I(cpphdl_n2199, Vdd) <+ cpphdl_channel(V(BIT_N12_3, Vdd), V(cpphdl_n2199, Vdd), 0.080000000000000002, 0.69999999999999996, -1.0);
        // device 1725, IC IC294, analog/basic/inverter.hpp:12
        I(cpphdl_n2199, Vss) <+ cpphdl_channel(V(BIT_N12_3, Vss), V(cpphdl_n2199, Vss), 0.080000000000000002, 0.69999999999999996, 1.0);
        // device 1726, IC IC290, analog/basic/mos_r2r_dac.hpp:27
        I(cpphdl_n2199, Vss) <+ 2.9999999999999998e-15 * ddt(V(cpphdl_n2199, Vss)); // Bench initial voltage = 0.0 V.
        // device 1727, IC IC290, analog/basic/mos_r2r_dac.hpp:28
        I(cpphdl_n2199, cpphdl_n2219) <+ V(cpphdl_n2199, cpphdl_n2219) / 2000.0;
        // device 1728, IC IC290, analog/basic/mos_r2r_dac.hpp:29
        I(cpphdl_n2219, Vss) <+ 2.9999999999999998e-15 * ddt(V(cpphdl_n2219, Vss)); // Bench initial voltage = 0.0 V.
        // device 1729, IC IC290, analog/basic/mos_r2r_dac.hpp:31
        I(cpphdl_n2218, cpphdl_n2219) <+ V(cpphdl_n2218, cpphdl_n2219) / 1000.0;
        // device 1730, IC IC295, analog/basic/inverter.hpp:11
        I(cpphdl_n2203, Vdd) <+ cpphdl_channel(V(BIT_N12_4, Vdd), V(cpphdl_n2203, Vdd), 0.080000000000000002, 0.69999999999999996, -1.0);
        // device 1731, IC IC295, analog/basic/inverter.hpp:12
        I(cpphdl_n2203, Vss) <+ cpphdl_channel(V(BIT_N12_4, Vss), V(cpphdl_n2203, Vss), 0.080000000000000002, 0.69999999999999996, 1.0);
        // device 1732, IC IC290, analog/basic/mos_r2r_dac.hpp:27
        I(cpphdl_n2203, Vss) <+ 2.9999999999999998e-15 * ddt(V(cpphdl_n2203, Vss)); // Bench initial voltage = 0.0 V.
        // device 1733, IC IC290, analog/basic/mos_r2r_dac.hpp:28
        I(cpphdl_n2203, cpphdl_n2220) <+ V(cpphdl_n2203, cpphdl_n2220) / 2000.0;
        // device 1734, IC IC290, analog/basic/mos_r2r_dac.hpp:29
        I(cpphdl_n2220, Vss) <+ 2.9999999999999998e-15 * ddt(V(cpphdl_n2220, Vss)); // Bench initial voltage = 0.0 V.
        // device 1735, IC IC290, analog/basic/mos_r2r_dac.hpp:31
        I(cpphdl_n2219, cpphdl_n2220) <+ V(cpphdl_n2219, cpphdl_n2220) / 1000.0;
        // device 1736, IC IC296, analog/basic/inverter.hpp:11
        I(cpphdl_n2207, Vdd) <+ cpphdl_channel(V(BIT_N12_5, Vdd), V(cpphdl_n2207, Vdd), 0.080000000000000002, 0.69999999999999996, -1.0);
        // device 1737, IC IC296, analog/basic/inverter.hpp:12
        I(cpphdl_n2207, Vss) <+ cpphdl_channel(V(BIT_N12_5, Vss), V(cpphdl_n2207, Vss), 0.080000000000000002, 0.69999999999999996, 1.0);
        // device 1738, IC IC290, analog/basic/mos_r2r_dac.hpp:27
        I(cpphdl_n2207, Vss) <+ 2.9999999999999998e-15 * ddt(V(cpphdl_n2207, Vss)); // Bench initial voltage = 0.0 V.
        // device 1739, IC IC290, analog/basic/mos_r2r_dac.hpp:28
        I(cpphdl_n2207, cpphdl_n2221) <+ V(cpphdl_n2207, cpphdl_n2221) / 2000.0;
        // device 1740, IC IC290, analog/basic/mos_r2r_dac.hpp:29
        I(cpphdl_n2221, Vss) <+ 2.9999999999999998e-15 * ddt(V(cpphdl_n2221, Vss)); // Bench initial voltage = 0.0 V.
        // device 1741, IC IC290, analog/basic/mos_r2r_dac.hpp:31
        I(cpphdl_n2220, cpphdl_n2221) <+ V(cpphdl_n2220, cpphdl_n2221) / 1000.0;
        // device 1742, IC IC297, analog/basic/inverter.hpp:11
        I(cpphdl_n2211, Vdd) <+ cpphdl_channel(V(BIT_N12_6, Vdd), V(cpphdl_n2211, Vdd), 0.080000000000000002, 0.69999999999999996, -1.0);
        // device 1743, IC IC297, analog/basic/inverter.hpp:12
        I(cpphdl_n2211, Vss) <+ cpphdl_channel(V(BIT_N12_6, Vss), V(cpphdl_n2211, Vss), 0.080000000000000002, 0.69999999999999996, 1.0);
        // device 1744, IC IC290, analog/basic/mos_r2r_dac.hpp:27
        I(cpphdl_n2211, Vss) <+ 2.9999999999999998e-15 * ddt(V(cpphdl_n2211, Vss)); // Bench initial voltage = 0.0 V.
        // device 1745, IC IC290, analog/basic/mos_r2r_dac.hpp:28
        I(cpphdl_n2211, cpphdl_n2222) <+ V(cpphdl_n2211, cpphdl_n2222) / 2000.0;
        // device 1746, IC IC290, analog/basic/mos_r2r_dac.hpp:29
        I(cpphdl_n2222, Vss) <+ 2.9999999999999998e-15 * ddt(V(cpphdl_n2222, Vss)); // Bench initial voltage = 0.0 V.
        // device 1747, IC IC290, analog/basic/mos_r2r_dac.hpp:31
        I(cpphdl_n2221, cpphdl_n2222) <+ V(cpphdl_n2221, cpphdl_n2222) / 1000.0;
        // device 1748, IC IC298, analog/basic/inverter.hpp:11
        I(cpphdl_n2215, Vdd) <+ cpphdl_channel(V(BIT_N12_7, Vdd), V(cpphdl_n2215, Vdd), 0.080000000000000002, 0.69999999999999996, -1.0);
        // device 1749, IC IC298, analog/basic/inverter.hpp:12
        I(cpphdl_n2215, Vss) <+ cpphdl_channel(V(BIT_N12_7, Vss), V(cpphdl_n2215, Vss), 0.080000000000000002, 0.69999999999999996, 1.0);
        // device 1750, IC IC290, analog/basic/mos_r2r_dac.hpp:27
        I(cpphdl_n2215, Vss) <+ 2.9999999999999998e-15 * ddt(V(cpphdl_n2215, Vss)); // Bench initial voltage = 0.0 V.
        // device 1751, IC IC290, analog/basic/mos_r2r_dac.hpp:28
        I(cpphdl_n2215, cpphdl_n2227) <+ V(cpphdl_n2215, cpphdl_n2227) / 2000.0;
        // device 1752, IC IC290, analog/basic/mos_r2r_dac.hpp:29
        I(cpphdl_n2227, Vss) <+ 2.9999999999999998e-15 * ddt(V(cpphdl_n2227, Vss)); // Bench initial voltage = 0.0 V.
        // device 1753, IC IC290, analog/basic/mos_r2r_dac.hpp:31
        I(cpphdl_n2222, cpphdl_n2227) <+ V(cpphdl_n2222, cpphdl_n2227) / 1000.0;
        // device 1754, IC IC290, analog/basic/mos_r2r_dac.hpp:33
        I(Vss, cpphdl_n2216) <+ V(Vss, cpphdl_n2216) / 2000.0;
        // device 1755, IC IC299, analog/basic/nmos_resistor_amplifier.hpp:23
        I(Vdd, cpphdl_n2236) <+ V(Vdd, cpphdl_n2236) / 500.0;
        // device 1756, IC IC299, analog/basic/nmos_resistor_amplifier.hpp:24
        I(Vdd, cpphdl_n2235) <+ V(Vdd, cpphdl_n2235) / 500.0;
        // device 1757, IC IC299, analog/basic/nmos_resistor_amplifier.hpp:25
        I(cpphdl_n2236, cpphdl_n2230) <+ cpphdl_channel(V(cpphdl_n2226, cpphdl_n2230), V(cpphdl_n2236, cpphdl_n2230), 0.014999999999999999, 0.69999999999999996, 1.0);
        // device 1758, IC IC299, analog/basic/nmos_resistor_amplifier.hpp:26
        I(cpphdl_n2235, cpphdl_n2231) <+ cpphdl_channel(V(cpphdl_n2227, cpphdl_n2231), V(cpphdl_n2235, cpphdl_n2231), 0.014999999999999999, 0.69999999999999996, 1.0);
        // device 1759, IC IC299, analog/basic/nmos_resistor_amplifier.hpp:27
        I(cpphdl_n2232, cpphdl_n2230) <+ V(cpphdl_n2232, cpphdl_n2230) / 50.0;
        // device 1760, IC IC299, analog/basic/nmos_resistor_amplifier.hpp:28
        I(cpphdl_n2232, cpphdl_n2231) <+ V(cpphdl_n2232, cpphdl_n2231) / 50.0;
        // device 1761, IC IC299, analog/basic/nmos_resistor_amplifier.hpp:29
        I(Vss, cpphdl_n2232) <+ V(Vss, cpphdl_n2232) / 150.0;
        // device 1762, IC IC299, analog/basic/nmos_resistor_amplifier.hpp:30
        I(cpphdl_n2236, Vdd) <+ 2.9999999999999998e-13 * ddt(V(cpphdl_n2236, Vdd)); // Bench initial voltage = 0.0 V.
        // device 1763, IC IC299, analog/basic/nmos_resistor_amplifier.hpp:31
        I(cpphdl_n2235, Vdd) <+ 2.9999999999999998e-13 * ddt(V(cpphdl_n2235, Vdd)); // Bench initial voltage = 0.0 V.
        // device 1764, IC IC299, analog/basic/nmos_resistor_amplifier.hpp:32
        I(cpphdl_n2232, Vss) <+ 4e-14 * ddt(V(cpphdl_n2232, Vss)); // Bench initial voltage = 0.0 V.
        // device 1765, IC IC299, analog/basic/nmos_resistor_amplifier.hpp:34
        I(cpphdl_n2226, cpphdl_n2230) <+ 2e-14 * ddt(V(cpphdl_n2226, cpphdl_n2230)); // Bench initial voltage = 1.6499999999999999 V.
        // device 1766, IC IC299, analog/basic/nmos_resistor_amplifier.hpp:35
        I(cpphdl_n2227, cpphdl_n2231) <+ 2e-14 * ddt(V(cpphdl_n2227, cpphdl_n2231)); // Bench initial voltage = 0.0 V.
        // device 1767, IC IC299, analog/basic/nmos_resistor_amplifier.hpp:36
        I(cpphdl_n2226, cpphdl_n2236) <+ 2.9999999999999998e-15 * ddt(V(cpphdl_n2226, cpphdl_n2236)); // Bench initial voltage = -1.6499999999999999 V.
        // device 1768, IC IC299, analog/basic/nmos_resistor_amplifier.hpp:37
        I(cpphdl_n2227, cpphdl_n2235) <+ 2.9999999999999998e-15 * ddt(V(cpphdl_n2227, cpphdl_n2235)); // Bench initial voltage = -3.2999999999999998 V.
        // device 1769, IC IC300, analog/basic/strongarm_comparator.hpp:28
        I(cpphdl_n2240, cpphdl_n2242) <+ cpphdl_channel(V(cpphdl_n2235, cpphdl_n2242), V(cpphdl_n2240, cpphdl_n2242), 0.0080000000000000002, 0.69999999999999996, 1.0);
        // device 1770, IC IC300, analog/basic/strongarm_comparator.hpp:29
        I(cpphdl_n2241, cpphdl_n2242) <+ cpphdl_channel(V(cpphdl_n2236, cpphdl_n2242), V(cpphdl_n2241, cpphdl_n2242), 0.0080000000000000002, 0.69999999999999996, 1.0);
        // device 1771, IC IC300, analog/basic/strongarm_comparator.hpp:30
        I(cpphdl_n2242, Vss) <+ cpphdl_channel(V(EVALUATE, Vss), V(cpphdl_n2242, Vss), 0.0080000000000000002, 0.69999999999999996, 1.0);
        // device 1772, IC IC300, analog/basic/strongarm_comparator.hpp:33
        I(cpphdl_n2255, cpphdl_n2240) <+ cpphdl_channel(V(cpphdl_n2259, cpphdl_n2240), V(cpphdl_n2255, cpphdl_n2240), 0.0040000000000000001, 0.69999999999999996, 1.0);
        // device 1773, IC IC300, analog/basic/strongarm_comparator.hpp:34
        I(cpphdl_n2259, cpphdl_n2241) <+ cpphdl_channel(V(cpphdl_n2255, cpphdl_n2241), V(cpphdl_n2259, cpphdl_n2241), 0.0040000000000000001, 0.69999999999999996, 1.0);
        // device 1774, IC IC300, analog/basic/strongarm_comparator.hpp:35
        I(cpphdl_n2259, Vdd) <+ cpphdl_channel(V(cpphdl_n2255, Vdd), V(cpphdl_n2259, Vdd), 0.002, 0.69999999999999996, -1.0);
        // device 1775, IC IC300, analog/basic/strongarm_comparator.hpp:36
        I(cpphdl_n2255, Vdd) <+ cpphdl_channel(V(cpphdl_n2259, Vdd), V(cpphdl_n2255, Vdd), 0.002, 0.69999999999999996, -1.0);
        // device 1776, IC IC300, analog/basic/strongarm_comparator.hpp:38
        I(cpphdl_n2240, Vdd) <+ cpphdl_channel(V(EVALUATE, Vdd), V(cpphdl_n2240, Vdd), 0.002, 0.69999999999999996, -1.0);
        // device 1777, IC IC300, analog/basic/strongarm_comparator.hpp:39
        I(cpphdl_n2241, Vdd) <+ cpphdl_channel(V(EVALUATE, Vdd), V(cpphdl_n2241, Vdd), 0.002, 0.69999999999999996, -1.0);
        // device 1778, IC IC300, analog/basic/strongarm_comparator.hpp:40
        I(cpphdl_n2259, Vdd) <+ cpphdl_channel(V(EVALUATE, Vdd), V(cpphdl_n2259, Vdd), 0.002, 0.69999999999999996, -1.0);
        // device 1779, IC IC300, analog/basic/strongarm_comparator.hpp:41
        I(cpphdl_n2255, Vdd) <+ cpphdl_channel(V(EVALUATE, Vdd), V(cpphdl_n2255, Vdd), 0.002, 0.69999999999999996, -1.0);
        // device 1780, IC IC300, analog/basic/strongarm_comparator.hpp:42
        I(cpphdl_n2240, Vss) <+ 2.9999999999999998e-14 * ddt(V(cpphdl_n2240, Vss)); // Bench initial voltage = 0.0 V.
        // device 1781, IC IC300, analog/basic/strongarm_comparator.hpp:43
        I(cpphdl_n2241, Vss) <+ 2.9999999999999998e-14 * ddt(V(cpphdl_n2241, Vss)); // Bench initial voltage = 0.0 V.
        // device 1782, IC IC300, analog/basic/strongarm_comparator.hpp:44
        I(cpphdl_n2242, Vss) <+ 2.9999999999999998e-14 * ddt(V(cpphdl_n2242, Vss)); // Bench initial voltage = 0.0 V.
        // device 1783, IC IC300, analog/basic/strongarm_comparator.hpp:45
        I(cpphdl_n2259, Vss) <+ 5.0000000000000002e-14 * ddt(V(cpphdl_n2259, Vss)); // Bench initial voltage = 0.0 V.
        // device 1784, IC IC300, analog/basic/strongarm_comparator.hpp:46
        I(cpphdl_n2255, Vss) <+ 5.0000000000000002e-14 * ddt(V(cpphdl_n2255, Vss)); // Bench initial voltage = 0.0 V.
        // device 1785, IC IC300, analog/basic/strongarm_comparator.hpp:47
        I(cpphdl_n2235, cpphdl_n2242) <+ 2e-14 * ddt(V(cpphdl_n2235, cpphdl_n2242)); // Bench initial voltage = 3.2999999999999998 V.
        // device 1786, IC IC300, analog/basic/strongarm_comparator.hpp:48
        I(cpphdl_n2236, cpphdl_n2242) <+ 2e-14 * ddt(V(cpphdl_n2236, cpphdl_n2242)); // Bench initial voltage = 3.2999999999999998 V.
        // device 1787, IC IC300, analog/basic/strongarm_comparator.hpp:49
        I(cpphdl_n2235, cpphdl_n2240) <+ 2.9999999999999998e-15 * ddt(V(cpphdl_n2235, cpphdl_n2240)); // Bench initial voltage = 3.2999999999999998 V.
        // device 1788, IC IC300, analog/basic/strongarm_comparator.hpp:50
        I(cpphdl_n2236, cpphdl_n2241) <+ 2.9999999999999998e-15 * ddt(V(cpphdl_n2236, cpphdl_n2241)); // Bench initial voltage = 3.2999999999999998 V.
        // device 1789, IC IC302, analog/basic/inverter.hpp:11
        I(cpphdl_n2263, Vdd) <+ cpphdl_channel(V(cpphdl_n2255, Vdd), V(cpphdl_n2263, Vdd), 0.001, 0.69999999999999996, -1.0);
        // device 1790, IC IC302, analog/basic/inverter.hpp:12
        I(cpphdl_n2263, Vss) <+ cpphdl_channel(V(cpphdl_n2255, Vss), V(cpphdl_n2263, Vss), 0.001, 0.69999999999999996, 1.0);
        // device 1791, IC IC304, analog/basic/inverter.hpp:11
        I(cpphdl_n2277, Vdd) <+ cpphdl_channel(V(cpphdl_n2263, Vdd), V(cpphdl_n2277, Vdd), 0.0040000000000000001, 0.69999999999999996, -1.0);
        // device 1792, IC IC304, analog/basic/inverter.hpp:12
        I(cpphdl_n2277, Vss) <+ cpphdl_channel(V(cpphdl_n2263, Vss), V(cpphdl_n2277, Vss), 0.0040000000000000001, 0.69999999999999996, 1.0);
        // device 1793, IC IC301, analog/basic/buffered_nand_latch.hpp:33
        I(cpphdl_n2255, Vss) <+ 2.0000000000000002e-15 * ddt(V(cpphdl_n2255, Vss)); // Bench initial voltage = 0.0 V.
        // device 1794, IC IC301, analog/basic/buffered_nand_latch.hpp:34
        I(cpphdl_n2255, cpphdl_n2263) <+ 1.0000000000000001e-15 * ddt(V(cpphdl_n2255, cpphdl_n2263)); // Bench initial voltage = 0.0 V.
        // device 1795, IC IC301, analog/basic/buffered_nand_latch.hpp:35
        I(cpphdl_n2263, Vss) <+ 5e-15 * ddt(V(cpphdl_n2263, Vss)); // Bench initial voltage = 0.0 V.
        // device 1796, IC IC301, analog/basic/buffered_nand_latch.hpp:36
        I(cpphdl_n2263, Vss) <+ 8.0000000000000006e-15 * ddt(V(cpphdl_n2263, Vss)); // Bench initial voltage = 0.0 V.
        // device 1797, IC IC301, analog/basic/buffered_nand_latch.hpp:37
        I(cpphdl_n2277, Vss) <+ 1e-14 * ddt(V(cpphdl_n2277, Vss)); // Bench initial voltage = 0.0 V.
        // device 1798, IC IC303, analog/basic/inverter.hpp:11
        I(cpphdl_n2267, Vdd) <+ cpphdl_channel(V(cpphdl_n2259, Vdd), V(cpphdl_n2267, Vdd), 0.001, 0.69999999999999996, -1.0);
        // device 1799, IC IC303, analog/basic/inverter.hpp:12
        I(cpphdl_n2267, Vss) <+ cpphdl_channel(V(cpphdl_n2259, Vss), V(cpphdl_n2267, Vss), 0.001, 0.69999999999999996, 1.0);
        // device 1800, IC IC305, analog/basic/inverter.hpp:11
        I(cpphdl_n2283, Vdd) <+ cpphdl_channel(V(cpphdl_n2267, Vdd), V(cpphdl_n2283, Vdd), 0.0040000000000000001, 0.69999999999999996, -1.0);
        // device 1801, IC IC305, analog/basic/inverter.hpp:12
        I(cpphdl_n2283, Vss) <+ cpphdl_channel(V(cpphdl_n2267, Vss), V(cpphdl_n2283, Vss), 0.0040000000000000001, 0.69999999999999996, 1.0);
        // device 1802, IC IC301, analog/basic/buffered_nand_latch.hpp:33
        I(cpphdl_n2259, Vss) <+ 2.0000000000000002e-15 * ddt(V(cpphdl_n2259, Vss)); // Bench initial voltage = 0.0 V.
        // device 1803, IC IC301, analog/basic/buffered_nand_latch.hpp:34
        I(cpphdl_n2259, cpphdl_n2267) <+ 1.0000000000000001e-15 * ddt(V(cpphdl_n2259, cpphdl_n2267)); // Bench initial voltage = 0.0 V.
        // device 1804, IC IC301, analog/basic/buffered_nand_latch.hpp:35
        I(cpphdl_n2267, Vss) <+ 5e-15 * ddt(V(cpphdl_n2267, Vss)); // Bench initial voltage = 0.0 V.
        // device 1805, IC IC301, analog/basic/buffered_nand_latch.hpp:36
        I(cpphdl_n2267, Vss) <+ 8.0000000000000006e-15 * ddt(V(cpphdl_n2267, Vss)); // Bench initial voltage = 0.0 V.
        // device 1806, IC IC301, analog/basic/buffered_nand_latch.hpp:37
        I(cpphdl_n2283, Vss) <+ 1e-14 * ddt(V(cpphdl_n2283, Vss)); // Bench initial voltage = 0.0 V.
        // device 1807, IC IC307, analog/basic/cmos_logic.hpp:15
        I(cpphdl_n2800, Vss) <+ 5.0000000000000002e-14 * ddt(V(cpphdl_n2800, Vss)); // Bench initial voltage = 0.0 V.
        // device 1808, IC IC307, analog/basic/cmos_logic.hpp:16
        I(cpphdl_n2800, Vdd) <+ cpphdl_channel(V(cpphdl_n2277, Vdd), V(cpphdl_n2800, Vdd), 0.01, 0.69999999999999996, -1.0);
        // device 1809, IC IC307, analog/basic/cmos_logic.hpp:17
        I(cpphdl_n2800, Vdd) <+ cpphdl_channel(V(cpphdl_n2285, Vdd), V(cpphdl_n2800, Vdd), 0.01, 0.69999999999999996, -1.0);
        // device 1810, IC IC307, analog/basic/cmos_logic.hpp:18
        I(cpphdl_n2800, cpphdl_n2280) <+ cpphdl_channel(V(cpphdl_n2277, cpphdl_n2280), V(cpphdl_n2800, cpphdl_n2280), 0.01, 0.69999999999999996, 1.0);
        // device 1811, IC IC307, analog/basic/cmos_logic.hpp:19
        I(cpphdl_n2280, Vss) <+ cpphdl_channel(V(cpphdl_n2285, Vss), V(cpphdl_n2280, Vss), 0.01, 0.69999999999999996, 1.0);
        // device 1812, IC IC307, analog/basic/cmos_logic.hpp:20
        I(cpphdl_n2800, Vss) <+ V(cpphdl_n2800, Vss) / 1000000000.0;
        // device 1813, IC IC307, analog/basic/cmos_logic.hpp:21
        I(cpphdl_n2280, Vss) <+ V(cpphdl_n2280, Vss) / 1000000000.0;
        // device 1814, IC IC308, analog/basic/cmos_logic.hpp:15
        I(cpphdl_n2285, Vss) <+ 5.0000000000000002e-14 * ddt(V(cpphdl_n2285, Vss)); // Bench initial voltage = 0.0 V.
        // device 1815, IC IC308, analog/basic/cmos_logic.hpp:16
        I(cpphdl_n2285, Vdd) <+ cpphdl_channel(V(cpphdl_n2283, Vdd), V(cpphdl_n2285, Vdd), 0.01, 0.69999999999999996, -1.0);
        // device 1816, IC IC308, analog/basic/cmos_logic.hpp:17
        I(cpphdl_n2285, Vdd) <+ cpphdl_channel(V(cpphdl_n2800, Vdd), V(cpphdl_n2285, Vdd), 0.01, 0.69999999999999996, -1.0);
        // device 1817, IC IC308, analog/basic/cmos_logic.hpp:18
        I(cpphdl_n2285, cpphdl_n2286) <+ cpphdl_channel(V(cpphdl_n2283, cpphdl_n2286), V(cpphdl_n2285, cpphdl_n2286), 0.01, 0.69999999999999996, 1.0);
        // device 1818, IC IC308, analog/basic/cmos_logic.hpp:19
        I(cpphdl_n2286, Vss) <+ cpphdl_channel(V(cpphdl_n2800, Vss), V(cpphdl_n2286, Vss), 0.01, 0.69999999999999996, 1.0);
        // device 1819, IC IC308, analog/basic/cmos_logic.hpp:20
        I(cpphdl_n2285, Vss) <+ V(cpphdl_n2285, Vss) / 1000000000.0;
        // device 1820, IC IC308, analog/basic/cmos_logic.hpp:21
        I(cpphdl_n2286, Vss) <+ V(cpphdl_n2286, Vss) / 1000000000.0;
        // device 1821, IC IC306, analog/basic/nand_latch.hpp:34
        I(cpphdl_n2277, Vss) <+ 2.9999999999999998e-15 * ddt(V(cpphdl_n2277, Vss)); // Bench initial voltage = 0.0 V.
        // device 1822, IC IC306, analog/basic/nand_latch.hpp:35
        I(cpphdl_n2283, Vss) <+ 2.9999999999999998e-15 * ddt(V(cpphdl_n2283, Vss)); // Bench initial voltage = 0.0 V.
        // device 1823, IC IC309, analog/basic/inverter.hpp:11
        I(cpphdl_n2291, Vdd) <+ cpphdl_channel(V(CLEAR, Vdd), V(cpphdl_n2291, Vdd), 0.01, 0.69999999999999996, -1.0);
        // device 1824, IC IC309, analog/basic/inverter.hpp:12
        I(cpphdl_n2291, Vss) <+ cpphdl_channel(V(CLEAR, Vss), V(cpphdl_n2291, Vss), 0.01, 0.69999999999999996, 1.0);
        // device 1825, IC IC306, analog/basic/nand_latch.hpp:56
        I(cpphdl_n2291, Vss) <+ 2.9999999999999998e-15 * ddt(V(cpphdl_n2291, Vss)); // Bench initial voltage = 0.0 V.
        // device 1826, IC IC306, analog/basic/nand_latch.hpp:57
        I(cpphdl_n2800, Vss) <+ cpphdl_channel(V(CLEAR, Vss), V(cpphdl_n2800, Vss), 0.050000000000000003, 0.69999999999999996, 1.0);
        // device 1827, IC IC306, analog/basic/nand_latch.hpp:58
        I(cpphdl_n2285, Vdd) <+ cpphdl_channel(V(cpphdl_n2291, Vdd), V(cpphdl_n2285, Vdd), 0.050000000000000003, 0.69999999999999996, -1.0);
        // device 1828, IC IC312, analog/basic/inverter.hpp:11
        I(cpphdl_n2315, Vdd) <+ cpphdl_channel(V(TRACK13, Vdd), V(cpphdl_n2315, Vdd), 0.0040000000000000001, 0.69999999999999996, -1.0);
        // device 1829, IC IC312, analog/basic/inverter.hpp:12
        I(cpphdl_n2315, Vss) <+ cpphdl_channel(V(TRACK13, Vss), V(cpphdl_n2315, Vss), 0.0040000000000000001, 0.69999999999999996, 1.0);
        // device 1830, IC IC311, analog/basic/mos_track_hold.hpp:30
        I(cpphdl_n2315, Vss) <+ 2e-14 * ddt(V(cpphdl_n2315, Vss)); // Bench initial voltage = 3.2999999999999998 V.
        // device 1831, IC IC311, analog/basic/mos_track_hold.hpp:31
        I(cpphdl_n2595, cpphdl_n2369) <+ cpphdl_channel(V(TRACK13, cpphdl_n2369), V(cpphdl_n2595, cpphdl_n2369), 0.02, 0.69999999999999996, 1.0);
        // device 1832, IC IC311, analog/basic/mos_track_hold.hpp:32
        I(cpphdl_n2369, cpphdl_n2595) <+ cpphdl_channel(V(cpphdl_n2315, cpphdl_n2595), V(cpphdl_n2369, cpphdl_n2595), 0.01, 0.69999999999999996, -1.0);
        // device 1833, IC IC311, analog/basic/mos_track_hold.hpp:36
        I(cpphdl_n2369, cpphdl_n2369) <+ cpphdl_channel(V(cpphdl_n2315, cpphdl_n2369), V(cpphdl_n2369, cpphdl_n2369), 0.01, 0.69999999999999996, 1.0);
        // device 1834, IC IC311, analog/basic/mos_track_hold.hpp:37
        I(cpphdl_n2369, cpphdl_n2369) <+ cpphdl_channel(V(TRACK13, cpphdl_n2369), V(cpphdl_n2369, cpphdl_n2369), 0.0050000000000000001, 0.69999999999999996, -1.0);
        // device 1835, IC IC311, analog/basic/mos_track_hold.hpp:38
        I(cpphdl_n2369, Vss) <+ 1.5000000000000001e-12 * ddt(V(cpphdl_n2369, Vss)); // Bench initial voltage = 1.6499999999999999 V.
        // device 1836, IC IC311, analog/basic/mos_track_hold.hpp:39
        I(Vss, cpphdl_n2369) <+ V(Vss, cpphdl_n2369) / 1000000000.0;
        // device 1837, IC IC311, analog/basic/mos_track_hold.hpp:40
        I(TRACK13, cpphdl_n2369) <+ 2.0000000000000002e-15 * ddt(V(TRACK13, cpphdl_n2369)); // Bench initial voltage = -1.6499999999999999 V.
        // device 1838, IC IC311, analog/basic/mos_track_hold.hpp:41
        I(cpphdl_n2315, cpphdl_n2369) <+ 2.0000000000000002e-15 * ddt(V(cpphdl_n2315, cpphdl_n2369)); // Bench initial voltage = 1.6499999999999999 V.
        // device 1839, IC IC311, analog/basic/mos_track_hold.hpp:42
        I(cpphdl_n2595, cpphdl_n2369) <+ 1.0000000000000001e-15 * ddt(V(cpphdl_n2595, cpphdl_n2369)); // Bench initial voltage = 0.0 V.
        // device 1840, IC IC314, analog/basic/inverter.hpp:11
        I(cpphdl_n2330, Vdd) <+ cpphdl_channel(V(BIT_N13_0, Vdd), V(cpphdl_n2330, Vdd), 0.080000000000000002, 0.69999999999999996, -1.0);
        // device 1841, IC IC314, analog/basic/inverter.hpp:12
        I(cpphdl_n2330, Vss) <+ cpphdl_channel(V(BIT_N13_0, Vss), V(cpphdl_n2330, Vss), 0.080000000000000002, 0.69999999999999996, 1.0);
        // device 1842, IC IC313, analog/basic/mos_r2r_dac.hpp:27
        I(cpphdl_n2330, Vss) <+ 2.9999999999999998e-15 * ddt(V(cpphdl_n2330, Vss)); // Bench initial voltage = 0.0 V.
        // device 1843, IC IC313, analog/basic/mos_r2r_dac.hpp:28
        I(cpphdl_n2330, cpphdl_n2359) <+ V(cpphdl_n2330, cpphdl_n2359) / 2000.0;
        // device 1844, IC IC313, analog/basic/mos_r2r_dac.hpp:29
        I(cpphdl_n2359, Vss) <+ 2.9999999999999998e-15 * ddt(V(cpphdl_n2359, Vss)); // Bench initial voltage = 0.0 V.
        // device 1845, IC IC315, analog/basic/inverter.hpp:11
        I(cpphdl_n2334, Vdd) <+ cpphdl_channel(V(BIT_N13_1, Vdd), V(cpphdl_n2334, Vdd), 0.080000000000000002, 0.69999999999999996, -1.0);
        // device 1846, IC IC315, analog/basic/inverter.hpp:12
        I(cpphdl_n2334, Vss) <+ cpphdl_channel(V(BIT_N13_1, Vss), V(cpphdl_n2334, Vss), 0.080000000000000002, 0.69999999999999996, 1.0);
        // device 1847, IC IC313, analog/basic/mos_r2r_dac.hpp:27
        I(cpphdl_n2334, Vss) <+ 2.9999999999999998e-15 * ddt(V(cpphdl_n2334, Vss)); // Bench initial voltage = 0.0 V.
        // device 1848, IC IC313, analog/basic/mos_r2r_dac.hpp:28
        I(cpphdl_n2334, cpphdl_n2360) <+ V(cpphdl_n2334, cpphdl_n2360) / 2000.0;
        // device 1849, IC IC313, analog/basic/mos_r2r_dac.hpp:29
        I(cpphdl_n2360, Vss) <+ 2.9999999999999998e-15 * ddt(V(cpphdl_n2360, Vss)); // Bench initial voltage = 0.0 V.
        // device 1850, IC IC313, analog/basic/mos_r2r_dac.hpp:31
        I(cpphdl_n2359, cpphdl_n2360) <+ V(cpphdl_n2359, cpphdl_n2360) / 1000.0;
        // device 1851, IC IC316, analog/basic/inverter.hpp:11
        I(cpphdl_n2338, Vdd) <+ cpphdl_channel(V(BIT_N13_2, Vdd), V(cpphdl_n2338, Vdd), 0.080000000000000002, 0.69999999999999996, -1.0);
        // device 1852, IC IC316, analog/basic/inverter.hpp:12
        I(cpphdl_n2338, Vss) <+ cpphdl_channel(V(BIT_N13_2, Vss), V(cpphdl_n2338, Vss), 0.080000000000000002, 0.69999999999999996, 1.0);
        // device 1853, IC IC313, analog/basic/mos_r2r_dac.hpp:27
        I(cpphdl_n2338, Vss) <+ 2.9999999999999998e-15 * ddt(V(cpphdl_n2338, Vss)); // Bench initial voltage = 0.0 V.
        // device 1854, IC IC313, analog/basic/mos_r2r_dac.hpp:28
        I(cpphdl_n2338, cpphdl_n2361) <+ V(cpphdl_n2338, cpphdl_n2361) / 2000.0;
        // device 1855, IC IC313, analog/basic/mos_r2r_dac.hpp:29
        I(cpphdl_n2361, Vss) <+ 2.9999999999999998e-15 * ddt(V(cpphdl_n2361, Vss)); // Bench initial voltage = 0.0 V.
        // device 1856, IC IC313, analog/basic/mos_r2r_dac.hpp:31
        I(cpphdl_n2360, cpphdl_n2361) <+ V(cpphdl_n2360, cpphdl_n2361) / 1000.0;
        // device 1857, IC IC317, analog/basic/inverter.hpp:11
        I(cpphdl_n2342, Vdd) <+ cpphdl_channel(V(BIT_N13_3, Vdd), V(cpphdl_n2342, Vdd), 0.080000000000000002, 0.69999999999999996, -1.0);
        // device 1858, IC IC317, analog/basic/inverter.hpp:12
        I(cpphdl_n2342, Vss) <+ cpphdl_channel(V(BIT_N13_3, Vss), V(cpphdl_n2342, Vss), 0.080000000000000002, 0.69999999999999996, 1.0);
        // device 1859, IC IC313, analog/basic/mos_r2r_dac.hpp:27
        I(cpphdl_n2342, Vss) <+ 2.9999999999999998e-15 * ddt(V(cpphdl_n2342, Vss)); // Bench initial voltage = 0.0 V.
        // device 1860, IC IC313, analog/basic/mos_r2r_dac.hpp:28
        I(cpphdl_n2342, cpphdl_n2362) <+ V(cpphdl_n2342, cpphdl_n2362) / 2000.0;
        // device 1861, IC IC313, analog/basic/mos_r2r_dac.hpp:29
        I(cpphdl_n2362, Vss) <+ 2.9999999999999998e-15 * ddt(V(cpphdl_n2362, Vss)); // Bench initial voltage = 0.0 V.
        // device 1862, IC IC313, analog/basic/mos_r2r_dac.hpp:31
        I(cpphdl_n2361, cpphdl_n2362) <+ V(cpphdl_n2361, cpphdl_n2362) / 1000.0;
        // device 1863, IC IC318, analog/basic/inverter.hpp:11
        I(cpphdl_n2346, Vdd) <+ cpphdl_channel(V(BIT_N13_4, Vdd), V(cpphdl_n2346, Vdd), 0.080000000000000002, 0.69999999999999996, -1.0);
        // device 1864, IC IC318, analog/basic/inverter.hpp:12
        I(cpphdl_n2346, Vss) <+ cpphdl_channel(V(BIT_N13_4, Vss), V(cpphdl_n2346, Vss), 0.080000000000000002, 0.69999999999999996, 1.0);
        // device 1865, IC IC313, analog/basic/mos_r2r_dac.hpp:27
        I(cpphdl_n2346, Vss) <+ 2.9999999999999998e-15 * ddt(V(cpphdl_n2346, Vss)); // Bench initial voltage = 0.0 V.
        // device 1866, IC IC313, analog/basic/mos_r2r_dac.hpp:28
        I(cpphdl_n2346, cpphdl_n2363) <+ V(cpphdl_n2346, cpphdl_n2363) / 2000.0;
        // device 1867, IC IC313, analog/basic/mos_r2r_dac.hpp:29
        I(cpphdl_n2363, Vss) <+ 2.9999999999999998e-15 * ddt(V(cpphdl_n2363, Vss)); // Bench initial voltage = 0.0 V.
        // device 1868, IC IC313, analog/basic/mos_r2r_dac.hpp:31
        I(cpphdl_n2362, cpphdl_n2363) <+ V(cpphdl_n2362, cpphdl_n2363) / 1000.0;
        // device 1869, IC IC319, analog/basic/inverter.hpp:11
        I(cpphdl_n2350, Vdd) <+ cpphdl_channel(V(BIT_N13_5, Vdd), V(cpphdl_n2350, Vdd), 0.080000000000000002, 0.69999999999999996, -1.0);
        // device 1870, IC IC319, analog/basic/inverter.hpp:12
        I(cpphdl_n2350, Vss) <+ cpphdl_channel(V(BIT_N13_5, Vss), V(cpphdl_n2350, Vss), 0.080000000000000002, 0.69999999999999996, 1.0);
        // device 1871, IC IC313, analog/basic/mos_r2r_dac.hpp:27
        I(cpphdl_n2350, Vss) <+ 2.9999999999999998e-15 * ddt(V(cpphdl_n2350, Vss)); // Bench initial voltage = 0.0 V.
        // device 1872, IC IC313, analog/basic/mos_r2r_dac.hpp:28
        I(cpphdl_n2350, cpphdl_n2364) <+ V(cpphdl_n2350, cpphdl_n2364) / 2000.0;
        // device 1873, IC IC313, analog/basic/mos_r2r_dac.hpp:29
        I(cpphdl_n2364, Vss) <+ 2.9999999999999998e-15 * ddt(V(cpphdl_n2364, Vss)); // Bench initial voltage = 0.0 V.
        // device 1874, IC IC313, analog/basic/mos_r2r_dac.hpp:31
        I(cpphdl_n2363, cpphdl_n2364) <+ V(cpphdl_n2363, cpphdl_n2364) / 1000.0;
        // device 1875, IC IC320, analog/basic/inverter.hpp:11
        I(cpphdl_n2354, Vdd) <+ cpphdl_channel(V(BIT_N13_6, Vdd), V(cpphdl_n2354, Vdd), 0.080000000000000002, 0.69999999999999996, -1.0);
        // device 1876, IC IC320, analog/basic/inverter.hpp:12
        I(cpphdl_n2354, Vss) <+ cpphdl_channel(V(BIT_N13_6, Vss), V(cpphdl_n2354, Vss), 0.080000000000000002, 0.69999999999999996, 1.0);
        // device 1877, IC IC313, analog/basic/mos_r2r_dac.hpp:27
        I(cpphdl_n2354, Vss) <+ 2.9999999999999998e-15 * ddt(V(cpphdl_n2354, Vss)); // Bench initial voltage = 0.0 V.
        // device 1878, IC IC313, analog/basic/mos_r2r_dac.hpp:28
        I(cpphdl_n2354, cpphdl_n2365) <+ V(cpphdl_n2354, cpphdl_n2365) / 2000.0;
        // device 1879, IC IC313, analog/basic/mos_r2r_dac.hpp:29
        I(cpphdl_n2365, Vss) <+ 2.9999999999999998e-15 * ddt(V(cpphdl_n2365, Vss)); // Bench initial voltage = 0.0 V.
        // device 1880, IC IC313, analog/basic/mos_r2r_dac.hpp:31
        I(cpphdl_n2364, cpphdl_n2365) <+ V(cpphdl_n2364, cpphdl_n2365) / 1000.0;
        // device 1881, IC IC321, analog/basic/inverter.hpp:11
        I(cpphdl_n2358, Vdd) <+ cpphdl_channel(V(BIT_N13_7, Vdd), V(cpphdl_n2358, Vdd), 0.080000000000000002, 0.69999999999999996, -1.0);
        // device 1882, IC IC321, analog/basic/inverter.hpp:12
        I(cpphdl_n2358, Vss) <+ cpphdl_channel(V(BIT_N13_7, Vss), V(cpphdl_n2358, Vss), 0.080000000000000002, 0.69999999999999996, 1.0);
        // device 1883, IC IC313, analog/basic/mos_r2r_dac.hpp:27
        I(cpphdl_n2358, Vss) <+ 2.9999999999999998e-15 * ddt(V(cpphdl_n2358, Vss)); // Bench initial voltage = 0.0 V.
        // device 1884, IC IC313, analog/basic/mos_r2r_dac.hpp:28
        I(cpphdl_n2358, cpphdl_n2370) <+ V(cpphdl_n2358, cpphdl_n2370) / 2000.0;
        // device 1885, IC IC313, analog/basic/mos_r2r_dac.hpp:29
        I(cpphdl_n2370, Vss) <+ 2.9999999999999998e-15 * ddt(V(cpphdl_n2370, Vss)); // Bench initial voltage = 0.0 V.
        // device 1886, IC IC313, analog/basic/mos_r2r_dac.hpp:31
        I(cpphdl_n2365, cpphdl_n2370) <+ V(cpphdl_n2365, cpphdl_n2370) / 1000.0;
        // device 1887, IC IC313, analog/basic/mos_r2r_dac.hpp:33
        I(Vss, cpphdl_n2359) <+ V(Vss, cpphdl_n2359) / 2000.0;
        // device 1888, IC IC322, analog/basic/nmos_resistor_amplifier.hpp:23
        I(Vdd, cpphdl_n2379) <+ V(Vdd, cpphdl_n2379) / 500.0;
        // device 1889, IC IC322, analog/basic/nmos_resistor_amplifier.hpp:24
        I(Vdd, cpphdl_n2378) <+ V(Vdd, cpphdl_n2378) / 500.0;
        // device 1890, IC IC322, analog/basic/nmos_resistor_amplifier.hpp:25
        I(cpphdl_n2379, cpphdl_n2373) <+ cpphdl_channel(V(cpphdl_n2369, cpphdl_n2373), V(cpphdl_n2379, cpphdl_n2373), 0.014999999999999999, 0.69999999999999996, 1.0);
        // device 1891, IC IC322, analog/basic/nmos_resistor_amplifier.hpp:26
        I(cpphdl_n2378, cpphdl_n2374) <+ cpphdl_channel(V(cpphdl_n2370, cpphdl_n2374), V(cpphdl_n2378, cpphdl_n2374), 0.014999999999999999, 0.69999999999999996, 1.0);
        // device 1892, IC IC322, analog/basic/nmos_resistor_amplifier.hpp:27
        I(cpphdl_n2375, cpphdl_n2373) <+ V(cpphdl_n2375, cpphdl_n2373) / 50.0;
        // device 1893, IC IC322, analog/basic/nmos_resistor_amplifier.hpp:28
        I(cpphdl_n2375, cpphdl_n2374) <+ V(cpphdl_n2375, cpphdl_n2374) / 50.0;
        // device 1894, IC IC322, analog/basic/nmos_resistor_amplifier.hpp:29
        I(Vss, cpphdl_n2375) <+ V(Vss, cpphdl_n2375) / 150.0;
        // device 1895, IC IC322, analog/basic/nmos_resistor_amplifier.hpp:30
        I(cpphdl_n2379, Vdd) <+ 2.9999999999999998e-13 * ddt(V(cpphdl_n2379, Vdd)); // Bench initial voltage = 0.0 V.
        // device 1896, IC IC322, analog/basic/nmos_resistor_amplifier.hpp:31
        I(cpphdl_n2378, Vdd) <+ 2.9999999999999998e-13 * ddt(V(cpphdl_n2378, Vdd)); // Bench initial voltage = 0.0 V.
        // device 1897, IC IC322, analog/basic/nmos_resistor_amplifier.hpp:32
        I(cpphdl_n2375, Vss) <+ 4e-14 * ddt(V(cpphdl_n2375, Vss)); // Bench initial voltage = 0.0 V.
        // device 1898, IC IC322, analog/basic/nmos_resistor_amplifier.hpp:34
        I(cpphdl_n2369, cpphdl_n2373) <+ 2e-14 * ddt(V(cpphdl_n2369, cpphdl_n2373)); // Bench initial voltage = 1.6499999999999999 V.
        // device 1899, IC IC322, analog/basic/nmos_resistor_amplifier.hpp:35
        I(cpphdl_n2370, cpphdl_n2374) <+ 2e-14 * ddt(V(cpphdl_n2370, cpphdl_n2374)); // Bench initial voltage = 0.0 V.
        // device 1900, IC IC322, analog/basic/nmos_resistor_amplifier.hpp:36
        I(cpphdl_n2369, cpphdl_n2379) <+ 2.9999999999999998e-15 * ddt(V(cpphdl_n2369, cpphdl_n2379)); // Bench initial voltage = -1.6499999999999999 V.
        // device 1901, IC IC322, analog/basic/nmos_resistor_amplifier.hpp:37
        I(cpphdl_n2370, cpphdl_n2378) <+ 2.9999999999999998e-15 * ddt(V(cpphdl_n2370, cpphdl_n2378)); // Bench initial voltage = -3.2999999999999998 V.
        // device 1902, IC IC323, analog/basic/strongarm_comparator.hpp:28
        I(cpphdl_n2383, cpphdl_n2385) <+ cpphdl_channel(V(cpphdl_n2378, cpphdl_n2385), V(cpphdl_n2383, cpphdl_n2385), 0.0080000000000000002, 0.69999999999999996, 1.0);
        // device 1903, IC IC323, analog/basic/strongarm_comparator.hpp:29
        I(cpphdl_n2384, cpphdl_n2385) <+ cpphdl_channel(V(cpphdl_n2379, cpphdl_n2385), V(cpphdl_n2384, cpphdl_n2385), 0.0080000000000000002, 0.69999999999999996, 1.0);
        // device 1904, IC IC323, analog/basic/strongarm_comparator.hpp:30
        I(cpphdl_n2385, Vss) <+ cpphdl_channel(V(EVALUATE, Vss), V(cpphdl_n2385, Vss), 0.0080000000000000002, 0.69999999999999996, 1.0);
        // device 1905, IC IC323, analog/basic/strongarm_comparator.hpp:33
        I(cpphdl_n2398, cpphdl_n2383) <+ cpphdl_channel(V(cpphdl_n2402, cpphdl_n2383), V(cpphdl_n2398, cpphdl_n2383), 0.0040000000000000001, 0.69999999999999996, 1.0);
        // device 1906, IC IC323, analog/basic/strongarm_comparator.hpp:34
        I(cpphdl_n2402, cpphdl_n2384) <+ cpphdl_channel(V(cpphdl_n2398, cpphdl_n2384), V(cpphdl_n2402, cpphdl_n2384), 0.0040000000000000001, 0.69999999999999996, 1.0);
        // device 1907, IC IC323, analog/basic/strongarm_comparator.hpp:35
        I(cpphdl_n2402, Vdd) <+ cpphdl_channel(V(cpphdl_n2398, Vdd), V(cpphdl_n2402, Vdd), 0.002, 0.69999999999999996, -1.0);
        // device 1908, IC IC323, analog/basic/strongarm_comparator.hpp:36
        I(cpphdl_n2398, Vdd) <+ cpphdl_channel(V(cpphdl_n2402, Vdd), V(cpphdl_n2398, Vdd), 0.002, 0.69999999999999996, -1.0);
        // device 1909, IC IC323, analog/basic/strongarm_comparator.hpp:38
        I(cpphdl_n2383, Vdd) <+ cpphdl_channel(V(EVALUATE, Vdd), V(cpphdl_n2383, Vdd), 0.002, 0.69999999999999996, -1.0);
        // device 1910, IC IC323, analog/basic/strongarm_comparator.hpp:39
        I(cpphdl_n2384, Vdd) <+ cpphdl_channel(V(EVALUATE, Vdd), V(cpphdl_n2384, Vdd), 0.002, 0.69999999999999996, -1.0);
        // device 1911, IC IC323, analog/basic/strongarm_comparator.hpp:40
        I(cpphdl_n2402, Vdd) <+ cpphdl_channel(V(EVALUATE, Vdd), V(cpphdl_n2402, Vdd), 0.002, 0.69999999999999996, -1.0);
        // device 1912, IC IC323, analog/basic/strongarm_comparator.hpp:41
        I(cpphdl_n2398, Vdd) <+ cpphdl_channel(V(EVALUATE, Vdd), V(cpphdl_n2398, Vdd), 0.002, 0.69999999999999996, -1.0);
        // device 1913, IC IC323, analog/basic/strongarm_comparator.hpp:42
        I(cpphdl_n2383, Vss) <+ 2.9999999999999998e-14 * ddt(V(cpphdl_n2383, Vss)); // Bench initial voltage = 0.0 V.
        // device 1914, IC IC323, analog/basic/strongarm_comparator.hpp:43
        I(cpphdl_n2384, Vss) <+ 2.9999999999999998e-14 * ddt(V(cpphdl_n2384, Vss)); // Bench initial voltage = 0.0 V.
        // device 1915, IC IC323, analog/basic/strongarm_comparator.hpp:44
        I(cpphdl_n2385, Vss) <+ 2.9999999999999998e-14 * ddt(V(cpphdl_n2385, Vss)); // Bench initial voltage = 0.0 V.
        // device 1916, IC IC323, analog/basic/strongarm_comparator.hpp:45
        I(cpphdl_n2402, Vss) <+ 5.0000000000000002e-14 * ddt(V(cpphdl_n2402, Vss)); // Bench initial voltage = 0.0 V.
        // device 1917, IC IC323, analog/basic/strongarm_comparator.hpp:46
        I(cpphdl_n2398, Vss) <+ 5.0000000000000002e-14 * ddt(V(cpphdl_n2398, Vss)); // Bench initial voltage = 0.0 V.
        // device 1918, IC IC323, analog/basic/strongarm_comparator.hpp:47
        I(cpphdl_n2378, cpphdl_n2385) <+ 2e-14 * ddt(V(cpphdl_n2378, cpphdl_n2385)); // Bench initial voltage = 3.2999999999999998 V.
        // device 1919, IC IC323, analog/basic/strongarm_comparator.hpp:48
        I(cpphdl_n2379, cpphdl_n2385) <+ 2e-14 * ddt(V(cpphdl_n2379, cpphdl_n2385)); // Bench initial voltage = 3.2999999999999998 V.
        // device 1920, IC IC323, analog/basic/strongarm_comparator.hpp:49
        I(cpphdl_n2378, cpphdl_n2383) <+ 2.9999999999999998e-15 * ddt(V(cpphdl_n2378, cpphdl_n2383)); // Bench initial voltage = 3.2999999999999998 V.
        // device 1921, IC IC323, analog/basic/strongarm_comparator.hpp:50
        I(cpphdl_n2379, cpphdl_n2384) <+ 2.9999999999999998e-15 * ddt(V(cpphdl_n2379, cpphdl_n2384)); // Bench initial voltage = 3.2999999999999998 V.
        // device 1922, IC IC325, analog/basic/inverter.hpp:11
        I(cpphdl_n2406, Vdd) <+ cpphdl_channel(V(cpphdl_n2398, Vdd), V(cpphdl_n2406, Vdd), 0.001, 0.69999999999999996, -1.0);
        // device 1923, IC IC325, analog/basic/inverter.hpp:12
        I(cpphdl_n2406, Vss) <+ cpphdl_channel(V(cpphdl_n2398, Vss), V(cpphdl_n2406, Vss), 0.001, 0.69999999999999996, 1.0);
        // device 1924, IC IC327, analog/basic/inverter.hpp:11
        I(cpphdl_n2420, Vdd) <+ cpphdl_channel(V(cpphdl_n2406, Vdd), V(cpphdl_n2420, Vdd), 0.0040000000000000001, 0.69999999999999996, -1.0);
        // device 1925, IC IC327, analog/basic/inverter.hpp:12
        I(cpphdl_n2420, Vss) <+ cpphdl_channel(V(cpphdl_n2406, Vss), V(cpphdl_n2420, Vss), 0.0040000000000000001, 0.69999999999999996, 1.0);
        // device 1926, IC IC324, analog/basic/buffered_nand_latch.hpp:33
        I(cpphdl_n2398, Vss) <+ 2.0000000000000002e-15 * ddt(V(cpphdl_n2398, Vss)); // Bench initial voltage = 0.0 V.
        // device 1927, IC IC324, analog/basic/buffered_nand_latch.hpp:34
        I(cpphdl_n2398, cpphdl_n2406) <+ 1.0000000000000001e-15 * ddt(V(cpphdl_n2398, cpphdl_n2406)); // Bench initial voltage = 0.0 V.
        // device 1928, IC IC324, analog/basic/buffered_nand_latch.hpp:35
        I(cpphdl_n2406, Vss) <+ 5e-15 * ddt(V(cpphdl_n2406, Vss)); // Bench initial voltage = 0.0 V.
        // device 1929, IC IC324, analog/basic/buffered_nand_latch.hpp:36
        I(cpphdl_n2406, Vss) <+ 8.0000000000000006e-15 * ddt(V(cpphdl_n2406, Vss)); // Bench initial voltage = 0.0 V.
        // device 1930, IC IC324, analog/basic/buffered_nand_latch.hpp:37
        I(cpphdl_n2420, Vss) <+ 1e-14 * ddt(V(cpphdl_n2420, Vss)); // Bench initial voltage = 0.0 V.
        // device 1931, IC IC326, analog/basic/inverter.hpp:11
        I(cpphdl_n2410, Vdd) <+ cpphdl_channel(V(cpphdl_n2402, Vdd), V(cpphdl_n2410, Vdd), 0.001, 0.69999999999999996, -1.0);
        // device 1932, IC IC326, analog/basic/inverter.hpp:12
        I(cpphdl_n2410, Vss) <+ cpphdl_channel(V(cpphdl_n2402, Vss), V(cpphdl_n2410, Vss), 0.001, 0.69999999999999996, 1.0);
        // device 1933, IC IC328, analog/basic/inverter.hpp:11
        I(cpphdl_n2426, Vdd) <+ cpphdl_channel(V(cpphdl_n2410, Vdd), V(cpphdl_n2426, Vdd), 0.0040000000000000001, 0.69999999999999996, -1.0);
        // device 1934, IC IC328, analog/basic/inverter.hpp:12
        I(cpphdl_n2426, Vss) <+ cpphdl_channel(V(cpphdl_n2410, Vss), V(cpphdl_n2426, Vss), 0.0040000000000000001, 0.69999999999999996, 1.0);
        // device 1935, IC IC324, analog/basic/buffered_nand_latch.hpp:33
        I(cpphdl_n2402, Vss) <+ 2.0000000000000002e-15 * ddt(V(cpphdl_n2402, Vss)); // Bench initial voltage = 0.0 V.
        // device 1936, IC IC324, analog/basic/buffered_nand_latch.hpp:34
        I(cpphdl_n2402, cpphdl_n2410) <+ 1.0000000000000001e-15 * ddt(V(cpphdl_n2402, cpphdl_n2410)); // Bench initial voltage = 0.0 V.
        // device 1937, IC IC324, analog/basic/buffered_nand_latch.hpp:35
        I(cpphdl_n2410, Vss) <+ 5e-15 * ddt(V(cpphdl_n2410, Vss)); // Bench initial voltage = 0.0 V.
        // device 1938, IC IC324, analog/basic/buffered_nand_latch.hpp:36
        I(cpphdl_n2410, Vss) <+ 8.0000000000000006e-15 * ddt(V(cpphdl_n2410, Vss)); // Bench initial voltage = 0.0 V.
        // device 1939, IC IC324, analog/basic/buffered_nand_latch.hpp:37
        I(cpphdl_n2426, Vss) <+ 1e-14 * ddt(V(cpphdl_n2426, Vss)); // Bench initial voltage = 0.0 V.
        // device 1940, IC IC330, analog/basic/cmos_logic.hpp:15
        I(cpphdl_n2805, Vss) <+ 5.0000000000000002e-14 * ddt(V(cpphdl_n2805, Vss)); // Bench initial voltage = 0.0 V.
        // device 1941, IC IC330, analog/basic/cmos_logic.hpp:16
        I(cpphdl_n2805, Vdd) <+ cpphdl_channel(V(cpphdl_n2420, Vdd), V(cpphdl_n2805, Vdd), 0.01, 0.69999999999999996, -1.0);
        // device 1942, IC IC330, analog/basic/cmos_logic.hpp:17
        I(cpphdl_n2805, Vdd) <+ cpphdl_channel(V(cpphdl_n2428, Vdd), V(cpphdl_n2805, Vdd), 0.01, 0.69999999999999996, -1.0);
        // device 1943, IC IC330, analog/basic/cmos_logic.hpp:18
        I(cpphdl_n2805, cpphdl_n2423) <+ cpphdl_channel(V(cpphdl_n2420, cpphdl_n2423), V(cpphdl_n2805, cpphdl_n2423), 0.01, 0.69999999999999996, 1.0);
        // device 1944, IC IC330, analog/basic/cmos_logic.hpp:19
        I(cpphdl_n2423, Vss) <+ cpphdl_channel(V(cpphdl_n2428, Vss), V(cpphdl_n2423, Vss), 0.01, 0.69999999999999996, 1.0);
        // device 1945, IC IC330, analog/basic/cmos_logic.hpp:20
        I(cpphdl_n2805, Vss) <+ V(cpphdl_n2805, Vss) / 1000000000.0;
        // device 1946, IC IC330, analog/basic/cmos_logic.hpp:21
        I(cpphdl_n2423, Vss) <+ V(cpphdl_n2423, Vss) / 1000000000.0;
        // device 1947, IC IC331, analog/basic/cmos_logic.hpp:15
        I(cpphdl_n2428, Vss) <+ 5.0000000000000002e-14 * ddt(V(cpphdl_n2428, Vss)); // Bench initial voltage = 0.0 V.
        // device 1948, IC IC331, analog/basic/cmos_logic.hpp:16
        I(cpphdl_n2428, Vdd) <+ cpphdl_channel(V(cpphdl_n2426, Vdd), V(cpphdl_n2428, Vdd), 0.01, 0.69999999999999996, -1.0);
        // device 1949, IC IC331, analog/basic/cmos_logic.hpp:17
        I(cpphdl_n2428, Vdd) <+ cpphdl_channel(V(cpphdl_n2805, Vdd), V(cpphdl_n2428, Vdd), 0.01, 0.69999999999999996, -1.0);
        // device 1950, IC IC331, analog/basic/cmos_logic.hpp:18
        I(cpphdl_n2428, cpphdl_n2429) <+ cpphdl_channel(V(cpphdl_n2426, cpphdl_n2429), V(cpphdl_n2428, cpphdl_n2429), 0.01, 0.69999999999999996, 1.0);
        // device 1951, IC IC331, analog/basic/cmos_logic.hpp:19
        I(cpphdl_n2429, Vss) <+ cpphdl_channel(V(cpphdl_n2805, Vss), V(cpphdl_n2429, Vss), 0.01, 0.69999999999999996, 1.0);
        // device 1952, IC IC331, analog/basic/cmos_logic.hpp:20
        I(cpphdl_n2428, Vss) <+ V(cpphdl_n2428, Vss) / 1000000000.0;
        // device 1953, IC IC331, analog/basic/cmos_logic.hpp:21
        I(cpphdl_n2429, Vss) <+ V(cpphdl_n2429, Vss) / 1000000000.0;
        // device 1954, IC IC329, analog/basic/nand_latch.hpp:34
        I(cpphdl_n2420, Vss) <+ 2.9999999999999998e-15 * ddt(V(cpphdl_n2420, Vss)); // Bench initial voltage = 0.0 V.
        // device 1955, IC IC329, analog/basic/nand_latch.hpp:35
        I(cpphdl_n2426, Vss) <+ 2.9999999999999998e-15 * ddt(V(cpphdl_n2426, Vss)); // Bench initial voltage = 0.0 V.
        // device 1956, IC IC332, analog/basic/inverter.hpp:11
        I(cpphdl_n2434, Vdd) <+ cpphdl_channel(V(CLEAR, Vdd), V(cpphdl_n2434, Vdd), 0.01, 0.69999999999999996, -1.0);
        // device 1957, IC IC332, analog/basic/inverter.hpp:12
        I(cpphdl_n2434, Vss) <+ cpphdl_channel(V(CLEAR, Vss), V(cpphdl_n2434, Vss), 0.01, 0.69999999999999996, 1.0);
        // device 1958, IC IC329, analog/basic/nand_latch.hpp:56
        I(cpphdl_n2434, Vss) <+ 2.9999999999999998e-15 * ddt(V(cpphdl_n2434, Vss)); // Bench initial voltage = 0.0 V.
        // device 1959, IC IC329, analog/basic/nand_latch.hpp:57
        I(cpphdl_n2805, Vss) <+ cpphdl_channel(V(CLEAR, Vss), V(cpphdl_n2805, Vss), 0.050000000000000003, 0.69999999999999996, 1.0);
        // device 1960, IC IC329, analog/basic/nand_latch.hpp:58
        I(cpphdl_n2428, Vdd) <+ cpphdl_channel(V(cpphdl_n2434, Vdd), V(cpphdl_n2428, Vdd), 0.050000000000000003, 0.69999999999999996, -1.0);
        // device 1961, IC IC335, analog/basic/inverter.hpp:11
        I(cpphdl_n2458, Vdd) <+ cpphdl_channel(V(TRACK14, Vdd), V(cpphdl_n2458, Vdd), 0.0040000000000000001, 0.69999999999999996, -1.0);
        // device 1962, IC IC335, analog/basic/inverter.hpp:12
        I(cpphdl_n2458, Vss) <+ cpphdl_channel(V(TRACK14, Vss), V(cpphdl_n2458, Vss), 0.0040000000000000001, 0.69999999999999996, 1.0);
        // device 1963, IC IC334, analog/basic/mos_track_hold.hpp:30
        I(cpphdl_n2458, Vss) <+ 2e-14 * ddt(V(cpphdl_n2458, Vss)); // Bench initial voltage = 3.2999999999999998 V.
        // device 1964, IC IC334, analog/basic/mos_track_hold.hpp:31
        I(cpphdl_n2595, cpphdl_n2512) <+ cpphdl_channel(V(TRACK14, cpphdl_n2512), V(cpphdl_n2595, cpphdl_n2512), 0.02, 0.69999999999999996, 1.0);
        // device 1965, IC IC334, analog/basic/mos_track_hold.hpp:32
        I(cpphdl_n2512, cpphdl_n2595) <+ cpphdl_channel(V(cpphdl_n2458, cpphdl_n2595), V(cpphdl_n2512, cpphdl_n2595), 0.01, 0.69999999999999996, -1.0);
        // device 1966, IC IC334, analog/basic/mos_track_hold.hpp:36
        I(cpphdl_n2512, cpphdl_n2512) <+ cpphdl_channel(V(cpphdl_n2458, cpphdl_n2512), V(cpphdl_n2512, cpphdl_n2512), 0.01, 0.69999999999999996, 1.0);
        // device 1967, IC IC334, analog/basic/mos_track_hold.hpp:37
        I(cpphdl_n2512, cpphdl_n2512) <+ cpphdl_channel(V(TRACK14, cpphdl_n2512), V(cpphdl_n2512, cpphdl_n2512), 0.0050000000000000001, 0.69999999999999996, -1.0);
        // device 1968, IC IC334, analog/basic/mos_track_hold.hpp:38
        I(cpphdl_n2512, Vss) <+ 1.5000000000000001e-12 * ddt(V(cpphdl_n2512, Vss)); // Bench initial voltage = 1.6499999999999999 V.
        // device 1969, IC IC334, analog/basic/mos_track_hold.hpp:39
        I(Vss, cpphdl_n2512) <+ V(Vss, cpphdl_n2512) / 1000000000.0;
        // device 1970, IC IC334, analog/basic/mos_track_hold.hpp:40
        I(TRACK14, cpphdl_n2512) <+ 2.0000000000000002e-15 * ddt(V(TRACK14, cpphdl_n2512)); // Bench initial voltage = -1.6499999999999999 V.
        // device 1971, IC IC334, analog/basic/mos_track_hold.hpp:41
        I(cpphdl_n2458, cpphdl_n2512) <+ 2.0000000000000002e-15 * ddt(V(cpphdl_n2458, cpphdl_n2512)); // Bench initial voltage = 1.6499999999999999 V.
        // device 1972, IC IC334, analog/basic/mos_track_hold.hpp:42
        I(cpphdl_n2595, cpphdl_n2512) <+ 1.0000000000000001e-15 * ddt(V(cpphdl_n2595, cpphdl_n2512)); // Bench initial voltage = 0.0 V.
        // device 1973, IC IC337, analog/basic/inverter.hpp:11
        I(cpphdl_n2473, Vdd) <+ cpphdl_channel(V(BIT_N14_0, Vdd), V(cpphdl_n2473, Vdd), 0.080000000000000002, 0.69999999999999996, -1.0);
        // device 1974, IC IC337, analog/basic/inverter.hpp:12
        I(cpphdl_n2473, Vss) <+ cpphdl_channel(V(BIT_N14_0, Vss), V(cpphdl_n2473, Vss), 0.080000000000000002, 0.69999999999999996, 1.0);
        // device 1975, IC IC336, analog/basic/mos_r2r_dac.hpp:27
        I(cpphdl_n2473, Vss) <+ 2.9999999999999998e-15 * ddt(V(cpphdl_n2473, Vss)); // Bench initial voltage = 0.0 V.
        // device 1976, IC IC336, analog/basic/mos_r2r_dac.hpp:28
        I(cpphdl_n2473, cpphdl_n2502) <+ V(cpphdl_n2473, cpphdl_n2502) / 2000.0;
        // device 1977, IC IC336, analog/basic/mos_r2r_dac.hpp:29
        I(cpphdl_n2502, Vss) <+ 2.9999999999999998e-15 * ddt(V(cpphdl_n2502, Vss)); // Bench initial voltage = 0.0 V.
        // device 1978, IC IC338, analog/basic/inverter.hpp:11
        I(cpphdl_n2477, Vdd) <+ cpphdl_channel(V(BIT_N14_1, Vdd), V(cpphdl_n2477, Vdd), 0.080000000000000002, 0.69999999999999996, -1.0);
        // device 1979, IC IC338, analog/basic/inverter.hpp:12
        I(cpphdl_n2477, Vss) <+ cpphdl_channel(V(BIT_N14_1, Vss), V(cpphdl_n2477, Vss), 0.080000000000000002, 0.69999999999999996, 1.0);
        // device 1980, IC IC336, analog/basic/mos_r2r_dac.hpp:27
        I(cpphdl_n2477, Vss) <+ 2.9999999999999998e-15 * ddt(V(cpphdl_n2477, Vss)); // Bench initial voltage = 0.0 V.
        // device 1981, IC IC336, analog/basic/mos_r2r_dac.hpp:28
        I(cpphdl_n2477, cpphdl_n2503) <+ V(cpphdl_n2477, cpphdl_n2503) / 2000.0;
        // device 1982, IC IC336, analog/basic/mos_r2r_dac.hpp:29
        I(cpphdl_n2503, Vss) <+ 2.9999999999999998e-15 * ddt(V(cpphdl_n2503, Vss)); // Bench initial voltage = 0.0 V.
        // device 1983, IC IC336, analog/basic/mos_r2r_dac.hpp:31
        I(cpphdl_n2502, cpphdl_n2503) <+ V(cpphdl_n2502, cpphdl_n2503) / 1000.0;
        // device 1984, IC IC339, analog/basic/inverter.hpp:11
        I(cpphdl_n2481, Vdd) <+ cpphdl_channel(V(BIT_N14_2, Vdd), V(cpphdl_n2481, Vdd), 0.080000000000000002, 0.69999999999999996, -1.0);
        // device 1985, IC IC339, analog/basic/inverter.hpp:12
        I(cpphdl_n2481, Vss) <+ cpphdl_channel(V(BIT_N14_2, Vss), V(cpphdl_n2481, Vss), 0.080000000000000002, 0.69999999999999996, 1.0);
        // device 1986, IC IC336, analog/basic/mos_r2r_dac.hpp:27
        I(cpphdl_n2481, Vss) <+ 2.9999999999999998e-15 * ddt(V(cpphdl_n2481, Vss)); // Bench initial voltage = 0.0 V.
        // device 1987, IC IC336, analog/basic/mos_r2r_dac.hpp:28
        I(cpphdl_n2481, cpphdl_n2504) <+ V(cpphdl_n2481, cpphdl_n2504) / 2000.0;
        // device 1988, IC IC336, analog/basic/mos_r2r_dac.hpp:29
        I(cpphdl_n2504, Vss) <+ 2.9999999999999998e-15 * ddt(V(cpphdl_n2504, Vss)); // Bench initial voltage = 0.0 V.
        // device 1989, IC IC336, analog/basic/mos_r2r_dac.hpp:31
        I(cpphdl_n2503, cpphdl_n2504) <+ V(cpphdl_n2503, cpphdl_n2504) / 1000.0;
        // device 1990, IC IC340, analog/basic/inverter.hpp:11
        I(cpphdl_n2485, Vdd) <+ cpphdl_channel(V(BIT_N14_3, Vdd), V(cpphdl_n2485, Vdd), 0.080000000000000002, 0.69999999999999996, -1.0);
        // device 1991, IC IC340, analog/basic/inverter.hpp:12
        I(cpphdl_n2485, Vss) <+ cpphdl_channel(V(BIT_N14_3, Vss), V(cpphdl_n2485, Vss), 0.080000000000000002, 0.69999999999999996, 1.0);
        // device 1992, IC IC336, analog/basic/mos_r2r_dac.hpp:27
        I(cpphdl_n2485, Vss) <+ 2.9999999999999998e-15 * ddt(V(cpphdl_n2485, Vss)); // Bench initial voltage = 0.0 V.
        // device 1993, IC IC336, analog/basic/mos_r2r_dac.hpp:28
        I(cpphdl_n2485, cpphdl_n2505) <+ V(cpphdl_n2485, cpphdl_n2505) / 2000.0;
        // device 1994, IC IC336, analog/basic/mos_r2r_dac.hpp:29
        I(cpphdl_n2505, Vss) <+ 2.9999999999999998e-15 * ddt(V(cpphdl_n2505, Vss)); // Bench initial voltage = 0.0 V.
        // device 1995, IC IC336, analog/basic/mos_r2r_dac.hpp:31
        I(cpphdl_n2504, cpphdl_n2505) <+ V(cpphdl_n2504, cpphdl_n2505) / 1000.0;
        // device 1996, IC IC341, analog/basic/inverter.hpp:11
        I(cpphdl_n2489, Vdd) <+ cpphdl_channel(V(BIT_N14_4, Vdd), V(cpphdl_n2489, Vdd), 0.080000000000000002, 0.69999999999999996, -1.0);
        // device 1997, IC IC341, analog/basic/inverter.hpp:12
        I(cpphdl_n2489, Vss) <+ cpphdl_channel(V(BIT_N14_4, Vss), V(cpphdl_n2489, Vss), 0.080000000000000002, 0.69999999999999996, 1.0);
        // device 1998, IC IC336, analog/basic/mos_r2r_dac.hpp:27
        I(cpphdl_n2489, Vss) <+ 2.9999999999999998e-15 * ddt(V(cpphdl_n2489, Vss)); // Bench initial voltage = 0.0 V.
        // device 1999, IC IC336, analog/basic/mos_r2r_dac.hpp:28
        I(cpphdl_n2489, cpphdl_n2506) <+ V(cpphdl_n2489, cpphdl_n2506) / 2000.0;
        // device 2000, IC IC336, analog/basic/mos_r2r_dac.hpp:29
        I(cpphdl_n2506, Vss) <+ 2.9999999999999998e-15 * ddt(V(cpphdl_n2506, Vss)); // Bench initial voltage = 0.0 V.
        // device 2001, IC IC336, analog/basic/mos_r2r_dac.hpp:31
        I(cpphdl_n2505, cpphdl_n2506) <+ V(cpphdl_n2505, cpphdl_n2506) / 1000.0;
        // device 2002, IC IC342, analog/basic/inverter.hpp:11
        I(cpphdl_n2493, Vdd) <+ cpphdl_channel(V(BIT_N14_5, Vdd), V(cpphdl_n2493, Vdd), 0.080000000000000002, 0.69999999999999996, -1.0);
        // device 2003, IC IC342, analog/basic/inverter.hpp:12
        I(cpphdl_n2493, Vss) <+ cpphdl_channel(V(BIT_N14_5, Vss), V(cpphdl_n2493, Vss), 0.080000000000000002, 0.69999999999999996, 1.0);
        // device 2004, IC IC336, analog/basic/mos_r2r_dac.hpp:27
        I(cpphdl_n2493, Vss) <+ 2.9999999999999998e-15 * ddt(V(cpphdl_n2493, Vss)); // Bench initial voltage = 0.0 V.
        // device 2005, IC IC336, analog/basic/mos_r2r_dac.hpp:28
        I(cpphdl_n2493, cpphdl_n2507) <+ V(cpphdl_n2493, cpphdl_n2507) / 2000.0;
        // device 2006, IC IC336, analog/basic/mos_r2r_dac.hpp:29
        I(cpphdl_n2507, Vss) <+ 2.9999999999999998e-15 * ddt(V(cpphdl_n2507, Vss)); // Bench initial voltage = 0.0 V.
        // device 2007, IC IC336, analog/basic/mos_r2r_dac.hpp:31
        I(cpphdl_n2506, cpphdl_n2507) <+ V(cpphdl_n2506, cpphdl_n2507) / 1000.0;
        // device 2008, IC IC343, analog/basic/inverter.hpp:11
        I(cpphdl_n2497, Vdd) <+ cpphdl_channel(V(BIT_N14_6, Vdd), V(cpphdl_n2497, Vdd), 0.080000000000000002, 0.69999999999999996, -1.0);
        // device 2009, IC IC343, analog/basic/inverter.hpp:12
        I(cpphdl_n2497, Vss) <+ cpphdl_channel(V(BIT_N14_6, Vss), V(cpphdl_n2497, Vss), 0.080000000000000002, 0.69999999999999996, 1.0);
        // device 2010, IC IC336, analog/basic/mos_r2r_dac.hpp:27
        I(cpphdl_n2497, Vss) <+ 2.9999999999999998e-15 * ddt(V(cpphdl_n2497, Vss)); // Bench initial voltage = 0.0 V.
        // device 2011, IC IC336, analog/basic/mos_r2r_dac.hpp:28
        I(cpphdl_n2497, cpphdl_n2508) <+ V(cpphdl_n2497, cpphdl_n2508) / 2000.0;
        // device 2012, IC IC336, analog/basic/mos_r2r_dac.hpp:29
        I(cpphdl_n2508, Vss) <+ 2.9999999999999998e-15 * ddt(V(cpphdl_n2508, Vss)); // Bench initial voltage = 0.0 V.
        // device 2013, IC IC336, analog/basic/mos_r2r_dac.hpp:31
        I(cpphdl_n2507, cpphdl_n2508) <+ V(cpphdl_n2507, cpphdl_n2508) / 1000.0;
        // device 2014, IC IC344, analog/basic/inverter.hpp:11
        I(cpphdl_n2501, Vdd) <+ cpphdl_channel(V(BIT_N14_7, Vdd), V(cpphdl_n2501, Vdd), 0.080000000000000002, 0.69999999999999996, -1.0);
        // device 2015, IC IC344, analog/basic/inverter.hpp:12
        I(cpphdl_n2501, Vss) <+ cpphdl_channel(V(BIT_N14_7, Vss), V(cpphdl_n2501, Vss), 0.080000000000000002, 0.69999999999999996, 1.0);
        // device 2016, IC IC336, analog/basic/mos_r2r_dac.hpp:27
        I(cpphdl_n2501, Vss) <+ 2.9999999999999998e-15 * ddt(V(cpphdl_n2501, Vss)); // Bench initial voltage = 0.0 V.
        // device 2017, IC IC336, analog/basic/mos_r2r_dac.hpp:28
        I(cpphdl_n2501, cpphdl_n2513) <+ V(cpphdl_n2501, cpphdl_n2513) / 2000.0;
        // device 2018, IC IC336, analog/basic/mos_r2r_dac.hpp:29
        I(cpphdl_n2513, Vss) <+ 2.9999999999999998e-15 * ddt(V(cpphdl_n2513, Vss)); // Bench initial voltage = 0.0 V.
        // device 2019, IC IC336, analog/basic/mos_r2r_dac.hpp:31
        I(cpphdl_n2508, cpphdl_n2513) <+ V(cpphdl_n2508, cpphdl_n2513) / 1000.0;
        // device 2020, IC IC336, analog/basic/mos_r2r_dac.hpp:33
        I(Vss, cpphdl_n2502) <+ V(Vss, cpphdl_n2502) / 2000.0;
        // device 2021, IC IC345, analog/basic/nmos_resistor_amplifier.hpp:23
        I(Vdd, cpphdl_n2522) <+ V(Vdd, cpphdl_n2522) / 500.0;
        // device 2022, IC IC345, analog/basic/nmos_resistor_amplifier.hpp:24
        I(Vdd, cpphdl_n2521) <+ V(Vdd, cpphdl_n2521) / 500.0;
        // device 2023, IC IC345, analog/basic/nmos_resistor_amplifier.hpp:25
        I(cpphdl_n2522, cpphdl_n2516) <+ cpphdl_channel(V(cpphdl_n2512, cpphdl_n2516), V(cpphdl_n2522, cpphdl_n2516), 0.014999999999999999, 0.69999999999999996, 1.0);
        // device 2024, IC IC345, analog/basic/nmos_resistor_amplifier.hpp:26
        I(cpphdl_n2521, cpphdl_n2517) <+ cpphdl_channel(V(cpphdl_n2513, cpphdl_n2517), V(cpphdl_n2521, cpphdl_n2517), 0.014999999999999999, 0.69999999999999996, 1.0);
        // device 2025, IC IC345, analog/basic/nmos_resistor_amplifier.hpp:27
        I(cpphdl_n2518, cpphdl_n2516) <+ V(cpphdl_n2518, cpphdl_n2516) / 50.0;
        // device 2026, IC IC345, analog/basic/nmos_resistor_amplifier.hpp:28
        I(cpphdl_n2518, cpphdl_n2517) <+ V(cpphdl_n2518, cpphdl_n2517) / 50.0;
        // device 2027, IC IC345, analog/basic/nmos_resistor_amplifier.hpp:29
        I(Vss, cpphdl_n2518) <+ V(Vss, cpphdl_n2518) / 150.0;
        // device 2028, IC IC345, analog/basic/nmos_resistor_amplifier.hpp:30
        I(cpphdl_n2522, Vdd) <+ 2.9999999999999998e-13 * ddt(V(cpphdl_n2522, Vdd)); // Bench initial voltage = 0.0 V.
        // device 2029, IC IC345, analog/basic/nmos_resistor_amplifier.hpp:31
        I(cpphdl_n2521, Vdd) <+ 2.9999999999999998e-13 * ddt(V(cpphdl_n2521, Vdd)); // Bench initial voltage = 0.0 V.
        // device 2030, IC IC345, analog/basic/nmos_resistor_amplifier.hpp:32
        I(cpphdl_n2518, Vss) <+ 4e-14 * ddt(V(cpphdl_n2518, Vss)); // Bench initial voltage = 0.0 V.
        // device 2031, IC IC345, analog/basic/nmos_resistor_amplifier.hpp:34
        I(cpphdl_n2512, cpphdl_n2516) <+ 2e-14 * ddt(V(cpphdl_n2512, cpphdl_n2516)); // Bench initial voltage = 1.6499999999999999 V.
        // device 2032, IC IC345, analog/basic/nmos_resistor_amplifier.hpp:35
        I(cpphdl_n2513, cpphdl_n2517) <+ 2e-14 * ddt(V(cpphdl_n2513, cpphdl_n2517)); // Bench initial voltage = 0.0 V.
        // device 2033, IC IC345, analog/basic/nmos_resistor_amplifier.hpp:36
        I(cpphdl_n2512, cpphdl_n2522) <+ 2.9999999999999998e-15 * ddt(V(cpphdl_n2512, cpphdl_n2522)); // Bench initial voltage = -1.6499999999999999 V.
        // device 2034, IC IC345, analog/basic/nmos_resistor_amplifier.hpp:37
        I(cpphdl_n2513, cpphdl_n2521) <+ 2.9999999999999998e-15 * ddt(V(cpphdl_n2513, cpphdl_n2521)); // Bench initial voltage = -3.2999999999999998 V.
        // device 2035, IC IC346, analog/basic/strongarm_comparator.hpp:28
        I(cpphdl_n2526, cpphdl_n2528) <+ cpphdl_channel(V(cpphdl_n2521, cpphdl_n2528), V(cpphdl_n2526, cpphdl_n2528), 0.0080000000000000002, 0.69999999999999996, 1.0);
        // device 2036, IC IC346, analog/basic/strongarm_comparator.hpp:29
        I(cpphdl_n2527, cpphdl_n2528) <+ cpphdl_channel(V(cpphdl_n2522, cpphdl_n2528), V(cpphdl_n2527, cpphdl_n2528), 0.0080000000000000002, 0.69999999999999996, 1.0);
        // device 2037, IC IC346, analog/basic/strongarm_comparator.hpp:30
        I(cpphdl_n2528, Vss) <+ cpphdl_channel(V(EVALUATE, Vss), V(cpphdl_n2528, Vss), 0.0080000000000000002, 0.69999999999999996, 1.0);
        // device 2038, IC IC346, analog/basic/strongarm_comparator.hpp:33
        I(cpphdl_n2541, cpphdl_n2526) <+ cpphdl_channel(V(cpphdl_n2545, cpphdl_n2526), V(cpphdl_n2541, cpphdl_n2526), 0.0040000000000000001, 0.69999999999999996, 1.0);
        // device 2039, IC IC346, analog/basic/strongarm_comparator.hpp:34
        I(cpphdl_n2545, cpphdl_n2527) <+ cpphdl_channel(V(cpphdl_n2541, cpphdl_n2527), V(cpphdl_n2545, cpphdl_n2527), 0.0040000000000000001, 0.69999999999999996, 1.0);
        // device 2040, IC IC346, analog/basic/strongarm_comparator.hpp:35
        I(cpphdl_n2545, Vdd) <+ cpphdl_channel(V(cpphdl_n2541, Vdd), V(cpphdl_n2545, Vdd), 0.002, 0.69999999999999996, -1.0);
        // device 2041, IC IC346, analog/basic/strongarm_comparator.hpp:36
        I(cpphdl_n2541, Vdd) <+ cpphdl_channel(V(cpphdl_n2545, Vdd), V(cpphdl_n2541, Vdd), 0.002, 0.69999999999999996, -1.0);
        // device 2042, IC IC346, analog/basic/strongarm_comparator.hpp:38
        I(cpphdl_n2526, Vdd) <+ cpphdl_channel(V(EVALUATE, Vdd), V(cpphdl_n2526, Vdd), 0.002, 0.69999999999999996, -1.0);
        // device 2043, IC IC346, analog/basic/strongarm_comparator.hpp:39
        I(cpphdl_n2527, Vdd) <+ cpphdl_channel(V(EVALUATE, Vdd), V(cpphdl_n2527, Vdd), 0.002, 0.69999999999999996, -1.0);
        // device 2044, IC IC346, analog/basic/strongarm_comparator.hpp:40
        I(cpphdl_n2545, Vdd) <+ cpphdl_channel(V(EVALUATE, Vdd), V(cpphdl_n2545, Vdd), 0.002, 0.69999999999999996, -1.0);
        // device 2045, IC IC346, analog/basic/strongarm_comparator.hpp:41
        I(cpphdl_n2541, Vdd) <+ cpphdl_channel(V(EVALUATE, Vdd), V(cpphdl_n2541, Vdd), 0.002, 0.69999999999999996, -1.0);
        // device 2046, IC IC346, analog/basic/strongarm_comparator.hpp:42
        I(cpphdl_n2526, Vss) <+ 2.9999999999999998e-14 * ddt(V(cpphdl_n2526, Vss)); // Bench initial voltage = 0.0 V.
        // device 2047, IC IC346, analog/basic/strongarm_comparator.hpp:43
        I(cpphdl_n2527, Vss) <+ 2.9999999999999998e-14 * ddt(V(cpphdl_n2527, Vss)); // Bench initial voltage = 0.0 V.
        // device 2048, IC IC346, analog/basic/strongarm_comparator.hpp:44
        I(cpphdl_n2528, Vss) <+ 2.9999999999999998e-14 * ddt(V(cpphdl_n2528, Vss)); // Bench initial voltage = 0.0 V.
        // device 2049, IC IC346, analog/basic/strongarm_comparator.hpp:45
        I(cpphdl_n2545, Vss) <+ 5.0000000000000002e-14 * ddt(V(cpphdl_n2545, Vss)); // Bench initial voltage = 0.0 V.
        // device 2050, IC IC346, analog/basic/strongarm_comparator.hpp:46
        I(cpphdl_n2541, Vss) <+ 5.0000000000000002e-14 * ddt(V(cpphdl_n2541, Vss)); // Bench initial voltage = 0.0 V.
        // device 2051, IC IC346, analog/basic/strongarm_comparator.hpp:47
        I(cpphdl_n2521, cpphdl_n2528) <+ 2e-14 * ddt(V(cpphdl_n2521, cpphdl_n2528)); // Bench initial voltage = 3.2999999999999998 V.
        // device 2052, IC IC346, analog/basic/strongarm_comparator.hpp:48
        I(cpphdl_n2522, cpphdl_n2528) <+ 2e-14 * ddt(V(cpphdl_n2522, cpphdl_n2528)); // Bench initial voltage = 3.2999999999999998 V.
        // device 2053, IC IC346, analog/basic/strongarm_comparator.hpp:49
        I(cpphdl_n2521, cpphdl_n2526) <+ 2.9999999999999998e-15 * ddt(V(cpphdl_n2521, cpphdl_n2526)); // Bench initial voltage = 3.2999999999999998 V.
        // device 2054, IC IC346, analog/basic/strongarm_comparator.hpp:50
        I(cpphdl_n2522, cpphdl_n2527) <+ 2.9999999999999998e-15 * ddt(V(cpphdl_n2522, cpphdl_n2527)); // Bench initial voltage = 3.2999999999999998 V.
        // device 2055, IC IC348, analog/basic/inverter.hpp:11
        I(cpphdl_n2549, Vdd) <+ cpphdl_channel(V(cpphdl_n2541, Vdd), V(cpphdl_n2549, Vdd), 0.001, 0.69999999999999996, -1.0);
        // device 2056, IC IC348, analog/basic/inverter.hpp:12
        I(cpphdl_n2549, Vss) <+ cpphdl_channel(V(cpphdl_n2541, Vss), V(cpphdl_n2549, Vss), 0.001, 0.69999999999999996, 1.0);
        // device 2057, IC IC350, analog/basic/inverter.hpp:11
        I(cpphdl_n2563, Vdd) <+ cpphdl_channel(V(cpphdl_n2549, Vdd), V(cpphdl_n2563, Vdd), 0.0040000000000000001, 0.69999999999999996, -1.0);
        // device 2058, IC IC350, analog/basic/inverter.hpp:12
        I(cpphdl_n2563, Vss) <+ cpphdl_channel(V(cpphdl_n2549, Vss), V(cpphdl_n2563, Vss), 0.0040000000000000001, 0.69999999999999996, 1.0);
        // device 2059, IC IC347, analog/basic/buffered_nand_latch.hpp:33
        I(cpphdl_n2541, Vss) <+ 2.0000000000000002e-15 * ddt(V(cpphdl_n2541, Vss)); // Bench initial voltage = 0.0 V.
        // device 2060, IC IC347, analog/basic/buffered_nand_latch.hpp:34
        I(cpphdl_n2541, cpphdl_n2549) <+ 1.0000000000000001e-15 * ddt(V(cpphdl_n2541, cpphdl_n2549)); // Bench initial voltage = 0.0 V.
        // device 2061, IC IC347, analog/basic/buffered_nand_latch.hpp:35
        I(cpphdl_n2549, Vss) <+ 5e-15 * ddt(V(cpphdl_n2549, Vss)); // Bench initial voltage = 0.0 V.
        // device 2062, IC IC347, analog/basic/buffered_nand_latch.hpp:36
        I(cpphdl_n2549, Vss) <+ 8.0000000000000006e-15 * ddt(V(cpphdl_n2549, Vss)); // Bench initial voltage = 0.0 V.
        // device 2063, IC IC347, analog/basic/buffered_nand_latch.hpp:37
        I(cpphdl_n2563, Vss) <+ 1e-14 * ddt(V(cpphdl_n2563, Vss)); // Bench initial voltage = 0.0 V.
        // device 2064, IC IC349, analog/basic/inverter.hpp:11
        I(cpphdl_n2553, Vdd) <+ cpphdl_channel(V(cpphdl_n2545, Vdd), V(cpphdl_n2553, Vdd), 0.001, 0.69999999999999996, -1.0);
        // device 2065, IC IC349, analog/basic/inverter.hpp:12
        I(cpphdl_n2553, Vss) <+ cpphdl_channel(V(cpphdl_n2545, Vss), V(cpphdl_n2553, Vss), 0.001, 0.69999999999999996, 1.0);
        // device 2066, IC IC351, analog/basic/inverter.hpp:11
        I(cpphdl_n2569, Vdd) <+ cpphdl_channel(V(cpphdl_n2553, Vdd), V(cpphdl_n2569, Vdd), 0.0040000000000000001, 0.69999999999999996, -1.0);
        // device 2067, IC IC351, analog/basic/inverter.hpp:12
        I(cpphdl_n2569, Vss) <+ cpphdl_channel(V(cpphdl_n2553, Vss), V(cpphdl_n2569, Vss), 0.0040000000000000001, 0.69999999999999996, 1.0);
        // device 2068, IC IC347, analog/basic/buffered_nand_latch.hpp:33
        I(cpphdl_n2545, Vss) <+ 2.0000000000000002e-15 * ddt(V(cpphdl_n2545, Vss)); // Bench initial voltage = 0.0 V.
        // device 2069, IC IC347, analog/basic/buffered_nand_latch.hpp:34
        I(cpphdl_n2545, cpphdl_n2553) <+ 1.0000000000000001e-15 * ddt(V(cpphdl_n2545, cpphdl_n2553)); // Bench initial voltage = 0.0 V.
        // device 2070, IC IC347, analog/basic/buffered_nand_latch.hpp:35
        I(cpphdl_n2553, Vss) <+ 5e-15 * ddt(V(cpphdl_n2553, Vss)); // Bench initial voltage = 0.0 V.
        // device 2071, IC IC347, analog/basic/buffered_nand_latch.hpp:36
        I(cpphdl_n2553, Vss) <+ 8.0000000000000006e-15 * ddt(V(cpphdl_n2553, Vss)); // Bench initial voltage = 0.0 V.
        // device 2072, IC IC347, analog/basic/buffered_nand_latch.hpp:37
        I(cpphdl_n2569, Vss) <+ 1e-14 * ddt(V(cpphdl_n2569, Vss)); // Bench initial voltage = 0.0 V.
        // device 2073, IC IC353, analog/basic/cmos_logic.hpp:15
        I(cpphdl_n2810, Vss) <+ 5.0000000000000002e-14 * ddt(V(cpphdl_n2810, Vss)); // Bench initial voltage = 0.0 V.
        // device 2074, IC IC353, analog/basic/cmos_logic.hpp:16
        I(cpphdl_n2810, Vdd) <+ cpphdl_channel(V(cpphdl_n2563, Vdd), V(cpphdl_n2810, Vdd), 0.01, 0.69999999999999996, -1.0);
        // device 2075, IC IC353, analog/basic/cmos_logic.hpp:17
        I(cpphdl_n2810, Vdd) <+ cpphdl_channel(V(cpphdl_n2571, Vdd), V(cpphdl_n2810, Vdd), 0.01, 0.69999999999999996, -1.0);
        // device 2076, IC IC353, analog/basic/cmos_logic.hpp:18
        I(cpphdl_n2810, cpphdl_n2566) <+ cpphdl_channel(V(cpphdl_n2563, cpphdl_n2566), V(cpphdl_n2810, cpphdl_n2566), 0.01, 0.69999999999999996, 1.0);
        // device 2077, IC IC353, analog/basic/cmos_logic.hpp:19
        I(cpphdl_n2566, Vss) <+ cpphdl_channel(V(cpphdl_n2571, Vss), V(cpphdl_n2566, Vss), 0.01, 0.69999999999999996, 1.0);
        // device 2078, IC IC353, analog/basic/cmos_logic.hpp:20
        I(cpphdl_n2810, Vss) <+ V(cpphdl_n2810, Vss) / 1000000000.0;
        // device 2079, IC IC353, analog/basic/cmos_logic.hpp:21
        I(cpphdl_n2566, Vss) <+ V(cpphdl_n2566, Vss) / 1000000000.0;
        // device 2080, IC IC354, analog/basic/cmos_logic.hpp:15
        I(cpphdl_n2571, Vss) <+ 5.0000000000000002e-14 * ddt(V(cpphdl_n2571, Vss)); // Bench initial voltage = 0.0 V.
        // device 2081, IC IC354, analog/basic/cmos_logic.hpp:16
        I(cpphdl_n2571, Vdd) <+ cpphdl_channel(V(cpphdl_n2569, Vdd), V(cpphdl_n2571, Vdd), 0.01, 0.69999999999999996, -1.0);
        // device 2082, IC IC354, analog/basic/cmos_logic.hpp:17
        I(cpphdl_n2571, Vdd) <+ cpphdl_channel(V(cpphdl_n2810, Vdd), V(cpphdl_n2571, Vdd), 0.01, 0.69999999999999996, -1.0);
        // device 2083, IC IC354, analog/basic/cmos_logic.hpp:18
        I(cpphdl_n2571, cpphdl_n2572) <+ cpphdl_channel(V(cpphdl_n2569, cpphdl_n2572), V(cpphdl_n2571, cpphdl_n2572), 0.01, 0.69999999999999996, 1.0);
        // device 2084, IC IC354, analog/basic/cmos_logic.hpp:19
        I(cpphdl_n2572, Vss) <+ cpphdl_channel(V(cpphdl_n2810, Vss), V(cpphdl_n2572, Vss), 0.01, 0.69999999999999996, 1.0);
        // device 2085, IC IC354, analog/basic/cmos_logic.hpp:20
        I(cpphdl_n2571, Vss) <+ V(cpphdl_n2571, Vss) / 1000000000.0;
        // device 2086, IC IC354, analog/basic/cmos_logic.hpp:21
        I(cpphdl_n2572, Vss) <+ V(cpphdl_n2572, Vss) / 1000000000.0;
        // device 2087, IC IC352, analog/basic/nand_latch.hpp:34
        I(cpphdl_n2563, Vss) <+ 2.9999999999999998e-15 * ddt(V(cpphdl_n2563, Vss)); // Bench initial voltage = 0.0 V.
        // device 2088, IC IC352, analog/basic/nand_latch.hpp:35
        I(cpphdl_n2569, Vss) <+ 2.9999999999999998e-15 * ddt(V(cpphdl_n2569, Vss)); // Bench initial voltage = 0.0 V.
        // device 2089, IC IC355, analog/basic/inverter.hpp:11
        I(cpphdl_n2577, Vdd) <+ cpphdl_channel(V(CLEAR, Vdd), V(cpphdl_n2577, Vdd), 0.01, 0.69999999999999996, -1.0);
        // device 2090, IC IC355, analog/basic/inverter.hpp:12
        I(cpphdl_n2577, Vss) <+ cpphdl_channel(V(CLEAR, Vss), V(cpphdl_n2577, Vss), 0.01, 0.69999999999999996, 1.0);
        // device 2091, IC IC352, analog/basic/nand_latch.hpp:56
        I(cpphdl_n2577, Vss) <+ 2.9999999999999998e-15 * ddt(V(cpphdl_n2577, Vss)); // Bench initial voltage = 0.0 V.
        // device 2092, IC IC352, analog/basic/nand_latch.hpp:57
        I(cpphdl_n2810, Vss) <+ cpphdl_channel(V(CLEAR, Vss), V(cpphdl_n2810, Vss), 0.050000000000000003, 0.69999999999999996, 1.0);
        // device 2093, IC IC352, analog/basic/nand_latch.hpp:58
        I(cpphdl_n2571, Vdd) <+ cpphdl_channel(V(cpphdl_n2577, Vdd), V(cpphdl_n2571, Vdd), 0.050000000000000003, 0.69999999999999996, -1.0);
        // device 2094, IC IC358, analog/basic/inverter.hpp:11
        I(cpphdl_n2601, Vdd) <+ cpphdl_channel(V(TRACK15, Vdd), V(cpphdl_n2601, Vdd), 0.0040000000000000001, 0.69999999999999996, -1.0);
        // device 2095, IC IC358, analog/basic/inverter.hpp:12
        I(cpphdl_n2601, Vss) <+ cpphdl_channel(V(TRACK15, Vss), V(cpphdl_n2601, Vss), 0.0040000000000000001, 0.69999999999999996, 1.0);
        // device 2096, IC IC357, analog/basic/mos_track_hold.hpp:30
        I(cpphdl_n2601, Vss) <+ 2e-14 * ddt(V(cpphdl_n2601, Vss)); // Bench initial voltage = 3.2999999999999998 V.
        // device 2097, IC IC357, analog/basic/mos_track_hold.hpp:31
        I(cpphdl_n2595, cpphdl_n2655) <+ cpphdl_channel(V(TRACK15, cpphdl_n2655), V(cpphdl_n2595, cpphdl_n2655), 0.02, 0.69999999999999996, 1.0);
        // device 2098, IC IC357, analog/basic/mos_track_hold.hpp:32
        I(cpphdl_n2655, cpphdl_n2595) <+ cpphdl_channel(V(cpphdl_n2601, cpphdl_n2595), V(cpphdl_n2655, cpphdl_n2595), 0.01, 0.69999999999999996, -1.0);
        // device 2099, IC IC357, analog/basic/mos_track_hold.hpp:36
        I(cpphdl_n2655, cpphdl_n2655) <+ cpphdl_channel(V(cpphdl_n2601, cpphdl_n2655), V(cpphdl_n2655, cpphdl_n2655), 0.01, 0.69999999999999996, 1.0);
        // device 2100, IC IC357, analog/basic/mos_track_hold.hpp:37
        I(cpphdl_n2655, cpphdl_n2655) <+ cpphdl_channel(V(TRACK15, cpphdl_n2655), V(cpphdl_n2655, cpphdl_n2655), 0.0050000000000000001, 0.69999999999999996, -1.0);
        // device 2101, IC IC357, analog/basic/mos_track_hold.hpp:38
        I(cpphdl_n2655, Vss) <+ 1.5000000000000001e-12 * ddt(V(cpphdl_n2655, Vss)); // Bench initial voltage = 1.6499999999999999 V.
        // device 2102, IC IC357, analog/basic/mos_track_hold.hpp:39
        I(Vss, cpphdl_n2655) <+ V(Vss, cpphdl_n2655) / 1000000000.0;
        // device 2103, IC IC357, analog/basic/mos_track_hold.hpp:40
        I(TRACK15, cpphdl_n2655) <+ 2.0000000000000002e-15 * ddt(V(TRACK15, cpphdl_n2655)); // Bench initial voltage = -1.6499999999999999 V.
        // device 2104, IC IC357, analog/basic/mos_track_hold.hpp:41
        I(cpphdl_n2601, cpphdl_n2655) <+ 2.0000000000000002e-15 * ddt(V(cpphdl_n2601, cpphdl_n2655)); // Bench initial voltage = 1.6499999999999999 V.
        // device 2105, IC IC357, analog/basic/mos_track_hold.hpp:42
        I(cpphdl_n2595, cpphdl_n2655) <+ 1.0000000000000001e-15 * ddt(V(cpphdl_n2595, cpphdl_n2655)); // Bench initial voltage = 0.0 V.
        // device 2106, IC IC360, analog/basic/inverter.hpp:11
        I(cpphdl_n2616, Vdd) <+ cpphdl_channel(V(BIT_N15_0, Vdd), V(cpphdl_n2616, Vdd), 0.080000000000000002, 0.69999999999999996, -1.0);
        // device 2107, IC IC360, analog/basic/inverter.hpp:12
        I(cpphdl_n2616, Vss) <+ cpphdl_channel(V(BIT_N15_0, Vss), V(cpphdl_n2616, Vss), 0.080000000000000002, 0.69999999999999996, 1.0);
        // device 2108, IC IC359, analog/basic/mos_r2r_dac.hpp:27
        I(cpphdl_n2616, Vss) <+ 2.9999999999999998e-15 * ddt(V(cpphdl_n2616, Vss)); // Bench initial voltage = 0.0 V.
        // device 2109, IC IC359, analog/basic/mos_r2r_dac.hpp:28
        I(cpphdl_n2616, cpphdl_n2645) <+ V(cpphdl_n2616, cpphdl_n2645) / 2000.0;
        // device 2110, IC IC359, analog/basic/mos_r2r_dac.hpp:29
        I(cpphdl_n2645, Vss) <+ 2.9999999999999998e-15 * ddt(V(cpphdl_n2645, Vss)); // Bench initial voltage = 0.0 V.
        // device 2111, IC IC361, analog/basic/inverter.hpp:11
        I(cpphdl_n2620, Vdd) <+ cpphdl_channel(V(BIT_N15_1, Vdd), V(cpphdl_n2620, Vdd), 0.080000000000000002, 0.69999999999999996, -1.0);
        // device 2112, IC IC361, analog/basic/inverter.hpp:12
        I(cpphdl_n2620, Vss) <+ cpphdl_channel(V(BIT_N15_1, Vss), V(cpphdl_n2620, Vss), 0.080000000000000002, 0.69999999999999996, 1.0);
        // device 2113, IC IC359, analog/basic/mos_r2r_dac.hpp:27
        I(cpphdl_n2620, Vss) <+ 2.9999999999999998e-15 * ddt(V(cpphdl_n2620, Vss)); // Bench initial voltage = 0.0 V.
        // device 2114, IC IC359, analog/basic/mos_r2r_dac.hpp:28
        I(cpphdl_n2620, cpphdl_n2646) <+ V(cpphdl_n2620, cpphdl_n2646) / 2000.0;
        // device 2115, IC IC359, analog/basic/mos_r2r_dac.hpp:29
        I(cpphdl_n2646, Vss) <+ 2.9999999999999998e-15 * ddt(V(cpphdl_n2646, Vss)); // Bench initial voltage = 0.0 V.
        // device 2116, IC IC359, analog/basic/mos_r2r_dac.hpp:31
        I(cpphdl_n2645, cpphdl_n2646) <+ V(cpphdl_n2645, cpphdl_n2646) / 1000.0;
        // device 2117, IC IC362, analog/basic/inverter.hpp:11
        I(cpphdl_n2624, Vdd) <+ cpphdl_channel(V(BIT_N15_2, Vdd), V(cpphdl_n2624, Vdd), 0.080000000000000002, 0.69999999999999996, -1.0);
        // device 2118, IC IC362, analog/basic/inverter.hpp:12
        I(cpphdl_n2624, Vss) <+ cpphdl_channel(V(BIT_N15_2, Vss), V(cpphdl_n2624, Vss), 0.080000000000000002, 0.69999999999999996, 1.0);
        // device 2119, IC IC359, analog/basic/mos_r2r_dac.hpp:27
        I(cpphdl_n2624, Vss) <+ 2.9999999999999998e-15 * ddt(V(cpphdl_n2624, Vss)); // Bench initial voltage = 0.0 V.
        // device 2120, IC IC359, analog/basic/mos_r2r_dac.hpp:28
        I(cpphdl_n2624, cpphdl_n2647) <+ V(cpphdl_n2624, cpphdl_n2647) / 2000.0;
        // device 2121, IC IC359, analog/basic/mos_r2r_dac.hpp:29
        I(cpphdl_n2647, Vss) <+ 2.9999999999999998e-15 * ddt(V(cpphdl_n2647, Vss)); // Bench initial voltage = 0.0 V.
        // device 2122, IC IC359, analog/basic/mos_r2r_dac.hpp:31
        I(cpphdl_n2646, cpphdl_n2647) <+ V(cpphdl_n2646, cpphdl_n2647) / 1000.0;
        // device 2123, IC IC363, analog/basic/inverter.hpp:11
        I(cpphdl_n2628, Vdd) <+ cpphdl_channel(V(BIT_N15_3, Vdd), V(cpphdl_n2628, Vdd), 0.080000000000000002, 0.69999999999999996, -1.0);
        // device 2124, IC IC363, analog/basic/inverter.hpp:12
        I(cpphdl_n2628, Vss) <+ cpphdl_channel(V(BIT_N15_3, Vss), V(cpphdl_n2628, Vss), 0.080000000000000002, 0.69999999999999996, 1.0);
        // device 2125, IC IC359, analog/basic/mos_r2r_dac.hpp:27
        I(cpphdl_n2628, Vss) <+ 2.9999999999999998e-15 * ddt(V(cpphdl_n2628, Vss)); // Bench initial voltage = 0.0 V.
        // device 2126, IC IC359, analog/basic/mos_r2r_dac.hpp:28
        I(cpphdl_n2628, cpphdl_n2648) <+ V(cpphdl_n2628, cpphdl_n2648) / 2000.0;
        // device 2127, IC IC359, analog/basic/mos_r2r_dac.hpp:29
        I(cpphdl_n2648, Vss) <+ 2.9999999999999998e-15 * ddt(V(cpphdl_n2648, Vss)); // Bench initial voltage = 0.0 V.
        // device 2128, IC IC359, analog/basic/mos_r2r_dac.hpp:31
        I(cpphdl_n2647, cpphdl_n2648) <+ V(cpphdl_n2647, cpphdl_n2648) / 1000.0;
        // device 2129, IC IC364, analog/basic/inverter.hpp:11
        I(cpphdl_n2632, Vdd) <+ cpphdl_channel(V(BIT_N15_4, Vdd), V(cpphdl_n2632, Vdd), 0.080000000000000002, 0.69999999999999996, -1.0);
        // device 2130, IC IC364, analog/basic/inverter.hpp:12
        I(cpphdl_n2632, Vss) <+ cpphdl_channel(V(BIT_N15_4, Vss), V(cpphdl_n2632, Vss), 0.080000000000000002, 0.69999999999999996, 1.0);
        // device 2131, IC IC359, analog/basic/mos_r2r_dac.hpp:27
        I(cpphdl_n2632, Vss) <+ 2.9999999999999998e-15 * ddt(V(cpphdl_n2632, Vss)); // Bench initial voltage = 0.0 V.
        // device 2132, IC IC359, analog/basic/mos_r2r_dac.hpp:28
        I(cpphdl_n2632, cpphdl_n2649) <+ V(cpphdl_n2632, cpphdl_n2649) / 2000.0;
        // device 2133, IC IC359, analog/basic/mos_r2r_dac.hpp:29
        I(cpphdl_n2649, Vss) <+ 2.9999999999999998e-15 * ddt(V(cpphdl_n2649, Vss)); // Bench initial voltage = 0.0 V.
        // device 2134, IC IC359, analog/basic/mos_r2r_dac.hpp:31
        I(cpphdl_n2648, cpphdl_n2649) <+ V(cpphdl_n2648, cpphdl_n2649) / 1000.0;
        // device 2135, IC IC365, analog/basic/inverter.hpp:11
        I(cpphdl_n2636, Vdd) <+ cpphdl_channel(V(BIT_N15_5, Vdd), V(cpphdl_n2636, Vdd), 0.080000000000000002, 0.69999999999999996, -1.0);
        // device 2136, IC IC365, analog/basic/inverter.hpp:12
        I(cpphdl_n2636, Vss) <+ cpphdl_channel(V(BIT_N15_5, Vss), V(cpphdl_n2636, Vss), 0.080000000000000002, 0.69999999999999996, 1.0);
        // device 2137, IC IC359, analog/basic/mos_r2r_dac.hpp:27
        I(cpphdl_n2636, Vss) <+ 2.9999999999999998e-15 * ddt(V(cpphdl_n2636, Vss)); // Bench initial voltage = 0.0 V.
        // device 2138, IC IC359, analog/basic/mos_r2r_dac.hpp:28
        I(cpphdl_n2636, cpphdl_n2650) <+ V(cpphdl_n2636, cpphdl_n2650) / 2000.0;
        // device 2139, IC IC359, analog/basic/mos_r2r_dac.hpp:29
        I(cpphdl_n2650, Vss) <+ 2.9999999999999998e-15 * ddt(V(cpphdl_n2650, Vss)); // Bench initial voltage = 0.0 V.
        // device 2140, IC IC359, analog/basic/mos_r2r_dac.hpp:31
        I(cpphdl_n2649, cpphdl_n2650) <+ V(cpphdl_n2649, cpphdl_n2650) / 1000.0;
        // device 2141, IC IC366, analog/basic/inverter.hpp:11
        I(cpphdl_n2640, Vdd) <+ cpphdl_channel(V(BIT_N15_6, Vdd), V(cpphdl_n2640, Vdd), 0.080000000000000002, 0.69999999999999996, -1.0);
        // device 2142, IC IC366, analog/basic/inverter.hpp:12
        I(cpphdl_n2640, Vss) <+ cpphdl_channel(V(BIT_N15_6, Vss), V(cpphdl_n2640, Vss), 0.080000000000000002, 0.69999999999999996, 1.0);
        // device 2143, IC IC359, analog/basic/mos_r2r_dac.hpp:27
        I(cpphdl_n2640, Vss) <+ 2.9999999999999998e-15 * ddt(V(cpphdl_n2640, Vss)); // Bench initial voltage = 0.0 V.
        // device 2144, IC IC359, analog/basic/mos_r2r_dac.hpp:28
        I(cpphdl_n2640, cpphdl_n2651) <+ V(cpphdl_n2640, cpphdl_n2651) / 2000.0;
        // device 2145, IC IC359, analog/basic/mos_r2r_dac.hpp:29
        I(cpphdl_n2651, Vss) <+ 2.9999999999999998e-15 * ddt(V(cpphdl_n2651, Vss)); // Bench initial voltage = 0.0 V.
        // device 2146, IC IC359, analog/basic/mos_r2r_dac.hpp:31
        I(cpphdl_n2650, cpphdl_n2651) <+ V(cpphdl_n2650, cpphdl_n2651) / 1000.0;
        // device 2147, IC IC367, analog/basic/inverter.hpp:11
        I(cpphdl_n2644, Vdd) <+ cpphdl_channel(V(BIT_N15_7, Vdd), V(cpphdl_n2644, Vdd), 0.080000000000000002, 0.69999999999999996, -1.0);
        // device 2148, IC IC367, analog/basic/inverter.hpp:12
        I(cpphdl_n2644, Vss) <+ cpphdl_channel(V(BIT_N15_7, Vss), V(cpphdl_n2644, Vss), 0.080000000000000002, 0.69999999999999996, 1.0);
        // device 2149, IC IC359, analog/basic/mos_r2r_dac.hpp:27
        I(cpphdl_n2644, Vss) <+ 2.9999999999999998e-15 * ddt(V(cpphdl_n2644, Vss)); // Bench initial voltage = 0.0 V.
        // device 2150, IC IC359, analog/basic/mos_r2r_dac.hpp:28
        I(cpphdl_n2644, cpphdl_n2656) <+ V(cpphdl_n2644, cpphdl_n2656) / 2000.0;
        // device 2151, IC IC359, analog/basic/mos_r2r_dac.hpp:29
        I(cpphdl_n2656, Vss) <+ 2.9999999999999998e-15 * ddt(V(cpphdl_n2656, Vss)); // Bench initial voltage = 0.0 V.
        // device 2152, IC IC359, analog/basic/mos_r2r_dac.hpp:31
        I(cpphdl_n2651, cpphdl_n2656) <+ V(cpphdl_n2651, cpphdl_n2656) / 1000.0;
        // device 2153, IC IC359, analog/basic/mos_r2r_dac.hpp:33
        I(Vss, cpphdl_n2645) <+ V(Vss, cpphdl_n2645) / 2000.0;
        // device 2154, IC IC368, analog/basic/nmos_resistor_amplifier.hpp:23
        I(Vdd, cpphdl_n2665) <+ V(Vdd, cpphdl_n2665) / 500.0;
        // device 2155, IC IC368, analog/basic/nmos_resistor_amplifier.hpp:24
        I(Vdd, cpphdl_n2664) <+ V(Vdd, cpphdl_n2664) / 500.0;
        // device 2156, IC IC368, analog/basic/nmos_resistor_amplifier.hpp:25
        I(cpphdl_n2665, cpphdl_n2659) <+ cpphdl_channel(V(cpphdl_n2655, cpphdl_n2659), V(cpphdl_n2665, cpphdl_n2659), 0.014999999999999999, 0.69999999999999996, 1.0);
        // device 2157, IC IC368, analog/basic/nmos_resistor_amplifier.hpp:26
        I(cpphdl_n2664, cpphdl_n2660) <+ cpphdl_channel(V(cpphdl_n2656, cpphdl_n2660), V(cpphdl_n2664, cpphdl_n2660), 0.014999999999999999, 0.69999999999999996, 1.0);
        // device 2158, IC IC368, analog/basic/nmos_resistor_amplifier.hpp:27
        I(cpphdl_n2661, cpphdl_n2659) <+ V(cpphdl_n2661, cpphdl_n2659) / 50.0;
        // device 2159, IC IC368, analog/basic/nmos_resistor_amplifier.hpp:28
        I(cpphdl_n2661, cpphdl_n2660) <+ V(cpphdl_n2661, cpphdl_n2660) / 50.0;
        // device 2160, IC IC368, analog/basic/nmos_resistor_amplifier.hpp:29
        I(Vss, cpphdl_n2661) <+ V(Vss, cpphdl_n2661) / 150.0;
        // device 2161, IC IC368, analog/basic/nmos_resistor_amplifier.hpp:30
        I(cpphdl_n2665, Vdd) <+ 2.9999999999999998e-13 * ddt(V(cpphdl_n2665, Vdd)); // Bench initial voltage = 0.0 V.
        // device 2162, IC IC368, analog/basic/nmos_resistor_amplifier.hpp:31
        I(cpphdl_n2664, Vdd) <+ 2.9999999999999998e-13 * ddt(V(cpphdl_n2664, Vdd)); // Bench initial voltage = 0.0 V.
        // device 2163, IC IC368, analog/basic/nmos_resistor_amplifier.hpp:32
        I(cpphdl_n2661, Vss) <+ 4e-14 * ddt(V(cpphdl_n2661, Vss)); // Bench initial voltage = 0.0 V.
        // device 2164, IC IC368, analog/basic/nmos_resistor_amplifier.hpp:34
        I(cpphdl_n2655, cpphdl_n2659) <+ 2e-14 * ddt(V(cpphdl_n2655, cpphdl_n2659)); // Bench initial voltage = 1.6499999999999999 V.
        // device 2165, IC IC368, analog/basic/nmos_resistor_amplifier.hpp:35
        I(cpphdl_n2656, cpphdl_n2660) <+ 2e-14 * ddt(V(cpphdl_n2656, cpphdl_n2660)); // Bench initial voltage = 0.0 V.
        // device 2166, IC IC368, analog/basic/nmos_resistor_amplifier.hpp:36
        I(cpphdl_n2655, cpphdl_n2665) <+ 2.9999999999999998e-15 * ddt(V(cpphdl_n2655, cpphdl_n2665)); // Bench initial voltage = -1.6499999999999999 V.
        // device 2167, IC IC368, analog/basic/nmos_resistor_amplifier.hpp:37
        I(cpphdl_n2656, cpphdl_n2664) <+ 2.9999999999999998e-15 * ddt(V(cpphdl_n2656, cpphdl_n2664)); // Bench initial voltage = -3.2999999999999998 V.
        // device 2168, IC IC369, analog/basic/strongarm_comparator.hpp:28
        I(cpphdl_n2669, cpphdl_n2671) <+ cpphdl_channel(V(cpphdl_n2664, cpphdl_n2671), V(cpphdl_n2669, cpphdl_n2671), 0.0080000000000000002, 0.69999999999999996, 1.0);
        // device 2169, IC IC369, analog/basic/strongarm_comparator.hpp:29
        I(cpphdl_n2670, cpphdl_n2671) <+ cpphdl_channel(V(cpphdl_n2665, cpphdl_n2671), V(cpphdl_n2670, cpphdl_n2671), 0.0080000000000000002, 0.69999999999999996, 1.0);
        // device 2170, IC IC369, analog/basic/strongarm_comparator.hpp:30
        I(cpphdl_n2671, Vss) <+ cpphdl_channel(V(EVALUATE, Vss), V(cpphdl_n2671, Vss), 0.0080000000000000002, 0.69999999999999996, 1.0);
        // device 2171, IC IC369, analog/basic/strongarm_comparator.hpp:33
        I(cpphdl_n2684, cpphdl_n2669) <+ cpphdl_channel(V(cpphdl_n2688, cpphdl_n2669), V(cpphdl_n2684, cpphdl_n2669), 0.0040000000000000001, 0.69999999999999996, 1.0);
        // device 2172, IC IC369, analog/basic/strongarm_comparator.hpp:34
        I(cpphdl_n2688, cpphdl_n2670) <+ cpphdl_channel(V(cpphdl_n2684, cpphdl_n2670), V(cpphdl_n2688, cpphdl_n2670), 0.0040000000000000001, 0.69999999999999996, 1.0);
        // device 2173, IC IC369, analog/basic/strongarm_comparator.hpp:35
        I(cpphdl_n2688, Vdd) <+ cpphdl_channel(V(cpphdl_n2684, Vdd), V(cpphdl_n2688, Vdd), 0.002, 0.69999999999999996, -1.0);
        // device 2174, IC IC369, analog/basic/strongarm_comparator.hpp:36
        I(cpphdl_n2684, Vdd) <+ cpphdl_channel(V(cpphdl_n2688, Vdd), V(cpphdl_n2684, Vdd), 0.002, 0.69999999999999996, -1.0);
        // device 2175, IC IC369, analog/basic/strongarm_comparator.hpp:38
        I(cpphdl_n2669, Vdd) <+ cpphdl_channel(V(EVALUATE, Vdd), V(cpphdl_n2669, Vdd), 0.002, 0.69999999999999996, -1.0);
        // device 2176, IC IC369, analog/basic/strongarm_comparator.hpp:39
        I(cpphdl_n2670, Vdd) <+ cpphdl_channel(V(EVALUATE, Vdd), V(cpphdl_n2670, Vdd), 0.002, 0.69999999999999996, -1.0);
        // device 2177, IC IC369, analog/basic/strongarm_comparator.hpp:40
        I(cpphdl_n2688, Vdd) <+ cpphdl_channel(V(EVALUATE, Vdd), V(cpphdl_n2688, Vdd), 0.002, 0.69999999999999996, -1.0);
        // device 2178, IC IC369, analog/basic/strongarm_comparator.hpp:41
        I(cpphdl_n2684, Vdd) <+ cpphdl_channel(V(EVALUATE, Vdd), V(cpphdl_n2684, Vdd), 0.002, 0.69999999999999996, -1.0);
        // device 2179, IC IC369, analog/basic/strongarm_comparator.hpp:42
        I(cpphdl_n2669, Vss) <+ 2.9999999999999998e-14 * ddt(V(cpphdl_n2669, Vss)); // Bench initial voltage = 0.0 V.
        // device 2180, IC IC369, analog/basic/strongarm_comparator.hpp:43
        I(cpphdl_n2670, Vss) <+ 2.9999999999999998e-14 * ddt(V(cpphdl_n2670, Vss)); // Bench initial voltage = 0.0 V.
        // device 2181, IC IC369, analog/basic/strongarm_comparator.hpp:44
        I(cpphdl_n2671, Vss) <+ 2.9999999999999998e-14 * ddt(V(cpphdl_n2671, Vss)); // Bench initial voltage = 0.0 V.
        // device 2182, IC IC369, analog/basic/strongarm_comparator.hpp:45
        I(cpphdl_n2688, Vss) <+ 5.0000000000000002e-14 * ddt(V(cpphdl_n2688, Vss)); // Bench initial voltage = 0.0 V.
        // device 2183, IC IC369, analog/basic/strongarm_comparator.hpp:46
        I(cpphdl_n2684, Vss) <+ 5.0000000000000002e-14 * ddt(V(cpphdl_n2684, Vss)); // Bench initial voltage = 0.0 V.
        // device 2184, IC IC369, analog/basic/strongarm_comparator.hpp:47
        I(cpphdl_n2664, cpphdl_n2671) <+ 2e-14 * ddt(V(cpphdl_n2664, cpphdl_n2671)); // Bench initial voltage = 3.2999999999999998 V.
        // device 2185, IC IC369, analog/basic/strongarm_comparator.hpp:48
        I(cpphdl_n2665, cpphdl_n2671) <+ 2e-14 * ddt(V(cpphdl_n2665, cpphdl_n2671)); // Bench initial voltage = 3.2999999999999998 V.
        // device 2186, IC IC369, analog/basic/strongarm_comparator.hpp:49
        I(cpphdl_n2664, cpphdl_n2669) <+ 2.9999999999999998e-15 * ddt(V(cpphdl_n2664, cpphdl_n2669)); // Bench initial voltage = 3.2999999999999998 V.
        // device 2187, IC IC369, analog/basic/strongarm_comparator.hpp:50
        I(cpphdl_n2665, cpphdl_n2670) <+ 2.9999999999999998e-15 * ddt(V(cpphdl_n2665, cpphdl_n2670)); // Bench initial voltage = 3.2999999999999998 V.
        // device 2188, IC IC371, analog/basic/inverter.hpp:11
        I(cpphdl_n2692, Vdd) <+ cpphdl_channel(V(cpphdl_n2684, Vdd), V(cpphdl_n2692, Vdd), 0.001, 0.69999999999999996, -1.0);
        // device 2189, IC IC371, analog/basic/inverter.hpp:12
        I(cpphdl_n2692, Vss) <+ cpphdl_channel(V(cpphdl_n2684, Vss), V(cpphdl_n2692, Vss), 0.001, 0.69999999999999996, 1.0);
        // device 2190, IC IC373, analog/basic/inverter.hpp:11
        I(cpphdl_n2706, Vdd) <+ cpphdl_channel(V(cpphdl_n2692, Vdd), V(cpphdl_n2706, Vdd), 0.0040000000000000001, 0.69999999999999996, -1.0);
        // device 2191, IC IC373, analog/basic/inverter.hpp:12
        I(cpphdl_n2706, Vss) <+ cpphdl_channel(V(cpphdl_n2692, Vss), V(cpphdl_n2706, Vss), 0.0040000000000000001, 0.69999999999999996, 1.0);
        // device 2192, IC IC370, analog/basic/buffered_nand_latch.hpp:33
        I(cpphdl_n2684, Vss) <+ 2.0000000000000002e-15 * ddt(V(cpphdl_n2684, Vss)); // Bench initial voltage = 0.0 V.
        // device 2193, IC IC370, analog/basic/buffered_nand_latch.hpp:34
        I(cpphdl_n2684, cpphdl_n2692) <+ 1.0000000000000001e-15 * ddt(V(cpphdl_n2684, cpphdl_n2692)); // Bench initial voltage = 0.0 V.
        // device 2194, IC IC370, analog/basic/buffered_nand_latch.hpp:35
        I(cpphdl_n2692, Vss) <+ 5e-15 * ddt(V(cpphdl_n2692, Vss)); // Bench initial voltage = 0.0 V.
        // device 2195, IC IC370, analog/basic/buffered_nand_latch.hpp:36
        I(cpphdl_n2692, Vss) <+ 8.0000000000000006e-15 * ddt(V(cpphdl_n2692, Vss)); // Bench initial voltage = 0.0 V.
        // device 2196, IC IC370, analog/basic/buffered_nand_latch.hpp:37
        I(cpphdl_n2706, Vss) <+ 1e-14 * ddt(V(cpphdl_n2706, Vss)); // Bench initial voltage = 0.0 V.
        // device 2197, IC IC372, analog/basic/inverter.hpp:11
        I(cpphdl_n2696, Vdd) <+ cpphdl_channel(V(cpphdl_n2688, Vdd), V(cpphdl_n2696, Vdd), 0.001, 0.69999999999999996, -1.0);
        // device 2198, IC IC372, analog/basic/inverter.hpp:12
        I(cpphdl_n2696, Vss) <+ cpphdl_channel(V(cpphdl_n2688, Vss), V(cpphdl_n2696, Vss), 0.001, 0.69999999999999996, 1.0);
        // device 2199, IC IC374, analog/basic/inverter.hpp:11
        I(cpphdl_n2712, Vdd) <+ cpphdl_channel(V(cpphdl_n2696, Vdd), V(cpphdl_n2712, Vdd), 0.0040000000000000001, 0.69999999999999996, -1.0);
        // device 2200, IC IC374, analog/basic/inverter.hpp:12
        I(cpphdl_n2712, Vss) <+ cpphdl_channel(V(cpphdl_n2696, Vss), V(cpphdl_n2712, Vss), 0.0040000000000000001, 0.69999999999999996, 1.0);
        // device 2201, IC IC370, analog/basic/buffered_nand_latch.hpp:33
        I(cpphdl_n2688, Vss) <+ 2.0000000000000002e-15 * ddt(V(cpphdl_n2688, Vss)); // Bench initial voltage = 0.0 V.
        // device 2202, IC IC370, analog/basic/buffered_nand_latch.hpp:34
        I(cpphdl_n2688, cpphdl_n2696) <+ 1.0000000000000001e-15 * ddt(V(cpphdl_n2688, cpphdl_n2696)); // Bench initial voltage = 0.0 V.
        // device 2203, IC IC370, analog/basic/buffered_nand_latch.hpp:35
        I(cpphdl_n2696, Vss) <+ 5e-15 * ddt(V(cpphdl_n2696, Vss)); // Bench initial voltage = 0.0 V.
        // device 2204, IC IC370, analog/basic/buffered_nand_latch.hpp:36
        I(cpphdl_n2696, Vss) <+ 8.0000000000000006e-15 * ddt(V(cpphdl_n2696, Vss)); // Bench initial voltage = 0.0 V.
        // device 2205, IC IC370, analog/basic/buffered_nand_latch.hpp:37
        I(cpphdl_n2712, Vss) <+ 1e-14 * ddt(V(cpphdl_n2712, Vss)); // Bench initial voltage = 0.0 V.
        // device 2206, IC IC376, analog/basic/cmos_logic.hpp:15
        I(cpphdl_n2815, Vss) <+ 5.0000000000000002e-14 * ddt(V(cpphdl_n2815, Vss)); // Bench initial voltage = 0.0 V.
        // device 2207, IC IC376, analog/basic/cmos_logic.hpp:16
        I(cpphdl_n2815, Vdd) <+ cpphdl_channel(V(cpphdl_n2706, Vdd), V(cpphdl_n2815, Vdd), 0.01, 0.69999999999999996, -1.0);
        // device 2208, IC IC376, analog/basic/cmos_logic.hpp:17
        I(cpphdl_n2815, Vdd) <+ cpphdl_channel(V(cpphdl_n2714, Vdd), V(cpphdl_n2815, Vdd), 0.01, 0.69999999999999996, -1.0);
        // device 2209, IC IC376, analog/basic/cmos_logic.hpp:18
        I(cpphdl_n2815, cpphdl_n2709) <+ cpphdl_channel(V(cpphdl_n2706, cpphdl_n2709), V(cpphdl_n2815, cpphdl_n2709), 0.01, 0.69999999999999996, 1.0);
        // device 2210, IC IC376, analog/basic/cmos_logic.hpp:19
        I(cpphdl_n2709, Vss) <+ cpphdl_channel(V(cpphdl_n2714, Vss), V(cpphdl_n2709, Vss), 0.01, 0.69999999999999996, 1.0);
        // device 2211, IC IC376, analog/basic/cmos_logic.hpp:20
        I(cpphdl_n2815, Vss) <+ V(cpphdl_n2815, Vss) / 1000000000.0;
        // device 2212, IC IC376, analog/basic/cmos_logic.hpp:21
        I(cpphdl_n2709, Vss) <+ V(cpphdl_n2709, Vss) / 1000000000.0;
        // device 2213, IC IC377, analog/basic/cmos_logic.hpp:15
        I(cpphdl_n2714, Vss) <+ 5.0000000000000002e-14 * ddt(V(cpphdl_n2714, Vss)); // Bench initial voltage = 0.0 V.
        // device 2214, IC IC377, analog/basic/cmos_logic.hpp:16
        I(cpphdl_n2714, Vdd) <+ cpphdl_channel(V(cpphdl_n2712, Vdd), V(cpphdl_n2714, Vdd), 0.01, 0.69999999999999996, -1.0);
        // device 2215, IC IC377, analog/basic/cmos_logic.hpp:17
        I(cpphdl_n2714, Vdd) <+ cpphdl_channel(V(cpphdl_n2815, Vdd), V(cpphdl_n2714, Vdd), 0.01, 0.69999999999999996, -1.0);
        // device 2216, IC IC377, analog/basic/cmos_logic.hpp:18
        I(cpphdl_n2714, cpphdl_n2715) <+ cpphdl_channel(V(cpphdl_n2712, cpphdl_n2715), V(cpphdl_n2714, cpphdl_n2715), 0.01, 0.69999999999999996, 1.0);
        // device 2217, IC IC377, analog/basic/cmos_logic.hpp:19
        I(cpphdl_n2715, Vss) <+ cpphdl_channel(V(cpphdl_n2815, Vss), V(cpphdl_n2715, Vss), 0.01, 0.69999999999999996, 1.0);
        // device 2218, IC IC377, analog/basic/cmos_logic.hpp:20
        I(cpphdl_n2714, Vss) <+ V(cpphdl_n2714, Vss) / 1000000000.0;
        // device 2219, IC IC377, analog/basic/cmos_logic.hpp:21
        I(cpphdl_n2715, Vss) <+ V(cpphdl_n2715, Vss) / 1000000000.0;
        // device 2220, IC IC375, analog/basic/nand_latch.hpp:34
        I(cpphdl_n2706, Vss) <+ 2.9999999999999998e-15 * ddt(V(cpphdl_n2706, Vss)); // Bench initial voltage = 0.0 V.
        // device 2221, IC IC375, analog/basic/nand_latch.hpp:35
        I(cpphdl_n2712, Vss) <+ 2.9999999999999998e-15 * ddt(V(cpphdl_n2712, Vss)); // Bench initial voltage = 0.0 V.
        // device 2222, IC IC378, analog/basic/inverter.hpp:11
        I(cpphdl_n2720, Vdd) <+ cpphdl_channel(V(CLEAR, Vdd), V(cpphdl_n2720, Vdd), 0.01, 0.69999999999999996, -1.0);
        // device 2223, IC IC378, analog/basic/inverter.hpp:12
        I(cpphdl_n2720, Vss) <+ cpphdl_channel(V(CLEAR, Vss), V(cpphdl_n2720, Vss), 0.01, 0.69999999999999996, 1.0);
        // device 2224, IC IC375, analog/basic/nand_latch.hpp:56
        I(cpphdl_n2720, Vss) <+ 2.9999999999999998e-15 * ddt(V(cpphdl_n2720, Vss)); // Bench initial voltage = 0.0 V.
        // device 2225, IC IC375, analog/basic/nand_latch.hpp:57
        I(cpphdl_n2815, Vss) <+ cpphdl_channel(V(CLEAR, Vss), V(cpphdl_n2815, Vss), 0.050000000000000003, 0.69999999999999996, 1.0);
        // device 2226, IC IC375, analog/basic/nand_latch.hpp:58
        I(cpphdl_n2714, Vdd) <+ cpphdl_channel(V(cpphdl_n2720, Vdd), V(cpphdl_n2714, Vdd), 0.050000000000000003, 0.69999999999999996, -1.0);
        // device 2227, IC IC379, analog/basic/level_down.hpp:23
        I(cpphdl_n2742, Vlogic) <+ cpphdl_channel(V(Vss, Vlogic), V(cpphdl_n2742, Vlogic), 0.00050000000000000001, 0.34999999999999998, -1.0);
        // device 2228, IC IC379, analog/basic/level_down.hpp:24
        I(cpphdl_n2742, Vss) <+ cpphdl_channel(V(cpphdl_n2740, Vss), V(cpphdl_n2742, Vss), 0.0040000000000000001, 0.69999999999999996, 1.0);
        // device 2229, IC IC379, analog/basic/level_down.hpp:25
        I(CORE_DECISION0, Vlogic) <+ cpphdl_channel(V(cpphdl_n2742, Vlogic), V(CORE_DECISION0, Vlogic), 0.0050000000000000001, 0.34999999999999998, -1.0);
        // device 2230, IC IC379, analog/basic/level_down.hpp:26
        I(CORE_DECISION0, Vss) <+ cpphdl_channel(V(cpphdl_n2742, Vss), V(CORE_DECISION0, Vss), 0.01, 0.34999999999999998, 1.0);
        // device 2231, IC IC379, analog/basic/level_down.hpp:27
        I(cpphdl_n2740, Vss) <+ 5e-15 * ddt(V(cpphdl_n2740, Vss)); // Bench initial voltage = 0.0 V.
        // device 2232, IC IC379, analog/basic/level_down.hpp:28
        I(cpphdl_n2740, Vlogic) <+ 5e-15 * ddt(V(cpphdl_n2740, Vlogic)); // Bench initial voltage = 0.0 V.
        // device 2233, IC IC379, analog/basic/level_down.hpp:29
        I(cpphdl_n2740, cpphdl_n2742) <+ 2.0000000000000002e-15 * ddt(V(cpphdl_n2740, cpphdl_n2742)); // Bench initial voltage = 0.0 V.
        // device 2234, IC IC379, analog/basic/level_down.hpp:30
        I(cpphdl_n2742, Vss) <+ 8e-14 * ddt(V(cpphdl_n2742, Vss)); // Bench initial voltage = 0.0 V.
        // device 2235, IC IC379, analog/basic/level_down.hpp:31
        I(cpphdl_n2742, Vlogic) <+ 5e-15 * ddt(V(cpphdl_n2742, Vlogic)); // Bench initial voltage = 0.0 V.
        // device 2236, IC IC379, analog/basic/level_down.hpp:32
        I(cpphdl_n2742, CORE_DECISION0) <+ 2.0000000000000002e-15 * ddt(V(cpphdl_n2742, CORE_DECISION0)); // Bench initial voltage = 0.0 V.
        // device 2237, IC IC379, analog/basic/level_down.hpp:33
        I(CORE_DECISION0, Vss) <+ 1e-14 * ddt(V(CORE_DECISION0, Vss)); // Bench initial voltage = 0.0 V.
        // device 2238, IC IC380, analog/basic/level_down.hpp:23
        I(cpphdl_n2747, Vlogic) <+ cpphdl_channel(V(Vss, Vlogic), V(cpphdl_n2747, Vlogic), 0.00050000000000000001, 0.34999999999999998, -1.0);
        // device 2239, IC IC380, analog/basic/level_down.hpp:24
        I(cpphdl_n2747, Vss) <+ cpphdl_channel(V(cpphdl_n2745, Vss), V(cpphdl_n2747, Vss), 0.0040000000000000001, 0.69999999999999996, 1.0);
        // device 2240, IC IC380, analog/basic/level_down.hpp:25
        I(CORE_DECISION1, Vlogic) <+ cpphdl_channel(V(cpphdl_n2747, Vlogic), V(CORE_DECISION1, Vlogic), 0.0050000000000000001, 0.34999999999999998, -1.0);
        // device 2241, IC IC380, analog/basic/level_down.hpp:26
        I(CORE_DECISION1, Vss) <+ cpphdl_channel(V(cpphdl_n2747, Vss), V(CORE_DECISION1, Vss), 0.01, 0.34999999999999998, 1.0);
        // device 2242, IC IC380, analog/basic/level_down.hpp:27
        I(cpphdl_n2745, Vss) <+ 5e-15 * ddt(V(cpphdl_n2745, Vss)); // Bench initial voltage = 0.0 V.
        // device 2243, IC IC380, analog/basic/level_down.hpp:28
        I(cpphdl_n2745, Vlogic) <+ 5e-15 * ddt(V(cpphdl_n2745, Vlogic)); // Bench initial voltage = 0.0 V.
        // device 2244, IC IC380, analog/basic/level_down.hpp:29
        I(cpphdl_n2745, cpphdl_n2747) <+ 2.0000000000000002e-15 * ddt(V(cpphdl_n2745, cpphdl_n2747)); // Bench initial voltage = 0.0 V.
        // device 2245, IC IC380, analog/basic/level_down.hpp:30
        I(cpphdl_n2747, Vss) <+ 8e-14 * ddt(V(cpphdl_n2747, Vss)); // Bench initial voltage = 0.0 V.
        // device 2246, IC IC380, analog/basic/level_down.hpp:31
        I(cpphdl_n2747, Vlogic) <+ 5e-15 * ddt(V(cpphdl_n2747, Vlogic)); // Bench initial voltage = 0.0 V.
        // device 2247, IC IC380, analog/basic/level_down.hpp:32
        I(cpphdl_n2747, CORE_DECISION1) <+ 2.0000000000000002e-15 * ddt(V(cpphdl_n2747, CORE_DECISION1)); // Bench initial voltage = 0.0 V.
        // device 2248, IC IC380, analog/basic/level_down.hpp:33
        I(CORE_DECISION1, Vss) <+ 1e-14 * ddt(V(CORE_DECISION1, Vss)); // Bench initial voltage = 0.0 V.
        // device 2249, IC IC381, analog/basic/level_down.hpp:23
        I(cpphdl_n2752, Vlogic) <+ cpphdl_channel(V(Vss, Vlogic), V(cpphdl_n2752, Vlogic), 0.00050000000000000001, 0.34999999999999998, -1.0);
        // device 2250, IC IC381, analog/basic/level_down.hpp:24
        I(cpphdl_n2752, Vss) <+ cpphdl_channel(V(cpphdl_n2750, Vss), V(cpphdl_n2752, Vss), 0.0040000000000000001, 0.69999999999999996, 1.0);
        // device 2251, IC IC381, analog/basic/level_down.hpp:25
        I(CORE_DECISION2, Vlogic) <+ cpphdl_channel(V(cpphdl_n2752, Vlogic), V(CORE_DECISION2, Vlogic), 0.0050000000000000001, 0.34999999999999998, -1.0);
        // device 2252, IC IC381, analog/basic/level_down.hpp:26
        I(CORE_DECISION2, Vss) <+ cpphdl_channel(V(cpphdl_n2752, Vss), V(CORE_DECISION2, Vss), 0.01, 0.34999999999999998, 1.0);
        // device 2253, IC IC381, analog/basic/level_down.hpp:27
        I(cpphdl_n2750, Vss) <+ 5e-15 * ddt(V(cpphdl_n2750, Vss)); // Bench initial voltage = 0.0 V.
        // device 2254, IC IC381, analog/basic/level_down.hpp:28
        I(cpphdl_n2750, Vlogic) <+ 5e-15 * ddt(V(cpphdl_n2750, Vlogic)); // Bench initial voltage = 0.0 V.
        // device 2255, IC IC381, analog/basic/level_down.hpp:29
        I(cpphdl_n2750, cpphdl_n2752) <+ 2.0000000000000002e-15 * ddt(V(cpphdl_n2750, cpphdl_n2752)); // Bench initial voltage = 0.0 V.
        // device 2256, IC IC381, analog/basic/level_down.hpp:30
        I(cpphdl_n2752, Vss) <+ 8e-14 * ddt(V(cpphdl_n2752, Vss)); // Bench initial voltage = 0.0 V.
        // device 2257, IC IC381, analog/basic/level_down.hpp:31
        I(cpphdl_n2752, Vlogic) <+ 5e-15 * ddt(V(cpphdl_n2752, Vlogic)); // Bench initial voltage = 0.0 V.
        // device 2258, IC IC381, analog/basic/level_down.hpp:32
        I(cpphdl_n2752, CORE_DECISION2) <+ 2.0000000000000002e-15 * ddt(V(cpphdl_n2752, CORE_DECISION2)); // Bench initial voltage = 0.0 V.
        // device 2259, IC IC381, analog/basic/level_down.hpp:33
        I(CORE_DECISION2, Vss) <+ 1e-14 * ddt(V(CORE_DECISION2, Vss)); // Bench initial voltage = 0.0 V.
        // device 2260, IC IC382, analog/basic/level_down.hpp:23
        I(cpphdl_n2757, Vlogic) <+ cpphdl_channel(V(Vss, Vlogic), V(cpphdl_n2757, Vlogic), 0.00050000000000000001, 0.34999999999999998, -1.0);
        // device 2261, IC IC382, analog/basic/level_down.hpp:24
        I(cpphdl_n2757, Vss) <+ cpphdl_channel(V(cpphdl_n2755, Vss), V(cpphdl_n2757, Vss), 0.0040000000000000001, 0.69999999999999996, 1.0);
        // device 2262, IC IC382, analog/basic/level_down.hpp:25
        I(CORE_DECISION3, Vlogic) <+ cpphdl_channel(V(cpphdl_n2757, Vlogic), V(CORE_DECISION3, Vlogic), 0.0050000000000000001, 0.34999999999999998, -1.0);
        // device 2263, IC IC382, analog/basic/level_down.hpp:26
        I(CORE_DECISION3, Vss) <+ cpphdl_channel(V(cpphdl_n2757, Vss), V(CORE_DECISION3, Vss), 0.01, 0.34999999999999998, 1.0);
        // device 2264, IC IC382, analog/basic/level_down.hpp:27
        I(cpphdl_n2755, Vss) <+ 5e-15 * ddt(V(cpphdl_n2755, Vss)); // Bench initial voltage = 0.0 V.
        // device 2265, IC IC382, analog/basic/level_down.hpp:28
        I(cpphdl_n2755, Vlogic) <+ 5e-15 * ddt(V(cpphdl_n2755, Vlogic)); // Bench initial voltage = 0.0 V.
        // device 2266, IC IC382, analog/basic/level_down.hpp:29
        I(cpphdl_n2755, cpphdl_n2757) <+ 2.0000000000000002e-15 * ddt(V(cpphdl_n2755, cpphdl_n2757)); // Bench initial voltage = 0.0 V.
        // device 2267, IC IC382, analog/basic/level_down.hpp:30
        I(cpphdl_n2757, Vss) <+ 8e-14 * ddt(V(cpphdl_n2757, Vss)); // Bench initial voltage = 0.0 V.
        // device 2268, IC IC382, analog/basic/level_down.hpp:31
        I(cpphdl_n2757, Vlogic) <+ 5e-15 * ddt(V(cpphdl_n2757, Vlogic)); // Bench initial voltage = 0.0 V.
        // device 2269, IC IC382, analog/basic/level_down.hpp:32
        I(cpphdl_n2757, CORE_DECISION3) <+ 2.0000000000000002e-15 * ddt(V(cpphdl_n2757, CORE_DECISION3)); // Bench initial voltage = 0.0 V.
        // device 2270, IC IC382, analog/basic/level_down.hpp:33
        I(CORE_DECISION3, Vss) <+ 1e-14 * ddt(V(CORE_DECISION3, Vss)); // Bench initial voltage = 0.0 V.
        // device 2271, IC IC383, analog/basic/level_down.hpp:23
        I(cpphdl_n2762, Vlogic) <+ cpphdl_channel(V(Vss, Vlogic), V(cpphdl_n2762, Vlogic), 0.00050000000000000001, 0.34999999999999998, -1.0);
        // device 2272, IC IC383, analog/basic/level_down.hpp:24
        I(cpphdl_n2762, Vss) <+ cpphdl_channel(V(cpphdl_n2760, Vss), V(cpphdl_n2762, Vss), 0.0040000000000000001, 0.69999999999999996, 1.0);
        // device 2273, IC IC383, analog/basic/level_down.hpp:25
        I(CORE_DECISION4, Vlogic) <+ cpphdl_channel(V(cpphdl_n2762, Vlogic), V(CORE_DECISION4, Vlogic), 0.0050000000000000001, 0.34999999999999998, -1.0);
        // device 2274, IC IC383, analog/basic/level_down.hpp:26
        I(CORE_DECISION4, Vss) <+ cpphdl_channel(V(cpphdl_n2762, Vss), V(CORE_DECISION4, Vss), 0.01, 0.34999999999999998, 1.0);
        // device 2275, IC IC383, analog/basic/level_down.hpp:27
        I(cpphdl_n2760, Vss) <+ 5e-15 * ddt(V(cpphdl_n2760, Vss)); // Bench initial voltage = 0.0 V.
        // device 2276, IC IC383, analog/basic/level_down.hpp:28
        I(cpphdl_n2760, Vlogic) <+ 5e-15 * ddt(V(cpphdl_n2760, Vlogic)); // Bench initial voltage = 0.0 V.
        // device 2277, IC IC383, analog/basic/level_down.hpp:29
        I(cpphdl_n2760, cpphdl_n2762) <+ 2.0000000000000002e-15 * ddt(V(cpphdl_n2760, cpphdl_n2762)); // Bench initial voltage = 0.0 V.
        // device 2278, IC IC383, analog/basic/level_down.hpp:30
        I(cpphdl_n2762, Vss) <+ 8e-14 * ddt(V(cpphdl_n2762, Vss)); // Bench initial voltage = 0.0 V.
        // device 2279, IC IC383, analog/basic/level_down.hpp:31
        I(cpphdl_n2762, Vlogic) <+ 5e-15 * ddt(V(cpphdl_n2762, Vlogic)); // Bench initial voltage = 0.0 V.
        // device 2280, IC IC383, analog/basic/level_down.hpp:32
        I(cpphdl_n2762, CORE_DECISION4) <+ 2.0000000000000002e-15 * ddt(V(cpphdl_n2762, CORE_DECISION4)); // Bench initial voltage = 0.0 V.
        // device 2281, IC IC383, analog/basic/level_down.hpp:33
        I(CORE_DECISION4, Vss) <+ 1e-14 * ddt(V(CORE_DECISION4, Vss)); // Bench initial voltage = 0.0 V.
        // device 2282, IC IC384, analog/basic/level_down.hpp:23
        I(cpphdl_n2767, Vlogic) <+ cpphdl_channel(V(Vss, Vlogic), V(cpphdl_n2767, Vlogic), 0.00050000000000000001, 0.34999999999999998, -1.0);
        // device 2283, IC IC384, analog/basic/level_down.hpp:24
        I(cpphdl_n2767, Vss) <+ cpphdl_channel(V(cpphdl_n2765, Vss), V(cpphdl_n2767, Vss), 0.0040000000000000001, 0.69999999999999996, 1.0);
        // device 2284, IC IC384, analog/basic/level_down.hpp:25
        I(CORE_DECISION5, Vlogic) <+ cpphdl_channel(V(cpphdl_n2767, Vlogic), V(CORE_DECISION5, Vlogic), 0.0050000000000000001, 0.34999999999999998, -1.0);
        // device 2285, IC IC384, analog/basic/level_down.hpp:26
        I(CORE_DECISION5, Vss) <+ cpphdl_channel(V(cpphdl_n2767, Vss), V(CORE_DECISION5, Vss), 0.01, 0.34999999999999998, 1.0);
        // device 2286, IC IC384, analog/basic/level_down.hpp:27
        I(cpphdl_n2765, Vss) <+ 5e-15 * ddt(V(cpphdl_n2765, Vss)); // Bench initial voltage = 0.0 V.
        // device 2287, IC IC384, analog/basic/level_down.hpp:28
        I(cpphdl_n2765, Vlogic) <+ 5e-15 * ddt(V(cpphdl_n2765, Vlogic)); // Bench initial voltage = 0.0 V.
        // device 2288, IC IC384, analog/basic/level_down.hpp:29
        I(cpphdl_n2765, cpphdl_n2767) <+ 2.0000000000000002e-15 * ddt(V(cpphdl_n2765, cpphdl_n2767)); // Bench initial voltage = 0.0 V.
        // device 2289, IC IC384, analog/basic/level_down.hpp:30
        I(cpphdl_n2767, Vss) <+ 8e-14 * ddt(V(cpphdl_n2767, Vss)); // Bench initial voltage = 0.0 V.
        // device 2290, IC IC384, analog/basic/level_down.hpp:31
        I(cpphdl_n2767, Vlogic) <+ 5e-15 * ddt(V(cpphdl_n2767, Vlogic)); // Bench initial voltage = 0.0 V.
        // device 2291, IC IC384, analog/basic/level_down.hpp:32
        I(cpphdl_n2767, CORE_DECISION5) <+ 2.0000000000000002e-15 * ddt(V(cpphdl_n2767, CORE_DECISION5)); // Bench initial voltage = 0.0 V.
        // device 2292, IC IC384, analog/basic/level_down.hpp:33
        I(CORE_DECISION5, Vss) <+ 1e-14 * ddt(V(CORE_DECISION5, Vss)); // Bench initial voltage = 0.0 V.
        // device 2293, IC IC385, analog/basic/level_down.hpp:23
        I(cpphdl_n2772, Vlogic) <+ cpphdl_channel(V(Vss, Vlogic), V(cpphdl_n2772, Vlogic), 0.00050000000000000001, 0.34999999999999998, -1.0);
        // device 2294, IC IC385, analog/basic/level_down.hpp:24
        I(cpphdl_n2772, Vss) <+ cpphdl_channel(V(cpphdl_n2770, Vss), V(cpphdl_n2772, Vss), 0.0040000000000000001, 0.69999999999999996, 1.0);
        // device 2295, IC IC385, analog/basic/level_down.hpp:25
        I(CORE_DECISION6, Vlogic) <+ cpphdl_channel(V(cpphdl_n2772, Vlogic), V(CORE_DECISION6, Vlogic), 0.0050000000000000001, 0.34999999999999998, -1.0);
        // device 2296, IC IC385, analog/basic/level_down.hpp:26
        I(CORE_DECISION6, Vss) <+ cpphdl_channel(V(cpphdl_n2772, Vss), V(CORE_DECISION6, Vss), 0.01, 0.34999999999999998, 1.0);
        // device 2297, IC IC385, analog/basic/level_down.hpp:27
        I(cpphdl_n2770, Vss) <+ 5e-15 * ddt(V(cpphdl_n2770, Vss)); // Bench initial voltage = 0.0 V.
        // device 2298, IC IC385, analog/basic/level_down.hpp:28
        I(cpphdl_n2770, Vlogic) <+ 5e-15 * ddt(V(cpphdl_n2770, Vlogic)); // Bench initial voltage = 0.0 V.
        // device 2299, IC IC385, analog/basic/level_down.hpp:29
        I(cpphdl_n2770, cpphdl_n2772) <+ 2.0000000000000002e-15 * ddt(V(cpphdl_n2770, cpphdl_n2772)); // Bench initial voltage = 0.0 V.
        // device 2300, IC IC385, analog/basic/level_down.hpp:30
        I(cpphdl_n2772, Vss) <+ 8e-14 * ddt(V(cpphdl_n2772, Vss)); // Bench initial voltage = 0.0 V.
        // device 2301, IC IC385, analog/basic/level_down.hpp:31
        I(cpphdl_n2772, Vlogic) <+ 5e-15 * ddt(V(cpphdl_n2772, Vlogic)); // Bench initial voltage = 0.0 V.
        // device 2302, IC IC385, analog/basic/level_down.hpp:32
        I(cpphdl_n2772, CORE_DECISION6) <+ 2.0000000000000002e-15 * ddt(V(cpphdl_n2772, CORE_DECISION6)); // Bench initial voltage = 0.0 V.
        // device 2303, IC IC385, analog/basic/level_down.hpp:33
        I(CORE_DECISION6, Vss) <+ 1e-14 * ddt(V(CORE_DECISION6, Vss)); // Bench initial voltage = 0.0 V.
        // device 2304, IC IC386, analog/basic/level_down.hpp:23
        I(cpphdl_n2777, Vlogic) <+ cpphdl_channel(V(Vss, Vlogic), V(cpphdl_n2777, Vlogic), 0.00050000000000000001, 0.34999999999999998, -1.0);
        // device 2305, IC IC386, analog/basic/level_down.hpp:24
        I(cpphdl_n2777, Vss) <+ cpphdl_channel(V(cpphdl_n2775, Vss), V(cpphdl_n2777, Vss), 0.0040000000000000001, 0.69999999999999996, 1.0);
        // device 2306, IC IC386, analog/basic/level_down.hpp:25
        I(CORE_DECISION7, Vlogic) <+ cpphdl_channel(V(cpphdl_n2777, Vlogic), V(CORE_DECISION7, Vlogic), 0.0050000000000000001, 0.34999999999999998, -1.0);
        // device 2307, IC IC386, analog/basic/level_down.hpp:26
        I(CORE_DECISION7, Vss) <+ cpphdl_channel(V(cpphdl_n2777, Vss), V(CORE_DECISION7, Vss), 0.01, 0.34999999999999998, 1.0);
        // device 2308, IC IC386, analog/basic/level_down.hpp:27
        I(cpphdl_n2775, Vss) <+ 5e-15 * ddt(V(cpphdl_n2775, Vss)); // Bench initial voltage = 0.0 V.
        // device 2309, IC IC386, analog/basic/level_down.hpp:28
        I(cpphdl_n2775, Vlogic) <+ 5e-15 * ddt(V(cpphdl_n2775, Vlogic)); // Bench initial voltage = 0.0 V.
        // device 2310, IC IC386, analog/basic/level_down.hpp:29
        I(cpphdl_n2775, cpphdl_n2777) <+ 2.0000000000000002e-15 * ddt(V(cpphdl_n2775, cpphdl_n2777)); // Bench initial voltage = 0.0 V.
        // device 2311, IC IC386, analog/basic/level_down.hpp:30
        I(cpphdl_n2777, Vss) <+ 8e-14 * ddt(V(cpphdl_n2777, Vss)); // Bench initial voltage = 0.0 V.
        // device 2312, IC IC386, analog/basic/level_down.hpp:31
        I(cpphdl_n2777, Vlogic) <+ 5e-15 * ddt(V(cpphdl_n2777, Vlogic)); // Bench initial voltage = 0.0 V.
        // device 2313, IC IC386, analog/basic/level_down.hpp:32
        I(cpphdl_n2777, CORE_DECISION7) <+ 2.0000000000000002e-15 * ddt(V(cpphdl_n2777, CORE_DECISION7)); // Bench initial voltage = 0.0 V.
        // device 2314, IC IC386, analog/basic/level_down.hpp:33
        I(CORE_DECISION7, Vss) <+ 1e-14 * ddt(V(CORE_DECISION7, Vss)); // Bench initial voltage = 0.0 V.
        // device 2315, IC IC387, analog/basic/level_down.hpp:23
        I(cpphdl_n2782, Vlogic) <+ cpphdl_channel(V(Vss, Vlogic), V(cpphdl_n2782, Vlogic), 0.00050000000000000001, 0.34999999999999998, -1.0);
        // device 2316, IC IC387, analog/basic/level_down.hpp:24
        I(cpphdl_n2782, Vss) <+ cpphdl_channel(V(cpphdl_n2780, Vss), V(cpphdl_n2782, Vss), 0.0040000000000000001, 0.69999999999999996, 1.0);
        // device 2317, IC IC387, analog/basic/level_down.hpp:25
        I(CORE_DECISION8, Vlogic) <+ cpphdl_channel(V(cpphdl_n2782, Vlogic), V(CORE_DECISION8, Vlogic), 0.0050000000000000001, 0.34999999999999998, -1.0);
        // device 2318, IC IC387, analog/basic/level_down.hpp:26
        I(CORE_DECISION8, Vss) <+ cpphdl_channel(V(cpphdl_n2782, Vss), V(CORE_DECISION8, Vss), 0.01, 0.34999999999999998, 1.0);
        // device 2319, IC IC387, analog/basic/level_down.hpp:27
        I(cpphdl_n2780, Vss) <+ 5e-15 * ddt(V(cpphdl_n2780, Vss)); // Bench initial voltage = 0.0 V.
        // device 2320, IC IC387, analog/basic/level_down.hpp:28
        I(cpphdl_n2780, Vlogic) <+ 5e-15 * ddt(V(cpphdl_n2780, Vlogic)); // Bench initial voltage = 0.0 V.
        // device 2321, IC IC387, analog/basic/level_down.hpp:29
        I(cpphdl_n2780, cpphdl_n2782) <+ 2.0000000000000002e-15 * ddt(V(cpphdl_n2780, cpphdl_n2782)); // Bench initial voltage = 0.0 V.
        // device 2322, IC IC387, analog/basic/level_down.hpp:30
        I(cpphdl_n2782, Vss) <+ 8e-14 * ddt(V(cpphdl_n2782, Vss)); // Bench initial voltage = 0.0 V.
        // device 2323, IC IC387, analog/basic/level_down.hpp:31
        I(cpphdl_n2782, Vlogic) <+ 5e-15 * ddt(V(cpphdl_n2782, Vlogic)); // Bench initial voltage = 0.0 V.
        // device 2324, IC IC387, analog/basic/level_down.hpp:32
        I(cpphdl_n2782, CORE_DECISION8) <+ 2.0000000000000002e-15 * ddt(V(cpphdl_n2782, CORE_DECISION8)); // Bench initial voltage = 0.0 V.
        // device 2325, IC IC387, analog/basic/level_down.hpp:33
        I(CORE_DECISION8, Vss) <+ 1e-14 * ddt(V(CORE_DECISION8, Vss)); // Bench initial voltage = 0.0 V.
        // device 2326, IC IC388, analog/basic/level_down.hpp:23
        I(cpphdl_n2787, Vlogic) <+ cpphdl_channel(V(Vss, Vlogic), V(cpphdl_n2787, Vlogic), 0.00050000000000000001, 0.34999999999999998, -1.0);
        // device 2327, IC IC388, analog/basic/level_down.hpp:24
        I(cpphdl_n2787, Vss) <+ cpphdl_channel(V(cpphdl_n2785, Vss), V(cpphdl_n2787, Vss), 0.0040000000000000001, 0.69999999999999996, 1.0);
        // device 2328, IC IC388, analog/basic/level_down.hpp:25
        I(CORE_DECISION9, Vlogic) <+ cpphdl_channel(V(cpphdl_n2787, Vlogic), V(CORE_DECISION9, Vlogic), 0.0050000000000000001, 0.34999999999999998, -1.0);
        // device 2329, IC IC388, analog/basic/level_down.hpp:26
        I(CORE_DECISION9, Vss) <+ cpphdl_channel(V(cpphdl_n2787, Vss), V(CORE_DECISION9, Vss), 0.01, 0.34999999999999998, 1.0);
        // device 2330, IC IC388, analog/basic/level_down.hpp:27
        I(cpphdl_n2785, Vss) <+ 5e-15 * ddt(V(cpphdl_n2785, Vss)); // Bench initial voltage = 0.0 V.
        // device 2331, IC IC388, analog/basic/level_down.hpp:28
        I(cpphdl_n2785, Vlogic) <+ 5e-15 * ddt(V(cpphdl_n2785, Vlogic)); // Bench initial voltage = 0.0 V.
        // device 2332, IC IC388, analog/basic/level_down.hpp:29
        I(cpphdl_n2785, cpphdl_n2787) <+ 2.0000000000000002e-15 * ddt(V(cpphdl_n2785, cpphdl_n2787)); // Bench initial voltage = 0.0 V.
        // device 2333, IC IC388, analog/basic/level_down.hpp:30
        I(cpphdl_n2787, Vss) <+ 8e-14 * ddt(V(cpphdl_n2787, Vss)); // Bench initial voltage = 0.0 V.
        // device 2334, IC IC388, analog/basic/level_down.hpp:31
        I(cpphdl_n2787, Vlogic) <+ 5e-15 * ddt(V(cpphdl_n2787, Vlogic)); // Bench initial voltage = 0.0 V.
        // device 2335, IC IC388, analog/basic/level_down.hpp:32
        I(cpphdl_n2787, CORE_DECISION9) <+ 2.0000000000000002e-15 * ddt(V(cpphdl_n2787, CORE_DECISION9)); // Bench initial voltage = 0.0 V.
        // device 2336, IC IC388, analog/basic/level_down.hpp:33
        I(CORE_DECISION9, Vss) <+ 1e-14 * ddt(V(CORE_DECISION9, Vss)); // Bench initial voltage = 0.0 V.
        // device 2337, IC IC389, analog/basic/level_down.hpp:23
        I(cpphdl_n2792, Vlogic) <+ cpphdl_channel(V(Vss, Vlogic), V(cpphdl_n2792, Vlogic), 0.00050000000000000001, 0.34999999999999998, -1.0);
        // device 2338, IC IC389, analog/basic/level_down.hpp:24
        I(cpphdl_n2792, Vss) <+ cpphdl_channel(V(cpphdl_n2790, Vss), V(cpphdl_n2792, Vss), 0.0040000000000000001, 0.69999999999999996, 1.0);
        // device 2339, IC IC389, analog/basic/level_down.hpp:25
        I(CORE_DECISION10, Vlogic) <+ cpphdl_channel(V(cpphdl_n2792, Vlogic), V(CORE_DECISION10, Vlogic), 0.0050000000000000001, 0.34999999999999998, -1.0);
        // device 2340, IC IC389, analog/basic/level_down.hpp:26
        I(CORE_DECISION10, Vss) <+ cpphdl_channel(V(cpphdl_n2792, Vss), V(CORE_DECISION10, Vss), 0.01, 0.34999999999999998, 1.0);
        // device 2341, IC IC389, analog/basic/level_down.hpp:27
        I(cpphdl_n2790, Vss) <+ 5e-15 * ddt(V(cpphdl_n2790, Vss)); // Bench initial voltage = 0.0 V.
        // device 2342, IC IC389, analog/basic/level_down.hpp:28
        I(cpphdl_n2790, Vlogic) <+ 5e-15 * ddt(V(cpphdl_n2790, Vlogic)); // Bench initial voltage = 0.0 V.
        // device 2343, IC IC389, analog/basic/level_down.hpp:29
        I(cpphdl_n2790, cpphdl_n2792) <+ 2.0000000000000002e-15 * ddt(V(cpphdl_n2790, cpphdl_n2792)); // Bench initial voltage = 0.0 V.
        // device 2344, IC IC389, analog/basic/level_down.hpp:30
        I(cpphdl_n2792, Vss) <+ 8e-14 * ddt(V(cpphdl_n2792, Vss)); // Bench initial voltage = 0.0 V.
        // device 2345, IC IC389, analog/basic/level_down.hpp:31
        I(cpphdl_n2792, Vlogic) <+ 5e-15 * ddt(V(cpphdl_n2792, Vlogic)); // Bench initial voltage = 0.0 V.
        // device 2346, IC IC389, analog/basic/level_down.hpp:32
        I(cpphdl_n2792, CORE_DECISION10) <+ 2.0000000000000002e-15 * ddt(V(cpphdl_n2792, CORE_DECISION10)); // Bench initial voltage = 0.0 V.
        // device 2347, IC IC389, analog/basic/level_down.hpp:33
        I(CORE_DECISION10, Vss) <+ 1e-14 * ddt(V(CORE_DECISION10, Vss)); // Bench initial voltage = 0.0 V.
        // device 2348, IC IC390, analog/basic/level_down.hpp:23
        I(cpphdl_n2797, Vlogic) <+ cpphdl_channel(V(Vss, Vlogic), V(cpphdl_n2797, Vlogic), 0.00050000000000000001, 0.34999999999999998, -1.0);
        // device 2349, IC IC390, analog/basic/level_down.hpp:24
        I(cpphdl_n2797, Vss) <+ cpphdl_channel(V(cpphdl_n2795, Vss), V(cpphdl_n2797, Vss), 0.0040000000000000001, 0.69999999999999996, 1.0);
        // device 2350, IC IC390, analog/basic/level_down.hpp:25
        I(CORE_DECISION11, Vlogic) <+ cpphdl_channel(V(cpphdl_n2797, Vlogic), V(CORE_DECISION11, Vlogic), 0.0050000000000000001, 0.34999999999999998, -1.0);
        // device 2351, IC IC390, analog/basic/level_down.hpp:26
        I(CORE_DECISION11, Vss) <+ cpphdl_channel(V(cpphdl_n2797, Vss), V(CORE_DECISION11, Vss), 0.01, 0.34999999999999998, 1.0);
        // device 2352, IC IC390, analog/basic/level_down.hpp:27
        I(cpphdl_n2795, Vss) <+ 5e-15 * ddt(V(cpphdl_n2795, Vss)); // Bench initial voltage = 0.0 V.
        // device 2353, IC IC390, analog/basic/level_down.hpp:28
        I(cpphdl_n2795, Vlogic) <+ 5e-15 * ddt(V(cpphdl_n2795, Vlogic)); // Bench initial voltage = 0.0 V.
        // device 2354, IC IC390, analog/basic/level_down.hpp:29
        I(cpphdl_n2795, cpphdl_n2797) <+ 2.0000000000000002e-15 * ddt(V(cpphdl_n2795, cpphdl_n2797)); // Bench initial voltage = 0.0 V.
        // device 2355, IC IC390, analog/basic/level_down.hpp:30
        I(cpphdl_n2797, Vss) <+ 8e-14 * ddt(V(cpphdl_n2797, Vss)); // Bench initial voltage = 0.0 V.
        // device 2356, IC IC390, analog/basic/level_down.hpp:31
        I(cpphdl_n2797, Vlogic) <+ 5e-15 * ddt(V(cpphdl_n2797, Vlogic)); // Bench initial voltage = 0.0 V.
        // device 2357, IC IC390, analog/basic/level_down.hpp:32
        I(cpphdl_n2797, CORE_DECISION11) <+ 2.0000000000000002e-15 * ddt(V(cpphdl_n2797, CORE_DECISION11)); // Bench initial voltage = 0.0 V.
        // device 2358, IC IC390, analog/basic/level_down.hpp:33
        I(CORE_DECISION11, Vss) <+ 1e-14 * ddt(V(CORE_DECISION11, Vss)); // Bench initial voltage = 0.0 V.
        // device 2359, IC IC391, analog/basic/level_down.hpp:23
        I(cpphdl_n2802, Vlogic) <+ cpphdl_channel(V(Vss, Vlogic), V(cpphdl_n2802, Vlogic), 0.00050000000000000001, 0.34999999999999998, -1.0);
        // device 2360, IC IC391, analog/basic/level_down.hpp:24
        I(cpphdl_n2802, Vss) <+ cpphdl_channel(V(cpphdl_n2800, Vss), V(cpphdl_n2802, Vss), 0.0040000000000000001, 0.69999999999999996, 1.0);
        // device 2361, IC IC391, analog/basic/level_down.hpp:25
        I(CORE_DECISION12, Vlogic) <+ cpphdl_channel(V(cpphdl_n2802, Vlogic), V(CORE_DECISION12, Vlogic), 0.0050000000000000001, 0.34999999999999998, -1.0);
        // device 2362, IC IC391, analog/basic/level_down.hpp:26
        I(CORE_DECISION12, Vss) <+ cpphdl_channel(V(cpphdl_n2802, Vss), V(CORE_DECISION12, Vss), 0.01, 0.34999999999999998, 1.0);
        // device 2363, IC IC391, analog/basic/level_down.hpp:27
        I(cpphdl_n2800, Vss) <+ 5e-15 * ddt(V(cpphdl_n2800, Vss)); // Bench initial voltage = 0.0 V.
        // device 2364, IC IC391, analog/basic/level_down.hpp:28
        I(cpphdl_n2800, Vlogic) <+ 5e-15 * ddt(V(cpphdl_n2800, Vlogic)); // Bench initial voltage = 0.0 V.
        // device 2365, IC IC391, analog/basic/level_down.hpp:29
        I(cpphdl_n2800, cpphdl_n2802) <+ 2.0000000000000002e-15 * ddt(V(cpphdl_n2800, cpphdl_n2802)); // Bench initial voltage = 0.0 V.
        // device 2366, IC IC391, analog/basic/level_down.hpp:30
        I(cpphdl_n2802, Vss) <+ 8e-14 * ddt(V(cpphdl_n2802, Vss)); // Bench initial voltage = 0.0 V.
        // device 2367, IC IC391, analog/basic/level_down.hpp:31
        I(cpphdl_n2802, Vlogic) <+ 5e-15 * ddt(V(cpphdl_n2802, Vlogic)); // Bench initial voltage = 0.0 V.
        // device 2368, IC IC391, analog/basic/level_down.hpp:32
        I(cpphdl_n2802, CORE_DECISION12) <+ 2.0000000000000002e-15 * ddt(V(cpphdl_n2802, CORE_DECISION12)); // Bench initial voltage = 0.0 V.
        // device 2369, IC IC391, analog/basic/level_down.hpp:33
        I(CORE_DECISION12, Vss) <+ 1e-14 * ddt(V(CORE_DECISION12, Vss)); // Bench initial voltage = 0.0 V.
        // device 2370, IC IC392, analog/basic/level_down.hpp:23
        I(cpphdl_n2807, Vlogic) <+ cpphdl_channel(V(Vss, Vlogic), V(cpphdl_n2807, Vlogic), 0.00050000000000000001, 0.34999999999999998, -1.0);
        // device 2371, IC IC392, analog/basic/level_down.hpp:24
        I(cpphdl_n2807, Vss) <+ cpphdl_channel(V(cpphdl_n2805, Vss), V(cpphdl_n2807, Vss), 0.0040000000000000001, 0.69999999999999996, 1.0);
        // device 2372, IC IC392, analog/basic/level_down.hpp:25
        I(CORE_DECISION13, Vlogic) <+ cpphdl_channel(V(cpphdl_n2807, Vlogic), V(CORE_DECISION13, Vlogic), 0.0050000000000000001, 0.34999999999999998, -1.0);
        // device 2373, IC IC392, analog/basic/level_down.hpp:26
        I(CORE_DECISION13, Vss) <+ cpphdl_channel(V(cpphdl_n2807, Vss), V(CORE_DECISION13, Vss), 0.01, 0.34999999999999998, 1.0);
        // device 2374, IC IC392, analog/basic/level_down.hpp:27
        I(cpphdl_n2805, Vss) <+ 5e-15 * ddt(V(cpphdl_n2805, Vss)); // Bench initial voltage = 0.0 V.
        // device 2375, IC IC392, analog/basic/level_down.hpp:28
        I(cpphdl_n2805, Vlogic) <+ 5e-15 * ddt(V(cpphdl_n2805, Vlogic)); // Bench initial voltage = 0.0 V.
        // device 2376, IC IC392, analog/basic/level_down.hpp:29
        I(cpphdl_n2805, cpphdl_n2807) <+ 2.0000000000000002e-15 * ddt(V(cpphdl_n2805, cpphdl_n2807)); // Bench initial voltage = 0.0 V.
        // device 2377, IC IC392, analog/basic/level_down.hpp:30
        I(cpphdl_n2807, Vss) <+ 8e-14 * ddt(V(cpphdl_n2807, Vss)); // Bench initial voltage = 0.0 V.
        // device 2378, IC IC392, analog/basic/level_down.hpp:31
        I(cpphdl_n2807, Vlogic) <+ 5e-15 * ddt(V(cpphdl_n2807, Vlogic)); // Bench initial voltage = 0.0 V.
        // device 2379, IC IC392, analog/basic/level_down.hpp:32
        I(cpphdl_n2807, CORE_DECISION13) <+ 2.0000000000000002e-15 * ddt(V(cpphdl_n2807, CORE_DECISION13)); // Bench initial voltage = 0.0 V.
        // device 2380, IC IC392, analog/basic/level_down.hpp:33
        I(CORE_DECISION13, Vss) <+ 1e-14 * ddt(V(CORE_DECISION13, Vss)); // Bench initial voltage = 0.0 V.
        // device 2381, IC IC393, analog/basic/level_down.hpp:23
        I(cpphdl_n2812, Vlogic) <+ cpphdl_channel(V(Vss, Vlogic), V(cpphdl_n2812, Vlogic), 0.00050000000000000001, 0.34999999999999998, -1.0);
        // device 2382, IC IC393, analog/basic/level_down.hpp:24
        I(cpphdl_n2812, Vss) <+ cpphdl_channel(V(cpphdl_n2810, Vss), V(cpphdl_n2812, Vss), 0.0040000000000000001, 0.69999999999999996, 1.0);
        // device 2383, IC IC393, analog/basic/level_down.hpp:25
        I(CORE_DECISION14, Vlogic) <+ cpphdl_channel(V(cpphdl_n2812, Vlogic), V(CORE_DECISION14, Vlogic), 0.0050000000000000001, 0.34999999999999998, -1.0);
        // device 2384, IC IC393, analog/basic/level_down.hpp:26
        I(CORE_DECISION14, Vss) <+ cpphdl_channel(V(cpphdl_n2812, Vss), V(CORE_DECISION14, Vss), 0.01, 0.34999999999999998, 1.0);
        // device 2385, IC IC393, analog/basic/level_down.hpp:27
        I(cpphdl_n2810, Vss) <+ 5e-15 * ddt(V(cpphdl_n2810, Vss)); // Bench initial voltage = 0.0 V.
        // device 2386, IC IC393, analog/basic/level_down.hpp:28
        I(cpphdl_n2810, Vlogic) <+ 5e-15 * ddt(V(cpphdl_n2810, Vlogic)); // Bench initial voltage = 0.0 V.
        // device 2387, IC IC393, analog/basic/level_down.hpp:29
        I(cpphdl_n2810, cpphdl_n2812) <+ 2.0000000000000002e-15 * ddt(V(cpphdl_n2810, cpphdl_n2812)); // Bench initial voltage = 0.0 V.
        // device 2388, IC IC393, analog/basic/level_down.hpp:30
        I(cpphdl_n2812, Vss) <+ 8e-14 * ddt(V(cpphdl_n2812, Vss)); // Bench initial voltage = 0.0 V.
        // device 2389, IC IC393, analog/basic/level_down.hpp:31
        I(cpphdl_n2812, Vlogic) <+ 5e-15 * ddt(V(cpphdl_n2812, Vlogic)); // Bench initial voltage = 0.0 V.
        // device 2390, IC IC393, analog/basic/level_down.hpp:32
        I(cpphdl_n2812, CORE_DECISION14) <+ 2.0000000000000002e-15 * ddt(V(cpphdl_n2812, CORE_DECISION14)); // Bench initial voltage = 0.0 V.
        // device 2391, IC IC393, analog/basic/level_down.hpp:33
        I(CORE_DECISION14, Vss) <+ 1e-14 * ddt(V(CORE_DECISION14, Vss)); // Bench initial voltage = 0.0 V.
        // device 2392, IC IC394, analog/basic/level_down.hpp:23
        I(cpphdl_n2817, Vlogic) <+ cpphdl_channel(V(Vss, Vlogic), V(cpphdl_n2817, Vlogic), 0.00050000000000000001, 0.34999999999999998, -1.0);
        // device 2393, IC IC394, analog/basic/level_down.hpp:24
        I(cpphdl_n2817, Vss) <+ cpphdl_channel(V(cpphdl_n2815, Vss), V(cpphdl_n2817, Vss), 0.0040000000000000001, 0.69999999999999996, 1.0);
        // device 2394, IC IC394, analog/basic/level_down.hpp:25
        I(CORE_DECISION15, Vlogic) <+ cpphdl_channel(V(cpphdl_n2817, Vlogic), V(CORE_DECISION15, Vlogic), 0.0050000000000000001, 0.34999999999999998, -1.0);
        // device 2395, IC IC394, analog/basic/level_down.hpp:26
        I(CORE_DECISION15, Vss) <+ cpphdl_channel(V(cpphdl_n2817, Vss), V(CORE_DECISION15, Vss), 0.01, 0.34999999999999998, 1.0);
        // device 2396, IC IC394, analog/basic/level_down.hpp:27
        I(cpphdl_n2815, Vss) <+ 5e-15 * ddt(V(cpphdl_n2815, Vss)); // Bench initial voltage = 0.0 V.
        // device 2397, IC IC394, analog/basic/level_down.hpp:28
        I(cpphdl_n2815, Vlogic) <+ 5e-15 * ddt(V(cpphdl_n2815, Vlogic)); // Bench initial voltage = 0.0 V.
        // device 2398, IC IC394, analog/basic/level_down.hpp:29
        I(cpphdl_n2815, cpphdl_n2817) <+ 2.0000000000000002e-15 * ddt(V(cpphdl_n2815, cpphdl_n2817)); // Bench initial voltage = 0.0 V.
        // device 2399, IC IC394, analog/basic/level_down.hpp:30
        I(cpphdl_n2817, Vss) <+ 8e-14 * ddt(V(cpphdl_n2817, Vss)); // Bench initial voltage = 0.0 V.
        // device 2400, IC IC394, analog/basic/level_down.hpp:31
        I(cpphdl_n2817, Vlogic) <+ 5e-15 * ddt(V(cpphdl_n2817, Vlogic)); // Bench initial voltage = 0.0 V.
        // device 2401, IC IC394, analog/basic/level_down.hpp:32
        I(cpphdl_n2817, CORE_DECISION15) <+ 2.0000000000000002e-15 * ddt(V(cpphdl_n2817, CORE_DECISION15)); // Bench initial voltage = 0.0 V.
        // device 2402, IC IC394, analog/basic/level_down.hpp:33
        I(CORE_DECISION15, Vss) <+ 1e-14 * ddt(V(CORE_DECISION15, Vss)); // Bench initial voltage = 0.0 V.
    end
endmodule
