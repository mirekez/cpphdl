// SIMULATION APPROXIMATION: controlled conductances are not physical MOS devices.
// Generated from elaborated C++HDL IC purposes; all contributions coexist.
// Capacitor initialization belongs to the host analysis; declared initial voltages appear below.
`include "disciplines.vams"

module OneGIHPMDIReceiveFrontend(Vdd, Vss, Vlogic, PLUS, MINUS, EVALUATE, CLEAR, TRACK0, CORE_DECISION0, BIT_N0_0, BIT_N0_1, BIT_N0_2, BIT_N0_3, BIT_N0_4, BIT_N0_5, BIT_N0_6, BIT_N0_7, TRACK1, CORE_DECISION1, BIT_N1_0, BIT_N1_1, BIT_N1_2, BIT_N1_3, BIT_N1_4, BIT_N1_5, BIT_N1_6, BIT_N1_7, TRACK2, CORE_DECISION2, BIT_N2_0, BIT_N2_1, BIT_N2_2, BIT_N2_3, BIT_N2_4, BIT_N2_5, BIT_N2_6, BIT_N2_7, TRACK3, CORE_DECISION3, BIT_N3_0, BIT_N3_1, BIT_N3_2, BIT_N3_3, BIT_N3_4, BIT_N3_5, BIT_N3_6, BIT_N3_7, TRACK4, CORE_DECISION4, BIT_N4_0, BIT_N4_1, BIT_N4_2, BIT_N4_3, BIT_N4_4, BIT_N4_5, BIT_N4_6, BIT_N4_7, TRACK5, CORE_DECISION5, BIT_N5_0, BIT_N5_1, BIT_N5_2, BIT_N5_3, BIT_N5_4, BIT_N5_5, BIT_N5_6, BIT_N5_7, TRACK6, CORE_DECISION6, BIT_N6_0, BIT_N6_1, BIT_N6_2, BIT_N6_3, BIT_N6_4, BIT_N6_5, BIT_N6_6, BIT_N6_7, TRACK7, CORE_DECISION7, BIT_N7_0, BIT_N7_1, BIT_N7_2, BIT_N7_3, BIT_N7_4, BIT_N7_5, BIT_N7_6, BIT_N7_7, TRACK8, CORE_DECISION8, BIT_N8_0, BIT_N8_1, BIT_N8_2, BIT_N8_3, BIT_N8_4, BIT_N8_5, BIT_N8_6, BIT_N8_7, TRACK9, CORE_DECISION9, BIT_N9_0, BIT_N9_1, BIT_N9_2, BIT_N9_3, BIT_N9_4, BIT_N9_5, BIT_N9_6, BIT_N9_7, TRACK10, CORE_DECISION10, BIT_N10_0, BIT_N10_1, BIT_N10_2, BIT_N10_3, BIT_N10_4, BIT_N10_5, BIT_N10_6, BIT_N10_7, TRACK11, CORE_DECISION11, BIT_N11_0, BIT_N11_1, BIT_N11_2, BIT_N11_3, BIT_N11_4, BIT_N11_5, BIT_N11_6, BIT_N11_7, TRACK12, CORE_DECISION12, BIT_N12_0, BIT_N12_1, BIT_N12_2, BIT_N12_3, BIT_N12_4, BIT_N12_5, BIT_N12_6, BIT_N12_7, TRACK13, CORE_DECISION13, BIT_N13_0, BIT_N13_1, BIT_N13_2, BIT_N13_3, BIT_N13_4, BIT_N13_5, BIT_N13_6, BIT_N13_7, TRACK14, CORE_DECISION14, BIT_N14_0, BIT_N14_1, BIT_N14_2, BIT_N14_3, BIT_N14_4, BIT_N14_5, BIT_N14_6, BIT_N14_7, TRACK15, CORE_DECISION15, BIT_N15_0, BIT_N15_1, BIT_N15_2, BIT_N15_3, BIT_N15_4, BIT_N15_5, BIT_N15_6, BIT_N15_7);
    inout Vdd, Vss, Vlogic, PLUS, MINUS, EVALUATE, CLEAR, TRACK0, CORE_DECISION0, BIT_N0_0, BIT_N0_1, BIT_N0_2, BIT_N0_3, BIT_N0_4, BIT_N0_5, BIT_N0_6, BIT_N0_7, TRACK1, CORE_DECISION1, BIT_N1_0, BIT_N1_1, BIT_N1_2, BIT_N1_3, BIT_N1_4, BIT_N1_5, BIT_N1_6, BIT_N1_7, TRACK2, CORE_DECISION2, BIT_N2_0, BIT_N2_1, BIT_N2_2, BIT_N2_3, BIT_N2_4, BIT_N2_5, BIT_N2_6, BIT_N2_7, TRACK3, CORE_DECISION3, BIT_N3_0, BIT_N3_1, BIT_N3_2, BIT_N3_3, BIT_N3_4, BIT_N3_5, BIT_N3_6, BIT_N3_7, TRACK4, CORE_DECISION4, BIT_N4_0, BIT_N4_1, BIT_N4_2, BIT_N4_3, BIT_N4_4, BIT_N4_5, BIT_N4_6, BIT_N4_7, TRACK5, CORE_DECISION5, BIT_N5_0, BIT_N5_1, BIT_N5_2, BIT_N5_3, BIT_N5_4, BIT_N5_5, BIT_N5_6, BIT_N5_7, TRACK6, CORE_DECISION6, BIT_N6_0, BIT_N6_1, BIT_N6_2, BIT_N6_3, BIT_N6_4, BIT_N6_5, BIT_N6_6, BIT_N6_7, TRACK7, CORE_DECISION7, BIT_N7_0, BIT_N7_1, BIT_N7_2, BIT_N7_3, BIT_N7_4, BIT_N7_5, BIT_N7_6, BIT_N7_7, TRACK8, CORE_DECISION8, BIT_N8_0, BIT_N8_1, BIT_N8_2, BIT_N8_3, BIT_N8_4, BIT_N8_5, BIT_N8_6, BIT_N8_7, TRACK9, CORE_DECISION9, BIT_N9_0, BIT_N9_1, BIT_N9_2, BIT_N9_3, BIT_N9_4, BIT_N9_5, BIT_N9_6, BIT_N9_7, TRACK10, CORE_DECISION10, BIT_N10_0, BIT_N10_1, BIT_N10_2, BIT_N10_3, BIT_N10_4, BIT_N10_5, BIT_N10_6, BIT_N10_7, TRACK11, CORE_DECISION11, BIT_N11_0, BIT_N11_1, BIT_N11_2, BIT_N11_3, BIT_N11_4, BIT_N11_5, BIT_N11_6, BIT_N11_7, TRACK12, CORE_DECISION12, BIT_N12_0, BIT_N12_1, BIT_N12_2, BIT_N12_3, BIT_N12_4, BIT_N12_5, BIT_N12_6, BIT_N12_7, TRACK13, CORE_DECISION13, BIT_N13_0, BIT_N13_1, BIT_N13_2, BIT_N13_3, BIT_N13_4, BIT_N13_5, BIT_N13_6, BIT_N13_7, TRACK14, CORE_DECISION14, BIT_N14_0, BIT_N14_1, BIT_N14_2, BIT_N14_3, BIT_N14_4, BIT_N14_5, BIT_N14_6, BIT_N14_7, TRACK15, CORE_DECISION15, BIT_N15_0, BIT_N15_1, BIT_N15_2, BIT_N15_3, BIT_N15_4, BIT_N15_5, BIT_N15_6, BIT_N15_7;
    electrical Vdd, Vss, Vlogic, PLUS, MINUS, EVALUATE, CLEAR, TRACK0, CORE_DECISION0, BIT_N0_0, BIT_N0_1, BIT_N0_2, BIT_N0_3, BIT_N0_4, BIT_N0_5, BIT_N0_6, BIT_N0_7, TRACK1, CORE_DECISION1, BIT_N1_0, BIT_N1_1, BIT_N1_2, BIT_N1_3, BIT_N1_4, BIT_N1_5, BIT_N1_6, BIT_N1_7, TRACK2, CORE_DECISION2, BIT_N2_0, BIT_N2_1, BIT_N2_2, BIT_N2_3, BIT_N2_4, BIT_N2_5, BIT_N2_6, BIT_N2_7, TRACK3, CORE_DECISION3, BIT_N3_0, BIT_N3_1, BIT_N3_2, BIT_N3_3, BIT_N3_4, BIT_N3_5, BIT_N3_6, BIT_N3_7, TRACK4, CORE_DECISION4, BIT_N4_0, BIT_N4_1, BIT_N4_2, BIT_N4_3, BIT_N4_4, BIT_N4_5, BIT_N4_6, BIT_N4_7, TRACK5, CORE_DECISION5, BIT_N5_0, BIT_N5_1, BIT_N5_2, BIT_N5_3, BIT_N5_4, BIT_N5_5, BIT_N5_6, BIT_N5_7, TRACK6, CORE_DECISION6, BIT_N6_0, BIT_N6_1, BIT_N6_2, BIT_N6_3, BIT_N6_4, BIT_N6_5, BIT_N6_6, BIT_N6_7, TRACK7, CORE_DECISION7, BIT_N7_0, BIT_N7_1, BIT_N7_2, BIT_N7_3, BIT_N7_4, BIT_N7_5, BIT_N7_6, BIT_N7_7, TRACK8, CORE_DECISION8, BIT_N8_0, BIT_N8_1, BIT_N8_2, BIT_N8_3, BIT_N8_4, BIT_N8_5, BIT_N8_6, BIT_N8_7, TRACK9, CORE_DECISION9, BIT_N9_0, BIT_N9_1, BIT_N9_2, BIT_N9_3, BIT_N9_4, BIT_N9_5, BIT_N9_6, BIT_N9_7, TRACK10, CORE_DECISION10, BIT_N10_0, BIT_N10_1, BIT_N10_2, BIT_N10_3, BIT_N10_4, BIT_N10_5, BIT_N10_6, BIT_N10_7, TRACK11, CORE_DECISION11, BIT_N11_0, BIT_N11_1, BIT_N11_2, BIT_N11_3, BIT_N11_4, BIT_N11_5, BIT_N11_6, BIT_N11_7, TRACK12, CORE_DECISION12, BIT_N12_0, BIT_N12_1, BIT_N12_2, BIT_N12_3, BIT_N12_4, BIT_N12_5, BIT_N12_6, BIT_N12_7, TRACK13, CORE_DECISION13, BIT_N13_0, BIT_N13_1, BIT_N13_2, BIT_N13_3, BIT_N13_4, BIT_N13_5, BIT_N13_6, BIT_N13_7, TRACK14, CORE_DECISION14, BIT_N14_0, BIT_N14_1, BIT_N14_2, BIT_N14_3, BIT_N14_4, BIT_N14_5, BIT_N14_6, BIT_N14_7, TRACK15, CORE_DECISION15, BIT_N15_0, BIT_N15_1, BIT_N15_2, BIT_N15_3, BIT_N15_4, BIT_N15_5, BIT_N15_6, BIT_N15_7;
    electrical cpphdl_n351;
    electrical cpphdl_n352;
    electrical cpphdl_n354;
    electrical cpphdl_n355;
    electrical cpphdl_n356;
    electrical cpphdl_n357;
    electrical cpphdl_n360;
    electrical cpphdl_n566;
    electrical cpphdl_n581;
    electrical cpphdl_n585;
    electrical cpphdl_n589;
    electrical cpphdl_n593;
    electrical cpphdl_n597;
    electrical cpphdl_n601;
    electrical cpphdl_n605;
    electrical cpphdl_n609;
    electrical cpphdl_n610;
    electrical cpphdl_n611;
    electrical cpphdl_n612;
    electrical cpphdl_n613;
    electrical cpphdl_n614;
    electrical cpphdl_n615;
    electrical cpphdl_n616;
    electrical cpphdl_n620;
    electrical cpphdl_n621;
    electrical cpphdl_n624;
    electrical cpphdl_n625;
    electrical cpphdl_n626;
    electrical cpphdl_n629;
    electrical cpphdl_n630;
    electrical cpphdl_n634;
    electrical cpphdl_n635;
    electrical cpphdl_n636;
    electrical cpphdl_n649;
    electrical cpphdl_n653;
    electrical cpphdl_n657;
    electrical cpphdl_n661;
    electrical cpphdl_n671;
    electrical cpphdl_n674;
    electrical cpphdl_n677;
    electrical cpphdl_n679;
    electrical cpphdl_n680;
    electrical cpphdl_n685;
    electrical cpphdl_n709;
    electrical cpphdl_n724;
    electrical cpphdl_n728;
    electrical cpphdl_n732;
    electrical cpphdl_n736;
    electrical cpphdl_n740;
    electrical cpphdl_n744;
    electrical cpphdl_n748;
    electrical cpphdl_n752;
    electrical cpphdl_n753;
    electrical cpphdl_n754;
    electrical cpphdl_n755;
    electrical cpphdl_n756;
    electrical cpphdl_n757;
    electrical cpphdl_n758;
    electrical cpphdl_n759;
    electrical cpphdl_n763;
    electrical cpphdl_n764;
    electrical cpphdl_n767;
    electrical cpphdl_n768;
    electrical cpphdl_n769;
    electrical cpphdl_n772;
    electrical cpphdl_n773;
    electrical cpphdl_n777;
    electrical cpphdl_n778;
    electrical cpphdl_n779;
    electrical cpphdl_n792;
    electrical cpphdl_n796;
    electrical cpphdl_n800;
    electrical cpphdl_n804;
    electrical cpphdl_n814;
    electrical cpphdl_n817;
    electrical cpphdl_n820;
    electrical cpphdl_n822;
    electrical cpphdl_n823;
    electrical cpphdl_n828;
    electrical cpphdl_n852;
    electrical cpphdl_n867;
    electrical cpphdl_n871;
    electrical cpphdl_n875;
    electrical cpphdl_n879;
    electrical cpphdl_n883;
    electrical cpphdl_n887;
    electrical cpphdl_n891;
    electrical cpphdl_n895;
    electrical cpphdl_n896;
    electrical cpphdl_n897;
    electrical cpphdl_n898;
    electrical cpphdl_n899;
    electrical cpphdl_n900;
    electrical cpphdl_n901;
    electrical cpphdl_n902;
    electrical cpphdl_n906;
    electrical cpphdl_n907;
    electrical cpphdl_n910;
    electrical cpphdl_n911;
    electrical cpphdl_n912;
    electrical cpphdl_n915;
    electrical cpphdl_n916;
    electrical cpphdl_n920;
    electrical cpphdl_n921;
    electrical cpphdl_n922;
    electrical cpphdl_n935;
    electrical cpphdl_n939;
    electrical cpphdl_n943;
    electrical cpphdl_n947;
    electrical cpphdl_n957;
    electrical cpphdl_n960;
    electrical cpphdl_n963;
    electrical cpphdl_n965;
    electrical cpphdl_n966;
    electrical cpphdl_n971;
    electrical cpphdl_n995;
    electrical cpphdl_n1010;
    electrical cpphdl_n1014;
    electrical cpphdl_n1018;
    electrical cpphdl_n1022;
    electrical cpphdl_n1026;
    electrical cpphdl_n1030;
    electrical cpphdl_n1034;
    electrical cpphdl_n1038;
    electrical cpphdl_n1039;
    electrical cpphdl_n1040;
    electrical cpphdl_n1041;
    electrical cpphdl_n1042;
    electrical cpphdl_n1043;
    electrical cpphdl_n1044;
    electrical cpphdl_n1045;
    electrical cpphdl_n1049;
    electrical cpphdl_n1050;
    electrical cpphdl_n1053;
    electrical cpphdl_n1054;
    electrical cpphdl_n1055;
    electrical cpphdl_n1058;
    electrical cpphdl_n1059;
    electrical cpphdl_n1063;
    electrical cpphdl_n1064;
    electrical cpphdl_n1065;
    electrical cpphdl_n1078;
    electrical cpphdl_n1082;
    electrical cpphdl_n1086;
    electrical cpphdl_n1090;
    electrical cpphdl_n1100;
    electrical cpphdl_n1103;
    electrical cpphdl_n1106;
    electrical cpphdl_n1108;
    electrical cpphdl_n1109;
    electrical cpphdl_n1114;
    electrical cpphdl_n1138;
    electrical cpphdl_n1153;
    electrical cpphdl_n1157;
    electrical cpphdl_n1161;
    electrical cpphdl_n1165;
    electrical cpphdl_n1169;
    electrical cpphdl_n1173;
    electrical cpphdl_n1177;
    electrical cpphdl_n1181;
    electrical cpphdl_n1182;
    electrical cpphdl_n1183;
    electrical cpphdl_n1184;
    electrical cpphdl_n1185;
    electrical cpphdl_n1186;
    electrical cpphdl_n1187;
    electrical cpphdl_n1188;
    electrical cpphdl_n1192;
    electrical cpphdl_n1193;
    electrical cpphdl_n1196;
    electrical cpphdl_n1197;
    electrical cpphdl_n1198;
    electrical cpphdl_n1201;
    electrical cpphdl_n1202;
    electrical cpphdl_n1206;
    electrical cpphdl_n1207;
    electrical cpphdl_n1208;
    electrical cpphdl_n1221;
    electrical cpphdl_n1225;
    electrical cpphdl_n1229;
    electrical cpphdl_n1233;
    electrical cpphdl_n1243;
    electrical cpphdl_n1246;
    electrical cpphdl_n1249;
    electrical cpphdl_n1251;
    electrical cpphdl_n1252;
    electrical cpphdl_n1257;
    electrical cpphdl_n1281;
    electrical cpphdl_n1296;
    electrical cpphdl_n1300;
    electrical cpphdl_n1304;
    electrical cpphdl_n1308;
    electrical cpphdl_n1312;
    electrical cpphdl_n1316;
    electrical cpphdl_n1320;
    electrical cpphdl_n1324;
    electrical cpphdl_n1325;
    electrical cpphdl_n1326;
    electrical cpphdl_n1327;
    electrical cpphdl_n1328;
    electrical cpphdl_n1329;
    electrical cpphdl_n1330;
    electrical cpphdl_n1331;
    electrical cpphdl_n1335;
    electrical cpphdl_n1336;
    electrical cpphdl_n1339;
    electrical cpphdl_n1340;
    electrical cpphdl_n1341;
    electrical cpphdl_n1344;
    electrical cpphdl_n1345;
    electrical cpphdl_n1349;
    electrical cpphdl_n1350;
    electrical cpphdl_n1351;
    electrical cpphdl_n1364;
    electrical cpphdl_n1368;
    electrical cpphdl_n1372;
    electrical cpphdl_n1376;
    electrical cpphdl_n1386;
    electrical cpphdl_n1389;
    electrical cpphdl_n1392;
    electrical cpphdl_n1394;
    electrical cpphdl_n1395;
    electrical cpphdl_n1400;
    electrical cpphdl_n1424;
    electrical cpphdl_n1439;
    electrical cpphdl_n1443;
    electrical cpphdl_n1447;
    electrical cpphdl_n1451;
    electrical cpphdl_n1455;
    electrical cpphdl_n1459;
    electrical cpphdl_n1463;
    electrical cpphdl_n1467;
    electrical cpphdl_n1468;
    electrical cpphdl_n1469;
    electrical cpphdl_n1470;
    electrical cpphdl_n1471;
    electrical cpphdl_n1472;
    electrical cpphdl_n1473;
    electrical cpphdl_n1474;
    electrical cpphdl_n1478;
    electrical cpphdl_n1479;
    electrical cpphdl_n1482;
    electrical cpphdl_n1483;
    electrical cpphdl_n1484;
    electrical cpphdl_n1487;
    electrical cpphdl_n1488;
    electrical cpphdl_n1492;
    electrical cpphdl_n1493;
    electrical cpphdl_n1494;
    electrical cpphdl_n1507;
    electrical cpphdl_n1511;
    electrical cpphdl_n1515;
    electrical cpphdl_n1519;
    electrical cpphdl_n1529;
    electrical cpphdl_n1532;
    electrical cpphdl_n1535;
    electrical cpphdl_n1537;
    electrical cpphdl_n1538;
    electrical cpphdl_n1543;
    electrical cpphdl_n1567;
    electrical cpphdl_n1582;
    electrical cpphdl_n1586;
    electrical cpphdl_n1590;
    electrical cpphdl_n1594;
    electrical cpphdl_n1598;
    electrical cpphdl_n1602;
    electrical cpphdl_n1606;
    electrical cpphdl_n1610;
    electrical cpphdl_n1611;
    electrical cpphdl_n1612;
    electrical cpphdl_n1613;
    electrical cpphdl_n1614;
    electrical cpphdl_n1615;
    electrical cpphdl_n1616;
    electrical cpphdl_n1617;
    electrical cpphdl_n1621;
    electrical cpphdl_n1622;
    electrical cpphdl_n1625;
    electrical cpphdl_n1626;
    electrical cpphdl_n1627;
    electrical cpphdl_n1630;
    electrical cpphdl_n1631;
    electrical cpphdl_n1635;
    electrical cpphdl_n1636;
    electrical cpphdl_n1637;
    electrical cpphdl_n1650;
    electrical cpphdl_n1654;
    electrical cpphdl_n1658;
    electrical cpphdl_n1662;
    electrical cpphdl_n1672;
    electrical cpphdl_n1675;
    electrical cpphdl_n1678;
    electrical cpphdl_n1680;
    electrical cpphdl_n1681;
    electrical cpphdl_n1686;
    electrical cpphdl_n1710;
    electrical cpphdl_n1725;
    electrical cpphdl_n1729;
    electrical cpphdl_n1733;
    electrical cpphdl_n1737;
    electrical cpphdl_n1741;
    electrical cpphdl_n1745;
    electrical cpphdl_n1749;
    electrical cpphdl_n1753;
    electrical cpphdl_n1754;
    electrical cpphdl_n1755;
    electrical cpphdl_n1756;
    electrical cpphdl_n1757;
    electrical cpphdl_n1758;
    electrical cpphdl_n1759;
    electrical cpphdl_n1760;
    electrical cpphdl_n1764;
    electrical cpphdl_n1765;
    electrical cpphdl_n1768;
    electrical cpphdl_n1769;
    electrical cpphdl_n1770;
    electrical cpphdl_n1773;
    electrical cpphdl_n1774;
    electrical cpphdl_n1778;
    electrical cpphdl_n1779;
    electrical cpphdl_n1780;
    electrical cpphdl_n1793;
    electrical cpphdl_n1797;
    electrical cpphdl_n1801;
    electrical cpphdl_n1805;
    electrical cpphdl_n1815;
    electrical cpphdl_n1818;
    electrical cpphdl_n1821;
    electrical cpphdl_n1823;
    electrical cpphdl_n1824;
    electrical cpphdl_n1829;
    electrical cpphdl_n1853;
    electrical cpphdl_n1868;
    electrical cpphdl_n1872;
    electrical cpphdl_n1876;
    electrical cpphdl_n1880;
    electrical cpphdl_n1884;
    electrical cpphdl_n1888;
    electrical cpphdl_n1892;
    electrical cpphdl_n1896;
    electrical cpphdl_n1897;
    electrical cpphdl_n1898;
    electrical cpphdl_n1899;
    electrical cpphdl_n1900;
    electrical cpphdl_n1901;
    electrical cpphdl_n1902;
    electrical cpphdl_n1903;
    electrical cpphdl_n1907;
    electrical cpphdl_n1908;
    electrical cpphdl_n1911;
    electrical cpphdl_n1912;
    electrical cpphdl_n1913;
    electrical cpphdl_n1916;
    electrical cpphdl_n1917;
    electrical cpphdl_n1921;
    electrical cpphdl_n1922;
    electrical cpphdl_n1923;
    electrical cpphdl_n1936;
    electrical cpphdl_n1940;
    electrical cpphdl_n1944;
    electrical cpphdl_n1948;
    electrical cpphdl_n1958;
    electrical cpphdl_n1961;
    electrical cpphdl_n1964;
    electrical cpphdl_n1966;
    electrical cpphdl_n1967;
    electrical cpphdl_n1972;
    electrical cpphdl_n1996;
    electrical cpphdl_n2011;
    electrical cpphdl_n2015;
    electrical cpphdl_n2019;
    electrical cpphdl_n2023;
    electrical cpphdl_n2027;
    electrical cpphdl_n2031;
    electrical cpphdl_n2035;
    electrical cpphdl_n2039;
    electrical cpphdl_n2040;
    electrical cpphdl_n2041;
    electrical cpphdl_n2042;
    electrical cpphdl_n2043;
    electrical cpphdl_n2044;
    electrical cpphdl_n2045;
    electrical cpphdl_n2046;
    electrical cpphdl_n2050;
    electrical cpphdl_n2051;
    electrical cpphdl_n2054;
    electrical cpphdl_n2055;
    electrical cpphdl_n2056;
    electrical cpphdl_n2059;
    electrical cpphdl_n2060;
    electrical cpphdl_n2064;
    electrical cpphdl_n2065;
    electrical cpphdl_n2066;
    electrical cpphdl_n2079;
    electrical cpphdl_n2083;
    electrical cpphdl_n2087;
    electrical cpphdl_n2091;
    electrical cpphdl_n2101;
    electrical cpphdl_n2104;
    electrical cpphdl_n2107;
    electrical cpphdl_n2109;
    electrical cpphdl_n2110;
    electrical cpphdl_n2115;
    electrical cpphdl_n2139;
    electrical cpphdl_n2154;
    electrical cpphdl_n2158;
    electrical cpphdl_n2162;
    electrical cpphdl_n2166;
    electrical cpphdl_n2170;
    electrical cpphdl_n2174;
    electrical cpphdl_n2178;
    electrical cpphdl_n2182;
    electrical cpphdl_n2183;
    electrical cpphdl_n2184;
    electrical cpphdl_n2185;
    electrical cpphdl_n2186;
    electrical cpphdl_n2187;
    electrical cpphdl_n2188;
    electrical cpphdl_n2189;
    electrical cpphdl_n2193;
    electrical cpphdl_n2194;
    electrical cpphdl_n2197;
    electrical cpphdl_n2198;
    electrical cpphdl_n2199;
    electrical cpphdl_n2202;
    electrical cpphdl_n2203;
    electrical cpphdl_n2207;
    electrical cpphdl_n2208;
    electrical cpphdl_n2209;
    electrical cpphdl_n2222;
    electrical cpphdl_n2226;
    electrical cpphdl_n2230;
    electrical cpphdl_n2234;
    electrical cpphdl_n2244;
    electrical cpphdl_n2247;
    electrical cpphdl_n2250;
    electrical cpphdl_n2252;
    electrical cpphdl_n2253;
    electrical cpphdl_n2258;
    electrical cpphdl_n2282;
    electrical cpphdl_n2297;
    electrical cpphdl_n2301;
    electrical cpphdl_n2305;
    electrical cpphdl_n2309;
    electrical cpphdl_n2313;
    electrical cpphdl_n2317;
    electrical cpphdl_n2321;
    electrical cpphdl_n2325;
    electrical cpphdl_n2326;
    electrical cpphdl_n2327;
    electrical cpphdl_n2328;
    electrical cpphdl_n2329;
    electrical cpphdl_n2330;
    electrical cpphdl_n2331;
    electrical cpphdl_n2332;
    electrical cpphdl_n2336;
    electrical cpphdl_n2337;
    electrical cpphdl_n2340;
    electrical cpphdl_n2341;
    electrical cpphdl_n2342;
    electrical cpphdl_n2345;
    electrical cpphdl_n2346;
    electrical cpphdl_n2350;
    electrical cpphdl_n2351;
    electrical cpphdl_n2352;
    electrical cpphdl_n2365;
    electrical cpphdl_n2369;
    electrical cpphdl_n2373;
    electrical cpphdl_n2377;
    electrical cpphdl_n2387;
    electrical cpphdl_n2390;
    electrical cpphdl_n2393;
    electrical cpphdl_n2395;
    electrical cpphdl_n2396;
    electrical cpphdl_n2401;
    electrical cpphdl_n2425;
    electrical cpphdl_n2440;
    electrical cpphdl_n2444;
    electrical cpphdl_n2448;
    electrical cpphdl_n2452;
    electrical cpphdl_n2456;
    electrical cpphdl_n2460;
    electrical cpphdl_n2464;
    electrical cpphdl_n2468;
    electrical cpphdl_n2469;
    electrical cpphdl_n2470;
    electrical cpphdl_n2471;
    electrical cpphdl_n2472;
    electrical cpphdl_n2473;
    electrical cpphdl_n2474;
    electrical cpphdl_n2475;
    electrical cpphdl_n2479;
    electrical cpphdl_n2480;
    electrical cpphdl_n2483;
    electrical cpphdl_n2484;
    electrical cpphdl_n2485;
    electrical cpphdl_n2488;
    electrical cpphdl_n2489;
    electrical cpphdl_n2493;
    electrical cpphdl_n2494;
    electrical cpphdl_n2495;
    electrical cpphdl_n2508;
    electrical cpphdl_n2512;
    electrical cpphdl_n2516;
    electrical cpphdl_n2520;
    electrical cpphdl_n2530;
    electrical cpphdl_n2533;
    electrical cpphdl_n2536;
    electrical cpphdl_n2538;
    electrical cpphdl_n2539;
    electrical cpphdl_n2544;
    electrical cpphdl_n2568;
    electrical cpphdl_n2583;
    electrical cpphdl_n2587;
    electrical cpphdl_n2591;
    electrical cpphdl_n2595;
    electrical cpphdl_n2599;
    electrical cpphdl_n2603;
    electrical cpphdl_n2607;
    electrical cpphdl_n2611;
    electrical cpphdl_n2612;
    electrical cpphdl_n2613;
    electrical cpphdl_n2614;
    electrical cpphdl_n2615;
    electrical cpphdl_n2616;
    electrical cpphdl_n2617;
    electrical cpphdl_n2618;
    electrical cpphdl_n2622;
    electrical cpphdl_n2623;
    electrical cpphdl_n2626;
    electrical cpphdl_n2627;
    electrical cpphdl_n2628;
    electrical cpphdl_n2631;
    electrical cpphdl_n2632;
    electrical cpphdl_n2636;
    electrical cpphdl_n2637;
    electrical cpphdl_n2638;
    electrical cpphdl_n2651;
    electrical cpphdl_n2655;
    electrical cpphdl_n2659;
    electrical cpphdl_n2663;
    electrical cpphdl_n2673;
    electrical cpphdl_n2676;
    electrical cpphdl_n2679;
    electrical cpphdl_n2681;
    electrical cpphdl_n2682;
    electrical cpphdl_n2687;
    electrical cpphdl_n2705;
    electrical cpphdl_n2711;
    electrical cpphdl_n2726;
    electrical cpphdl_n2730;
    electrical cpphdl_n2734;
    electrical cpphdl_n2738;
    electrical cpphdl_n2742;
    electrical cpphdl_n2746;
    electrical cpphdl_n2750;
    electrical cpphdl_n2754;
    electrical cpphdl_n2755;
    electrical cpphdl_n2756;
    electrical cpphdl_n2757;
    electrical cpphdl_n2758;
    electrical cpphdl_n2759;
    electrical cpphdl_n2760;
    electrical cpphdl_n2761;
    electrical cpphdl_n2765;
    electrical cpphdl_n2766;
    electrical cpphdl_n2769;
    electrical cpphdl_n2770;
    electrical cpphdl_n2771;
    electrical cpphdl_n2774;
    electrical cpphdl_n2775;
    electrical cpphdl_n2779;
    electrical cpphdl_n2780;
    electrical cpphdl_n2781;
    electrical cpphdl_n2794;
    electrical cpphdl_n2798;
    electrical cpphdl_n2802;
    electrical cpphdl_n2806;
    electrical cpphdl_n2816;
    electrical cpphdl_n2819;
    electrical cpphdl_n2822;
    electrical cpphdl_n2824;
    electrical cpphdl_n2825;
    electrical cpphdl_n2830;
    electrical cpphdl_n2850;
    electrical cpphdl_n2852;
    electrical cpphdl_n2855;
    electrical cpphdl_n2857;
    electrical cpphdl_n2860;
    electrical cpphdl_n2862;
    electrical cpphdl_n2865;
    electrical cpphdl_n2867;
    electrical cpphdl_n2870;
    electrical cpphdl_n2872;
    electrical cpphdl_n2875;
    electrical cpphdl_n2877;
    electrical cpphdl_n2880;
    electrical cpphdl_n2882;
    electrical cpphdl_n2885;
    electrical cpphdl_n2887;
    electrical cpphdl_n2890;
    electrical cpphdl_n2892;
    electrical cpphdl_n2895;
    electrical cpphdl_n2897;
    electrical cpphdl_n2900;
    electrical cpphdl_n2902;
    electrical cpphdl_n2905;
    electrical cpphdl_n2907;
    electrical cpphdl_n2910;
    electrical cpphdl_n2912;
    electrical cpphdl_n2915;
    electrical cpphdl_n2917;
    electrical cpphdl_n2920;
    electrical cpphdl_n2922;
    electrical cpphdl_n2925;
    electrical cpphdl_n2927;

    // Square-law channel, including reverse conduction. This is not a BSIM model.
    analog function real cpphdl_channel;
        input vgs, vds, beta, threshold, polarity;
        real vgs, vds, beta, threshold, polarity;
        real gate, drain, direction, overdrive, current;
        begin
            gate = polarity * vgs;
            drain = polarity * vds;
            direction = 1.0;
            if (drain < 0.0) begin
                gate = gate - drain;
                drain = -drain;
                direction = -1.0;
            end
            overdrive = gate - threshold;
            current = 0.0;
            if (overdrive > 0.0) begin
                if (drain < overdrive)
                    current = beta * (overdrive * drain - drain * drain / 2.0);
                else
                    current = beta * overdrive * overdrive / 2.0;
            end
            cpphdl_channel = polarity * direction * current;
        end
    endfunction

    analog begin
        // device 0, IC IC2, analog/basic/nmos_source_follower.hpp:19
        I(Vdd, cpphdl_n351) <+ cpphdl_channel(V(PLUS, cpphdl_n351), V(Vdd, cpphdl_n351), 0.050000000000000003, 0.69999999999999996, 1.0);
        // device 1, IC IC2, analog/basic/nmos_source_follower.hpp:20
        I(Vss, cpphdl_n351) <+ V(Vss, cpphdl_n351) / 500.0;
        // device 2, IC IC2, analog/basic/nmos_source_follower.hpp:23
        I(PLUS, cpphdl_n351) <+ 2e-14 * ddt(V(PLUS, cpphdl_n351)); // Bench initial voltage = 1.1499999999999999 V.
        // device 3, IC IC2, analog/basic/nmos_source_follower.hpp:24
        I(PLUS, Vdd) <+ 5e-15 * ddt(V(PLUS, Vdd)); // Bench initial voltage = -0.5 V.
        // device 4, IC IC2, analog/basic/nmos_source_follower.hpp:25
        I(cpphdl_n351, Vss) <+ 2e-14 * ddt(V(cpphdl_n351, Vss)); // Bench initial voltage = 1.6499999999999999 V.
        // device 5, IC IC3, analog/basic/nmos_source_follower.hpp:19
        I(Vdd, cpphdl_n352) <+ cpphdl_channel(V(MINUS, cpphdl_n352), V(Vdd, cpphdl_n352), 0.050000000000000003, 0.69999999999999996, 1.0);
        // device 6, IC IC3, analog/basic/nmos_source_follower.hpp:20
        I(Vss, cpphdl_n352) <+ V(Vss, cpphdl_n352) / 500.0;
        // device 7, IC IC3, analog/basic/nmos_source_follower.hpp:23
        I(MINUS, cpphdl_n352) <+ 2e-14 * ddt(V(MINUS, cpphdl_n352)); // Bench initial voltage = 1.1499999999999999 V.
        // device 8, IC IC3, analog/basic/nmos_source_follower.hpp:24
        I(MINUS, Vdd) <+ 5e-15 * ddt(V(MINUS, Vdd)); // Bench initial voltage = -0.5 V.
        // device 9, IC IC3, analog/basic/nmos_source_follower.hpp:25
        I(cpphdl_n352, Vss) <+ 2e-14 * ddt(V(cpphdl_n352, Vss)); // Bench initial voltage = 1.6499999999999999 V.
        // device 10, IC IC5, analog/basic/nmos_resistor_amplifier.hpp:23
        I(Vdd, cpphdl_n354) <+ V(Vdd, cpphdl_n354) / 500.0;
        // device 11, IC IC5, analog/basic/nmos_resistor_amplifier.hpp:24
        I(Vdd, cpphdl_n360) <+ V(Vdd, cpphdl_n360) / 500.0;
        // device 12, IC IC5, analog/basic/nmos_resistor_amplifier.hpp:25
        I(cpphdl_n354, cpphdl_n355) <+ cpphdl_channel(V(cpphdl_n351, cpphdl_n355), V(cpphdl_n354, cpphdl_n355), 0.014999999999999999, 0.69999999999999996, 1.0);
        // device 13, IC IC5, analog/basic/nmos_resistor_amplifier.hpp:26
        I(cpphdl_n360, cpphdl_n356) <+ cpphdl_channel(V(cpphdl_n352, cpphdl_n356), V(cpphdl_n360, cpphdl_n356), 0.014999999999999999, 0.69999999999999996, 1.0);
        // device 14, IC IC5, analog/basic/nmos_resistor_amplifier.hpp:27
        I(cpphdl_n357, cpphdl_n355) <+ V(cpphdl_n357, cpphdl_n355) / 50.0;
        // device 15, IC IC5, analog/basic/nmos_resistor_amplifier.hpp:28
        I(cpphdl_n357, cpphdl_n356) <+ V(cpphdl_n357, cpphdl_n356) / 50.0;
        // device 16, IC IC5, analog/basic/nmos_resistor_amplifier.hpp:29
        I(Vss, cpphdl_n357) <+ V(Vss, cpphdl_n357) / 150.0;
        // device 17, IC IC5, analog/basic/nmos_resistor_amplifier.hpp:30
        I(cpphdl_n354, Vdd) <+ 2.9999999999999998e-13 * ddt(V(cpphdl_n354, Vdd)); // Bench initial voltage = 0.0 V.
        // device 18, IC IC5, analog/basic/nmos_resistor_amplifier.hpp:31
        I(cpphdl_n360, Vdd) <+ 2.9999999999999998e-13 * ddt(V(cpphdl_n360, Vdd)); // Bench initial voltage = 0.0 V.
        // device 19, IC IC5, analog/basic/nmos_resistor_amplifier.hpp:32
        I(cpphdl_n357, Vss) <+ 4e-14 * ddt(V(cpphdl_n357, Vss)); // Bench initial voltage = 0.0 V.
        // device 20, IC IC5, analog/basic/nmos_resistor_amplifier.hpp:34
        I(cpphdl_n351, cpphdl_n355) <+ 1.4999999999999999e-13 * ddt(V(cpphdl_n351, cpphdl_n355)); // Bench initial voltage = 1.6499999999999999 V.
        // device 21, IC IC5, analog/basic/nmos_resistor_amplifier.hpp:35
        I(cpphdl_n352, cpphdl_n356) <+ 1.4999999999999999e-13 * ddt(V(cpphdl_n352, cpphdl_n356)); // Bench initial voltage = 1.6499999999999999 V.
        // device 22, IC IC5, analog/basic/nmos_resistor_amplifier.hpp:36
        I(cpphdl_n351, cpphdl_n354) <+ 2e-14 * ddt(V(cpphdl_n351, cpphdl_n354)); // Bench initial voltage = -1.6499999999999999 V.
        // device 23, IC IC5, analog/basic/nmos_resistor_amplifier.hpp:37
        I(cpphdl_n352, cpphdl_n360) <+ 2e-14 * ddt(V(cpphdl_n352, cpphdl_n360)); // Bench initial voltage = -1.6499999999999999 V.
        // device 24, IC IC6, analog/basic/nmos_source_follower.hpp:19
        I(Vdd, cpphdl_n2705) <+ cpphdl_channel(V(cpphdl_n360, cpphdl_n2705), V(Vdd, cpphdl_n2705), 0.10000000000000001, 0.69999999999999996, 1.0);
        // device 25, IC IC6, analog/basic/nmos_source_follower.hpp:20
        I(Vss, cpphdl_n2705) <+ V(Vss, cpphdl_n2705) / 250.0;
        // device 26, IC IC6, analog/basic/nmos_source_follower.hpp:23
        I(cpphdl_n360, cpphdl_n2705) <+ 4e-14 * ddt(V(cpphdl_n360, cpphdl_n2705)); // Bench initial voltage = 1.6499999999999999 V.
        // device 27, IC IC6, analog/basic/nmos_source_follower.hpp:24
        I(cpphdl_n360, Vdd) <+ 1e-14 * ddt(V(cpphdl_n360, Vdd)); // Bench initial voltage = 0.0 V.
        // device 28, IC IC6, analog/basic/nmos_source_follower.hpp:25
        I(cpphdl_n2705, Vss) <+ 4e-14 * ddt(V(cpphdl_n2705, Vss)); // Bench initial voltage = 1.6499999999999999 V.
        // device 29, IC IC10, analog/basic/inverter.hpp:11
        I(cpphdl_n566, Vdd) <+ cpphdl_channel(V(TRACK0, Vdd), V(cpphdl_n566, Vdd), 0.0040000000000000001, 0.69999999999999996, -1.0);
        // device 30, IC IC10, analog/basic/inverter.hpp:12
        I(cpphdl_n566, Vss) <+ cpphdl_channel(V(TRACK0, Vss), V(cpphdl_n566, Vss), 0.0040000000000000001, 0.69999999999999996, 1.0);
        // device 31, IC IC9, analog/basic/mos_track_hold.hpp:31
        I(cpphdl_n566, Vss) <+ 2e-14 * ddt(V(cpphdl_n566, Vss)); // Bench initial voltage = 3.2999999999999998 V.
        // device 32, IC IC9, analog/basic/mos_track_hold.hpp:32
        I(cpphdl_n2705, cpphdl_n620) <+ cpphdl_channel(V(TRACK0, cpphdl_n620), V(cpphdl_n2705, cpphdl_n620), 0.080000000000000002, 0.69999999999999996, 1.0);
        // device 33, IC IC9, analog/basic/mos_track_hold.hpp:33
        I(cpphdl_n620, cpphdl_n2705) <+ cpphdl_channel(V(cpphdl_n566, cpphdl_n2705), V(cpphdl_n620, cpphdl_n2705), 0.040000000000000001, 0.69999999999999996, -1.0);
        // device 34, IC IC9, analog/basic/mos_track_hold.hpp:37
        I(cpphdl_n620, cpphdl_n620) <+ cpphdl_channel(V(cpphdl_n566, cpphdl_n620), V(cpphdl_n620, cpphdl_n620), 0.040000000000000001, 0.69999999999999996, 1.0);
        // device 35, IC IC9, analog/basic/mos_track_hold.hpp:38
        I(cpphdl_n620, cpphdl_n620) <+ cpphdl_channel(V(TRACK0, cpphdl_n620), V(cpphdl_n620, cpphdl_n620), 0.02, 0.69999999999999996, -1.0);
        // device 36, IC IC9, analog/basic/mos_track_hold.hpp:39
        I(cpphdl_n620, Vss) <+ 2e-12 * ddt(V(cpphdl_n620, Vss)); // Bench initial voltage = 1.6499999999999999 V.
        // device 37, IC IC9, analog/basic/mos_track_hold.hpp:41
        I(Vss, cpphdl_n620) <+ V(Vss, cpphdl_n620) / 1000000000.0;
        // device 38, IC IC9, analog/basic/mos_track_hold.hpp:42
        I(TRACK0, cpphdl_n620) <+ 8.0000000000000006e-15 * ddt(V(TRACK0, cpphdl_n620)); // Bench initial voltage = -1.6499999999999999 V.
        // device 39, IC IC9, analog/basic/mos_track_hold.hpp:43
        I(cpphdl_n566, cpphdl_n620) <+ 8.0000000000000006e-15 * ddt(V(cpphdl_n566, cpphdl_n620)); // Bench initial voltage = 1.6499999999999999 V.
        // device 40, IC IC9, analog/basic/mos_track_hold.hpp:44
        I(cpphdl_n2705, cpphdl_n620) <+ 4.0000000000000003e-15 * ddt(V(cpphdl_n2705, cpphdl_n620)); // Bench initial voltage = 0.0 V.
        // device 41, IC IC12, analog/basic/inverter.hpp:11
        I(cpphdl_n581, Vdd) <+ cpphdl_channel(V(BIT_N0_0, Vdd), V(cpphdl_n581, Vdd), 0.080000000000000002, 0.69999999999999996, -1.0);
        // device 42, IC IC12, analog/basic/inverter.hpp:12
        I(cpphdl_n581, Vss) <+ cpphdl_channel(V(BIT_N0_0, Vss), V(cpphdl_n581, Vss), 0.080000000000000002, 0.69999999999999996, 1.0);
        // device 43, IC IC11, analog/basic/mos_r2r_dac.hpp:27
        I(cpphdl_n581, Vss) <+ 2.9999999999999998e-15 * ddt(V(cpphdl_n581, Vss)); // Bench initial voltage = 0.0 V.
        // device 44, IC IC11, analog/basic/mos_r2r_dac.hpp:28
        I(cpphdl_n581, cpphdl_n610) <+ V(cpphdl_n581, cpphdl_n610) / 2000.0;
        // device 45, IC IC11, analog/basic/mos_r2r_dac.hpp:29
        I(cpphdl_n610, Vss) <+ 2.9999999999999998e-15 * ddt(V(cpphdl_n610, Vss)); // Bench initial voltage = 0.0 V.
        // device 46, IC IC13, analog/basic/inverter.hpp:11
        I(cpphdl_n585, Vdd) <+ cpphdl_channel(V(BIT_N0_1, Vdd), V(cpphdl_n585, Vdd), 0.080000000000000002, 0.69999999999999996, -1.0);
        // device 47, IC IC13, analog/basic/inverter.hpp:12
        I(cpphdl_n585, Vss) <+ cpphdl_channel(V(BIT_N0_1, Vss), V(cpphdl_n585, Vss), 0.080000000000000002, 0.69999999999999996, 1.0);
        // device 48, IC IC11, analog/basic/mos_r2r_dac.hpp:27
        I(cpphdl_n585, Vss) <+ 2.9999999999999998e-15 * ddt(V(cpphdl_n585, Vss)); // Bench initial voltage = 0.0 V.
        // device 49, IC IC11, analog/basic/mos_r2r_dac.hpp:28
        I(cpphdl_n585, cpphdl_n611) <+ V(cpphdl_n585, cpphdl_n611) / 2000.0;
        // device 50, IC IC11, analog/basic/mos_r2r_dac.hpp:29
        I(cpphdl_n611, Vss) <+ 2.9999999999999998e-15 * ddt(V(cpphdl_n611, Vss)); // Bench initial voltage = 0.0 V.
        // device 51, IC IC11, analog/basic/mos_r2r_dac.hpp:31
        I(cpphdl_n610, cpphdl_n611) <+ V(cpphdl_n610, cpphdl_n611) / 1000.0;
        // device 52, IC IC14, analog/basic/inverter.hpp:11
        I(cpphdl_n589, Vdd) <+ cpphdl_channel(V(BIT_N0_2, Vdd), V(cpphdl_n589, Vdd), 0.080000000000000002, 0.69999999999999996, -1.0);
        // device 53, IC IC14, analog/basic/inverter.hpp:12
        I(cpphdl_n589, Vss) <+ cpphdl_channel(V(BIT_N0_2, Vss), V(cpphdl_n589, Vss), 0.080000000000000002, 0.69999999999999996, 1.0);
        // device 54, IC IC11, analog/basic/mos_r2r_dac.hpp:27
        I(cpphdl_n589, Vss) <+ 2.9999999999999998e-15 * ddt(V(cpphdl_n589, Vss)); // Bench initial voltage = 0.0 V.
        // device 55, IC IC11, analog/basic/mos_r2r_dac.hpp:28
        I(cpphdl_n589, cpphdl_n612) <+ V(cpphdl_n589, cpphdl_n612) / 2000.0;
        // device 56, IC IC11, analog/basic/mos_r2r_dac.hpp:29
        I(cpphdl_n612, Vss) <+ 2.9999999999999998e-15 * ddt(V(cpphdl_n612, Vss)); // Bench initial voltage = 0.0 V.
        // device 57, IC IC11, analog/basic/mos_r2r_dac.hpp:31
        I(cpphdl_n611, cpphdl_n612) <+ V(cpphdl_n611, cpphdl_n612) / 1000.0;
        // device 58, IC IC15, analog/basic/inverter.hpp:11
        I(cpphdl_n593, Vdd) <+ cpphdl_channel(V(BIT_N0_3, Vdd), V(cpphdl_n593, Vdd), 0.080000000000000002, 0.69999999999999996, -1.0);
        // device 59, IC IC15, analog/basic/inverter.hpp:12
        I(cpphdl_n593, Vss) <+ cpphdl_channel(V(BIT_N0_3, Vss), V(cpphdl_n593, Vss), 0.080000000000000002, 0.69999999999999996, 1.0);
        // device 60, IC IC11, analog/basic/mos_r2r_dac.hpp:27
        I(cpphdl_n593, Vss) <+ 2.9999999999999998e-15 * ddt(V(cpphdl_n593, Vss)); // Bench initial voltage = 0.0 V.
        // device 61, IC IC11, analog/basic/mos_r2r_dac.hpp:28
        I(cpphdl_n593, cpphdl_n613) <+ V(cpphdl_n593, cpphdl_n613) / 2000.0;
        // device 62, IC IC11, analog/basic/mos_r2r_dac.hpp:29
        I(cpphdl_n613, Vss) <+ 2.9999999999999998e-15 * ddt(V(cpphdl_n613, Vss)); // Bench initial voltage = 0.0 V.
        // device 63, IC IC11, analog/basic/mos_r2r_dac.hpp:31
        I(cpphdl_n612, cpphdl_n613) <+ V(cpphdl_n612, cpphdl_n613) / 1000.0;
        // device 64, IC IC16, analog/basic/inverter.hpp:11
        I(cpphdl_n597, Vdd) <+ cpphdl_channel(V(BIT_N0_4, Vdd), V(cpphdl_n597, Vdd), 0.080000000000000002, 0.69999999999999996, -1.0);
        // device 65, IC IC16, analog/basic/inverter.hpp:12
        I(cpphdl_n597, Vss) <+ cpphdl_channel(V(BIT_N0_4, Vss), V(cpphdl_n597, Vss), 0.080000000000000002, 0.69999999999999996, 1.0);
        // device 66, IC IC11, analog/basic/mos_r2r_dac.hpp:27
        I(cpphdl_n597, Vss) <+ 2.9999999999999998e-15 * ddt(V(cpphdl_n597, Vss)); // Bench initial voltage = 0.0 V.
        // device 67, IC IC11, analog/basic/mos_r2r_dac.hpp:28
        I(cpphdl_n597, cpphdl_n614) <+ V(cpphdl_n597, cpphdl_n614) / 2000.0;
        // device 68, IC IC11, analog/basic/mos_r2r_dac.hpp:29
        I(cpphdl_n614, Vss) <+ 2.9999999999999998e-15 * ddt(V(cpphdl_n614, Vss)); // Bench initial voltage = 0.0 V.
        // device 69, IC IC11, analog/basic/mos_r2r_dac.hpp:31
        I(cpphdl_n613, cpphdl_n614) <+ V(cpphdl_n613, cpphdl_n614) / 1000.0;
        // device 70, IC IC17, analog/basic/inverter.hpp:11
        I(cpphdl_n601, Vdd) <+ cpphdl_channel(V(BIT_N0_5, Vdd), V(cpphdl_n601, Vdd), 0.080000000000000002, 0.69999999999999996, -1.0);
        // device 71, IC IC17, analog/basic/inverter.hpp:12
        I(cpphdl_n601, Vss) <+ cpphdl_channel(V(BIT_N0_5, Vss), V(cpphdl_n601, Vss), 0.080000000000000002, 0.69999999999999996, 1.0);
        // device 72, IC IC11, analog/basic/mos_r2r_dac.hpp:27
        I(cpphdl_n601, Vss) <+ 2.9999999999999998e-15 * ddt(V(cpphdl_n601, Vss)); // Bench initial voltage = 0.0 V.
        // device 73, IC IC11, analog/basic/mos_r2r_dac.hpp:28
        I(cpphdl_n601, cpphdl_n615) <+ V(cpphdl_n601, cpphdl_n615) / 2000.0;
        // device 74, IC IC11, analog/basic/mos_r2r_dac.hpp:29
        I(cpphdl_n615, Vss) <+ 2.9999999999999998e-15 * ddt(V(cpphdl_n615, Vss)); // Bench initial voltage = 0.0 V.
        // device 75, IC IC11, analog/basic/mos_r2r_dac.hpp:31
        I(cpphdl_n614, cpphdl_n615) <+ V(cpphdl_n614, cpphdl_n615) / 1000.0;
        // device 76, IC IC18, analog/basic/inverter.hpp:11
        I(cpphdl_n605, Vdd) <+ cpphdl_channel(V(BIT_N0_6, Vdd), V(cpphdl_n605, Vdd), 0.080000000000000002, 0.69999999999999996, -1.0);
        // device 77, IC IC18, analog/basic/inverter.hpp:12
        I(cpphdl_n605, Vss) <+ cpphdl_channel(V(BIT_N0_6, Vss), V(cpphdl_n605, Vss), 0.080000000000000002, 0.69999999999999996, 1.0);
        // device 78, IC IC11, analog/basic/mos_r2r_dac.hpp:27
        I(cpphdl_n605, Vss) <+ 2.9999999999999998e-15 * ddt(V(cpphdl_n605, Vss)); // Bench initial voltage = 0.0 V.
        // device 79, IC IC11, analog/basic/mos_r2r_dac.hpp:28
        I(cpphdl_n605, cpphdl_n616) <+ V(cpphdl_n605, cpphdl_n616) / 2000.0;
        // device 80, IC IC11, analog/basic/mos_r2r_dac.hpp:29
        I(cpphdl_n616, Vss) <+ 2.9999999999999998e-15 * ddt(V(cpphdl_n616, Vss)); // Bench initial voltage = 0.0 V.
        // device 81, IC IC11, analog/basic/mos_r2r_dac.hpp:31
        I(cpphdl_n615, cpphdl_n616) <+ V(cpphdl_n615, cpphdl_n616) / 1000.0;
        // device 82, IC IC19, analog/basic/inverter.hpp:11
        I(cpphdl_n609, Vdd) <+ cpphdl_channel(V(BIT_N0_7, Vdd), V(cpphdl_n609, Vdd), 0.080000000000000002, 0.69999999999999996, -1.0);
        // device 83, IC IC19, analog/basic/inverter.hpp:12
        I(cpphdl_n609, Vss) <+ cpphdl_channel(V(BIT_N0_7, Vss), V(cpphdl_n609, Vss), 0.080000000000000002, 0.69999999999999996, 1.0);
        // device 84, IC IC11, analog/basic/mos_r2r_dac.hpp:27
        I(cpphdl_n609, Vss) <+ 2.9999999999999998e-15 * ddt(V(cpphdl_n609, Vss)); // Bench initial voltage = 0.0 V.
        // device 85, IC IC11, analog/basic/mos_r2r_dac.hpp:28
        I(cpphdl_n609, cpphdl_n621) <+ V(cpphdl_n609, cpphdl_n621) / 2000.0;
        // device 86, IC IC11, analog/basic/mos_r2r_dac.hpp:29
        I(cpphdl_n621, Vss) <+ 2.9999999999999998e-15 * ddt(V(cpphdl_n621, Vss)); // Bench initial voltage = 0.0 V.
        // device 87, IC IC11, analog/basic/mos_r2r_dac.hpp:31
        I(cpphdl_n616, cpphdl_n621) <+ V(cpphdl_n616, cpphdl_n621) / 1000.0;
        // device 88, IC IC11, analog/basic/mos_r2r_dac.hpp:33
        I(Vss, cpphdl_n610) <+ V(Vss, cpphdl_n610) / 2000.0;
        // device 89, IC IC20, analog/basic/nmos_resistor_amplifier.hpp:23
        I(Vdd, cpphdl_n630) <+ V(Vdd, cpphdl_n630) / 1000.0;
        // device 90, IC IC20, analog/basic/nmos_resistor_amplifier.hpp:24
        I(Vdd, cpphdl_n629) <+ V(Vdd, cpphdl_n629) / 1000.0;
        // device 91, IC IC20, analog/basic/nmos_resistor_amplifier.hpp:25
        I(cpphdl_n630, cpphdl_n624) <+ cpphdl_channel(V(cpphdl_n620, cpphdl_n624), V(cpphdl_n630, cpphdl_n624), 0.014999999999999999, 0.69999999999999996, 1.0);
        // device 92, IC IC20, analog/basic/nmos_resistor_amplifier.hpp:26
        I(cpphdl_n629, cpphdl_n625) <+ cpphdl_channel(V(cpphdl_n621, cpphdl_n625), V(cpphdl_n629, cpphdl_n625), 0.014999999999999999, 0.69999999999999996, 1.0);
        // device 93, IC IC20, analog/basic/nmos_resistor_amplifier.hpp:27
        I(cpphdl_n626, cpphdl_n624) <+ V(cpphdl_n626, cpphdl_n624) / 50.0;
        // device 94, IC IC20, analog/basic/nmos_resistor_amplifier.hpp:28
        I(cpphdl_n626, cpphdl_n625) <+ V(cpphdl_n626, cpphdl_n625) / 50.0;
        // device 95, IC IC20, analog/basic/nmos_resistor_amplifier.hpp:29
        I(Vss, cpphdl_n626) <+ V(Vss, cpphdl_n626) / 150.0;
        // device 96, IC IC20, analog/basic/nmos_resistor_amplifier.hpp:30
        I(cpphdl_n630, Vdd) <+ 2.9999999999999998e-13 * ddt(V(cpphdl_n630, Vdd)); // Bench initial voltage = 0.0 V.
        // device 97, IC IC20, analog/basic/nmos_resistor_amplifier.hpp:31
        I(cpphdl_n629, Vdd) <+ 2.9999999999999998e-13 * ddt(V(cpphdl_n629, Vdd)); // Bench initial voltage = 0.0 V.
        // device 98, IC IC20, analog/basic/nmos_resistor_amplifier.hpp:32
        I(cpphdl_n626, Vss) <+ 4e-14 * ddt(V(cpphdl_n626, Vss)); // Bench initial voltage = 0.0 V.
        // device 99, IC IC20, analog/basic/nmos_resistor_amplifier.hpp:34
        I(cpphdl_n620, cpphdl_n624) <+ 2e-14 * ddt(V(cpphdl_n620, cpphdl_n624)); // Bench initial voltage = 1.6499999999999999 V.
        // device 100, IC IC20, analog/basic/nmos_resistor_amplifier.hpp:35
        I(cpphdl_n621, cpphdl_n625) <+ 2e-14 * ddt(V(cpphdl_n621, cpphdl_n625)); // Bench initial voltage = 0.0 V.
        // device 101, IC IC20, analog/basic/nmos_resistor_amplifier.hpp:36
        I(cpphdl_n620, cpphdl_n630) <+ 2.9999999999999998e-15 * ddt(V(cpphdl_n620, cpphdl_n630)); // Bench initial voltage = -1.6499999999999999 V.
        // device 102, IC IC20, analog/basic/nmos_resistor_amplifier.hpp:37
        I(cpphdl_n621, cpphdl_n629) <+ 2.9999999999999998e-15 * ddt(V(cpphdl_n621, cpphdl_n629)); // Bench initial voltage = -3.2999999999999998 V.
        // device 103, IC IC21, analog/basic/strongarm_comparator.hpp:28
        I(cpphdl_n634, cpphdl_n636) <+ cpphdl_channel(V(cpphdl_n629, cpphdl_n636), V(cpphdl_n634, cpphdl_n636), 0.0080000000000000002, 0.69999999999999996, 1.0);
        // device 104, IC IC21, analog/basic/strongarm_comparator.hpp:29
        I(cpphdl_n635, cpphdl_n636) <+ cpphdl_channel(V(cpphdl_n630, cpphdl_n636), V(cpphdl_n635, cpphdl_n636), 0.0080000000000000002, 0.69999999999999996, 1.0);
        // device 105, IC IC21, analog/basic/strongarm_comparator.hpp:30
        I(cpphdl_n636, Vss) <+ cpphdl_channel(V(EVALUATE, Vss), V(cpphdl_n636, Vss), 0.0080000000000000002, 0.69999999999999996, 1.0);
        // device 106, IC IC21, analog/basic/strongarm_comparator.hpp:33
        I(cpphdl_n649, cpphdl_n634) <+ cpphdl_channel(V(cpphdl_n653, cpphdl_n634), V(cpphdl_n649, cpphdl_n634), 0.0040000000000000001, 0.69999999999999996, 1.0);
        // device 107, IC IC21, analog/basic/strongarm_comparator.hpp:34
        I(cpphdl_n653, cpphdl_n635) <+ cpphdl_channel(V(cpphdl_n649, cpphdl_n635), V(cpphdl_n653, cpphdl_n635), 0.0040000000000000001, 0.69999999999999996, 1.0);
        // device 108, IC IC21, analog/basic/strongarm_comparator.hpp:35
        I(cpphdl_n653, Vdd) <+ cpphdl_channel(V(cpphdl_n649, Vdd), V(cpphdl_n653, Vdd), 0.002, 0.69999999999999996, -1.0);
        // device 109, IC IC21, analog/basic/strongarm_comparator.hpp:36
        I(cpphdl_n649, Vdd) <+ cpphdl_channel(V(cpphdl_n653, Vdd), V(cpphdl_n649, Vdd), 0.002, 0.69999999999999996, -1.0);
        // device 110, IC IC21, analog/basic/strongarm_comparator.hpp:38
        I(cpphdl_n634, Vdd) <+ cpphdl_channel(V(EVALUATE, Vdd), V(cpphdl_n634, Vdd), 0.002, 0.69999999999999996, -1.0);
        // device 111, IC IC21, analog/basic/strongarm_comparator.hpp:39
        I(cpphdl_n635, Vdd) <+ cpphdl_channel(V(EVALUATE, Vdd), V(cpphdl_n635, Vdd), 0.002, 0.69999999999999996, -1.0);
        // device 112, IC IC21, analog/basic/strongarm_comparator.hpp:40
        I(cpphdl_n653, Vdd) <+ cpphdl_channel(V(EVALUATE, Vdd), V(cpphdl_n653, Vdd), 0.002, 0.69999999999999996, -1.0);
        // device 113, IC IC21, analog/basic/strongarm_comparator.hpp:41
        I(cpphdl_n649, Vdd) <+ cpphdl_channel(V(EVALUATE, Vdd), V(cpphdl_n649, Vdd), 0.002, 0.69999999999999996, -1.0);
        // device 114, IC IC21, analog/basic/strongarm_comparator.hpp:42
        I(cpphdl_n634, Vss) <+ 2.9999999999999998e-14 * ddt(V(cpphdl_n634, Vss)); // Bench initial voltage = 0.0 V.
        // device 115, IC IC21, analog/basic/strongarm_comparator.hpp:43
        I(cpphdl_n635, Vss) <+ 2.9999999999999998e-14 * ddt(V(cpphdl_n635, Vss)); // Bench initial voltage = 0.0 V.
        // device 116, IC IC21, analog/basic/strongarm_comparator.hpp:44
        I(cpphdl_n636, Vss) <+ 2.9999999999999998e-14 * ddt(V(cpphdl_n636, Vss)); // Bench initial voltage = 0.0 V.
        // device 117, IC IC21, analog/basic/strongarm_comparator.hpp:45
        I(cpphdl_n653, Vss) <+ 5.0000000000000002e-14 * ddt(V(cpphdl_n653, Vss)); // Bench initial voltage = 0.0 V.
        // device 118, IC IC21, analog/basic/strongarm_comparator.hpp:46
        I(cpphdl_n649, Vss) <+ 5.0000000000000002e-14 * ddt(V(cpphdl_n649, Vss)); // Bench initial voltage = 0.0 V.
        // device 119, IC IC21, analog/basic/strongarm_comparator.hpp:47
        I(cpphdl_n629, cpphdl_n636) <+ 2e-14 * ddt(V(cpphdl_n629, cpphdl_n636)); // Bench initial voltage = 3.2999999999999998 V.
        // device 120, IC IC21, analog/basic/strongarm_comparator.hpp:48
        I(cpphdl_n630, cpphdl_n636) <+ 2e-14 * ddt(V(cpphdl_n630, cpphdl_n636)); // Bench initial voltage = 3.2999999999999998 V.
        // device 121, IC IC21, analog/basic/strongarm_comparator.hpp:49
        I(cpphdl_n629, cpphdl_n634) <+ 2.9999999999999998e-15 * ddt(V(cpphdl_n629, cpphdl_n634)); // Bench initial voltage = 3.2999999999999998 V.
        // device 122, IC IC21, analog/basic/strongarm_comparator.hpp:50
        I(cpphdl_n630, cpphdl_n635) <+ 2.9999999999999998e-15 * ddt(V(cpphdl_n630, cpphdl_n635)); // Bench initial voltage = 3.2999999999999998 V.
        // device 123, IC IC23, analog/basic/inverter.hpp:11
        I(cpphdl_n657, Vdd) <+ cpphdl_channel(V(cpphdl_n649, Vdd), V(cpphdl_n657, Vdd), 0.001, 0.69999999999999996, -1.0);
        // device 124, IC IC23, analog/basic/inverter.hpp:12
        I(cpphdl_n657, Vss) <+ cpphdl_channel(V(cpphdl_n649, Vss), V(cpphdl_n657, Vss), 0.001, 0.69999999999999996, 1.0);
        // device 125, IC IC25, analog/basic/inverter.hpp:11
        I(cpphdl_n671, Vdd) <+ cpphdl_channel(V(cpphdl_n657, Vdd), V(cpphdl_n671, Vdd), 0.0040000000000000001, 0.69999999999999996, -1.0);
        // device 126, IC IC25, analog/basic/inverter.hpp:12
        I(cpphdl_n671, Vss) <+ cpphdl_channel(V(cpphdl_n657, Vss), V(cpphdl_n671, Vss), 0.0040000000000000001, 0.69999999999999996, 1.0);
        // device 127, IC IC22, analog/basic/buffered_nand_latch.hpp:34
        I(cpphdl_n649, Vss) <+ 2.0000000000000002e-15 * ddt(V(cpphdl_n649, Vss)); // Bench initial voltage = 0.0 V.
        // device 128, IC IC22, analog/basic/buffered_nand_latch.hpp:35
        I(cpphdl_n649, cpphdl_n657) <+ 1.0000000000000001e-15 * ddt(V(cpphdl_n649, cpphdl_n657)); // Bench initial voltage = 0.0 V.
        // device 129, IC IC22, analog/basic/buffered_nand_latch.hpp:36
        I(cpphdl_n657, Vss) <+ 5e-15 * ddt(V(cpphdl_n657, Vss)); // Bench initial voltage = 0.0 V.
        // device 130, IC IC22, analog/basic/buffered_nand_latch.hpp:37
        I(cpphdl_n657, Vss) <+ 8.0000000000000006e-15 * ddt(V(cpphdl_n657, Vss)); // Bench initial voltage = 0.0 V.
        // device 131, IC IC22, analog/basic/buffered_nand_latch.hpp:38
        I(cpphdl_n671, Vss) <+ 1e-14 * ddt(V(cpphdl_n671, Vss)); // Bench initial voltage = 0.0 V.
        // device 132, IC IC24, analog/basic/inverter.hpp:11
        I(cpphdl_n661, Vdd) <+ cpphdl_channel(V(cpphdl_n653, Vdd), V(cpphdl_n661, Vdd), 0.001, 0.69999999999999996, -1.0);
        // device 133, IC IC24, analog/basic/inverter.hpp:12
        I(cpphdl_n661, Vss) <+ cpphdl_channel(V(cpphdl_n653, Vss), V(cpphdl_n661, Vss), 0.001, 0.69999999999999996, 1.0);
        // device 134, IC IC26, analog/basic/inverter.hpp:11
        I(cpphdl_n677, Vdd) <+ cpphdl_channel(V(cpphdl_n661, Vdd), V(cpphdl_n677, Vdd), 0.0040000000000000001, 0.69999999999999996, -1.0);
        // device 135, IC IC26, analog/basic/inverter.hpp:12
        I(cpphdl_n677, Vss) <+ cpphdl_channel(V(cpphdl_n661, Vss), V(cpphdl_n677, Vss), 0.0040000000000000001, 0.69999999999999996, 1.0);
        // device 136, IC IC22, analog/basic/buffered_nand_latch.hpp:34
        I(cpphdl_n653, Vss) <+ 2.0000000000000002e-15 * ddt(V(cpphdl_n653, Vss)); // Bench initial voltage = 0.0 V.
        // device 137, IC IC22, analog/basic/buffered_nand_latch.hpp:35
        I(cpphdl_n653, cpphdl_n661) <+ 1.0000000000000001e-15 * ddt(V(cpphdl_n653, cpphdl_n661)); // Bench initial voltage = 0.0 V.
        // device 138, IC IC22, analog/basic/buffered_nand_latch.hpp:36
        I(cpphdl_n661, Vss) <+ 5e-15 * ddt(V(cpphdl_n661, Vss)); // Bench initial voltage = 0.0 V.
        // device 139, IC IC22, analog/basic/buffered_nand_latch.hpp:37
        I(cpphdl_n661, Vss) <+ 8.0000000000000006e-15 * ddt(V(cpphdl_n661, Vss)); // Bench initial voltage = 0.0 V.
        // device 140, IC IC22, analog/basic/buffered_nand_latch.hpp:38
        I(cpphdl_n677, Vss) <+ 1e-14 * ddt(V(cpphdl_n677, Vss)); // Bench initial voltage = 0.0 V.
        // device 141, IC IC28, analog/basic/cmos_logic.hpp:17
        I(cpphdl_n2850, Vss) <+ 5.0000000000000002e-14 * ddt(V(cpphdl_n2850, Vss)); // Bench initial voltage = 0.0 V.
        // device 142, IC IC28, analog/basic/cmos_logic.hpp:18
        I(cpphdl_n2850, Vdd) <+ cpphdl_channel(V(cpphdl_n671, Vdd), V(cpphdl_n2850, Vdd), 0.01, 0.69999999999999996, -1.0);
        // device 143, IC IC28, analog/basic/cmos_logic.hpp:19
        I(cpphdl_n2850, Vdd) <+ cpphdl_channel(V(cpphdl_n679, Vdd), V(cpphdl_n2850, Vdd), 0.01, 0.69999999999999996, -1.0);
        // device 144, IC IC28, analog/basic/cmos_logic.hpp:20
        I(cpphdl_n2850, cpphdl_n674) <+ cpphdl_channel(V(cpphdl_n671, cpphdl_n674), V(cpphdl_n2850, cpphdl_n674), 0.01, 0.69999999999999996, 1.0);
        // device 145, IC IC28, analog/basic/cmos_logic.hpp:21
        I(cpphdl_n674, Vss) <+ cpphdl_channel(V(cpphdl_n679, Vss), V(cpphdl_n674, Vss), 0.01, 0.69999999999999996, 1.0);
        // device 146, IC IC28, analog/basic/cmos_logic.hpp:23
        I(cpphdl_n2850, Vss) <+ V(cpphdl_n2850, Vss) / 1000000000.0;
        // device 147, IC IC28, analog/basic/cmos_logic.hpp:24
        I(cpphdl_n674, Vss) <+ V(cpphdl_n674, Vss) / 1000000000.0;
        // device 148, IC IC29, analog/basic/cmos_logic.hpp:17
        I(cpphdl_n679, Vss) <+ 5.0000000000000002e-14 * ddt(V(cpphdl_n679, Vss)); // Bench initial voltage = 0.0 V.
        // device 149, IC IC29, analog/basic/cmos_logic.hpp:18
        I(cpphdl_n679, Vdd) <+ cpphdl_channel(V(cpphdl_n677, Vdd), V(cpphdl_n679, Vdd), 0.01, 0.69999999999999996, -1.0);
        // device 150, IC IC29, analog/basic/cmos_logic.hpp:19
        I(cpphdl_n679, Vdd) <+ cpphdl_channel(V(cpphdl_n2850, Vdd), V(cpphdl_n679, Vdd), 0.01, 0.69999999999999996, -1.0);
        // device 151, IC IC29, analog/basic/cmos_logic.hpp:20
        I(cpphdl_n679, cpphdl_n680) <+ cpphdl_channel(V(cpphdl_n677, cpphdl_n680), V(cpphdl_n679, cpphdl_n680), 0.01, 0.69999999999999996, 1.0);
        // device 152, IC IC29, analog/basic/cmos_logic.hpp:21
        I(cpphdl_n680, Vss) <+ cpphdl_channel(V(cpphdl_n2850, Vss), V(cpphdl_n680, Vss), 0.01, 0.69999999999999996, 1.0);
        // device 153, IC IC29, analog/basic/cmos_logic.hpp:23
        I(cpphdl_n679, Vss) <+ V(cpphdl_n679, Vss) / 1000000000.0;
        // device 154, IC IC29, analog/basic/cmos_logic.hpp:24
        I(cpphdl_n680, Vss) <+ V(cpphdl_n680, Vss) / 1000000000.0;
        // device 155, IC IC27, analog/basic/nand_latch.hpp:36
        I(cpphdl_n671, Vss) <+ 2.9999999999999998e-15 * ddt(V(cpphdl_n671, Vss)); // Bench initial voltage = 0.0 V.
        // device 156, IC IC27, analog/basic/nand_latch.hpp:37
        I(cpphdl_n677, Vss) <+ 2.9999999999999998e-15 * ddt(V(cpphdl_n677, Vss)); // Bench initial voltage = 0.0 V.
        // device 157, IC IC30, analog/basic/inverter.hpp:11
        I(cpphdl_n685, Vdd) <+ cpphdl_channel(V(CLEAR, Vdd), V(cpphdl_n685, Vdd), 0.01, 0.69999999999999996, -1.0);
        // device 158, IC IC30, analog/basic/inverter.hpp:12
        I(cpphdl_n685, Vss) <+ cpphdl_channel(V(CLEAR, Vss), V(cpphdl_n685, Vss), 0.01, 0.69999999999999996, 1.0);
        // device 159, IC IC27, analog/basic/nand_latch.hpp:58
        I(cpphdl_n685, Vss) <+ 2.9999999999999998e-15 * ddt(V(cpphdl_n685, Vss)); // Bench initial voltage = 0.0 V.
        // device 160, IC IC27, analog/basic/nand_latch.hpp:59
        I(cpphdl_n2850, Vss) <+ cpphdl_channel(V(CLEAR, Vss), V(cpphdl_n2850, Vss), 0.050000000000000003, 0.69999999999999996, 1.0);
        // device 161, IC IC27, analog/basic/nand_latch.hpp:60
        I(cpphdl_n679, Vdd) <+ cpphdl_channel(V(cpphdl_n685, Vdd), V(cpphdl_n679, Vdd), 0.050000000000000003, 0.69999999999999996, -1.0);
        // device 162, IC IC33, analog/basic/inverter.hpp:11
        I(cpphdl_n709, Vdd) <+ cpphdl_channel(V(TRACK1, Vdd), V(cpphdl_n709, Vdd), 0.0040000000000000001, 0.69999999999999996, -1.0);
        // device 163, IC IC33, analog/basic/inverter.hpp:12
        I(cpphdl_n709, Vss) <+ cpphdl_channel(V(TRACK1, Vss), V(cpphdl_n709, Vss), 0.0040000000000000001, 0.69999999999999996, 1.0);
        // device 164, IC IC32, analog/basic/mos_track_hold.hpp:31
        I(cpphdl_n709, Vss) <+ 2e-14 * ddt(V(cpphdl_n709, Vss)); // Bench initial voltage = 3.2999999999999998 V.
        // device 165, IC IC32, analog/basic/mos_track_hold.hpp:32
        I(cpphdl_n2705, cpphdl_n763) <+ cpphdl_channel(V(TRACK1, cpphdl_n763), V(cpphdl_n2705, cpphdl_n763), 0.080000000000000002, 0.69999999999999996, 1.0);
        // device 166, IC IC32, analog/basic/mos_track_hold.hpp:33
        I(cpphdl_n763, cpphdl_n2705) <+ cpphdl_channel(V(cpphdl_n709, cpphdl_n2705), V(cpphdl_n763, cpphdl_n2705), 0.040000000000000001, 0.69999999999999996, -1.0);
        // device 167, IC IC32, analog/basic/mos_track_hold.hpp:37
        I(cpphdl_n763, cpphdl_n763) <+ cpphdl_channel(V(cpphdl_n709, cpphdl_n763), V(cpphdl_n763, cpphdl_n763), 0.040000000000000001, 0.69999999999999996, 1.0);
        // device 168, IC IC32, analog/basic/mos_track_hold.hpp:38
        I(cpphdl_n763, cpphdl_n763) <+ cpphdl_channel(V(TRACK1, cpphdl_n763), V(cpphdl_n763, cpphdl_n763), 0.02, 0.69999999999999996, -1.0);
        // device 169, IC IC32, analog/basic/mos_track_hold.hpp:39
        I(cpphdl_n763, Vss) <+ 2e-12 * ddt(V(cpphdl_n763, Vss)); // Bench initial voltage = 1.6499999999999999 V.
        // device 170, IC IC32, analog/basic/mos_track_hold.hpp:41
        I(Vss, cpphdl_n763) <+ V(Vss, cpphdl_n763) / 1000000000.0;
        // device 171, IC IC32, analog/basic/mos_track_hold.hpp:42
        I(TRACK1, cpphdl_n763) <+ 8.0000000000000006e-15 * ddt(V(TRACK1, cpphdl_n763)); // Bench initial voltage = -1.6499999999999999 V.
        // device 172, IC IC32, analog/basic/mos_track_hold.hpp:43
        I(cpphdl_n709, cpphdl_n763) <+ 8.0000000000000006e-15 * ddt(V(cpphdl_n709, cpphdl_n763)); // Bench initial voltage = 1.6499999999999999 V.
        // device 173, IC IC32, analog/basic/mos_track_hold.hpp:44
        I(cpphdl_n2705, cpphdl_n763) <+ 4.0000000000000003e-15 * ddt(V(cpphdl_n2705, cpphdl_n763)); // Bench initial voltage = 0.0 V.
        // device 174, IC IC35, analog/basic/inverter.hpp:11
        I(cpphdl_n724, Vdd) <+ cpphdl_channel(V(BIT_N1_0, Vdd), V(cpphdl_n724, Vdd), 0.080000000000000002, 0.69999999999999996, -1.0);
        // device 175, IC IC35, analog/basic/inverter.hpp:12
        I(cpphdl_n724, Vss) <+ cpphdl_channel(V(BIT_N1_0, Vss), V(cpphdl_n724, Vss), 0.080000000000000002, 0.69999999999999996, 1.0);
        // device 176, IC IC34, analog/basic/mos_r2r_dac.hpp:27
        I(cpphdl_n724, Vss) <+ 2.9999999999999998e-15 * ddt(V(cpphdl_n724, Vss)); // Bench initial voltage = 0.0 V.
        // device 177, IC IC34, analog/basic/mos_r2r_dac.hpp:28
        I(cpphdl_n724, cpphdl_n753) <+ V(cpphdl_n724, cpphdl_n753) / 2000.0;
        // device 178, IC IC34, analog/basic/mos_r2r_dac.hpp:29
        I(cpphdl_n753, Vss) <+ 2.9999999999999998e-15 * ddt(V(cpphdl_n753, Vss)); // Bench initial voltage = 0.0 V.
        // device 179, IC IC36, analog/basic/inverter.hpp:11
        I(cpphdl_n728, Vdd) <+ cpphdl_channel(V(BIT_N1_1, Vdd), V(cpphdl_n728, Vdd), 0.080000000000000002, 0.69999999999999996, -1.0);
        // device 180, IC IC36, analog/basic/inverter.hpp:12
        I(cpphdl_n728, Vss) <+ cpphdl_channel(V(BIT_N1_1, Vss), V(cpphdl_n728, Vss), 0.080000000000000002, 0.69999999999999996, 1.0);
        // device 181, IC IC34, analog/basic/mos_r2r_dac.hpp:27
        I(cpphdl_n728, Vss) <+ 2.9999999999999998e-15 * ddt(V(cpphdl_n728, Vss)); // Bench initial voltage = 0.0 V.
        // device 182, IC IC34, analog/basic/mos_r2r_dac.hpp:28
        I(cpphdl_n728, cpphdl_n754) <+ V(cpphdl_n728, cpphdl_n754) / 2000.0;
        // device 183, IC IC34, analog/basic/mos_r2r_dac.hpp:29
        I(cpphdl_n754, Vss) <+ 2.9999999999999998e-15 * ddt(V(cpphdl_n754, Vss)); // Bench initial voltage = 0.0 V.
        // device 184, IC IC34, analog/basic/mos_r2r_dac.hpp:31
        I(cpphdl_n753, cpphdl_n754) <+ V(cpphdl_n753, cpphdl_n754) / 1000.0;
        // device 185, IC IC37, analog/basic/inverter.hpp:11
        I(cpphdl_n732, Vdd) <+ cpphdl_channel(V(BIT_N1_2, Vdd), V(cpphdl_n732, Vdd), 0.080000000000000002, 0.69999999999999996, -1.0);
        // device 186, IC IC37, analog/basic/inverter.hpp:12
        I(cpphdl_n732, Vss) <+ cpphdl_channel(V(BIT_N1_2, Vss), V(cpphdl_n732, Vss), 0.080000000000000002, 0.69999999999999996, 1.0);
        // device 187, IC IC34, analog/basic/mos_r2r_dac.hpp:27
        I(cpphdl_n732, Vss) <+ 2.9999999999999998e-15 * ddt(V(cpphdl_n732, Vss)); // Bench initial voltage = 0.0 V.
        // device 188, IC IC34, analog/basic/mos_r2r_dac.hpp:28
        I(cpphdl_n732, cpphdl_n755) <+ V(cpphdl_n732, cpphdl_n755) / 2000.0;
        // device 189, IC IC34, analog/basic/mos_r2r_dac.hpp:29
        I(cpphdl_n755, Vss) <+ 2.9999999999999998e-15 * ddt(V(cpphdl_n755, Vss)); // Bench initial voltage = 0.0 V.
        // device 190, IC IC34, analog/basic/mos_r2r_dac.hpp:31
        I(cpphdl_n754, cpphdl_n755) <+ V(cpphdl_n754, cpphdl_n755) / 1000.0;
        // device 191, IC IC38, analog/basic/inverter.hpp:11
        I(cpphdl_n736, Vdd) <+ cpphdl_channel(V(BIT_N1_3, Vdd), V(cpphdl_n736, Vdd), 0.080000000000000002, 0.69999999999999996, -1.0);
        // device 192, IC IC38, analog/basic/inverter.hpp:12
        I(cpphdl_n736, Vss) <+ cpphdl_channel(V(BIT_N1_3, Vss), V(cpphdl_n736, Vss), 0.080000000000000002, 0.69999999999999996, 1.0);
        // device 193, IC IC34, analog/basic/mos_r2r_dac.hpp:27
        I(cpphdl_n736, Vss) <+ 2.9999999999999998e-15 * ddt(V(cpphdl_n736, Vss)); // Bench initial voltage = 0.0 V.
        // device 194, IC IC34, analog/basic/mos_r2r_dac.hpp:28
        I(cpphdl_n736, cpphdl_n756) <+ V(cpphdl_n736, cpphdl_n756) / 2000.0;
        // device 195, IC IC34, analog/basic/mos_r2r_dac.hpp:29
        I(cpphdl_n756, Vss) <+ 2.9999999999999998e-15 * ddt(V(cpphdl_n756, Vss)); // Bench initial voltage = 0.0 V.
        // device 196, IC IC34, analog/basic/mos_r2r_dac.hpp:31
        I(cpphdl_n755, cpphdl_n756) <+ V(cpphdl_n755, cpphdl_n756) / 1000.0;
        // device 197, IC IC39, analog/basic/inverter.hpp:11
        I(cpphdl_n740, Vdd) <+ cpphdl_channel(V(BIT_N1_4, Vdd), V(cpphdl_n740, Vdd), 0.080000000000000002, 0.69999999999999996, -1.0);
        // device 198, IC IC39, analog/basic/inverter.hpp:12
        I(cpphdl_n740, Vss) <+ cpphdl_channel(V(BIT_N1_4, Vss), V(cpphdl_n740, Vss), 0.080000000000000002, 0.69999999999999996, 1.0);
        // device 199, IC IC34, analog/basic/mos_r2r_dac.hpp:27
        I(cpphdl_n740, Vss) <+ 2.9999999999999998e-15 * ddt(V(cpphdl_n740, Vss)); // Bench initial voltage = 0.0 V.
        // device 200, IC IC34, analog/basic/mos_r2r_dac.hpp:28
        I(cpphdl_n740, cpphdl_n757) <+ V(cpphdl_n740, cpphdl_n757) / 2000.0;
        // device 201, IC IC34, analog/basic/mos_r2r_dac.hpp:29
        I(cpphdl_n757, Vss) <+ 2.9999999999999998e-15 * ddt(V(cpphdl_n757, Vss)); // Bench initial voltage = 0.0 V.
        // device 202, IC IC34, analog/basic/mos_r2r_dac.hpp:31
        I(cpphdl_n756, cpphdl_n757) <+ V(cpphdl_n756, cpphdl_n757) / 1000.0;
        // device 203, IC IC40, analog/basic/inverter.hpp:11
        I(cpphdl_n744, Vdd) <+ cpphdl_channel(V(BIT_N1_5, Vdd), V(cpphdl_n744, Vdd), 0.080000000000000002, 0.69999999999999996, -1.0);
        // device 204, IC IC40, analog/basic/inverter.hpp:12
        I(cpphdl_n744, Vss) <+ cpphdl_channel(V(BIT_N1_5, Vss), V(cpphdl_n744, Vss), 0.080000000000000002, 0.69999999999999996, 1.0);
        // device 205, IC IC34, analog/basic/mos_r2r_dac.hpp:27
        I(cpphdl_n744, Vss) <+ 2.9999999999999998e-15 * ddt(V(cpphdl_n744, Vss)); // Bench initial voltage = 0.0 V.
        // device 206, IC IC34, analog/basic/mos_r2r_dac.hpp:28
        I(cpphdl_n744, cpphdl_n758) <+ V(cpphdl_n744, cpphdl_n758) / 2000.0;
        // device 207, IC IC34, analog/basic/mos_r2r_dac.hpp:29
        I(cpphdl_n758, Vss) <+ 2.9999999999999998e-15 * ddt(V(cpphdl_n758, Vss)); // Bench initial voltage = 0.0 V.
        // device 208, IC IC34, analog/basic/mos_r2r_dac.hpp:31
        I(cpphdl_n757, cpphdl_n758) <+ V(cpphdl_n757, cpphdl_n758) / 1000.0;
        // device 209, IC IC41, analog/basic/inverter.hpp:11
        I(cpphdl_n748, Vdd) <+ cpphdl_channel(V(BIT_N1_6, Vdd), V(cpphdl_n748, Vdd), 0.080000000000000002, 0.69999999999999996, -1.0);
        // device 210, IC IC41, analog/basic/inverter.hpp:12
        I(cpphdl_n748, Vss) <+ cpphdl_channel(V(BIT_N1_6, Vss), V(cpphdl_n748, Vss), 0.080000000000000002, 0.69999999999999996, 1.0);
        // device 211, IC IC34, analog/basic/mos_r2r_dac.hpp:27
        I(cpphdl_n748, Vss) <+ 2.9999999999999998e-15 * ddt(V(cpphdl_n748, Vss)); // Bench initial voltage = 0.0 V.
        // device 212, IC IC34, analog/basic/mos_r2r_dac.hpp:28
        I(cpphdl_n748, cpphdl_n759) <+ V(cpphdl_n748, cpphdl_n759) / 2000.0;
        // device 213, IC IC34, analog/basic/mos_r2r_dac.hpp:29
        I(cpphdl_n759, Vss) <+ 2.9999999999999998e-15 * ddt(V(cpphdl_n759, Vss)); // Bench initial voltage = 0.0 V.
        // device 214, IC IC34, analog/basic/mos_r2r_dac.hpp:31
        I(cpphdl_n758, cpphdl_n759) <+ V(cpphdl_n758, cpphdl_n759) / 1000.0;
        // device 215, IC IC42, analog/basic/inverter.hpp:11
        I(cpphdl_n752, Vdd) <+ cpphdl_channel(V(BIT_N1_7, Vdd), V(cpphdl_n752, Vdd), 0.080000000000000002, 0.69999999999999996, -1.0);
        // device 216, IC IC42, analog/basic/inverter.hpp:12
        I(cpphdl_n752, Vss) <+ cpphdl_channel(V(BIT_N1_7, Vss), V(cpphdl_n752, Vss), 0.080000000000000002, 0.69999999999999996, 1.0);
        // device 217, IC IC34, analog/basic/mos_r2r_dac.hpp:27
        I(cpphdl_n752, Vss) <+ 2.9999999999999998e-15 * ddt(V(cpphdl_n752, Vss)); // Bench initial voltage = 0.0 V.
        // device 218, IC IC34, analog/basic/mos_r2r_dac.hpp:28
        I(cpphdl_n752, cpphdl_n764) <+ V(cpphdl_n752, cpphdl_n764) / 2000.0;
        // device 219, IC IC34, analog/basic/mos_r2r_dac.hpp:29
        I(cpphdl_n764, Vss) <+ 2.9999999999999998e-15 * ddt(V(cpphdl_n764, Vss)); // Bench initial voltage = 0.0 V.
        // device 220, IC IC34, analog/basic/mos_r2r_dac.hpp:31
        I(cpphdl_n759, cpphdl_n764) <+ V(cpphdl_n759, cpphdl_n764) / 1000.0;
        // device 221, IC IC34, analog/basic/mos_r2r_dac.hpp:33
        I(Vss, cpphdl_n753) <+ V(Vss, cpphdl_n753) / 2000.0;
        // device 222, IC IC43, analog/basic/nmos_resistor_amplifier.hpp:23
        I(Vdd, cpphdl_n773) <+ V(Vdd, cpphdl_n773) / 1000.0;
        // device 223, IC IC43, analog/basic/nmos_resistor_amplifier.hpp:24
        I(Vdd, cpphdl_n772) <+ V(Vdd, cpphdl_n772) / 1000.0;
        // device 224, IC IC43, analog/basic/nmos_resistor_amplifier.hpp:25
        I(cpphdl_n773, cpphdl_n767) <+ cpphdl_channel(V(cpphdl_n763, cpphdl_n767), V(cpphdl_n773, cpphdl_n767), 0.014999999999999999, 0.69999999999999996, 1.0);
        // device 225, IC IC43, analog/basic/nmos_resistor_amplifier.hpp:26
        I(cpphdl_n772, cpphdl_n768) <+ cpphdl_channel(V(cpphdl_n764, cpphdl_n768), V(cpphdl_n772, cpphdl_n768), 0.014999999999999999, 0.69999999999999996, 1.0);
        // device 226, IC IC43, analog/basic/nmos_resistor_amplifier.hpp:27
        I(cpphdl_n769, cpphdl_n767) <+ V(cpphdl_n769, cpphdl_n767) / 50.0;
        // device 227, IC IC43, analog/basic/nmos_resistor_amplifier.hpp:28
        I(cpphdl_n769, cpphdl_n768) <+ V(cpphdl_n769, cpphdl_n768) / 50.0;
        // device 228, IC IC43, analog/basic/nmos_resistor_amplifier.hpp:29
        I(Vss, cpphdl_n769) <+ V(Vss, cpphdl_n769) / 150.0;
        // device 229, IC IC43, analog/basic/nmos_resistor_amplifier.hpp:30
        I(cpphdl_n773, Vdd) <+ 2.9999999999999998e-13 * ddt(V(cpphdl_n773, Vdd)); // Bench initial voltage = 0.0 V.
        // device 230, IC IC43, analog/basic/nmos_resistor_amplifier.hpp:31
        I(cpphdl_n772, Vdd) <+ 2.9999999999999998e-13 * ddt(V(cpphdl_n772, Vdd)); // Bench initial voltage = 0.0 V.
        // device 231, IC IC43, analog/basic/nmos_resistor_amplifier.hpp:32
        I(cpphdl_n769, Vss) <+ 4e-14 * ddt(V(cpphdl_n769, Vss)); // Bench initial voltage = 0.0 V.
        // device 232, IC IC43, analog/basic/nmos_resistor_amplifier.hpp:34
        I(cpphdl_n763, cpphdl_n767) <+ 2e-14 * ddt(V(cpphdl_n763, cpphdl_n767)); // Bench initial voltage = 1.6499999999999999 V.
        // device 233, IC IC43, analog/basic/nmos_resistor_amplifier.hpp:35
        I(cpphdl_n764, cpphdl_n768) <+ 2e-14 * ddt(V(cpphdl_n764, cpphdl_n768)); // Bench initial voltage = 0.0 V.
        // device 234, IC IC43, analog/basic/nmos_resistor_amplifier.hpp:36
        I(cpphdl_n763, cpphdl_n773) <+ 2.9999999999999998e-15 * ddt(V(cpphdl_n763, cpphdl_n773)); // Bench initial voltage = -1.6499999999999999 V.
        // device 235, IC IC43, analog/basic/nmos_resistor_amplifier.hpp:37
        I(cpphdl_n764, cpphdl_n772) <+ 2.9999999999999998e-15 * ddt(V(cpphdl_n764, cpphdl_n772)); // Bench initial voltage = -3.2999999999999998 V.
        // device 236, IC IC44, analog/basic/strongarm_comparator.hpp:28
        I(cpphdl_n777, cpphdl_n779) <+ cpphdl_channel(V(cpphdl_n772, cpphdl_n779), V(cpphdl_n777, cpphdl_n779), 0.0080000000000000002, 0.69999999999999996, 1.0);
        // device 237, IC IC44, analog/basic/strongarm_comparator.hpp:29
        I(cpphdl_n778, cpphdl_n779) <+ cpphdl_channel(V(cpphdl_n773, cpphdl_n779), V(cpphdl_n778, cpphdl_n779), 0.0080000000000000002, 0.69999999999999996, 1.0);
        // device 238, IC IC44, analog/basic/strongarm_comparator.hpp:30
        I(cpphdl_n779, Vss) <+ cpphdl_channel(V(EVALUATE, Vss), V(cpphdl_n779, Vss), 0.0080000000000000002, 0.69999999999999996, 1.0);
        // device 239, IC IC44, analog/basic/strongarm_comparator.hpp:33
        I(cpphdl_n792, cpphdl_n777) <+ cpphdl_channel(V(cpphdl_n796, cpphdl_n777), V(cpphdl_n792, cpphdl_n777), 0.0040000000000000001, 0.69999999999999996, 1.0);
        // device 240, IC IC44, analog/basic/strongarm_comparator.hpp:34
        I(cpphdl_n796, cpphdl_n778) <+ cpphdl_channel(V(cpphdl_n792, cpphdl_n778), V(cpphdl_n796, cpphdl_n778), 0.0040000000000000001, 0.69999999999999996, 1.0);
        // device 241, IC IC44, analog/basic/strongarm_comparator.hpp:35
        I(cpphdl_n796, Vdd) <+ cpphdl_channel(V(cpphdl_n792, Vdd), V(cpphdl_n796, Vdd), 0.002, 0.69999999999999996, -1.0);
        // device 242, IC IC44, analog/basic/strongarm_comparator.hpp:36
        I(cpphdl_n792, Vdd) <+ cpphdl_channel(V(cpphdl_n796, Vdd), V(cpphdl_n792, Vdd), 0.002, 0.69999999999999996, -1.0);
        // device 243, IC IC44, analog/basic/strongarm_comparator.hpp:38
        I(cpphdl_n777, Vdd) <+ cpphdl_channel(V(EVALUATE, Vdd), V(cpphdl_n777, Vdd), 0.002, 0.69999999999999996, -1.0);
        // device 244, IC IC44, analog/basic/strongarm_comparator.hpp:39
        I(cpphdl_n778, Vdd) <+ cpphdl_channel(V(EVALUATE, Vdd), V(cpphdl_n778, Vdd), 0.002, 0.69999999999999996, -1.0);
        // device 245, IC IC44, analog/basic/strongarm_comparator.hpp:40
        I(cpphdl_n796, Vdd) <+ cpphdl_channel(V(EVALUATE, Vdd), V(cpphdl_n796, Vdd), 0.002, 0.69999999999999996, -1.0);
        // device 246, IC IC44, analog/basic/strongarm_comparator.hpp:41
        I(cpphdl_n792, Vdd) <+ cpphdl_channel(V(EVALUATE, Vdd), V(cpphdl_n792, Vdd), 0.002, 0.69999999999999996, -1.0);
        // device 247, IC IC44, analog/basic/strongarm_comparator.hpp:42
        I(cpphdl_n777, Vss) <+ 2.9999999999999998e-14 * ddt(V(cpphdl_n777, Vss)); // Bench initial voltage = 0.0 V.
        // device 248, IC IC44, analog/basic/strongarm_comparator.hpp:43
        I(cpphdl_n778, Vss) <+ 2.9999999999999998e-14 * ddt(V(cpphdl_n778, Vss)); // Bench initial voltage = 0.0 V.
        // device 249, IC IC44, analog/basic/strongarm_comparator.hpp:44
        I(cpphdl_n779, Vss) <+ 2.9999999999999998e-14 * ddt(V(cpphdl_n779, Vss)); // Bench initial voltage = 0.0 V.
        // device 250, IC IC44, analog/basic/strongarm_comparator.hpp:45
        I(cpphdl_n796, Vss) <+ 5.0000000000000002e-14 * ddt(V(cpphdl_n796, Vss)); // Bench initial voltage = 0.0 V.
        // device 251, IC IC44, analog/basic/strongarm_comparator.hpp:46
        I(cpphdl_n792, Vss) <+ 5.0000000000000002e-14 * ddt(V(cpphdl_n792, Vss)); // Bench initial voltage = 0.0 V.
        // device 252, IC IC44, analog/basic/strongarm_comparator.hpp:47
        I(cpphdl_n772, cpphdl_n779) <+ 2e-14 * ddt(V(cpphdl_n772, cpphdl_n779)); // Bench initial voltage = 3.2999999999999998 V.
        // device 253, IC IC44, analog/basic/strongarm_comparator.hpp:48
        I(cpphdl_n773, cpphdl_n779) <+ 2e-14 * ddt(V(cpphdl_n773, cpphdl_n779)); // Bench initial voltage = 3.2999999999999998 V.
        // device 254, IC IC44, analog/basic/strongarm_comparator.hpp:49
        I(cpphdl_n772, cpphdl_n777) <+ 2.9999999999999998e-15 * ddt(V(cpphdl_n772, cpphdl_n777)); // Bench initial voltage = 3.2999999999999998 V.
        // device 255, IC IC44, analog/basic/strongarm_comparator.hpp:50
        I(cpphdl_n773, cpphdl_n778) <+ 2.9999999999999998e-15 * ddt(V(cpphdl_n773, cpphdl_n778)); // Bench initial voltage = 3.2999999999999998 V.
        // device 256, IC IC46, analog/basic/inverter.hpp:11
        I(cpphdl_n800, Vdd) <+ cpphdl_channel(V(cpphdl_n792, Vdd), V(cpphdl_n800, Vdd), 0.001, 0.69999999999999996, -1.0);
        // device 257, IC IC46, analog/basic/inverter.hpp:12
        I(cpphdl_n800, Vss) <+ cpphdl_channel(V(cpphdl_n792, Vss), V(cpphdl_n800, Vss), 0.001, 0.69999999999999996, 1.0);
        // device 258, IC IC48, analog/basic/inverter.hpp:11
        I(cpphdl_n814, Vdd) <+ cpphdl_channel(V(cpphdl_n800, Vdd), V(cpphdl_n814, Vdd), 0.0040000000000000001, 0.69999999999999996, -1.0);
        // device 259, IC IC48, analog/basic/inverter.hpp:12
        I(cpphdl_n814, Vss) <+ cpphdl_channel(V(cpphdl_n800, Vss), V(cpphdl_n814, Vss), 0.0040000000000000001, 0.69999999999999996, 1.0);
        // device 260, IC IC45, analog/basic/buffered_nand_latch.hpp:34
        I(cpphdl_n792, Vss) <+ 2.0000000000000002e-15 * ddt(V(cpphdl_n792, Vss)); // Bench initial voltage = 0.0 V.
        // device 261, IC IC45, analog/basic/buffered_nand_latch.hpp:35
        I(cpphdl_n792, cpphdl_n800) <+ 1.0000000000000001e-15 * ddt(V(cpphdl_n792, cpphdl_n800)); // Bench initial voltage = 0.0 V.
        // device 262, IC IC45, analog/basic/buffered_nand_latch.hpp:36
        I(cpphdl_n800, Vss) <+ 5e-15 * ddt(V(cpphdl_n800, Vss)); // Bench initial voltage = 0.0 V.
        // device 263, IC IC45, analog/basic/buffered_nand_latch.hpp:37
        I(cpphdl_n800, Vss) <+ 8.0000000000000006e-15 * ddt(V(cpphdl_n800, Vss)); // Bench initial voltage = 0.0 V.
        // device 264, IC IC45, analog/basic/buffered_nand_latch.hpp:38
        I(cpphdl_n814, Vss) <+ 1e-14 * ddt(V(cpphdl_n814, Vss)); // Bench initial voltage = 0.0 V.
        // device 265, IC IC47, analog/basic/inverter.hpp:11
        I(cpphdl_n804, Vdd) <+ cpphdl_channel(V(cpphdl_n796, Vdd), V(cpphdl_n804, Vdd), 0.001, 0.69999999999999996, -1.0);
        // device 266, IC IC47, analog/basic/inverter.hpp:12
        I(cpphdl_n804, Vss) <+ cpphdl_channel(V(cpphdl_n796, Vss), V(cpphdl_n804, Vss), 0.001, 0.69999999999999996, 1.0);
        // device 267, IC IC49, analog/basic/inverter.hpp:11
        I(cpphdl_n820, Vdd) <+ cpphdl_channel(V(cpphdl_n804, Vdd), V(cpphdl_n820, Vdd), 0.0040000000000000001, 0.69999999999999996, -1.0);
        // device 268, IC IC49, analog/basic/inverter.hpp:12
        I(cpphdl_n820, Vss) <+ cpphdl_channel(V(cpphdl_n804, Vss), V(cpphdl_n820, Vss), 0.0040000000000000001, 0.69999999999999996, 1.0);
        // device 269, IC IC45, analog/basic/buffered_nand_latch.hpp:34
        I(cpphdl_n796, Vss) <+ 2.0000000000000002e-15 * ddt(V(cpphdl_n796, Vss)); // Bench initial voltage = 0.0 V.
        // device 270, IC IC45, analog/basic/buffered_nand_latch.hpp:35
        I(cpphdl_n796, cpphdl_n804) <+ 1.0000000000000001e-15 * ddt(V(cpphdl_n796, cpphdl_n804)); // Bench initial voltage = 0.0 V.
        // device 271, IC IC45, analog/basic/buffered_nand_latch.hpp:36
        I(cpphdl_n804, Vss) <+ 5e-15 * ddt(V(cpphdl_n804, Vss)); // Bench initial voltage = 0.0 V.
        // device 272, IC IC45, analog/basic/buffered_nand_latch.hpp:37
        I(cpphdl_n804, Vss) <+ 8.0000000000000006e-15 * ddt(V(cpphdl_n804, Vss)); // Bench initial voltage = 0.0 V.
        // device 273, IC IC45, analog/basic/buffered_nand_latch.hpp:38
        I(cpphdl_n820, Vss) <+ 1e-14 * ddt(V(cpphdl_n820, Vss)); // Bench initial voltage = 0.0 V.
        // device 274, IC IC51, analog/basic/cmos_logic.hpp:17
        I(cpphdl_n2855, Vss) <+ 5.0000000000000002e-14 * ddt(V(cpphdl_n2855, Vss)); // Bench initial voltage = 0.0 V.
        // device 275, IC IC51, analog/basic/cmos_logic.hpp:18
        I(cpphdl_n2855, Vdd) <+ cpphdl_channel(V(cpphdl_n814, Vdd), V(cpphdl_n2855, Vdd), 0.01, 0.69999999999999996, -1.0);
        // device 276, IC IC51, analog/basic/cmos_logic.hpp:19
        I(cpphdl_n2855, Vdd) <+ cpphdl_channel(V(cpphdl_n822, Vdd), V(cpphdl_n2855, Vdd), 0.01, 0.69999999999999996, -1.0);
        // device 277, IC IC51, analog/basic/cmos_logic.hpp:20
        I(cpphdl_n2855, cpphdl_n817) <+ cpphdl_channel(V(cpphdl_n814, cpphdl_n817), V(cpphdl_n2855, cpphdl_n817), 0.01, 0.69999999999999996, 1.0);
        // device 278, IC IC51, analog/basic/cmos_logic.hpp:21
        I(cpphdl_n817, Vss) <+ cpphdl_channel(V(cpphdl_n822, Vss), V(cpphdl_n817, Vss), 0.01, 0.69999999999999996, 1.0);
        // device 279, IC IC51, analog/basic/cmos_logic.hpp:23
        I(cpphdl_n2855, Vss) <+ V(cpphdl_n2855, Vss) / 1000000000.0;
        // device 280, IC IC51, analog/basic/cmos_logic.hpp:24
        I(cpphdl_n817, Vss) <+ V(cpphdl_n817, Vss) / 1000000000.0;
        // device 281, IC IC52, analog/basic/cmos_logic.hpp:17
        I(cpphdl_n822, Vss) <+ 5.0000000000000002e-14 * ddt(V(cpphdl_n822, Vss)); // Bench initial voltage = 0.0 V.
        // device 282, IC IC52, analog/basic/cmos_logic.hpp:18
        I(cpphdl_n822, Vdd) <+ cpphdl_channel(V(cpphdl_n820, Vdd), V(cpphdl_n822, Vdd), 0.01, 0.69999999999999996, -1.0);
        // device 283, IC IC52, analog/basic/cmos_logic.hpp:19
        I(cpphdl_n822, Vdd) <+ cpphdl_channel(V(cpphdl_n2855, Vdd), V(cpphdl_n822, Vdd), 0.01, 0.69999999999999996, -1.0);
        // device 284, IC IC52, analog/basic/cmos_logic.hpp:20
        I(cpphdl_n822, cpphdl_n823) <+ cpphdl_channel(V(cpphdl_n820, cpphdl_n823), V(cpphdl_n822, cpphdl_n823), 0.01, 0.69999999999999996, 1.0);
        // device 285, IC IC52, analog/basic/cmos_logic.hpp:21
        I(cpphdl_n823, Vss) <+ cpphdl_channel(V(cpphdl_n2855, Vss), V(cpphdl_n823, Vss), 0.01, 0.69999999999999996, 1.0);
        // device 286, IC IC52, analog/basic/cmos_logic.hpp:23
        I(cpphdl_n822, Vss) <+ V(cpphdl_n822, Vss) / 1000000000.0;
        // device 287, IC IC52, analog/basic/cmos_logic.hpp:24
        I(cpphdl_n823, Vss) <+ V(cpphdl_n823, Vss) / 1000000000.0;
        // device 288, IC IC50, analog/basic/nand_latch.hpp:36
        I(cpphdl_n814, Vss) <+ 2.9999999999999998e-15 * ddt(V(cpphdl_n814, Vss)); // Bench initial voltage = 0.0 V.
        // device 289, IC IC50, analog/basic/nand_latch.hpp:37
        I(cpphdl_n820, Vss) <+ 2.9999999999999998e-15 * ddt(V(cpphdl_n820, Vss)); // Bench initial voltage = 0.0 V.
        // device 290, IC IC53, analog/basic/inverter.hpp:11
        I(cpphdl_n828, Vdd) <+ cpphdl_channel(V(CLEAR, Vdd), V(cpphdl_n828, Vdd), 0.01, 0.69999999999999996, -1.0);
        // device 291, IC IC53, analog/basic/inverter.hpp:12
        I(cpphdl_n828, Vss) <+ cpphdl_channel(V(CLEAR, Vss), V(cpphdl_n828, Vss), 0.01, 0.69999999999999996, 1.0);
        // device 292, IC IC50, analog/basic/nand_latch.hpp:58
        I(cpphdl_n828, Vss) <+ 2.9999999999999998e-15 * ddt(V(cpphdl_n828, Vss)); // Bench initial voltage = 0.0 V.
        // device 293, IC IC50, analog/basic/nand_latch.hpp:59
        I(cpphdl_n2855, Vss) <+ cpphdl_channel(V(CLEAR, Vss), V(cpphdl_n2855, Vss), 0.050000000000000003, 0.69999999999999996, 1.0);
        // device 294, IC IC50, analog/basic/nand_latch.hpp:60
        I(cpphdl_n822, Vdd) <+ cpphdl_channel(V(cpphdl_n828, Vdd), V(cpphdl_n822, Vdd), 0.050000000000000003, 0.69999999999999996, -1.0);
        // device 295, IC IC56, analog/basic/inverter.hpp:11
        I(cpphdl_n852, Vdd) <+ cpphdl_channel(V(TRACK2, Vdd), V(cpphdl_n852, Vdd), 0.0040000000000000001, 0.69999999999999996, -1.0);
        // device 296, IC IC56, analog/basic/inverter.hpp:12
        I(cpphdl_n852, Vss) <+ cpphdl_channel(V(TRACK2, Vss), V(cpphdl_n852, Vss), 0.0040000000000000001, 0.69999999999999996, 1.0);
        // device 297, IC IC55, analog/basic/mos_track_hold.hpp:31
        I(cpphdl_n852, Vss) <+ 2e-14 * ddt(V(cpphdl_n852, Vss)); // Bench initial voltage = 3.2999999999999998 V.
        // device 298, IC IC55, analog/basic/mos_track_hold.hpp:32
        I(cpphdl_n2705, cpphdl_n906) <+ cpphdl_channel(V(TRACK2, cpphdl_n906), V(cpphdl_n2705, cpphdl_n906), 0.080000000000000002, 0.69999999999999996, 1.0);
        // device 299, IC IC55, analog/basic/mos_track_hold.hpp:33
        I(cpphdl_n906, cpphdl_n2705) <+ cpphdl_channel(V(cpphdl_n852, cpphdl_n2705), V(cpphdl_n906, cpphdl_n2705), 0.040000000000000001, 0.69999999999999996, -1.0);
        // device 300, IC IC55, analog/basic/mos_track_hold.hpp:37
        I(cpphdl_n906, cpphdl_n906) <+ cpphdl_channel(V(cpphdl_n852, cpphdl_n906), V(cpphdl_n906, cpphdl_n906), 0.040000000000000001, 0.69999999999999996, 1.0);
        // device 301, IC IC55, analog/basic/mos_track_hold.hpp:38
        I(cpphdl_n906, cpphdl_n906) <+ cpphdl_channel(V(TRACK2, cpphdl_n906), V(cpphdl_n906, cpphdl_n906), 0.02, 0.69999999999999996, -1.0);
        // device 302, IC IC55, analog/basic/mos_track_hold.hpp:39
        I(cpphdl_n906, Vss) <+ 2e-12 * ddt(V(cpphdl_n906, Vss)); // Bench initial voltage = 1.6499999999999999 V.
        // device 303, IC IC55, analog/basic/mos_track_hold.hpp:41
        I(Vss, cpphdl_n906) <+ V(Vss, cpphdl_n906) / 1000000000.0;
        // device 304, IC IC55, analog/basic/mos_track_hold.hpp:42
        I(TRACK2, cpphdl_n906) <+ 8.0000000000000006e-15 * ddt(V(TRACK2, cpphdl_n906)); // Bench initial voltage = -1.6499999999999999 V.
        // device 305, IC IC55, analog/basic/mos_track_hold.hpp:43
        I(cpphdl_n852, cpphdl_n906) <+ 8.0000000000000006e-15 * ddt(V(cpphdl_n852, cpphdl_n906)); // Bench initial voltage = 1.6499999999999999 V.
        // device 306, IC IC55, analog/basic/mos_track_hold.hpp:44
        I(cpphdl_n2705, cpphdl_n906) <+ 4.0000000000000003e-15 * ddt(V(cpphdl_n2705, cpphdl_n906)); // Bench initial voltage = 0.0 V.
        // device 307, IC IC58, analog/basic/inverter.hpp:11
        I(cpphdl_n867, Vdd) <+ cpphdl_channel(V(BIT_N2_0, Vdd), V(cpphdl_n867, Vdd), 0.080000000000000002, 0.69999999999999996, -1.0);
        // device 308, IC IC58, analog/basic/inverter.hpp:12
        I(cpphdl_n867, Vss) <+ cpphdl_channel(V(BIT_N2_0, Vss), V(cpphdl_n867, Vss), 0.080000000000000002, 0.69999999999999996, 1.0);
        // device 309, IC IC57, analog/basic/mos_r2r_dac.hpp:27
        I(cpphdl_n867, Vss) <+ 2.9999999999999998e-15 * ddt(V(cpphdl_n867, Vss)); // Bench initial voltage = 0.0 V.
        // device 310, IC IC57, analog/basic/mos_r2r_dac.hpp:28
        I(cpphdl_n867, cpphdl_n896) <+ V(cpphdl_n867, cpphdl_n896) / 2000.0;
        // device 311, IC IC57, analog/basic/mos_r2r_dac.hpp:29
        I(cpphdl_n896, Vss) <+ 2.9999999999999998e-15 * ddt(V(cpphdl_n896, Vss)); // Bench initial voltage = 0.0 V.
        // device 312, IC IC59, analog/basic/inverter.hpp:11
        I(cpphdl_n871, Vdd) <+ cpphdl_channel(V(BIT_N2_1, Vdd), V(cpphdl_n871, Vdd), 0.080000000000000002, 0.69999999999999996, -1.0);
        // device 313, IC IC59, analog/basic/inverter.hpp:12
        I(cpphdl_n871, Vss) <+ cpphdl_channel(V(BIT_N2_1, Vss), V(cpphdl_n871, Vss), 0.080000000000000002, 0.69999999999999996, 1.0);
        // device 314, IC IC57, analog/basic/mos_r2r_dac.hpp:27
        I(cpphdl_n871, Vss) <+ 2.9999999999999998e-15 * ddt(V(cpphdl_n871, Vss)); // Bench initial voltage = 0.0 V.
        // device 315, IC IC57, analog/basic/mos_r2r_dac.hpp:28
        I(cpphdl_n871, cpphdl_n897) <+ V(cpphdl_n871, cpphdl_n897) / 2000.0;
        // device 316, IC IC57, analog/basic/mos_r2r_dac.hpp:29
        I(cpphdl_n897, Vss) <+ 2.9999999999999998e-15 * ddt(V(cpphdl_n897, Vss)); // Bench initial voltage = 0.0 V.
        // device 317, IC IC57, analog/basic/mos_r2r_dac.hpp:31
        I(cpphdl_n896, cpphdl_n897) <+ V(cpphdl_n896, cpphdl_n897) / 1000.0;
        // device 318, IC IC60, analog/basic/inverter.hpp:11
        I(cpphdl_n875, Vdd) <+ cpphdl_channel(V(BIT_N2_2, Vdd), V(cpphdl_n875, Vdd), 0.080000000000000002, 0.69999999999999996, -1.0);
        // device 319, IC IC60, analog/basic/inverter.hpp:12
        I(cpphdl_n875, Vss) <+ cpphdl_channel(V(BIT_N2_2, Vss), V(cpphdl_n875, Vss), 0.080000000000000002, 0.69999999999999996, 1.0);
        // device 320, IC IC57, analog/basic/mos_r2r_dac.hpp:27
        I(cpphdl_n875, Vss) <+ 2.9999999999999998e-15 * ddt(V(cpphdl_n875, Vss)); // Bench initial voltage = 0.0 V.
        // device 321, IC IC57, analog/basic/mos_r2r_dac.hpp:28
        I(cpphdl_n875, cpphdl_n898) <+ V(cpphdl_n875, cpphdl_n898) / 2000.0;
        // device 322, IC IC57, analog/basic/mos_r2r_dac.hpp:29
        I(cpphdl_n898, Vss) <+ 2.9999999999999998e-15 * ddt(V(cpphdl_n898, Vss)); // Bench initial voltage = 0.0 V.
        // device 323, IC IC57, analog/basic/mos_r2r_dac.hpp:31
        I(cpphdl_n897, cpphdl_n898) <+ V(cpphdl_n897, cpphdl_n898) / 1000.0;
        // device 324, IC IC61, analog/basic/inverter.hpp:11
        I(cpphdl_n879, Vdd) <+ cpphdl_channel(V(BIT_N2_3, Vdd), V(cpphdl_n879, Vdd), 0.080000000000000002, 0.69999999999999996, -1.0);
        // device 325, IC IC61, analog/basic/inverter.hpp:12
        I(cpphdl_n879, Vss) <+ cpphdl_channel(V(BIT_N2_3, Vss), V(cpphdl_n879, Vss), 0.080000000000000002, 0.69999999999999996, 1.0);
        // device 326, IC IC57, analog/basic/mos_r2r_dac.hpp:27
        I(cpphdl_n879, Vss) <+ 2.9999999999999998e-15 * ddt(V(cpphdl_n879, Vss)); // Bench initial voltage = 0.0 V.
        // device 327, IC IC57, analog/basic/mos_r2r_dac.hpp:28
        I(cpphdl_n879, cpphdl_n899) <+ V(cpphdl_n879, cpphdl_n899) / 2000.0;
        // device 328, IC IC57, analog/basic/mos_r2r_dac.hpp:29
        I(cpphdl_n899, Vss) <+ 2.9999999999999998e-15 * ddt(V(cpphdl_n899, Vss)); // Bench initial voltage = 0.0 V.
        // device 329, IC IC57, analog/basic/mos_r2r_dac.hpp:31
        I(cpphdl_n898, cpphdl_n899) <+ V(cpphdl_n898, cpphdl_n899) / 1000.0;
        // device 330, IC IC62, analog/basic/inverter.hpp:11
        I(cpphdl_n883, Vdd) <+ cpphdl_channel(V(BIT_N2_4, Vdd), V(cpphdl_n883, Vdd), 0.080000000000000002, 0.69999999999999996, -1.0);
        // device 331, IC IC62, analog/basic/inverter.hpp:12
        I(cpphdl_n883, Vss) <+ cpphdl_channel(V(BIT_N2_4, Vss), V(cpphdl_n883, Vss), 0.080000000000000002, 0.69999999999999996, 1.0);
        // device 332, IC IC57, analog/basic/mos_r2r_dac.hpp:27
        I(cpphdl_n883, Vss) <+ 2.9999999999999998e-15 * ddt(V(cpphdl_n883, Vss)); // Bench initial voltage = 0.0 V.
        // device 333, IC IC57, analog/basic/mos_r2r_dac.hpp:28
        I(cpphdl_n883, cpphdl_n900) <+ V(cpphdl_n883, cpphdl_n900) / 2000.0;
        // device 334, IC IC57, analog/basic/mos_r2r_dac.hpp:29
        I(cpphdl_n900, Vss) <+ 2.9999999999999998e-15 * ddt(V(cpphdl_n900, Vss)); // Bench initial voltage = 0.0 V.
        // device 335, IC IC57, analog/basic/mos_r2r_dac.hpp:31
        I(cpphdl_n899, cpphdl_n900) <+ V(cpphdl_n899, cpphdl_n900) / 1000.0;
        // device 336, IC IC63, analog/basic/inverter.hpp:11
        I(cpphdl_n887, Vdd) <+ cpphdl_channel(V(BIT_N2_5, Vdd), V(cpphdl_n887, Vdd), 0.080000000000000002, 0.69999999999999996, -1.0);
        // device 337, IC IC63, analog/basic/inverter.hpp:12
        I(cpphdl_n887, Vss) <+ cpphdl_channel(V(BIT_N2_5, Vss), V(cpphdl_n887, Vss), 0.080000000000000002, 0.69999999999999996, 1.0);
        // device 338, IC IC57, analog/basic/mos_r2r_dac.hpp:27
        I(cpphdl_n887, Vss) <+ 2.9999999999999998e-15 * ddt(V(cpphdl_n887, Vss)); // Bench initial voltage = 0.0 V.
        // device 339, IC IC57, analog/basic/mos_r2r_dac.hpp:28
        I(cpphdl_n887, cpphdl_n901) <+ V(cpphdl_n887, cpphdl_n901) / 2000.0;
        // device 340, IC IC57, analog/basic/mos_r2r_dac.hpp:29
        I(cpphdl_n901, Vss) <+ 2.9999999999999998e-15 * ddt(V(cpphdl_n901, Vss)); // Bench initial voltage = 0.0 V.
        // device 341, IC IC57, analog/basic/mos_r2r_dac.hpp:31
        I(cpphdl_n900, cpphdl_n901) <+ V(cpphdl_n900, cpphdl_n901) / 1000.0;
        // device 342, IC IC64, analog/basic/inverter.hpp:11
        I(cpphdl_n891, Vdd) <+ cpphdl_channel(V(BIT_N2_6, Vdd), V(cpphdl_n891, Vdd), 0.080000000000000002, 0.69999999999999996, -1.0);
        // device 343, IC IC64, analog/basic/inverter.hpp:12
        I(cpphdl_n891, Vss) <+ cpphdl_channel(V(BIT_N2_6, Vss), V(cpphdl_n891, Vss), 0.080000000000000002, 0.69999999999999996, 1.0);
        // device 344, IC IC57, analog/basic/mos_r2r_dac.hpp:27
        I(cpphdl_n891, Vss) <+ 2.9999999999999998e-15 * ddt(V(cpphdl_n891, Vss)); // Bench initial voltage = 0.0 V.
        // device 345, IC IC57, analog/basic/mos_r2r_dac.hpp:28
        I(cpphdl_n891, cpphdl_n902) <+ V(cpphdl_n891, cpphdl_n902) / 2000.0;
        // device 346, IC IC57, analog/basic/mos_r2r_dac.hpp:29
        I(cpphdl_n902, Vss) <+ 2.9999999999999998e-15 * ddt(V(cpphdl_n902, Vss)); // Bench initial voltage = 0.0 V.
        // device 347, IC IC57, analog/basic/mos_r2r_dac.hpp:31
        I(cpphdl_n901, cpphdl_n902) <+ V(cpphdl_n901, cpphdl_n902) / 1000.0;
        // device 348, IC IC65, analog/basic/inverter.hpp:11
        I(cpphdl_n895, Vdd) <+ cpphdl_channel(V(BIT_N2_7, Vdd), V(cpphdl_n895, Vdd), 0.080000000000000002, 0.69999999999999996, -1.0);
        // device 349, IC IC65, analog/basic/inverter.hpp:12
        I(cpphdl_n895, Vss) <+ cpphdl_channel(V(BIT_N2_7, Vss), V(cpphdl_n895, Vss), 0.080000000000000002, 0.69999999999999996, 1.0);
        // device 350, IC IC57, analog/basic/mos_r2r_dac.hpp:27
        I(cpphdl_n895, Vss) <+ 2.9999999999999998e-15 * ddt(V(cpphdl_n895, Vss)); // Bench initial voltage = 0.0 V.
        // device 351, IC IC57, analog/basic/mos_r2r_dac.hpp:28
        I(cpphdl_n895, cpphdl_n907) <+ V(cpphdl_n895, cpphdl_n907) / 2000.0;
        // device 352, IC IC57, analog/basic/mos_r2r_dac.hpp:29
        I(cpphdl_n907, Vss) <+ 2.9999999999999998e-15 * ddt(V(cpphdl_n907, Vss)); // Bench initial voltage = 0.0 V.
        // device 353, IC IC57, analog/basic/mos_r2r_dac.hpp:31
        I(cpphdl_n902, cpphdl_n907) <+ V(cpphdl_n902, cpphdl_n907) / 1000.0;
        // device 354, IC IC57, analog/basic/mos_r2r_dac.hpp:33
        I(Vss, cpphdl_n896) <+ V(Vss, cpphdl_n896) / 2000.0;
        // device 355, IC IC66, analog/basic/nmos_resistor_amplifier.hpp:23
        I(Vdd, cpphdl_n916) <+ V(Vdd, cpphdl_n916) / 1000.0;
        // device 356, IC IC66, analog/basic/nmos_resistor_amplifier.hpp:24
        I(Vdd, cpphdl_n915) <+ V(Vdd, cpphdl_n915) / 1000.0;
        // device 357, IC IC66, analog/basic/nmos_resistor_amplifier.hpp:25
        I(cpphdl_n916, cpphdl_n910) <+ cpphdl_channel(V(cpphdl_n906, cpphdl_n910), V(cpphdl_n916, cpphdl_n910), 0.014999999999999999, 0.69999999999999996, 1.0);
        // device 358, IC IC66, analog/basic/nmos_resistor_amplifier.hpp:26
        I(cpphdl_n915, cpphdl_n911) <+ cpphdl_channel(V(cpphdl_n907, cpphdl_n911), V(cpphdl_n915, cpphdl_n911), 0.014999999999999999, 0.69999999999999996, 1.0);
        // device 359, IC IC66, analog/basic/nmos_resistor_amplifier.hpp:27
        I(cpphdl_n912, cpphdl_n910) <+ V(cpphdl_n912, cpphdl_n910) / 50.0;
        // device 360, IC IC66, analog/basic/nmos_resistor_amplifier.hpp:28
        I(cpphdl_n912, cpphdl_n911) <+ V(cpphdl_n912, cpphdl_n911) / 50.0;
        // device 361, IC IC66, analog/basic/nmos_resistor_amplifier.hpp:29
        I(Vss, cpphdl_n912) <+ V(Vss, cpphdl_n912) / 150.0;
        // device 362, IC IC66, analog/basic/nmos_resistor_amplifier.hpp:30
        I(cpphdl_n916, Vdd) <+ 2.9999999999999998e-13 * ddt(V(cpphdl_n916, Vdd)); // Bench initial voltage = 0.0 V.
        // device 363, IC IC66, analog/basic/nmos_resistor_amplifier.hpp:31
        I(cpphdl_n915, Vdd) <+ 2.9999999999999998e-13 * ddt(V(cpphdl_n915, Vdd)); // Bench initial voltage = 0.0 V.
        // device 364, IC IC66, analog/basic/nmos_resistor_amplifier.hpp:32
        I(cpphdl_n912, Vss) <+ 4e-14 * ddt(V(cpphdl_n912, Vss)); // Bench initial voltage = 0.0 V.
        // device 365, IC IC66, analog/basic/nmos_resistor_amplifier.hpp:34
        I(cpphdl_n906, cpphdl_n910) <+ 2e-14 * ddt(V(cpphdl_n906, cpphdl_n910)); // Bench initial voltage = 1.6499999999999999 V.
        // device 366, IC IC66, analog/basic/nmos_resistor_amplifier.hpp:35
        I(cpphdl_n907, cpphdl_n911) <+ 2e-14 * ddt(V(cpphdl_n907, cpphdl_n911)); // Bench initial voltage = 0.0 V.
        // device 367, IC IC66, analog/basic/nmos_resistor_amplifier.hpp:36
        I(cpphdl_n906, cpphdl_n916) <+ 2.9999999999999998e-15 * ddt(V(cpphdl_n906, cpphdl_n916)); // Bench initial voltage = -1.6499999999999999 V.
        // device 368, IC IC66, analog/basic/nmos_resistor_amplifier.hpp:37
        I(cpphdl_n907, cpphdl_n915) <+ 2.9999999999999998e-15 * ddt(V(cpphdl_n907, cpphdl_n915)); // Bench initial voltage = -3.2999999999999998 V.
        // device 369, IC IC67, analog/basic/strongarm_comparator.hpp:28
        I(cpphdl_n920, cpphdl_n922) <+ cpphdl_channel(V(cpphdl_n915, cpphdl_n922), V(cpphdl_n920, cpphdl_n922), 0.0080000000000000002, 0.69999999999999996, 1.0);
        // device 370, IC IC67, analog/basic/strongarm_comparator.hpp:29
        I(cpphdl_n921, cpphdl_n922) <+ cpphdl_channel(V(cpphdl_n916, cpphdl_n922), V(cpphdl_n921, cpphdl_n922), 0.0080000000000000002, 0.69999999999999996, 1.0);
        // device 371, IC IC67, analog/basic/strongarm_comparator.hpp:30
        I(cpphdl_n922, Vss) <+ cpphdl_channel(V(EVALUATE, Vss), V(cpphdl_n922, Vss), 0.0080000000000000002, 0.69999999999999996, 1.0);
        // device 372, IC IC67, analog/basic/strongarm_comparator.hpp:33
        I(cpphdl_n935, cpphdl_n920) <+ cpphdl_channel(V(cpphdl_n939, cpphdl_n920), V(cpphdl_n935, cpphdl_n920), 0.0040000000000000001, 0.69999999999999996, 1.0);
        // device 373, IC IC67, analog/basic/strongarm_comparator.hpp:34
        I(cpphdl_n939, cpphdl_n921) <+ cpphdl_channel(V(cpphdl_n935, cpphdl_n921), V(cpphdl_n939, cpphdl_n921), 0.0040000000000000001, 0.69999999999999996, 1.0);
        // device 374, IC IC67, analog/basic/strongarm_comparator.hpp:35
        I(cpphdl_n939, Vdd) <+ cpphdl_channel(V(cpphdl_n935, Vdd), V(cpphdl_n939, Vdd), 0.002, 0.69999999999999996, -1.0);
        // device 375, IC IC67, analog/basic/strongarm_comparator.hpp:36
        I(cpphdl_n935, Vdd) <+ cpphdl_channel(V(cpphdl_n939, Vdd), V(cpphdl_n935, Vdd), 0.002, 0.69999999999999996, -1.0);
        // device 376, IC IC67, analog/basic/strongarm_comparator.hpp:38
        I(cpphdl_n920, Vdd) <+ cpphdl_channel(V(EVALUATE, Vdd), V(cpphdl_n920, Vdd), 0.002, 0.69999999999999996, -1.0);
        // device 377, IC IC67, analog/basic/strongarm_comparator.hpp:39
        I(cpphdl_n921, Vdd) <+ cpphdl_channel(V(EVALUATE, Vdd), V(cpphdl_n921, Vdd), 0.002, 0.69999999999999996, -1.0);
        // device 378, IC IC67, analog/basic/strongarm_comparator.hpp:40
        I(cpphdl_n939, Vdd) <+ cpphdl_channel(V(EVALUATE, Vdd), V(cpphdl_n939, Vdd), 0.002, 0.69999999999999996, -1.0);
        // device 379, IC IC67, analog/basic/strongarm_comparator.hpp:41
        I(cpphdl_n935, Vdd) <+ cpphdl_channel(V(EVALUATE, Vdd), V(cpphdl_n935, Vdd), 0.002, 0.69999999999999996, -1.0);
        // device 380, IC IC67, analog/basic/strongarm_comparator.hpp:42
        I(cpphdl_n920, Vss) <+ 2.9999999999999998e-14 * ddt(V(cpphdl_n920, Vss)); // Bench initial voltage = 0.0 V.
        // device 381, IC IC67, analog/basic/strongarm_comparator.hpp:43
        I(cpphdl_n921, Vss) <+ 2.9999999999999998e-14 * ddt(V(cpphdl_n921, Vss)); // Bench initial voltage = 0.0 V.
        // device 382, IC IC67, analog/basic/strongarm_comparator.hpp:44
        I(cpphdl_n922, Vss) <+ 2.9999999999999998e-14 * ddt(V(cpphdl_n922, Vss)); // Bench initial voltage = 0.0 V.
        // device 383, IC IC67, analog/basic/strongarm_comparator.hpp:45
        I(cpphdl_n939, Vss) <+ 5.0000000000000002e-14 * ddt(V(cpphdl_n939, Vss)); // Bench initial voltage = 0.0 V.
        // device 384, IC IC67, analog/basic/strongarm_comparator.hpp:46
        I(cpphdl_n935, Vss) <+ 5.0000000000000002e-14 * ddt(V(cpphdl_n935, Vss)); // Bench initial voltage = 0.0 V.
        // device 385, IC IC67, analog/basic/strongarm_comparator.hpp:47
        I(cpphdl_n915, cpphdl_n922) <+ 2e-14 * ddt(V(cpphdl_n915, cpphdl_n922)); // Bench initial voltage = 3.2999999999999998 V.
        // device 386, IC IC67, analog/basic/strongarm_comparator.hpp:48
        I(cpphdl_n916, cpphdl_n922) <+ 2e-14 * ddt(V(cpphdl_n916, cpphdl_n922)); // Bench initial voltage = 3.2999999999999998 V.
        // device 387, IC IC67, analog/basic/strongarm_comparator.hpp:49
        I(cpphdl_n915, cpphdl_n920) <+ 2.9999999999999998e-15 * ddt(V(cpphdl_n915, cpphdl_n920)); // Bench initial voltage = 3.2999999999999998 V.
        // device 388, IC IC67, analog/basic/strongarm_comparator.hpp:50
        I(cpphdl_n916, cpphdl_n921) <+ 2.9999999999999998e-15 * ddt(V(cpphdl_n916, cpphdl_n921)); // Bench initial voltage = 3.2999999999999998 V.
        // device 389, IC IC69, analog/basic/inverter.hpp:11
        I(cpphdl_n943, Vdd) <+ cpphdl_channel(V(cpphdl_n935, Vdd), V(cpphdl_n943, Vdd), 0.001, 0.69999999999999996, -1.0);
        // device 390, IC IC69, analog/basic/inverter.hpp:12
        I(cpphdl_n943, Vss) <+ cpphdl_channel(V(cpphdl_n935, Vss), V(cpphdl_n943, Vss), 0.001, 0.69999999999999996, 1.0);
        // device 391, IC IC71, analog/basic/inverter.hpp:11
        I(cpphdl_n957, Vdd) <+ cpphdl_channel(V(cpphdl_n943, Vdd), V(cpphdl_n957, Vdd), 0.0040000000000000001, 0.69999999999999996, -1.0);
        // device 392, IC IC71, analog/basic/inverter.hpp:12
        I(cpphdl_n957, Vss) <+ cpphdl_channel(V(cpphdl_n943, Vss), V(cpphdl_n957, Vss), 0.0040000000000000001, 0.69999999999999996, 1.0);
        // device 393, IC IC68, analog/basic/buffered_nand_latch.hpp:34
        I(cpphdl_n935, Vss) <+ 2.0000000000000002e-15 * ddt(V(cpphdl_n935, Vss)); // Bench initial voltage = 0.0 V.
        // device 394, IC IC68, analog/basic/buffered_nand_latch.hpp:35
        I(cpphdl_n935, cpphdl_n943) <+ 1.0000000000000001e-15 * ddt(V(cpphdl_n935, cpphdl_n943)); // Bench initial voltage = 0.0 V.
        // device 395, IC IC68, analog/basic/buffered_nand_latch.hpp:36
        I(cpphdl_n943, Vss) <+ 5e-15 * ddt(V(cpphdl_n943, Vss)); // Bench initial voltage = 0.0 V.
        // device 396, IC IC68, analog/basic/buffered_nand_latch.hpp:37
        I(cpphdl_n943, Vss) <+ 8.0000000000000006e-15 * ddt(V(cpphdl_n943, Vss)); // Bench initial voltage = 0.0 V.
        // device 397, IC IC68, analog/basic/buffered_nand_latch.hpp:38
        I(cpphdl_n957, Vss) <+ 1e-14 * ddt(V(cpphdl_n957, Vss)); // Bench initial voltage = 0.0 V.
        // device 398, IC IC70, analog/basic/inverter.hpp:11
        I(cpphdl_n947, Vdd) <+ cpphdl_channel(V(cpphdl_n939, Vdd), V(cpphdl_n947, Vdd), 0.001, 0.69999999999999996, -1.0);
        // device 399, IC IC70, analog/basic/inverter.hpp:12
        I(cpphdl_n947, Vss) <+ cpphdl_channel(V(cpphdl_n939, Vss), V(cpphdl_n947, Vss), 0.001, 0.69999999999999996, 1.0);
        // device 400, IC IC72, analog/basic/inverter.hpp:11
        I(cpphdl_n963, Vdd) <+ cpphdl_channel(V(cpphdl_n947, Vdd), V(cpphdl_n963, Vdd), 0.0040000000000000001, 0.69999999999999996, -1.0);
        // device 401, IC IC72, analog/basic/inverter.hpp:12
        I(cpphdl_n963, Vss) <+ cpphdl_channel(V(cpphdl_n947, Vss), V(cpphdl_n963, Vss), 0.0040000000000000001, 0.69999999999999996, 1.0);
        // device 402, IC IC68, analog/basic/buffered_nand_latch.hpp:34
        I(cpphdl_n939, Vss) <+ 2.0000000000000002e-15 * ddt(V(cpphdl_n939, Vss)); // Bench initial voltage = 0.0 V.
        // device 403, IC IC68, analog/basic/buffered_nand_latch.hpp:35
        I(cpphdl_n939, cpphdl_n947) <+ 1.0000000000000001e-15 * ddt(V(cpphdl_n939, cpphdl_n947)); // Bench initial voltage = 0.0 V.
        // device 404, IC IC68, analog/basic/buffered_nand_latch.hpp:36
        I(cpphdl_n947, Vss) <+ 5e-15 * ddt(V(cpphdl_n947, Vss)); // Bench initial voltage = 0.0 V.
        // device 405, IC IC68, analog/basic/buffered_nand_latch.hpp:37
        I(cpphdl_n947, Vss) <+ 8.0000000000000006e-15 * ddt(V(cpphdl_n947, Vss)); // Bench initial voltage = 0.0 V.
        // device 406, IC IC68, analog/basic/buffered_nand_latch.hpp:38
        I(cpphdl_n963, Vss) <+ 1e-14 * ddt(V(cpphdl_n963, Vss)); // Bench initial voltage = 0.0 V.
        // device 407, IC IC74, analog/basic/cmos_logic.hpp:17
        I(cpphdl_n2860, Vss) <+ 5.0000000000000002e-14 * ddt(V(cpphdl_n2860, Vss)); // Bench initial voltage = 0.0 V.
        // device 408, IC IC74, analog/basic/cmos_logic.hpp:18
        I(cpphdl_n2860, Vdd) <+ cpphdl_channel(V(cpphdl_n957, Vdd), V(cpphdl_n2860, Vdd), 0.01, 0.69999999999999996, -1.0);
        // device 409, IC IC74, analog/basic/cmos_logic.hpp:19
        I(cpphdl_n2860, Vdd) <+ cpphdl_channel(V(cpphdl_n965, Vdd), V(cpphdl_n2860, Vdd), 0.01, 0.69999999999999996, -1.0);
        // device 410, IC IC74, analog/basic/cmos_logic.hpp:20
        I(cpphdl_n2860, cpphdl_n960) <+ cpphdl_channel(V(cpphdl_n957, cpphdl_n960), V(cpphdl_n2860, cpphdl_n960), 0.01, 0.69999999999999996, 1.0);
        // device 411, IC IC74, analog/basic/cmos_logic.hpp:21
        I(cpphdl_n960, Vss) <+ cpphdl_channel(V(cpphdl_n965, Vss), V(cpphdl_n960, Vss), 0.01, 0.69999999999999996, 1.0);
        // device 412, IC IC74, analog/basic/cmos_logic.hpp:23
        I(cpphdl_n2860, Vss) <+ V(cpphdl_n2860, Vss) / 1000000000.0;
        // device 413, IC IC74, analog/basic/cmos_logic.hpp:24
        I(cpphdl_n960, Vss) <+ V(cpphdl_n960, Vss) / 1000000000.0;
        // device 414, IC IC75, analog/basic/cmos_logic.hpp:17
        I(cpphdl_n965, Vss) <+ 5.0000000000000002e-14 * ddt(V(cpphdl_n965, Vss)); // Bench initial voltage = 0.0 V.
        // device 415, IC IC75, analog/basic/cmos_logic.hpp:18
        I(cpphdl_n965, Vdd) <+ cpphdl_channel(V(cpphdl_n963, Vdd), V(cpphdl_n965, Vdd), 0.01, 0.69999999999999996, -1.0);
        // device 416, IC IC75, analog/basic/cmos_logic.hpp:19
        I(cpphdl_n965, Vdd) <+ cpphdl_channel(V(cpphdl_n2860, Vdd), V(cpphdl_n965, Vdd), 0.01, 0.69999999999999996, -1.0);
        // device 417, IC IC75, analog/basic/cmos_logic.hpp:20
        I(cpphdl_n965, cpphdl_n966) <+ cpphdl_channel(V(cpphdl_n963, cpphdl_n966), V(cpphdl_n965, cpphdl_n966), 0.01, 0.69999999999999996, 1.0);
        // device 418, IC IC75, analog/basic/cmos_logic.hpp:21
        I(cpphdl_n966, Vss) <+ cpphdl_channel(V(cpphdl_n2860, Vss), V(cpphdl_n966, Vss), 0.01, 0.69999999999999996, 1.0);
        // device 419, IC IC75, analog/basic/cmos_logic.hpp:23
        I(cpphdl_n965, Vss) <+ V(cpphdl_n965, Vss) / 1000000000.0;
        // device 420, IC IC75, analog/basic/cmos_logic.hpp:24
        I(cpphdl_n966, Vss) <+ V(cpphdl_n966, Vss) / 1000000000.0;
        // device 421, IC IC73, analog/basic/nand_latch.hpp:36
        I(cpphdl_n957, Vss) <+ 2.9999999999999998e-15 * ddt(V(cpphdl_n957, Vss)); // Bench initial voltage = 0.0 V.
        // device 422, IC IC73, analog/basic/nand_latch.hpp:37
        I(cpphdl_n963, Vss) <+ 2.9999999999999998e-15 * ddt(V(cpphdl_n963, Vss)); // Bench initial voltage = 0.0 V.
        // device 423, IC IC76, analog/basic/inverter.hpp:11
        I(cpphdl_n971, Vdd) <+ cpphdl_channel(V(CLEAR, Vdd), V(cpphdl_n971, Vdd), 0.01, 0.69999999999999996, -1.0);
        // device 424, IC IC76, analog/basic/inverter.hpp:12
        I(cpphdl_n971, Vss) <+ cpphdl_channel(V(CLEAR, Vss), V(cpphdl_n971, Vss), 0.01, 0.69999999999999996, 1.0);
        // device 425, IC IC73, analog/basic/nand_latch.hpp:58
        I(cpphdl_n971, Vss) <+ 2.9999999999999998e-15 * ddt(V(cpphdl_n971, Vss)); // Bench initial voltage = 0.0 V.
        // device 426, IC IC73, analog/basic/nand_latch.hpp:59
        I(cpphdl_n2860, Vss) <+ cpphdl_channel(V(CLEAR, Vss), V(cpphdl_n2860, Vss), 0.050000000000000003, 0.69999999999999996, 1.0);
        // device 427, IC IC73, analog/basic/nand_latch.hpp:60
        I(cpphdl_n965, Vdd) <+ cpphdl_channel(V(cpphdl_n971, Vdd), V(cpphdl_n965, Vdd), 0.050000000000000003, 0.69999999999999996, -1.0);
        // device 428, IC IC79, analog/basic/inverter.hpp:11
        I(cpphdl_n995, Vdd) <+ cpphdl_channel(V(TRACK3, Vdd), V(cpphdl_n995, Vdd), 0.0040000000000000001, 0.69999999999999996, -1.0);
        // device 429, IC IC79, analog/basic/inverter.hpp:12
        I(cpphdl_n995, Vss) <+ cpphdl_channel(V(TRACK3, Vss), V(cpphdl_n995, Vss), 0.0040000000000000001, 0.69999999999999996, 1.0);
        // device 430, IC IC78, analog/basic/mos_track_hold.hpp:31
        I(cpphdl_n995, Vss) <+ 2e-14 * ddt(V(cpphdl_n995, Vss)); // Bench initial voltage = 3.2999999999999998 V.
        // device 431, IC IC78, analog/basic/mos_track_hold.hpp:32
        I(cpphdl_n2705, cpphdl_n1049) <+ cpphdl_channel(V(TRACK3, cpphdl_n1049), V(cpphdl_n2705, cpphdl_n1049), 0.080000000000000002, 0.69999999999999996, 1.0);
        // device 432, IC IC78, analog/basic/mos_track_hold.hpp:33
        I(cpphdl_n1049, cpphdl_n2705) <+ cpphdl_channel(V(cpphdl_n995, cpphdl_n2705), V(cpphdl_n1049, cpphdl_n2705), 0.040000000000000001, 0.69999999999999996, -1.0);
        // device 433, IC IC78, analog/basic/mos_track_hold.hpp:37
        I(cpphdl_n1049, cpphdl_n1049) <+ cpphdl_channel(V(cpphdl_n995, cpphdl_n1049), V(cpphdl_n1049, cpphdl_n1049), 0.040000000000000001, 0.69999999999999996, 1.0);
        // device 434, IC IC78, analog/basic/mos_track_hold.hpp:38
        I(cpphdl_n1049, cpphdl_n1049) <+ cpphdl_channel(V(TRACK3, cpphdl_n1049), V(cpphdl_n1049, cpphdl_n1049), 0.02, 0.69999999999999996, -1.0);
        // device 435, IC IC78, analog/basic/mos_track_hold.hpp:39
        I(cpphdl_n1049, Vss) <+ 2e-12 * ddt(V(cpphdl_n1049, Vss)); // Bench initial voltage = 1.6499999999999999 V.
        // device 436, IC IC78, analog/basic/mos_track_hold.hpp:41
        I(Vss, cpphdl_n1049) <+ V(Vss, cpphdl_n1049) / 1000000000.0;
        // device 437, IC IC78, analog/basic/mos_track_hold.hpp:42
        I(TRACK3, cpphdl_n1049) <+ 8.0000000000000006e-15 * ddt(V(TRACK3, cpphdl_n1049)); // Bench initial voltage = -1.6499999999999999 V.
        // device 438, IC IC78, analog/basic/mos_track_hold.hpp:43
        I(cpphdl_n995, cpphdl_n1049) <+ 8.0000000000000006e-15 * ddt(V(cpphdl_n995, cpphdl_n1049)); // Bench initial voltage = 1.6499999999999999 V.
        // device 439, IC IC78, analog/basic/mos_track_hold.hpp:44
        I(cpphdl_n2705, cpphdl_n1049) <+ 4.0000000000000003e-15 * ddt(V(cpphdl_n2705, cpphdl_n1049)); // Bench initial voltage = 0.0 V.
        // device 440, IC IC81, analog/basic/inverter.hpp:11
        I(cpphdl_n1010, Vdd) <+ cpphdl_channel(V(BIT_N3_0, Vdd), V(cpphdl_n1010, Vdd), 0.080000000000000002, 0.69999999999999996, -1.0);
        // device 441, IC IC81, analog/basic/inverter.hpp:12
        I(cpphdl_n1010, Vss) <+ cpphdl_channel(V(BIT_N3_0, Vss), V(cpphdl_n1010, Vss), 0.080000000000000002, 0.69999999999999996, 1.0);
        // device 442, IC IC80, analog/basic/mos_r2r_dac.hpp:27
        I(cpphdl_n1010, Vss) <+ 2.9999999999999998e-15 * ddt(V(cpphdl_n1010, Vss)); // Bench initial voltage = 0.0 V.
        // device 443, IC IC80, analog/basic/mos_r2r_dac.hpp:28
        I(cpphdl_n1010, cpphdl_n1039) <+ V(cpphdl_n1010, cpphdl_n1039) / 2000.0;
        // device 444, IC IC80, analog/basic/mos_r2r_dac.hpp:29
        I(cpphdl_n1039, Vss) <+ 2.9999999999999998e-15 * ddt(V(cpphdl_n1039, Vss)); // Bench initial voltage = 0.0 V.
        // device 445, IC IC82, analog/basic/inverter.hpp:11
        I(cpphdl_n1014, Vdd) <+ cpphdl_channel(V(BIT_N3_1, Vdd), V(cpphdl_n1014, Vdd), 0.080000000000000002, 0.69999999999999996, -1.0);
        // device 446, IC IC82, analog/basic/inverter.hpp:12
        I(cpphdl_n1014, Vss) <+ cpphdl_channel(V(BIT_N3_1, Vss), V(cpphdl_n1014, Vss), 0.080000000000000002, 0.69999999999999996, 1.0);
        // device 447, IC IC80, analog/basic/mos_r2r_dac.hpp:27
        I(cpphdl_n1014, Vss) <+ 2.9999999999999998e-15 * ddt(V(cpphdl_n1014, Vss)); // Bench initial voltage = 0.0 V.
        // device 448, IC IC80, analog/basic/mos_r2r_dac.hpp:28
        I(cpphdl_n1014, cpphdl_n1040) <+ V(cpphdl_n1014, cpphdl_n1040) / 2000.0;
        // device 449, IC IC80, analog/basic/mos_r2r_dac.hpp:29
        I(cpphdl_n1040, Vss) <+ 2.9999999999999998e-15 * ddt(V(cpphdl_n1040, Vss)); // Bench initial voltage = 0.0 V.
        // device 450, IC IC80, analog/basic/mos_r2r_dac.hpp:31
        I(cpphdl_n1039, cpphdl_n1040) <+ V(cpphdl_n1039, cpphdl_n1040) / 1000.0;
        // device 451, IC IC83, analog/basic/inverter.hpp:11
        I(cpphdl_n1018, Vdd) <+ cpphdl_channel(V(BIT_N3_2, Vdd), V(cpphdl_n1018, Vdd), 0.080000000000000002, 0.69999999999999996, -1.0);
        // device 452, IC IC83, analog/basic/inverter.hpp:12
        I(cpphdl_n1018, Vss) <+ cpphdl_channel(V(BIT_N3_2, Vss), V(cpphdl_n1018, Vss), 0.080000000000000002, 0.69999999999999996, 1.0);
        // device 453, IC IC80, analog/basic/mos_r2r_dac.hpp:27
        I(cpphdl_n1018, Vss) <+ 2.9999999999999998e-15 * ddt(V(cpphdl_n1018, Vss)); // Bench initial voltage = 0.0 V.
        // device 454, IC IC80, analog/basic/mos_r2r_dac.hpp:28
        I(cpphdl_n1018, cpphdl_n1041) <+ V(cpphdl_n1018, cpphdl_n1041) / 2000.0;
        // device 455, IC IC80, analog/basic/mos_r2r_dac.hpp:29
        I(cpphdl_n1041, Vss) <+ 2.9999999999999998e-15 * ddt(V(cpphdl_n1041, Vss)); // Bench initial voltage = 0.0 V.
        // device 456, IC IC80, analog/basic/mos_r2r_dac.hpp:31
        I(cpphdl_n1040, cpphdl_n1041) <+ V(cpphdl_n1040, cpphdl_n1041) / 1000.0;
        // device 457, IC IC84, analog/basic/inverter.hpp:11
        I(cpphdl_n1022, Vdd) <+ cpphdl_channel(V(BIT_N3_3, Vdd), V(cpphdl_n1022, Vdd), 0.080000000000000002, 0.69999999999999996, -1.0);
        // device 458, IC IC84, analog/basic/inverter.hpp:12
        I(cpphdl_n1022, Vss) <+ cpphdl_channel(V(BIT_N3_3, Vss), V(cpphdl_n1022, Vss), 0.080000000000000002, 0.69999999999999996, 1.0);
        // device 459, IC IC80, analog/basic/mos_r2r_dac.hpp:27
        I(cpphdl_n1022, Vss) <+ 2.9999999999999998e-15 * ddt(V(cpphdl_n1022, Vss)); // Bench initial voltage = 0.0 V.
        // device 460, IC IC80, analog/basic/mos_r2r_dac.hpp:28
        I(cpphdl_n1022, cpphdl_n1042) <+ V(cpphdl_n1022, cpphdl_n1042) / 2000.0;
        // device 461, IC IC80, analog/basic/mos_r2r_dac.hpp:29
        I(cpphdl_n1042, Vss) <+ 2.9999999999999998e-15 * ddt(V(cpphdl_n1042, Vss)); // Bench initial voltage = 0.0 V.
        // device 462, IC IC80, analog/basic/mos_r2r_dac.hpp:31
        I(cpphdl_n1041, cpphdl_n1042) <+ V(cpphdl_n1041, cpphdl_n1042) / 1000.0;
        // device 463, IC IC85, analog/basic/inverter.hpp:11
        I(cpphdl_n1026, Vdd) <+ cpphdl_channel(V(BIT_N3_4, Vdd), V(cpphdl_n1026, Vdd), 0.080000000000000002, 0.69999999999999996, -1.0);
        // device 464, IC IC85, analog/basic/inverter.hpp:12
        I(cpphdl_n1026, Vss) <+ cpphdl_channel(V(BIT_N3_4, Vss), V(cpphdl_n1026, Vss), 0.080000000000000002, 0.69999999999999996, 1.0);
        // device 465, IC IC80, analog/basic/mos_r2r_dac.hpp:27
        I(cpphdl_n1026, Vss) <+ 2.9999999999999998e-15 * ddt(V(cpphdl_n1026, Vss)); // Bench initial voltage = 0.0 V.
        // device 466, IC IC80, analog/basic/mos_r2r_dac.hpp:28
        I(cpphdl_n1026, cpphdl_n1043) <+ V(cpphdl_n1026, cpphdl_n1043) / 2000.0;
        // device 467, IC IC80, analog/basic/mos_r2r_dac.hpp:29
        I(cpphdl_n1043, Vss) <+ 2.9999999999999998e-15 * ddt(V(cpphdl_n1043, Vss)); // Bench initial voltage = 0.0 V.
        // device 468, IC IC80, analog/basic/mos_r2r_dac.hpp:31
        I(cpphdl_n1042, cpphdl_n1043) <+ V(cpphdl_n1042, cpphdl_n1043) / 1000.0;
        // device 469, IC IC86, analog/basic/inverter.hpp:11
        I(cpphdl_n1030, Vdd) <+ cpphdl_channel(V(BIT_N3_5, Vdd), V(cpphdl_n1030, Vdd), 0.080000000000000002, 0.69999999999999996, -1.0);
        // device 470, IC IC86, analog/basic/inverter.hpp:12
        I(cpphdl_n1030, Vss) <+ cpphdl_channel(V(BIT_N3_5, Vss), V(cpphdl_n1030, Vss), 0.080000000000000002, 0.69999999999999996, 1.0);
        // device 471, IC IC80, analog/basic/mos_r2r_dac.hpp:27
        I(cpphdl_n1030, Vss) <+ 2.9999999999999998e-15 * ddt(V(cpphdl_n1030, Vss)); // Bench initial voltage = 0.0 V.
        // device 472, IC IC80, analog/basic/mos_r2r_dac.hpp:28
        I(cpphdl_n1030, cpphdl_n1044) <+ V(cpphdl_n1030, cpphdl_n1044) / 2000.0;
        // device 473, IC IC80, analog/basic/mos_r2r_dac.hpp:29
        I(cpphdl_n1044, Vss) <+ 2.9999999999999998e-15 * ddt(V(cpphdl_n1044, Vss)); // Bench initial voltage = 0.0 V.
        // device 474, IC IC80, analog/basic/mos_r2r_dac.hpp:31
        I(cpphdl_n1043, cpphdl_n1044) <+ V(cpphdl_n1043, cpphdl_n1044) / 1000.0;
        // device 475, IC IC87, analog/basic/inverter.hpp:11
        I(cpphdl_n1034, Vdd) <+ cpphdl_channel(V(BIT_N3_6, Vdd), V(cpphdl_n1034, Vdd), 0.080000000000000002, 0.69999999999999996, -1.0);
        // device 476, IC IC87, analog/basic/inverter.hpp:12
        I(cpphdl_n1034, Vss) <+ cpphdl_channel(V(BIT_N3_6, Vss), V(cpphdl_n1034, Vss), 0.080000000000000002, 0.69999999999999996, 1.0);
        // device 477, IC IC80, analog/basic/mos_r2r_dac.hpp:27
        I(cpphdl_n1034, Vss) <+ 2.9999999999999998e-15 * ddt(V(cpphdl_n1034, Vss)); // Bench initial voltage = 0.0 V.
        // device 478, IC IC80, analog/basic/mos_r2r_dac.hpp:28
        I(cpphdl_n1034, cpphdl_n1045) <+ V(cpphdl_n1034, cpphdl_n1045) / 2000.0;
        // device 479, IC IC80, analog/basic/mos_r2r_dac.hpp:29
        I(cpphdl_n1045, Vss) <+ 2.9999999999999998e-15 * ddt(V(cpphdl_n1045, Vss)); // Bench initial voltage = 0.0 V.
        // device 480, IC IC80, analog/basic/mos_r2r_dac.hpp:31
        I(cpphdl_n1044, cpphdl_n1045) <+ V(cpphdl_n1044, cpphdl_n1045) / 1000.0;
        // device 481, IC IC88, analog/basic/inverter.hpp:11
        I(cpphdl_n1038, Vdd) <+ cpphdl_channel(V(BIT_N3_7, Vdd), V(cpphdl_n1038, Vdd), 0.080000000000000002, 0.69999999999999996, -1.0);
        // device 482, IC IC88, analog/basic/inverter.hpp:12
        I(cpphdl_n1038, Vss) <+ cpphdl_channel(V(BIT_N3_7, Vss), V(cpphdl_n1038, Vss), 0.080000000000000002, 0.69999999999999996, 1.0);
        // device 483, IC IC80, analog/basic/mos_r2r_dac.hpp:27
        I(cpphdl_n1038, Vss) <+ 2.9999999999999998e-15 * ddt(V(cpphdl_n1038, Vss)); // Bench initial voltage = 0.0 V.
        // device 484, IC IC80, analog/basic/mos_r2r_dac.hpp:28
        I(cpphdl_n1038, cpphdl_n1050) <+ V(cpphdl_n1038, cpphdl_n1050) / 2000.0;
        // device 485, IC IC80, analog/basic/mos_r2r_dac.hpp:29
        I(cpphdl_n1050, Vss) <+ 2.9999999999999998e-15 * ddt(V(cpphdl_n1050, Vss)); // Bench initial voltage = 0.0 V.
        // device 486, IC IC80, analog/basic/mos_r2r_dac.hpp:31
        I(cpphdl_n1045, cpphdl_n1050) <+ V(cpphdl_n1045, cpphdl_n1050) / 1000.0;
        // device 487, IC IC80, analog/basic/mos_r2r_dac.hpp:33
        I(Vss, cpphdl_n1039) <+ V(Vss, cpphdl_n1039) / 2000.0;
        // device 488, IC IC89, analog/basic/nmos_resistor_amplifier.hpp:23
        I(Vdd, cpphdl_n1059) <+ V(Vdd, cpphdl_n1059) / 1000.0;
        // device 489, IC IC89, analog/basic/nmos_resistor_amplifier.hpp:24
        I(Vdd, cpphdl_n1058) <+ V(Vdd, cpphdl_n1058) / 1000.0;
        // device 490, IC IC89, analog/basic/nmos_resistor_amplifier.hpp:25
        I(cpphdl_n1059, cpphdl_n1053) <+ cpphdl_channel(V(cpphdl_n1049, cpphdl_n1053), V(cpphdl_n1059, cpphdl_n1053), 0.014999999999999999, 0.69999999999999996, 1.0);
        // device 491, IC IC89, analog/basic/nmos_resistor_amplifier.hpp:26
        I(cpphdl_n1058, cpphdl_n1054) <+ cpphdl_channel(V(cpphdl_n1050, cpphdl_n1054), V(cpphdl_n1058, cpphdl_n1054), 0.014999999999999999, 0.69999999999999996, 1.0);
        // device 492, IC IC89, analog/basic/nmos_resistor_amplifier.hpp:27
        I(cpphdl_n1055, cpphdl_n1053) <+ V(cpphdl_n1055, cpphdl_n1053) / 50.0;
        // device 493, IC IC89, analog/basic/nmos_resistor_amplifier.hpp:28
        I(cpphdl_n1055, cpphdl_n1054) <+ V(cpphdl_n1055, cpphdl_n1054) / 50.0;
        // device 494, IC IC89, analog/basic/nmos_resistor_amplifier.hpp:29
        I(Vss, cpphdl_n1055) <+ V(Vss, cpphdl_n1055) / 150.0;
        // device 495, IC IC89, analog/basic/nmos_resistor_amplifier.hpp:30
        I(cpphdl_n1059, Vdd) <+ 2.9999999999999998e-13 * ddt(V(cpphdl_n1059, Vdd)); // Bench initial voltage = 0.0 V.
        // device 496, IC IC89, analog/basic/nmos_resistor_amplifier.hpp:31
        I(cpphdl_n1058, Vdd) <+ 2.9999999999999998e-13 * ddt(V(cpphdl_n1058, Vdd)); // Bench initial voltage = 0.0 V.
        // device 497, IC IC89, analog/basic/nmos_resistor_amplifier.hpp:32
        I(cpphdl_n1055, Vss) <+ 4e-14 * ddt(V(cpphdl_n1055, Vss)); // Bench initial voltage = 0.0 V.
        // device 498, IC IC89, analog/basic/nmos_resistor_amplifier.hpp:34
        I(cpphdl_n1049, cpphdl_n1053) <+ 2e-14 * ddt(V(cpphdl_n1049, cpphdl_n1053)); // Bench initial voltage = 1.6499999999999999 V.
        // device 499, IC IC89, analog/basic/nmos_resistor_amplifier.hpp:35
        I(cpphdl_n1050, cpphdl_n1054) <+ 2e-14 * ddt(V(cpphdl_n1050, cpphdl_n1054)); // Bench initial voltage = 0.0 V.
        // device 500, IC IC89, analog/basic/nmos_resistor_amplifier.hpp:36
        I(cpphdl_n1049, cpphdl_n1059) <+ 2.9999999999999998e-15 * ddt(V(cpphdl_n1049, cpphdl_n1059)); // Bench initial voltage = -1.6499999999999999 V.
        // device 501, IC IC89, analog/basic/nmos_resistor_amplifier.hpp:37
        I(cpphdl_n1050, cpphdl_n1058) <+ 2.9999999999999998e-15 * ddt(V(cpphdl_n1050, cpphdl_n1058)); // Bench initial voltage = -3.2999999999999998 V.
        // device 502, IC IC90, analog/basic/strongarm_comparator.hpp:28
        I(cpphdl_n1063, cpphdl_n1065) <+ cpphdl_channel(V(cpphdl_n1058, cpphdl_n1065), V(cpphdl_n1063, cpphdl_n1065), 0.0080000000000000002, 0.69999999999999996, 1.0);
        // device 503, IC IC90, analog/basic/strongarm_comparator.hpp:29
        I(cpphdl_n1064, cpphdl_n1065) <+ cpphdl_channel(V(cpphdl_n1059, cpphdl_n1065), V(cpphdl_n1064, cpphdl_n1065), 0.0080000000000000002, 0.69999999999999996, 1.0);
        // device 504, IC IC90, analog/basic/strongarm_comparator.hpp:30
        I(cpphdl_n1065, Vss) <+ cpphdl_channel(V(EVALUATE, Vss), V(cpphdl_n1065, Vss), 0.0080000000000000002, 0.69999999999999996, 1.0);
        // device 505, IC IC90, analog/basic/strongarm_comparator.hpp:33
        I(cpphdl_n1078, cpphdl_n1063) <+ cpphdl_channel(V(cpphdl_n1082, cpphdl_n1063), V(cpphdl_n1078, cpphdl_n1063), 0.0040000000000000001, 0.69999999999999996, 1.0);
        // device 506, IC IC90, analog/basic/strongarm_comparator.hpp:34
        I(cpphdl_n1082, cpphdl_n1064) <+ cpphdl_channel(V(cpphdl_n1078, cpphdl_n1064), V(cpphdl_n1082, cpphdl_n1064), 0.0040000000000000001, 0.69999999999999996, 1.0);
        // device 507, IC IC90, analog/basic/strongarm_comparator.hpp:35
        I(cpphdl_n1082, Vdd) <+ cpphdl_channel(V(cpphdl_n1078, Vdd), V(cpphdl_n1082, Vdd), 0.002, 0.69999999999999996, -1.0);
        // device 508, IC IC90, analog/basic/strongarm_comparator.hpp:36
        I(cpphdl_n1078, Vdd) <+ cpphdl_channel(V(cpphdl_n1082, Vdd), V(cpphdl_n1078, Vdd), 0.002, 0.69999999999999996, -1.0);
        // device 509, IC IC90, analog/basic/strongarm_comparator.hpp:38
        I(cpphdl_n1063, Vdd) <+ cpphdl_channel(V(EVALUATE, Vdd), V(cpphdl_n1063, Vdd), 0.002, 0.69999999999999996, -1.0);
        // device 510, IC IC90, analog/basic/strongarm_comparator.hpp:39
        I(cpphdl_n1064, Vdd) <+ cpphdl_channel(V(EVALUATE, Vdd), V(cpphdl_n1064, Vdd), 0.002, 0.69999999999999996, -1.0);
        // device 511, IC IC90, analog/basic/strongarm_comparator.hpp:40
        I(cpphdl_n1082, Vdd) <+ cpphdl_channel(V(EVALUATE, Vdd), V(cpphdl_n1082, Vdd), 0.002, 0.69999999999999996, -1.0);
        // device 512, IC IC90, analog/basic/strongarm_comparator.hpp:41
        I(cpphdl_n1078, Vdd) <+ cpphdl_channel(V(EVALUATE, Vdd), V(cpphdl_n1078, Vdd), 0.002, 0.69999999999999996, -1.0);
        // device 513, IC IC90, analog/basic/strongarm_comparator.hpp:42
        I(cpphdl_n1063, Vss) <+ 2.9999999999999998e-14 * ddt(V(cpphdl_n1063, Vss)); // Bench initial voltage = 0.0 V.
        // device 514, IC IC90, analog/basic/strongarm_comparator.hpp:43
        I(cpphdl_n1064, Vss) <+ 2.9999999999999998e-14 * ddt(V(cpphdl_n1064, Vss)); // Bench initial voltage = 0.0 V.
        // device 515, IC IC90, analog/basic/strongarm_comparator.hpp:44
        I(cpphdl_n1065, Vss) <+ 2.9999999999999998e-14 * ddt(V(cpphdl_n1065, Vss)); // Bench initial voltage = 0.0 V.
        // device 516, IC IC90, analog/basic/strongarm_comparator.hpp:45
        I(cpphdl_n1082, Vss) <+ 5.0000000000000002e-14 * ddt(V(cpphdl_n1082, Vss)); // Bench initial voltage = 0.0 V.
        // device 517, IC IC90, analog/basic/strongarm_comparator.hpp:46
        I(cpphdl_n1078, Vss) <+ 5.0000000000000002e-14 * ddt(V(cpphdl_n1078, Vss)); // Bench initial voltage = 0.0 V.
        // device 518, IC IC90, analog/basic/strongarm_comparator.hpp:47
        I(cpphdl_n1058, cpphdl_n1065) <+ 2e-14 * ddt(V(cpphdl_n1058, cpphdl_n1065)); // Bench initial voltage = 3.2999999999999998 V.
        // device 519, IC IC90, analog/basic/strongarm_comparator.hpp:48
        I(cpphdl_n1059, cpphdl_n1065) <+ 2e-14 * ddt(V(cpphdl_n1059, cpphdl_n1065)); // Bench initial voltage = 3.2999999999999998 V.
        // device 520, IC IC90, analog/basic/strongarm_comparator.hpp:49
        I(cpphdl_n1058, cpphdl_n1063) <+ 2.9999999999999998e-15 * ddt(V(cpphdl_n1058, cpphdl_n1063)); // Bench initial voltage = 3.2999999999999998 V.
        // device 521, IC IC90, analog/basic/strongarm_comparator.hpp:50
        I(cpphdl_n1059, cpphdl_n1064) <+ 2.9999999999999998e-15 * ddt(V(cpphdl_n1059, cpphdl_n1064)); // Bench initial voltage = 3.2999999999999998 V.
        // device 522, IC IC92, analog/basic/inverter.hpp:11
        I(cpphdl_n1086, Vdd) <+ cpphdl_channel(V(cpphdl_n1078, Vdd), V(cpphdl_n1086, Vdd), 0.001, 0.69999999999999996, -1.0);
        // device 523, IC IC92, analog/basic/inverter.hpp:12
        I(cpphdl_n1086, Vss) <+ cpphdl_channel(V(cpphdl_n1078, Vss), V(cpphdl_n1086, Vss), 0.001, 0.69999999999999996, 1.0);
        // device 524, IC IC94, analog/basic/inverter.hpp:11
        I(cpphdl_n1100, Vdd) <+ cpphdl_channel(V(cpphdl_n1086, Vdd), V(cpphdl_n1100, Vdd), 0.0040000000000000001, 0.69999999999999996, -1.0);
        // device 525, IC IC94, analog/basic/inverter.hpp:12
        I(cpphdl_n1100, Vss) <+ cpphdl_channel(V(cpphdl_n1086, Vss), V(cpphdl_n1100, Vss), 0.0040000000000000001, 0.69999999999999996, 1.0);
        // device 526, IC IC91, analog/basic/buffered_nand_latch.hpp:34
        I(cpphdl_n1078, Vss) <+ 2.0000000000000002e-15 * ddt(V(cpphdl_n1078, Vss)); // Bench initial voltage = 0.0 V.
        // device 527, IC IC91, analog/basic/buffered_nand_latch.hpp:35
        I(cpphdl_n1078, cpphdl_n1086) <+ 1.0000000000000001e-15 * ddt(V(cpphdl_n1078, cpphdl_n1086)); // Bench initial voltage = 0.0 V.
        // device 528, IC IC91, analog/basic/buffered_nand_latch.hpp:36
        I(cpphdl_n1086, Vss) <+ 5e-15 * ddt(V(cpphdl_n1086, Vss)); // Bench initial voltage = 0.0 V.
        // device 529, IC IC91, analog/basic/buffered_nand_latch.hpp:37
        I(cpphdl_n1086, Vss) <+ 8.0000000000000006e-15 * ddt(V(cpphdl_n1086, Vss)); // Bench initial voltage = 0.0 V.
        // device 530, IC IC91, analog/basic/buffered_nand_latch.hpp:38
        I(cpphdl_n1100, Vss) <+ 1e-14 * ddt(V(cpphdl_n1100, Vss)); // Bench initial voltage = 0.0 V.
        // device 531, IC IC93, analog/basic/inverter.hpp:11
        I(cpphdl_n1090, Vdd) <+ cpphdl_channel(V(cpphdl_n1082, Vdd), V(cpphdl_n1090, Vdd), 0.001, 0.69999999999999996, -1.0);
        // device 532, IC IC93, analog/basic/inverter.hpp:12
        I(cpphdl_n1090, Vss) <+ cpphdl_channel(V(cpphdl_n1082, Vss), V(cpphdl_n1090, Vss), 0.001, 0.69999999999999996, 1.0);
        // device 533, IC IC95, analog/basic/inverter.hpp:11
        I(cpphdl_n1106, Vdd) <+ cpphdl_channel(V(cpphdl_n1090, Vdd), V(cpphdl_n1106, Vdd), 0.0040000000000000001, 0.69999999999999996, -1.0);
        // device 534, IC IC95, analog/basic/inverter.hpp:12
        I(cpphdl_n1106, Vss) <+ cpphdl_channel(V(cpphdl_n1090, Vss), V(cpphdl_n1106, Vss), 0.0040000000000000001, 0.69999999999999996, 1.0);
        // device 535, IC IC91, analog/basic/buffered_nand_latch.hpp:34
        I(cpphdl_n1082, Vss) <+ 2.0000000000000002e-15 * ddt(V(cpphdl_n1082, Vss)); // Bench initial voltage = 0.0 V.
        // device 536, IC IC91, analog/basic/buffered_nand_latch.hpp:35
        I(cpphdl_n1082, cpphdl_n1090) <+ 1.0000000000000001e-15 * ddt(V(cpphdl_n1082, cpphdl_n1090)); // Bench initial voltage = 0.0 V.
        // device 537, IC IC91, analog/basic/buffered_nand_latch.hpp:36
        I(cpphdl_n1090, Vss) <+ 5e-15 * ddt(V(cpphdl_n1090, Vss)); // Bench initial voltage = 0.0 V.
        // device 538, IC IC91, analog/basic/buffered_nand_latch.hpp:37
        I(cpphdl_n1090, Vss) <+ 8.0000000000000006e-15 * ddt(V(cpphdl_n1090, Vss)); // Bench initial voltage = 0.0 V.
        // device 539, IC IC91, analog/basic/buffered_nand_latch.hpp:38
        I(cpphdl_n1106, Vss) <+ 1e-14 * ddt(V(cpphdl_n1106, Vss)); // Bench initial voltage = 0.0 V.
        // device 540, IC IC97, analog/basic/cmos_logic.hpp:17
        I(cpphdl_n2865, Vss) <+ 5.0000000000000002e-14 * ddt(V(cpphdl_n2865, Vss)); // Bench initial voltage = 0.0 V.
        // device 541, IC IC97, analog/basic/cmos_logic.hpp:18
        I(cpphdl_n2865, Vdd) <+ cpphdl_channel(V(cpphdl_n1100, Vdd), V(cpphdl_n2865, Vdd), 0.01, 0.69999999999999996, -1.0);
        // device 542, IC IC97, analog/basic/cmos_logic.hpp:19
        I(cpphdl_n2865, Vdd) <+ cpphdl_channel(V(cpphdl_n1108, Vdd), V(cpphdl_n2865, Vdd), 0.01, 0.69999999999999996, -1.0);
        // device 543, IC IC97, analog/basic/cmos_logic.hpp:20
        I(cpphdl_n2865, cpphdl_n1103) <+ cpphdl_channel(V(cpphdl_n1100, cpphdl_n1103), V(cpphdl_n2865, cpphdl_n1103), 0.01, 0.69999999999999996, 1.0);
        // device 544, IC IC97, analog/basic/cmos_logic.hpp:21
        I(cpphdl_n1103, Vss) <+ cpphdl_channel(V(cpphdl_n1108, Vss), V(cpphdl_n1103, Vss), 0.01, 0.69999999999999996, 1.0);
        // device 545, IC IC97, analog/basic/cmos_logic.hpp:23
        I(cpphdl_n2865, Vss) <+ V(cpphdl_n2865, Vss) / 1000000000.0;
        // device 546, IC IC97, analog/basic/cmos_logic.hpp:24
        I(cpphdl_n1103, Vss) <+ V(cpphdl_n1103, Vss) / 1000000000.0;
        // device 547, IC IC98, analog/basic/cmos_logic.hpp:17
        I(cpphdl_n1108, Vss) <+ 5.0000000000000002e-14 * ddt(V(cpphdl_n1108, Vss)); // Bench initial voltage = 0.0 V.
        // device 548, IC IC98, analog/basic/cmos_logic.hpp:18
        I(cpphdl_n1108, Vdd) <+ cpphdl_channel(V(cpphdl_n1106, Vdd), V(cpphdl_n1108, Vdd), 0.01, 0.69999999999999996, -1.0);
        // device 549, IC IC98, analog/basic/cmos_logic.hpp:19
        I(cpphdl_n1108, Vdd) <+ cpphdl_channel(V(cpphdl_n2865, Vdd), V(cpphdl_n1108, Vdd), 0.01, 0.69999999999999996, -1.0);
        // device 550, IC IC98, analog/basic/cmos_logic.hpp:20
        I(cpphdl_n1108, cpphdl_n1109) <+ cpphdl_channel(V(cpphdl_n1106, cpphdl_n1109), V(cpphdl_n1108, cpphdl_n1109), 0.01, 0.69999999999999996, 1.0);
        // device 551, IC IC98, analog/basic/cmos_logic.hpp:21
        I(cpphdl_n1109, Vss) <+ cpphdl_channel(V(cpphdl_n2865, Vss), V(cpphdl_n1109, Vss), 0.01, 0.69999999999999996, 1.0);
        // device 552, IC IC98, analog/basic/cmos_logic.hpp:23
        I(cpphdl_n1108, Vss) <+ V(cpphdl_n1108, Vss) / 1000000000.0;
        // device 553, IC IC98, analog/basic/cmos_logic.hpp:24
        I(cpphdl_n1109, Vss) <+ V(cpphdl_n1109, Vss) / 1000000000.0;
        // device 554, IC IC96, analog/basic/nand_latch.hpp:36
        I(cpphdl_n1100, Vss) <+ 2.9999999999999998e-15 * ddt(V(cpphdl_n1100, Vss)); // Bench initial voltage = 0.0 V.
        // device 555, IC IC96, analog/basic/nand_latch.hpp:37
        I(cpphdl_n1106, Vss) <+ 2.9999999999999998e-15 * ddt(V(cpphdl_n1106, Vss)); // Bench initial voltage = 0.0 V.
        // device 556, IC IC99, analog/basic/inverter.hpp:11
        I(cpphdl_n1114, Vdd) <+ cpphdl_channel(V(CLEAR, Vdd), V(cpphdl_n1114, Vdd), 0.01, 0.69999999999999996, -1.0);
        // device 557, IC IC99, analog/basic/inverter.hpp:12
        I(cpphdl_n1114, Vss) <+ cpphdl_channel(V(CLEAR, Vss), V(cpphdl_n1114, Vss), 0.01, 0.69999999999999996, 1.0);
        // device 558, IC IC96, analog/basic/nand_latch.hpp:58
        I(cpphdl_n1114, Vss) <+ 2.9999999999999998e-15 * ddt(V(cpphdl_n1114, Vss)); // Bench initial voltage = 0.0 V.
        // device 559, IC IC96, analog/basic/nand_latch.hpp:59
        I(cpphdl_n2865, Vss) <+ cpphdl_channel(V(CLEAR, Vss), V(cpphdl_n2865, Vss), 0.050000000000000003, 0.69999999999999996, 1.0);
        // device 560, IC IC96, analog/basic/nand_latch.hpp:60
        I(cpphdl_n1108, Vdd) <+ cpphdl_channel(V(cpphdl_n1114, Vdd), V(cpphdl_n1108, Vdd), 0.050000000000000003, 0.69999999999999996, -1.0);
        // device 561, IC IC102, analog/basic/inverter.hpp:11
        I(cpphdl_n1138, Vdd) <+ cpphdl_channel(V(TRACK4, Vdd), V(cpphdl_n1138, Vdd), 0.0040000000000000001, 0.69999999999999996, -1.0);
        // device 562, IC IC102, analog/basic/inverter.hpp:12
        I(cpphdl_n1138, Vss) <+ cpphdl_channel(V(TRACK4, Vss), V(cpphdl_n1138, Vss), 0.0040000000000000001, 0.69999999999999996, 1.0);
        // device 563, IC IC101, analog/basic/mos_track_hold.hpp:31
        I(cpphdl_n1138, Vss) <+ 2e-14 * ddt(V(cpphdl_n1138, Vss)); // Bench initial voltage = 3.2999999999999998 V.
        // device 564, IC IC101, analog/basic/mos_track_hold.hpp:32
        I(cpphdl_n2705, cpphdl_n1192) <+ cpphdl_channel(V(TRACK4, cpphdl_n1192), V(cpphdl_n2705, cpphdl_n1192), 0.080000000000000002, 0.69999999999999996, 1.0);
        // device 565, IC IC101, analog/basic/mos_track_hold.hpp:33
        I(cpphdl_n1192, cpphdl_n2705) <+ cpphdl_channel(V(cpphdl_n1138, cpphdl_n2705), V(cpphdl_n1192, cpphdl_n2705), 0.040000000000000001, 0.69999999999999996, -1.0);
        // device 566, IC IC101, analog/basic/mos_track_hold.hpp:37
        I(cpphdl_n1192, cpphdl_n1192) <+ cpphdl_channel(V(cpphdl_n1138, cpphdl_n1192), V(cpphdl_n1192, cpphdl_n1192), 0.040000000000000001, 0.69999999999999996, 1.0);
        // device 567, IC IC101, analog/basic/mos_track_hold.hpp:38
        I(cpphdl_n1192, cpphdl_n1192) <+ cpphdl_channel(V(TRACK4, cpphdl_n1192), V(cpphdl_n1192, cpphdl_n1192), 0.02, 0.69999999999999996, -1.0);
        // device 568, IC IC101, analog/basic/mos_track_hold.hpp:39
        I(cpphdl_n1192, Vss) <+ 2e-12 * ddt(V(cpphdl_n1192, Vss)); // Bench initial voltage = 1.6499999999999999 V.
        // device 569, IC IC101, analog/basic/mos_track_hold.hpp:41
        I(Vss, cpphdl_n1192) <+ V(Vss, cpphdl_n1192) / 1000000000.0;
        // device 570, IC IC101, analog/basic/mos_track_hold.hpp:42
        I(TRACK4, cpphdl_n1192) <+ 8.0000000000000006e-15 * ddt(V(TRACK4, cpphdl_n1192)); // Bench initial voltage = -1.6499999999999999 V.
        // device 571, IC IC101, analog/basic/mos_track_hold.hpp:43
        I(cpphdl_n1138, cpphdl_n1192) <+ 8.0000000000000006e-15 * ddt(V(cpphdl_n1138, cpphdl_n1192)); // Bench initial voltage = 1.6499999999999999 V.
        // device 572, IC IC101, analog/basic/mos_track_hold.hpp:44
        I(cpphdl_n2705, cpphdl_n1192) <+ 4.0000000000000003e-15 * ddt(V(cpphdl_n2705, cpphdl_n1192)); // Bench initial voltage = 0.0 V.
        // device 573, IC IC104, analog/basic/inverter.hpp:11
        I(cpphdl_n1153, Vdd) <+ cpphdl_channel(V(BIT_N4_0, Vdd), V(cpphdl_n1153, Vdd), 0.080000000000000002, 0.69999999999999996, -1.0);
        // device 574, IC IC104, analog/basic/inverter.hpp:12
        I(cpphdl_n1153, Vss) <+ cpphdl_channel(V(BIT_N4_0, Vss), V(cpphdl_n1153, Vss), 0.080000000000000002, 0.69999999999999996, 1.0);
        // device 575, IC IC103, analog/basic/mos_r2r_dac.hpp:27
        I(cpphdl_n1153, Vss) <+ 2.9999999999999998e-15 * ddt(V(cpphdl_n1153, Vss)); // Bench initial voltage = 0.0 V.
        // device 576, IC IC103, analog/basic/mos_r2r_dac.hpp:28
        I(cpphdl_n1153, cpphdl_n1182) <+ V(cpphdl_n1153, cpphdl_n1182) / 2000.0;
        // device 577, IC IC103, analog/basic/mos_r2r_dac.hpp:29
        I(cpphdl_n1182, Vss) <+ 2.9999999999999998e-15 * ddt(V(cpphdl_n1182, Vss)); // Bench initial voltage = 0.0 V.
        // device 578, IC IC105, analog/basic/inverter.hpp:11
        I(cpphdl_n1157, Vdd) <+ cpphdl_channel(V(BIT_N4_1, Vdd), V(cpphdl_n1157, Vdd), 0.080000000000000002, 0.69999999999999996, -1.0);
        // device 579, IC IC105, analog/basic/inverter.hpp:12
        I(cpphdl_n1157, Vss) <+ cpphdl_channel(V(BIT_N4_1, Vss), V(cpphdl_n1157, Vss), 0.080000000000000002, 0.69999999999999996, 1.0);
        // device 580, IC IC103, analog/basic/mos_r2r_dac.hpp:27
        I(cpphdl_n1157, Vss) <+ 2.9999999999999998e-15 * ddt(V(cpphdl_n1157, Vss)); // Bench initial voltage = 0.0 V.
        // device 581, IC IC103, analog/basic/mos_r2r_dac.hpp:28
        I(cpphdl_n1157, cpphdl_n1183) <+ V(cpphdl_n1157, cpphdl_n1183) / 2000.0;
        // device 582, IC IC103, analog/basic/mos_r2r_dac.hpp:29
        I(cpphdl_n1183, Vss) <+ 2.9999999999999998e-15 * ddt(V(cpphdl_n1183, Vss)); // Bench initial voltage = 0.0 V.
        // device 583, IC IC103, analog/basic/mos_r2r_dac.hpp:31
        I(cpphdl_n1182, cpphdl_n1183) <+ V(cpphdl_n1182, cpphdl_n1183) / 1000.0;
        // device 584, IC IC106, analog/basic/inverter.hpp:11
        I(cpphdl_n1161, Vdd) <+ cpphdl_channel(V(BIT_N4_2, Vdd), V(cpphdl_n1161, Vdd), 0.080000000000000002, 0.69999999999999996, -1.0);
        // device 585, IC IC106, analog/basic/inverter.hpp:12
        I(cpphdl_n1161, Vss) <+ cpphdl_channel(V(BIT_N4_2, Vss), V(cpphdl_n1161, Vss), 0.080000000000000002, 0.69999999999999996, 1.0);
        // device 586, IC IC103, analog/basic/mos_r2r_dac.hpp:27
        I(cpphdl_n1161, Vss) <+ 2.9999999999999998e-15 * ddt(V(cpphdl_n1161, Vss)); // Bench initial voltage = 0.0 V.
        // device 587, IC IC103, analog/basic/mos_r2r_dac.hpp:28
        I(cpphdl_n1161, cpphdl_n1184) <+ V(cpphdl_n1161, cpphdl_n1184) / 2000.0;
        // device 588, IC IC103, analog/basic/mos_r2r_dac.hpp:29
        I(cpphdl_n1184, Vss) <+ 2.9999999999999998e-15 * ddt(V(cpphdl_n1184, Vss)); // Bench initial voltage = 0.0 V.
        // device 589, IC IC103, analog/basic/mos_r2r_dac.hpp:31
        I(cpphdl_n1183, cpphdl_n1184) <+ V(cpphdl_n1183, cpphdl_n1184) / 1000.0;
        // device 590, IC IC107, analog/basic/inverter.hpp:11
        I(cpphdl_n1165, Vdd) <+ cpphdl_channel(V(BIT_N4_3, Vdd), V(cpphdl_n1165, Vdd), 0.080000000000000002, 0.69999999999999996, -1.0);
        // device 591, IC IC107, analog/basic/inverter.hpp:12
        I(cpphdl_n1165, Vss) <+ cpphdl_channel(V(BIT_N4_3, Vss), V(cpphdl_n1165, Vss), 0.080000000000000002, 0.69999999999999996, 1.0);
        // device 592, IC IC103, analog/basic/mos_r2r_dac.hpp:27
        I(cpphdl_n1165, Vss) <+ 2.9999999999999998e-15 * ddt(V(cpphdl_n1165, Vss)); // Bench initial voltage = 0.0 V.
        // device 593, IC IC103, analog/basic/mos_r2r_dac.hpp:28
        I(cpphdl_n1165, cpphdl_n1185) <+ V(cpphdl_n1165, cpphdl_n1185) / 2000.0;
        // device 594, IC IC103, analog/basic/mos_r2r_dac.hpp:29
        I(cpphdl_n1185, Vss) <+ 2.9999999999999998e-15 * ddt(V(cpphdl_n1185, Vss)); // Bench initial voltage = 0.0 V.
        // device 595, IC IC103, analog/basic/mos_r2r_dac.hpp:31
        I(cpphdl_n1184, cpphdl_n1185) <+ V(cpphdl_n1184, cpphdl_n1185) / 1000.0;
        // device 596, IC IC108, analog/basic/inverter.hpp:11
        I(cpphdl_n1169, Vdd) <+ cpphdl_channel(V(BIT_N4_4, Vdd), V(cpphdl_n1169, Vdd), 0.080000000000000002, 0.69999999999999996, -1.0);
        // device 597, IC IC108, analog/basic/inverter.hpp:12
        I(cpphdl_n1169, Vss) <+ cpphdl_channel(V(BIT_N4_4, Vss), V(cpphdl_n1169, Vss), 0.080000000000000002, 0.69999999999999996, 1.0);
        // device 598, IC IC103, analog/basic/mos_r2r_dac.hpp:27
        I(cpphdl_n1169, Vss) <+ 2.9999999999999998e-15 * ddt(V(cpphdl_n1169, Vss)); // Bench initial voltage = 0.0 V.
        // device 599, IC IC103, analog/basic/mos_r2r_dac.hpp:28
        I(cpphdl_n1169, cpphdl_n1186) <+ V(cpphdl_n1169, cpphdl_n1186) / 2000.0;
        // device 600, IC IC103, analog/basic/mos_r2r_dac.hpp:29
        I(cpphdl_n1186, Vss) <+ 2.9999999999999998e-15 * ddt(V(cpphdl_n1186, Vss)); // Bench initial voltage = 0.0 V.
        // device 601, IC IC103, analog/basic/mos_r2r_dac.hpp:31
        I(cpphdl_n1185, cpphdl_n1186) <+ V(cpphdl_n1185, cpphdl_n1186) / 1000.0;
        // device 602, IC IC109, analog/basic/inverter.hpp:11
        I(cpphdl_n1173, Vdd) <+ cpphdl_channel(V(BIT_N4_5, Vdd), V(cpphdl_n1173, Vdd), 0.080000000000000002, 0.69999999999999996, -1.0);
        // device 603, IC IC109, analog/basic/inverter.hpp:12
        I(cpphdl_n1173, Vss) <+ cpphdl_channel(V(BIT_N4_5, Vss), V(cpphdl_n1173, Vss), 0.080000000000000002, 0.69999999999999996, 1.0);
        // device 604, IC IC103, analog/basic/mos_r2r_dac.hpp:27
        I(cpphdl_n1173, Vss) <+ 2.9999999999999998e-15 * ddt(V(cpphdl_n1173, Vss)); // Bench initial voltage = 0.0 V.
        // device 605, IC IC103, analog/basic/mos_r2r_dac.hpp:28
        I(cpphdl_n1173, cpphdl_n1187) <+ V(cpphdl_n1173, cpphdl_n1187) / 2000.0;
        // device 606, IC IC103, analog/basic/mos_r2r_dac.hpp:29
        I(cpphdl_n1187, Vss) <+ 2.9999999999999998e-15 * ddt(V(cpphdl_n1187, Vss)); // Bench initial voltage = 0.0 V.
        // device 607, IC IC103, analog/basic/mos_r2r_dac.hpp:31
        I(cpphdl_n1186, cpphdl_n1187) <+ V(cpphdl_n1186, cpphdl_n1187) / 1000.0;
        // device 608, IC IC110, analog/basic/inverter.hpp:11
        I(cpphdl_n1177, Vdd) <+ cpphdl_channel(V(BIT_N4_6, Vdd), V(cpphdl_n1177, Vdd), 0.080000000000000002, 0.69999999999999996, -1.0);
        // device 609, IC IC110, analog/basic/inverter.hpp:12
        I(cpphdl_n1177, Vss) <+ cpphdl_channel(V(BIT_N4_6, Vss), V(cpphdl_n1177, Vss), 0.080000000000000002, 0.69999999999999996, 1.0);
        // device 610, IC IC103, analog/basic/mos_r2r_dac.hpp:27
        I(cpphdl_n1177, Vss) <+ 2.9999999999999998e-15 * ddt(V(cpphdl_n1177, Vss)); // Bench initial voltage = 0.0 V.
        // device 611, IC IC103, analog/basic/mos_r2r_dac.hpp:28
        I(cpphdl_n1177, cpphdl_n1188) <+ V(cpphdl_n1177, cpphdl_n1188) / 2000.0;
        // device 612, IC IC103, analog/basic/mos_r2r_dac.hpp:29
        I(cpphdl_n1188, Vss) <+ 2.9999999999999998e-15 * ddt(V(cpphdl_n1188, Vss)); // Bench initial voltage = 0.0 V.
        // device 613, IC IC103, analog/basic/mos_r2r_dac.hpp:31
        I(cpphdl_n1187, cpphdl_n1188) <+ V(cpphdl_n1187, cpphdl_n1188) / 1000.0;
        // device 614, IC IC111, analog/basic/inverter.hpp:11
        I(cpphdl_n1181, Vdd) <+ cpphdl_channel(V(BIT_N4_7, Vdd), V(cpphdl_n1181, Vdd), 0.080000000000000002, 0.69999999999999996, -1.0);
        // device 615, IC IC111, analog/basic/inverter.hpp:12
        I(cpphdl_n1181, Vss) <+ cpphdl_channel(V(BIT_N4_7, Vss), V(cpphdl_n1181, Vss), 0.080000000000000002, 0.69999999999999996, 1.0);
        // device 616, IC IC103, analog/basic/mos_r2r_dac.hpp:27
        I(cpphdl_n1181, Vss) <+ 2.9999999999999998e-15 * ddt(V(cpphdl_n1181, Vss)); // Bench initial voltage = 0.0 V.
        // device 617, IC IC103, analog/basic/mos_r2r_dac.hpp:28
        I(cpphdl_n1181, cpphdl_n1193) <+ V(cpphdl_n1181, cpphdl_n1193) / 2000.0;
        // device 618, IC IC103, analog/basic/mos_r2r_dac.hpp:29
        I(cpphdl_n1193, Vss) <+ 2.9999999999999998e-15 * ddt(V(cpphdl_n1193, Vss)); // Bench initial voltage = 0.0 V.
        // device 619, IC IC103, analog/basic/mos_r2r_dac.hpp:31
        I(cpphdl_n1188, cpphdl_n1193) <+ V(cpphdl_n1188, cpphdl_n1193) / 1000.0;
        // device 620, IC IC103, analog/basic/mos_r2r_dac.hpp:33
        I(Vss, cpphdl_n1182) <+ V(Vss, cpphdl_n1182) / 2000.0;
        // device 621, IC IC112, analog/basic/nmos_resistor_amplifier.hpp:23
        I(Vdd, cpphdl_n1202) <+ V(Vdd, cpphdl_n1202) / 1000.0;
        // device 622, IC IC112, analog/basic/nmos_resistor_amplifier.hpp:24
        I(Vdd, cpphdl_n1201) <+ V(Vdd, cpphdl_n1201) / 1000.0;
        // device 623, IC IC112, analog/basic/nmos_resistor_amplifier.hpp:25
        I(cpphdl_n1202, cpphdl_n1196) <+ cpphdl_channel(V(cpphdl_n1192, cpphdl_n1196), V(cpphdl_n1202, cpphdl_n1196), 0.014999999999999999, 0.69999999999999996, 1.0);
        // device 624, IC IC112, analog/basic/nmos_resistor_amplifier.hpp:26
        I(cpphdl_n1201, cpphdl_n1197) <+ cpphdl_channel(V(cpphdl_n1193, cpphdl_n1197), V(cpphdl_n1201, cpphdl_n1197), 0.014999999999999999, 0.69999999999999996, 1.0);
        // device 625, IC IC112, analog/basic/nmos_resistor_amplifier.hpp:27
        I(cpphdl_n1198, cpphdl_n1196) <+ V(cpphdl_n1198, cpphdl_n1196) / 50.0;
        // device 626, IC IC112, analog/basic/nmos_resistor_amplifier.hpp:28
        I(cpphdl_n1198, cpphdl_n1197) <+ V(cpphdl_n1198, cpphdl_n1197) / 50.0;
        // device 627, IC IC112, analog/basic/nmos_resistor_amplifier.hpp:29
        I(Vss, cpphdl_n1198) <+ V(Vss, cpphdl_n1198) / 150.0;
        // device 628, IC IC112, analog/basic/nmos_resistor_amplifier.hpp:30
        I(cpphdl_n1202, Vdd) <+ 2.9999999999999998e-13 * ddt(V(cpphdl_n1202, Vdd)); // Bench initial voltage = 0.0 V.
        // device 629, IC IC112, analog/basic/nmos_resistor_amplifier.hpp:31
        I(cpphdl_n1201, Vdd) <+ 2.9999999999999998e-13 * ddt(V(cpphdl_n1201, Vdd)); // Bench initial voltage = 0.0 V.
        // device 630, IC IC112, analog/basic/nmos_resistor_amplifier.hpp:32
        I(cpphdl_n1198, Vss) <+ 4e-14 * ddt(V(cpphdl_n1198, Vss)); // Bench initial voltage = 0.0 V.
        // device 631, IC IC112, analog/basic/nmos_resistor_amplifier.hpp:34
        I(cpphdl_n1192, cpphdl_n1196) <+ 2e-14 * ddt(V(cpphdl_n1192, cpphdl_n1196)); // Bench initial voltage = 1.6499999999999999 V.
        // device 632, IC IC112, analog/basic/nmos_resistor_amplifier.hpp:35
        I(cpphdl_n1193, cpphdl_n1197) <+ 2e-14 * ddt(V(cpphdl_n1193, cpphdl_n1197)); // Bench initial voltage = 0.0 V.
        // device 633, IC IC112, analog/basic/nmos_resistor_amplifier.hpp:36
        I(cpphdl_n1192, cpphdl_n1202) <+ 2.9999999999999998e-15 * ddt(V(cpphdl_n1192, cpphdl_n1202)); // Bench initial voltage = -1.6499999999999999 V.
        // device 634, IC IC112, analog/basic/nmos_resistor_amplifier.hpp:37
        I(cpphdl_n1193, cpphdl_n1201) <+ 2.9999999999999998e-15 * ddt(V(cpphdl_n1193, cpphdl_n1201)); // Bench initial voltage = -3.2999999999999998 V.
        // device 635, IC IC113, analog/basic/strongarm_comparator.hpp:28
        I(cpphdl_n1206, cpphdl_n1208) <+ cpphdl_channel(V(cpphdl_n1201, cpphdl_n1208), V(cpphdl_n1206, cpphdl_n1208), 0.0080000000000000002, 0.69999999999999996, 1.0);
        // device 636, IC IC113, analog/basic/strongarm_comparator.hpp:29
        I(cpphdl_n1207, cpphdl_n1208) <+ cpphdl_channel(V(cpphdl_n1202, cpphdl_n1208), V(cpphdl_n1207, cpphdl_n1208), 0.0080000000000000002, 0.69999999999999996, 1.0);
        // device 637, IC IC113, analog/basic/strongarm_comparator.hpp:30
        I(cpphdl_n1208, Vss) <+ cpphdl_channel(V(EVALUATE, Vss), V(cpphdl_n1208, Vss), 0.0080000000000000002, 0.69999999999999996, 1.0);
        // device 638, IC IC113, analog/basic/strongarm_comparator.hpp:33
        I(cpphdl_n1221, cpphdl_n1206) <+ cpphdl_channel(V(cpphdl_n1225, cpphdl_n1206), V(cpphdl_n1221, cpphdl_n1206), 0.0040000000000000001, 0.69999999999999996, 1.0);
        // device 639, IC IC113, analog/basic/strongarm_comparator.hpp:34
        I(cpphdl_n1225, cpphdl_n1207) <+ cpphdl_channel(V(cpphdl_n1221, cpphdl_n1207), V(cpphdl_n1225, cpphdl_n1207), 0.0040000000000000001, 0.69999999999999996, 1.0);
        // device 640, IC IC113, analog/basic/strongarm_comparator.hpp:35
        I(cpphdl_n1225, Vdd) <+ cpphdl_channel(V(cpphdl_n1221, Vdd), V(cpphdl_n1225, Vdd), 0.002, 0.69999999999999996, -1.0);
        // device 641, IC IC113, analog/basic/strongarm_comparator.hpp:36
        I(cpphdl_n1221, Vdd) <+ cpphdl_channel(V(cpphdl_n1225, Vdd), V(cpphdl_n1221, Vdd), 0.002, 0.69999999999999996, -1.0);
        // device 642, IC IC113, analog/basic/strongarm_comparator.hpp:38
        I(cpphdl_n1206, Vdd) <+ cpphdl_channel(V(EVALUATE, Vdd), V(cpphdl_n1206, Vdd), 0.002, 0.69999999999999996, -1.0);
        // device 643, IC IC113, analog/basic/strongarm_comparator.hpp:39
        I(cpphdl_n1207, Vdd) <+ cpphdl_channel(V(EVALUATE, Vdd), V(cpphdl_n1207, Vdd), 0.002, 0.69999999999999996, -1.0);
        // device 644, IC IC113, analog/basic/strongarm_comparator.hpp:40
        I(cpphdl_n1225, Vdd) <+ cpphdl_channel(V(EVALUATE, Vdd), V(cpphdl_n1225, Vdd), 0.002, 0.69999999999999996, -1.0);
        // device 645, IC IC113, analog/basic/strongarm_comparator.hpp:41
        I(cpphdl_n1221, Vdd) <+ cpphdl_channel(V(EVALUATE, Vdd), V(cpphdl_n1221, Vdd), 0.002, 0.69999999999999996, -1.0);
        // device 646, IC IC113, analog/basic/strongarm_comparator.hpp:42
        I(cpphdl_n1206, Vss) <+ 2.9999999999999998e-14 * ddt(V(cpphdl_n1206, Vss)); // Bench initial voltage = 0.0 V.
        // device 647, IC IC113, analog/basic/strongarm_comparator.hpp:43
        I(cpphdl_n1207, Vss) <+ 2.9999999999999998e-14 * ddt(V(cpphdl_n1207, Vss)); // Bench initial voltage = 0.0 V.
        // device 648, IC IC113, analog/basic/strongarm_comparator.hpp:44
        I(cpphdl_n1208, Vss) <+ 2.9999999999999998e-14 * ddt(V(cpphdl_n1208, Vss)); // Bench initial voltage = 0.0 V.
        // device 649, IC IC113, analog/basic/strongarm_comparator.hpp:45
        I(cpphdl_n1225, Vss) <+ 5.0000000000000002e-14 * ddt(V(cpphdl_n1225, Vss)); // Bench initial voltage = 0.0 V.
        // device 650, IC IC113, analog/basic/strongarm_comparator.hpp:46
        I(cpphdl_n1221, Vss) <+ 5.0000000000000002e-14 * ddt(V(cpphdl_n1221, Vss)); // Bench initial voltage = 0.0 V.
        // device 651, IC IC113, analog/basic/strongarm_comparator.hpp:47
        I(cpphdl_n1201, cpphdl_n1208) <+ 2e-14 * ddt(V(cpphdl_n1201, cpphdl_n1208)); // Bench initial voltage = 3.2999999999999998 V.
        // device 652, IC IC113, analog/basic/strongarm_comparator.hpp:48
        I(cpphdl_n1202, cpphdl_n1208) <+ 2e-14 * ddt(V(cpphdl_n1202, cpphdl_n1208)); // Bench initial voltage = 3.2999999999999998 V.
        // device 653, IC IC113, analog/basic/strongarm_comparator.hpp:49
        I(cpphdl_n1201, cpphdl_n1206) <+ 2.9999999999999998e-15 * ddt(V(cpphdl_n1201, cpphdl_n1206)); // Bench initial voltage = 3.2999999999999998 V.
        // device 654, IC IC113, analog/basic/strongarm_comparator.hpp:50
        I(cpphdl_n1202, cpphdl_n1207) <+ 2.9999999999999998e-15 * ddt(V(cpphdl_n1202, cpphdl_n1207)); // Bench initial voltage = 3.2999999999999998 V.
        // device 655, IC IC115, analog/basic/inverter.hpp:11
        I(cpphdl_n1229, Vdd) <+ cpphdl_channel(V(cpphdl_n1221, Vdd), V(cpphdl_n1229, Vdd), 0.001, 0.69999999999999996, -1.0);
        // device 656, IC IC115, analog/basic/inverter.hpp:12
        I(cpphdl_n1229, Vss) <+ cpphdl_channel(V(cpphdl_n1221, Vss), V(cpphdl_n1229, Vss), 0.001, 0.69999999999999996, 1.0);
        // device 657, IC IC117, analog/basic/inverter.hpp:11
        I(cpphdl_n1243, Vdd) <+ cpphdl_channel(V(cpphdl_n1229, Vdd), V(cpphdl_n1243, Vdd), 0.0040000000000000001, 0.69999999999999996, -1.0);
        // device 658, IC IC117, analog/basic/inverter.hpp:12
        I(cpphdl_n1243, Vss) <+ cpphdl_channel(V(cpphdl_n1229, Vss), V(cpphdl_n1243, Vss), 0.0040000000000000001, 0.69999999999999996, 1.0);
        // device 659, IC IC114, analog/basic/buffered_nand_latch.hpp:34
        I(cpphdl_n1221, Vss) <+ 2.0000000000000002e-15 * ddt(V(cpphdl_n1221, Vss)); // Bench initial voltage = 0.0 V.
        // device 660, IC IC114, analog/basic/buffered_nand_latch.hpp:35
        I(cpphdl_n1221, cpphdl_n1229) <+ 1.0000000000000001e-15 * ddt(V(cpphdl_n1221, cpphdl_n1229)); // Bench initial voltage = 0.0 V.
        // device 661, IC IC114, analog/basic/buffered_nand_latch.hpp:36
        I(cpphdl_n1229, Vss) <+ 5e-15 * ddt(V(cpphdl_n1229, Vss)); // Bench initial voltage = 0.0 V.
        // device 662, IC IC114, analog/basic/buffered_nand_latch.hpp:37
        I(cpphdl_n1229, Vss) <+ 8.0000000000000006e-15 * ddt(V(cpphdl_n1229, Vss)); // Bench initial voltage = 0.0 V.
        // device 663, IC IC114, analog/basic/buffered_nand_latch.hpp:38
        I(cpphdl_n1243, Vss) <+ 1e-14 * ddt(V(cpphdl_n1243, Vss)); // Bench initial voltage = 0.0 V.
        // device 664, IC IC116, analog/basic/inverter.hpp:11
        I(cpphdl_n1233, Vdd) <+ cpphdl_channel(V(cpphdl_n1225, Vdd), V(cpphdl_n1233, Vdd), 0.001, 0.69999999999999996, -1.0);
        // device 665, IC IC116, analog/basic/inverter.hpp:12
        I(cpphdl_n1233, Vss) <+ cpphdl_channel(V(cpphdl_n1225, Vss), V(cpphdl_n1233, Vss), 0.001, 0.69999999999999996, 1.0);
        // device 666, IC IC118, analog/basic/inverter.hpp:11
        I(cpphdl_n1249, Vdd) <+ cpphdl_channel(V(cpphdl_n1233, Vdd), V(cpphdl_n1249, Vdd), 0.0040000000000000001, 0.69999999999999996, -1.0);
        // device 667, IC IC118, analog/basic/inverter.hpp:12
        I(cpphdl_n1249, Vss) <+ cpphdl_channel(V(cpphdl_n1233, Vss), V(cpphdl_n1249, Vss), 0.0040000000000000001, 0.69999999999999996, 1.0);
        // device 668, IC IC114, analog/basic/buffered_nand_latch.hpp:34
        I(cpphdl_n1225, Vss) <+ 2.0000000000000002e-15 * ddt(V(cpphdl_n1225, Vss)); // Bench initial voltage = 0.0 V.
        // device 669, IC IC114, analog/basic/buffered_nand_latch.hpp:35
        I(cpphdl_n1225, cpphdl_n1233) <+ 1.0000000000000001e-15 * ddt(V(cpphdl_n1225, cpphdl_n1233)); // Bench initial voltage = 0.0 V.
        // device 670, IC IC114, analog/basic/buffered_nand_latch.hpp:36
        I(cpphdl_n1233, Vss) <+ 5e-15 * ddt(V(cpphdl_n1233, Vss)); // Bench initial voltage = 0.0 V.
        // device 671, IC IC114, analog/basic/buffered_nand_latch.hpp:37
        I(cpphdl_n1233, Vss) <+ 8.0000000000000006e-15 * ddt(V(cpphdl_n1233, Vss)); // Bench initial voltage = 0.0 V.
        // device 672, IC IC114, analog/basic/buffered_nand_latch.hpp:38
        I(cpphdl_n1249, Vss) <+ 1e-14 * ddt(V(cpphdl_n1249, Vss)); // Bench initial voltage = 0.0 V.
        // device 673, IC IC120, analog/basic/cmos_logic.hpp:17
        I(cpphdl_n2870, Vss) <+ 5.0000000000000002e-14 * ddt(V(cpphdl_n2870, Vss)); // Bench initial voltage = 0.0 V.
        // device 674, IC IC120, analog/basic/cmos_logic.hpp:18
        I(cpphdl_n2870, Vdd) <+ cpphdl_channel(V(cpphdl_n1243, Vdd), V(cpphdl_n2870, Vdd), 0.01, 0.69999999999999996, -1.0);
        // device 675, IC IC120, analog/basic/cmos_logic.hpp:19
        I(cpphdl_n2870, Vdd) <+ cpphdl_channel(V(cpphdl_n1251, Vdd), V(cpphdl_n2870, Vdd), 0.01, 0.69999999999999996, -1.0);
        // device 676, IC IC120, analog/basic/cmos_logic.hpp:20
        I(cpphdl_n2870, cpphdl_n1246) <+ cpphdl_channel(V(cpphdl_n1243, cpphdl_n1246), V(cpphdl_n2870, cpphdl_n1246), 0.01, 0.69999999999999996, 1.0);
        // device 677, IC IC120, analog/basic/cmos_logic.hpp:21
        I(cpphdl_n1246, Vss) <+ cpphdl_channel(V(cpphdl_n1251, Vss), V(cpphdl_n1246, Vss), 0.01, 0.69999999999999996, 1.0);
        // device 678, IC IC120, analog/basic/cmos_logic.hpp:23
        I(cpphdl_n2870, Vss) <+ V(cpphdl_n2870, Vss) / 1000000000.0;
        // device 679, IC IC120, analog/basic/cmos_logic.hpp:24
        I(cpphdl_n1246, Vss) <+ V(cpphdl_n1246, Vss) / 1000000000.0;
        // device 680, IC IC121, analog/basic/cmos_logic.hpp:17
        I(cpphdl_n1251, Vss) <+ 5.0000000000000002e-14 * ddt(V(cpphdl_n1251, Vss)); // Bench initial voltage = 0.0 V.
        // device 681, IC IC121, analog/basic/cmos_logic.hpp:18
        I(cpphdl_n1251, Vdd) <+ cpphdl_channel(V(cpphdl_n1249, Vdd), V(cpphdl_n1251, Vdd), 0.01, 0.69999999999999996, -1.0);
        // device 682, IC IC121, analog/basic/cmos_logic.hpp:19
        I(cpphdl_n1251, Vdd) <+ cpphdl_channel(V(cpphdl_n2870, Vdd), V(cpphdl_n1251, Vdd), 0.01, 0.69999999999999996, -1.0);
        // device 683, IC IC121, analog/basic/cmos_logic.hpp:20
        I(cpphdl_n1251, cpphdl_n1252) <+ cpphdl_channel(V(cpphdl_n1249, cpphdl_n1252), V(cpphdl_n1251, cpphdl_n1252), 0.01, 0.69999999999999996, 1.0);
        // device 684, IC IC121, analog/basic/cmos_logic.hpp:21
        I(cpphdl_n1252, Vss) <+ cpphdl_channel(V(cpphdl_n2870, Vss), V(cpphdl_n1252, Vss), 0.01, 0.69999999999999996, 1.0);
        // device 685, IC IC121, analog/basic/cmos_logic.hpp:23
        I(cpphdl_n1251, Vss) <+ V(cpphdl_n1251, Vss) / 1000000000.0;
        // device 686, IC IC121, analog/basic/cmos_logic.hpp:24
        I(cpphdl_n1252, Vss) <+ V(cpphdl_n1252, Vss) / 1000000000.0;
        // device 687, IC IC119, analog/basic/nand_latch.hpp:36
        I(cpphdl_n1243, Vss) <+ 2.9999999999999998e-15 * ddt(V(cpphdl_n1243, Vss)); // Bench initial voltage = 0.0 V.
        // device 688, IC IC119, analog/basic/nand_latch.hpp:37
        I(cpphdl_n1249, Vss) <+ 2.9999999999999998e-15 * ddt(V(cpphdl_n1249, Vss)); // Bench initial voltage = 0.0 V.
        // device 689, IC IC122, analog/basic/inverter.hpp:11
        I(cpphdl_n1257, Vdd) <+ cpphdl_channel(V(CLEAR, Vdd), V(cpphdl_n1257, Vdd), 0.01, 0.69999999999999996, -1.0);
        // device 690, IC IC122, analog/basic/inverter.hpp:12
        I(cpphdl_n1257, Vss) <+ cpphdl_channel(V(CLEAR, Vss), V(cpphdl_n1257, Vss), 0.01, 0.69999999999999996, 1.0);
        // device 691, IC IC119, analog/basic/nand_latch.hpp:58
        I(cpphdl_n1257, Vss) <+ 2.9999999999999998e-15 * ddt(V(cpphdl_n1257, Vss)); // Bench initial voltage = 0.0 V.
        // device 692, IC IC119, analog/basic/nand_latch.hpp:59
        I(cpphdl_n2870, Vss) <+ cpphdl_channel(V(CLEAR, Vss), V(cpphdl_n2870, Vss), 0.050000000000000003, 0.69999999999999996, 1.0);
        // device 693, IC IC119, analog/basic/nand_latch.hpp:60
        I(cpphdl_n1251, Vdd) <+ cpphdl_channel(V(cpphdl_n1257, Vdd), V(cpphdl_n1251, Vdd), 0.050000000000000003, 0.69999999999999996, -1.0);
        // device 694, IC IC125, analog/basic/inverter.hpp:11
        I(cpphdl_n1281, Vdd) <+ cpphdl_channel(V(TRACK5, Vdd), V(cpphdl_n1281, Vdd), 0.0040000000000000001, 0.69999999999999996, -1.0);
        // device 695, IC IC125, analog/basic/inverter.hpp:12
        I(cpphdl_n1281, Vss) <+ cpphdl_channel(V(TRACK5, Vss), V(cpphdl_n1281, Vss), 0.0040000000000000001, 0.69999999999999996, 1.0);
        // device 696, IC IC124, analog/basic/mos_track_hold.hpp:31
        I(cpphdl_n1281, Vss) <+ 2e-14 * ddt(V(cpphdl_n1281, Vss)); // Bench initial voltage = 3.2999999999999998 V.
        // device 697, IC IC124, analog/basic/mos_track_hold.hpp:32
        I(cpphdl_n2705, cpphdl_n1335) <+ cpphdl_channel(V(TRACK5, cpphdl_n1335), V(cpphdl_n2705, cpphdl_n1335), 0.080000000000000002, 0.69999999999999996, 1.0);
        // device 698, IC IC124, analog/basic/mos_track_hold.hpp:33
        I(cpphdl_n1335, cpphdl_n2705) <+ cpphdl_channel(V(cpphdl_n1281, cpphdl_n2705), V(cpphdl_n1335, cpphdl_n2705), 0.040000000000000001, 0.69999999999999996, -1.0);
        // device 699, IC IC124, analog/basic/mos_track_hold.hpp:37
        I(cpphdl_n1335, cpphdl_n1335) <+ cpphdl_channel(V(cpphdl_n1281, cpphdl_n1335), V(cpphdl_n1335, cpphdl_n1335), 0.040000000000000001, 0.69999999999999996, 1.0);
        // device 700, IC IC124, analog/basic/mos_track_hold.hpp:38
        I(cpphdl_n1335, cpphdl_n1335) <+ cpphdl_channel(V(TRACK5, cpphdl_n1335), V(cpphdl_n1335, cpphdl_n1335), 0.02, 0.69999999999999996, -1.0);
        // device 701, IC IC124, analog/basic/mos_track_hold.hpp:39
        I(cpphdl_n1335, Vss) <+ 2e-12 * ddt(V(cpphdl_n1335, Vss)); // Bench initial voltage = 1.6499999999999999 V.
        // device 702, IC IC124, analog/basic/mos_track_hold.hpp:41
        I(Vss, cpphdl_n1335) <+ V(Vss, cpphdl_n1335) / 1000000000.0;
        // device 703, IC IC124, analog/basic/mos_track_hold.hpp:42
        I(TRACK5, cpphdl_n1335) <+ 8.0000000000000006e-15 * ddt(V(TRACK5, cpphdl_n1335)); // Bench initial voltage = -1.6499999999999999 V.
        // device 704, IC IC124, analog/basic/mos_track_hold.hpp:43
        I(cpphdl_n1281, cpphdl_n1335) <+ 8.0000000000000006e-15 * ddt(V(cpphdl_n1281, cpphdl_n1335)); // Bench initial voltage = 1.6499999999999999 V.
        // device 705, IC IC124, analog/basic/mos_track_hold.hpp:44
        I(cpphdl_n2705, cpphdl_n1335) <+ 4.0000000000000003e-15 * ddt(V(cpphdl_n2705, cpphdl_n1335)); // Bench initial voltage = 0.0 V.
        // device 706, IC IC127, analog/basic/inverter.hpp:11
        I(cpphdl_n1296, Vdd) <+ cpphdl_channel(V(BIT_N5_0, Vdd), V(cpphdl_n1296, Vdd), 0.080000000000000002, 0.69999999999999996, -1.0);
        // device 707, IC IC127, analog/basic/inverter.hpp:12
        I(cpphdl_n1296, Vss) <+ cpphdl_channel(V(BIT_N5_0, Vss), V(cpphdl_n1296, Vss), 0.080000000000000002, 0.69999999999999996, 1.0);
        // device 708, IC IC126, analog/basic/mos_r2r_dac.hpp:27
        I(cpphdl_n1296, Vss) <+ 2.9999999999999998e-15 * ddt(V(cpphdl_n1296, Vss)); // Bench initial voltage = 0.0 V.
        // device 709, IC IC126, analog/basic/mos_r2r_dac.hpp:28
        I(cpphdl_n1296, cpphdl_n1325) <+ V(cpphdl_n1296, cpphdl_n1325) / 2000.0;
        // device 710, IC IC126, analog/basic/mos_r2r_dac.hpp:29
        I(cpphdl_n1325, Vss) <+ 2.9999999999999998e-15 * ddt(V(cpphdl_n1325, Vss)); // Bench initial voltage = 0.0 V.
        // device 711, IC IC128, analog/basic/inverter.hpp:11
        I(cpphdl_n1300, Vdd) <+ cpphdl_channel(V(BIT_N5_1, Vdd), V(cpphdl_n1300, Vdd), 0.080000000000000002, 0.69999999999999996, -1.0);
        // device 712, IC IC128, analog/basic/inverter.hpp:12
        I(cpphdl_n1300, Vss) <+ cpphdl_channel(V(BIT_N5_1, Vss), V(cpphdl_n1300, Vss), 0.080000000000000002, 0.69999999999999996, 1.0);
        // device 713, IC IC126, analog/basic/mos_r2r_dac.hpp:27
        I(cpphdl_n1300, Vss) <+ 2.9999999999999998e-15 * ddt(V(cpphdl_n1300, Vss)); // Bench initial voltage = 0.0 V.
        // device 714, IC IC126, analog/basic/mos_r2r_dac.hpp:28
        I(cpphdl_n1300, cpphdl_n1326) <+ V(cpphdl_n1300, cpphdl_n1326) / 2000.0;
        // device 715, IC IC126, analog/basic/mos_r2r_dac.hpp:29
        I(cpphdl_n1326, Vss) <+ 2.9999999999999998e-15 * ddt(V(cpphdl_n1326, Vss)); // Bench initial voltage = 0.0 V.
        // device 716, IC IC126, analog/basic/mos_r2r_dac.hpp:31
        I(cpphdl_n1325, cpphdl_n1326) <+ V(cpphdl_n1325, cpphdl_n1326) / 1000.0;
        // device 717, IC IC129, analog/basic/inverter.hpp:11
        I(cpphdl_n1304, Vdd) <+ cpphdl_channel(V(BIT_N5_2, Vdd), V(cpphdl_n1304, Vdd), 0.080000000000000002, 0.69999999999999996, -1.0);
        // device 718, IC IC129, analog/basic/inverter.hpp:12
        I(cpphdl_n1304, Vss) <+ cpphdl_channel(V(BIT_N5_2, Vss), V(cpphdl_n1304, Vss), 0.080000000000000002, 0.69999999999999996, 1.0);
        // device 719, IC IC126, analog/basic/mos_r2r_dac.hpp:27
        I(cpphdl_n1304, Vss) <+ 2.9999999999999998e-15 * ddt(V(cpphdl_n1304, Vss)); // Bench initial voltage = 0.0 V.
        // device 720, IC IC126, analog/basic/mos_r2r_dac.hpp:28
        I(cpphdl_n1304, cpphdl_n1327) <+ V(cpphdl_n1304, cpphdl_n1327) / 2000.0;
        // device 721, IC IC126, analog/basic/mos_r2r_dac.hpp:29
        I(cpphdl_n1327, Vss) <+ 2.9999999999999998e-15 * ddt(V(cpphdl_n1327, Vss)); // Bench initial voltage = 0.0 V.
        // device 722, IC IC126, analog/basic/mos_r2r_dac.hpp:31
        I(cpphdl_n1326, cpphdl_n1327) <+ V(cpphdl_n1326, cpphdl_n1327) / 1000.0;
        // device 723, IC IC130, analog/basic/inverter.hpp:11
        I(cpphdl_n1308, Vdd) <+ cpphdl_channel(V(BIT_N5_3, Vdd), V(cpphdl_n1308, Vdd), 0.080000000000000002, 0.69999999999999996, -1.0);
        // device 724, IC IC130, analog/basic/inverter.hpp:12
        I(cpphdl_n1308, Vss) <+ cpphdl_channel(V(BIT_N5_3, Vss), V(cpphdl_n1308, Vss), 0.080000000000000002, 0.69999999999999996, 1.0);
        // device 725, IC IC126, analog/basic/mos_r2r_dac.hpp:27
        I(cpphdl_n1308, Vss) <+ 2.9999999999999998e-15 * ddt(V(cpphdl_n1308, Vss)); // Bench initial voltage = 0.0 V.
        // device 726, IC IC126, analog/basic/mos_r2r_dac.hpp:28
        I(cpphdl_n1308, cpphdl_n1328) <+ V(cpphdl_n1308, cpphdl_n1328) / 2000.0;
        // device 727, IC IC126, analog/basic/mos_r2r_dac.hpp:29
        I(cpphdl_n1328, Vss) <+ 2.9999999999999998e-15 * ddt(V(cpphdl_n1328, Vss)); // Bench initial voltage = 0.0 V.
        // device 728, IC IC126, analog/basic/mos_r2r_dac.hpp:31
        I(cpphdl_n1327, cpphdl_n1328) <+ V(cpphdl_n1327, cpphdl_n1328) / 1000.0;
        // device 729, IC IC131, analog/basic/inverter.hpp:11
        I(cpphdl_n1312, Vdd) <+ cpphdl_channel(V(BIT_N5_4, Vdd), V(cpphdl_n1312, Vdd), 0.080000000000000002, 0.69999999999999996, -1.0);
        // device 730, IC IC131, analog/basic/inverter.hpp:12
        I(cpphdl_n1312, Vss) <+ cpphdl_channel(V(BIT_N5_4, Vss), V(cpphdl_n1312, Vss), 0.080000000000000002, 0.69999999999999996, 1.0);
        // device 731, IC IC126, analog/basic/mos_r2r_dac.hpp:27
        I(cpphdl_n1312, Vss) <+ 2.9999999999999998e-15 * ddt(V(cpphdl_n1312, Vss)); // Bench initial voltage = 0.0 V.
        // device 732, IC IC126, analog/basic/mos_r2r_dac.hpp:28
        I(cpphdl_n1312, cpphdl_n1329) <+ V(cpphdl_n1312, cpphdl_n1329) / 2000.0;
        // device 733, IC IC126, analog/basic/mos_r2r_dac.hpp:29
        I(cpphdl_n1329, Vss) <+ 2.9999999999999998e-15 * ddt(V(cpphdl_n1329, Vss)); // Bench initial voltage = 0.0 V.
        // device 734, IC IC126, analog/basic/mos_r2r_dac.hpp:31
        I(cpphdl_n1328, cpphdl_n1329) <+ V(cpphdl_n1328, cpphdl_n1329) / 1000.0;
        // device 735, IC IC132, analog/basic/inverter.hpp:11
        I(cpphdl_n1316, Vdd) <+ cpphdl_channel(V(BIT_N5_5, Vdd), V(cpphdl_n1316, Vdd), 0.080000000000000002, 0.69999999999999996, -1.0);
        // device 736, IC IC132, analog/basic/inverter.hpp:12
        I(cpphdl_n1316, Vss) <+ cpphdl_channel(V(BIT_N5_5, Vss), V(cpphdl_n1316, Vss), 0.080000000000000002, 0.69999999999999996, 1.0);
        // device 737, IC IC126, analog/basic/mos_r2r_dac.hpp:27
        I(cpphdl_n1316, Vss) <+ 2.9999999999999998e-15 * ddt(V(cpphdl_n1316, Vss)); // Bench initial voltage = 0.0 V.
        // device 738, IC IC126, analog/basic/mos_r2r_dac.hpp:28
        I(cpphdl_n1316, cpphdl_n1330) <+ V(cpphdl_n1316, cpphdl_n1330) / 2000.0;
        // device 739, IC IC126, analog/basic/mos_r2r_dac.hpp:29
        I(cpphdl_n1330, Vss) <+ 2.9999999999999998e-15 * ddt(V(cpphdl_n1330, Vss)); // Bench initial voltage = 0.0 V.
        // device 740, IC IC126, analog/basic/mos_r2r_dac.hpp:31
        I(cpphdl_n1329, cpphdl_n1330) <+ V(cpphdl_n1329, cpphdl_n1330) / 1000.0;
        // device 741, IC IC133, analog/basic/inverter.hpp:11
        I(cpphdl_n1320, Vdd) <+ cpphdl_channel(V(BIT_N5_6, Vdd), V(cpphdl_n1320, Vdd), 0.080000000000000002, 0.69999999999999996, -1.0);
        // device 742, IC IC133, analog/basic/inverter.hpp:12
        I(cpphdl_n1320, Vss) <+ cpphdl_channel(V(BIT_N5_6, Vss), V(cpphdl_n1320, Vss), 0.080000000000000002, 0.69999999999999996, 1.0);
        // device 743, IC IC126, analog/basic/mos_r2r_dac.hpp:27
        I(cpphdl_n1320, Vss) <+ 2.9999999999999998e-15 * ddt(V(cpphdl_n1320, Vss)); // Bench initial voltage = 0.0 V.
        // device 744, IC IC126, analog/basic/mos_r2r_dac.hpp:28
        I(cpphdl_n1320, cpphdl_n1331) <+ V(cpphdl_n1320, cpphdl_n1331) / 2000.0;
        // device 745, IC IC126, analog/basic/mos_r2r_dac.hpp:29
        I(cpphdl_n1331, Vss) <+ 2.9999999999999998e-15 * ddt(V(cpphdl_n1331, Vss)); // Bench initial voltage = 0.0 V.
        // device 746, IC IC126, analog/basic/mos_r2r_dac.hpp:31
        I(cpphdl_n1330, cpphdl_n1331) <+ V(cpphdl_n1330, cpphdl_n1331) / 1000.0;
        // device 747, IC IC134, analog/basic/inverter.hpp:11
        I(cpphdl_n1324, Vdd) <+ cpphdl_channel(V(BIT_N5_7, Vdd), V(cpphdl_n1324, Vdd), 0.080000000000000002, 0.69999999999999996, -1.0);
        // device 748, IC IC134, analog/basic/inverter.hpp:12
        I(cpphdl_n1324, Vss) <+ cpphdl_channel(V(BIT_N5_7, Vss), V(cpphdl_n1324, Vss), 0.080000000000000002, 0.69999999999999996, 1.0);
        // device 749, IC IC126, analog/basic/mos_r2r_dac.hpp:27
        I(cpphdl_n1324, Vss) <+ 2.9999999999999998e-15 * ddt(V(cpphdl_n1324, Vss)); // Bench initial voltage = 0.0 V.
        // device 750, IC IC126, analog/basic/mos_r2r_dac.hpp:28
        I(cpphdl_n1324, cpphdl_n1336) <+ V(cpphdl_n1324, cpphdl_n1336) / 2000.0;
        // device 751, IC IC126, analog/basic/mos_r2r_dac.hpp:29
        I(cpphdl_n1336, Vss) <+ 2.9999999999999998e-15 * ddt(V(cpphdl_n1336, Vss)); // Bench initial voltage = 0.0 V.
        // device 752, IC IC126, analog/basic/mos_r2r_dac.hpp:31
        I(cpphdl_n1331, cpphdl_n1336) <+ V(cpphdl_n1331, cpphdl_n1336) / 1000.0;
        // device 753, IC IC126, analog/basic/mos_r2r_dac.hpp:33
        I(Vss, cpphdl_n1325) <+ V(Vss, cpphdl_n1325) / 2000.0;
        // device 754, IC IC135, analog/basic/nmos_resistor_amplifier.hpp:23
        I(Vdd, cpphdl_n1345) <+ V(Vdd, cpphdl_n1345) / 1000.0;
        // device 755, IC IC135, analog/basic/nmos_resistor_amplifier.hpp:24
        I(Vdd, cpphdl_n1344) <+ V(Vdd, cpphdl_n1344) / 1000.0;
        // device 756, IC IC135, analog/basic/nmos_resistor_amplifier.hpp:25
        I(cpphdl_n1345, cpphdl_n1339) <+ cpphdl_channel(V(cpphdl_n1335, cpphdl_n1339), V(cpphdl_n1345, cpphdl_n1339), 0.014999999999999999, 0.69999999999999996, 1.0);
        // device 757, IC IC135, analog/basic/nmos_resistor_amplifier.hpp:26
        I(cpphdl_n1344, cpphdl_n1340) <+ cpphdl_channel(V(cpphdl_n1336, cpphdl_n1340), V(cpphdl_n1344, cpphdl_n1340), 0.014999999999999999, 0.69999999999999996, 1.0);
        // device 758, IC IC135, analog/basic/nmos_resistor_amplifier.hpp:27
        I(cpphdl_n1341, cpphdl_n1339) <+ V(cpphdl_n1341, cpphdl_n1339) / 50.0;
        // device 759, IC IC135, analog/basic/nmos_resistor_amplifier.hpp:28
        I(cpphdl_n1341, cpphdl_n1340) <+ V(cpphdl_n1341, cpphdl_n1340) / 50.0;
        // device 760, IC IC135, analog/basic/nmos_resistor_amplifier.hpp:29
        I(Vss, cpphdl_n1341) <+ V(Vss, cpphdl_n1341) / 150.0;
        // device 761, IC IC135, analog/basic/nmos_resistor_amplifier.hpp:30
        I(cpphdl_n1345, Vdd) <+ 2.9999999999999998e-13 * ddt(V(cpphdl_n1345, Vdd)); // Bench initial voltage = 0.0 V.
        // device 762, IC IC135, analog/basic/nmos_resistor_amplifier.hpp:31
        I(cpphdl_n1344, Vdd) <+ 2.9999999999999998e-13 * ddt(V(cpphdl_n1344, Vdd)); // Bench initial voltage = 0.0 V.
        // device 763, IC IC135, analog/basic/nmos_resistor_amplifier.hpp:32
        I(cpphdl_n1341, Vss) <+ 4e-14 * ddt(V(cpphdl_n1341, Vss)); // Bench initial voltage = 0.0 V.
        // device 764, IC IC135, analog/basic/nmos_resistor_amplifier.hpp:34
        I(cpphdl_n1335, cpphdl_n1339) <+ 2e-14 * ddt(V(cpphdl_n1335, cpphdl_n1339)); // Bench initial voltage = 1.6499999999999999 V.
        // device 765, IC IC135, analog/basic/nmos_resistor_amplifier.hpp:35
        I(cpphdl_n1336, cpphdl_n1340) <+ 2e-14 * ddt(V(cpphdl_n1336, cpphdl_n1340)); // Bench initial voltage = 0.0 V.
        // device 766, IC IC135, analog/basic/nmos_resistor_amplifier.hpp:36
        I(cpphdl_n1335, cpphdl_n1345) <+ 2.9999999999999998e-15 * ddt(V(cpphdl_n1335, cpphdl_n1345)); // Bench initial voltage = -1.6499999999999999 V.
        // device 767, IC IC135, analog/basic/nmos_resistor_amplifier.hpp:37
        I(cpphdl_n1336, cpphdl_n1344) <+ 2.9999999999999998e-15 * ddt(V(cpphdl_n1336, cpphdl_n1344)); // Bench initial voltage = -3.2999999999999998 V.
        // device 768, IC IC136, analog/basic/strongarm_comparator.hpp:28
        I(cpphdl_n1349, cpphdl_n1351) <+ cpphdl_channel(V(cpphdl_n1344, cpphdl_n1351), V(cpphdl_n1349, cpphdl_n1351), 0.0080000000000000002, 0.69999999999999996, 1.0);
        // device 769, IC IC136, analog/basic/strongarm_comparator.hpp:29
        I(cpphdl_n1350, cpphdl_n1351) <+ cpphdl_channel(V(cpphdl_n1345, cpphdl_n1351), V(cpphdl_n1350, cpphdl_n1351), 0.0080000000000000002, 0.69999999999999996, 1.0);
        // device 770, IC IC136, analog/basic/strongarm_comparator.hpp:30
        I(cpphdl_n1351, Vss) <+ cpphdl_channel(V(EVALUATE, Vss), V(cpphdl_n1351, Vss), 0.0080000000000000002, 0.69999999999999996, 1.0);
        // device 771, IC IC136, analog/basic/strongarm_comparator.hpp:33
        I(cpphdl_n1364, cpphdl_n1349) <+ cpphdl_channel(V(cpphdl_n1368, cpphdl_n1349), V(cpphdl_n1364, cpphdl_n1349), 0.0040000000000000001, 0.69999999999999996, 1.0);
        // device 772, IC IC136, analog/basic/strongarm_comparator.hpp:34
        I(cpphdl_n1368, cpphdl_n1350) <+ cpphdl_channel(V(cpphdl_n1364, cpphdl_n1350), V(cpphdl_n1368, cpphdl_n1350), 0.0040000000000000001, 0.69999999999999996, 1.0);
        // device 773, IC IC136, analog/basic/strongarm_comparator.hpp:35
        I(cpphdl_n1368, Vdd) <+ cpphdl_channel(V(cpphdl_n1364, Vdd), V(cpphdl_n1368, Vdd), 0.002, 0.69999999999999996, -1.0);
        // device 774, IC IC136, analog/basic/strongarm_comparator.hpp:36
        I(cpphdl_n1364, Vdd) <+ cpphdl_channel(V(cpphdl_n1368, Vdd), V(cpphdl_n1364, Vdd), 0.002, 0.69999999999999996, -1.0);
        // device 775, IC IC136, analog/basic/strongarm_comparator.hpp:38
        I(cpphdl_n1349, Vdd) <+ cpphdl_channel(V(EVALUATE, Vdd), V(cpphdl_n1349, Vdd), 0.002, 0.69999999999999996, -1.0);
        // device 776, IC IC136, analog/basic/strongarm_comparator.hpp:39
        I(cpphdl_n1350, Vdd) <+ cpphdl_channel(V(EVALUATE, Vdd), V(cpphdl_n1350, Vdd), 0.002, 0.69999999999999996, -1.0);
        // device 777, IC IC136, analog/basic/strongarm_comparator.hpp:40
        I(cpphdl_n1368, Vdd) <+ cpphdl_channel(V(EVALUATE, Vdd), V(cpphdl_n1368, Vdd), 0.002, 0.69999999999999996, -1.0);
        // device 778, IC IC136, analog/basic/strongarm_comparator.hpp:41
        I(cpphdl_n1364, Vdd) <+ cpphdl_channel(V(EVALUATE, Vdd), V(cpphdl_n1364, Vdd), 0.002, 0.69999999999999996, -1.0);
        // device 779, IC IC136, analog/basic/strongarm_comparator.hpp:42
        I(cpphdl_n1349, Vss) <+ 2.9999999999999998e-14 * ddt(V(cpphdl_n1349, Vss)); // Bench initial voltage = 0.0 V.
        // device 780, IC IC136, analog/basic/strongarm_comparator.hpp:43
        I(cpphdl_n1350, Vss) <+ 2.9999999999999998e-14 * ddt(V(cpphdl_n1350, Vss)); // Bench initial voltage = 0.0 V.
        // device 781, IC IC136, analog/basic/strongarm_comparator.hpp:44
        I(cpphdl_n1351, Vss) <+ 2.9999999999999998e-14 * ddt(V(cpphdl_n1351, Vss)); // Bench initial voltage = 0.0 V.
        // device 782, IC IC136, analog/basic/strongarm_comparator.hpp:45
        I(cpphdl_n1368, Vss) <+ 5.0000000000000002e-14 * ddt(V(cpphdl_n1368, Vss)); // Bench initial voltage = 0.0 V.
        // device 783, IC IC136, analog/basic/strongarm_comparator.hpp:46
        I(cpphdl_n1364, Vss) <+ 5.0000000000000002e-14 * ddt(V(cpphdl_n1364, Vss)); // Bench initial voltage = 0.0 V.
        // device 784, IC IC136, analog/basic/strongarm_comparator.hpp:47
        I(cpphdl_n1344, cpphdl_n1351) <+ 2e-14 * ddt(V(cpphdl_n1344, cpphdl_n1351)); // Bench initial voltage = 3.2999999999999998 V.
        // device 785, IC IC136, analog/basic/strongarm_comparator.hpp:48
        I(cpphdl_n1345, cpphdl_n1351) <+ 2e-14 * ddt(V(cpphdl_n1345, cpphdl_n1351)); // Bench initial voltage = 3.2999999999999998 V.
        // device 786, IC IC136, analog/basic/strongarm_comparator.hpp:49
        I(cpphdl_n1344, cpphdl_n1349) <+ 2.9999999999999998e-15 * ddt(V(cpphdl_n1344, cpphdl_n1349)); // Bench initial voltage = 3.2999999999999998 V.
        // device 787, IC IC136, analog/basic/strongarm_comparator.hpp:50
        I(cpphdl_n1345, cpphdl_n1350) <+ 2.9999999999999998e-15 * ddt(V(cpphdl_n1345, cpphdl_n1350)); // Bench initial voltage = 3.2999999999999998 V.
        // device 788, IC IC138, analog/basic/inverter.hpp:11
        I(cpphdl_n1372, Vdd) <+ cpphdl_channel(V(cpphdl_n1364, Vdd), V(cpphdl_n1372, Vdd), 0.001, 0.69999999999999996, -1.0);
        // device 789, IC IC138, analog/basic/inverter.hpp:12
        I(cpphdl_n1372, Vss) <+ cpphdl_channel(V(cpphdl_n1364, Vss), V(cpphdl_n1372, Vss), 0.001, 0.69999999999999996, 1.0);
        // device 790, IC IC140, analog/basic/inverter.hpp:11
        I(cpphdl_n1386, Vdd) <+ cpphdl_channel(V(cpphdl_n1372, Vdd), V(cpphdl_n1386, Vdd), 0.0040000000000000001, 0.69999999999999996, -1.0);
        // device 791, IC IC140, analog/basic/inverter.hpp:12
        I(cpphdl_n1386, Vss) <+ cpphdl_channel(V(cpphdl_n1372, Vss), V(cpphdl_n1386, Vss), 0.0040000000000000001, 0.69999999999999996, 1.0);
        // device 792, IC IC137, analog/basic/buffered_nand_latch.hpp:34
        I(cpphdl_n1364, Vss) <+ 2.0000000000000002e-15 * ddt(V(cpphdl_n1364, Vss)); // Bench initial voltage = 0.0 V.
        // device 793, IC IC137, analog/basic/buffered_nand_latch.hpp:35
        I(cpphdl_n1364, cpphdl_n1372) <+ 1.0000000000000001e-15 * ddt(V(cpphdl_n1364, cpphdl_n1372)); // Bench initial voltage = 0.0 V.
        // device 794, IC IC137, analog/basic/buffered_nand_latch.hpp:36
        I(cpphdl_n1372, Vss) <+ 5e-15 * ddt(V(cpphdl_n1372, Vss)); // Bench initial voltage = 0.0 V.
        // device 795, IC IC137, analog/basic/buffered_nand_latch.hpp:37
        I(cpphdl_n1372, Vss) <+ 8.0000000000000006e-15 * ddt(V(cpphdl_n1372, Vss)); // Bench initial voltage = 0.0 V.
        // device 796, IC IC137, analog/basic/buffered_nand_latch.hpp:38
        I(cpphdl_n1386, Vss) <+ 1e-14 * ddt(V(cpphdl_n1386, Vss)); // Bench initial voltage = 0.0 V.
        // device 797, IC IC139, analog/basic/inverter.hpp:11
        I(cpphdl_n1376, Vdd) <+ cpphdl_channel(V(cpphdl_n1368, Vdd), V(cpphdl_n1376, Vdd), 0.001, 0.69999999999999996, -1.0);
        // device 798, IC IC139, analog/basic/inverter.hpp:12
        I(cpphdl_n1376, Vss) <+ cpphdl_channel(V(cpphdl_n1368, Vss), V(cpphdl_n1376, Vss), 0.001, 0.69999999999999996, 1.0);
        // device 799, IC IC141, analog/basic/inverter.hpp:11
        I(cpphdl_n1392, Vdd) <+ cpphdl_channel(V(cpphdl_n1376, Vdd), V(cpphdl_n1392, Vdd), 0.0040000000000000001, 0.69999999999999996, -1.0);
        // device 800, IC IC141, analog/basic/inverter.hpp:12
        I(cpphdl_n1392, Vss) <+ cpphdl_channel(V(cpphdl_n1376, Vss), V(cpphdl_n1392, Vss), 0.0040000000000000001, 0.69999999999999996, 1.0);
        // device 801, IC IC137, analog/basic/buffered_nand_latch.hpp:34
        I(cpphdl_n1368, Vss) <+ 2.0000000000000002e-15 * ddt(V(cpphdl_n1368, Vss)); // Bench initial voltage = 0.0 V.
        // device 802, IC IC137, analog/basic/buffered_nand_latch.hpp:35
        I(cpphdl_n1368, cpphdl_n1376) <+ 1.0000000000000001e-15 * ddt(V(cpphdl_n1368, cpphdl_n1376)); // Bench initial voltage = 0.0 V.
        // device 803, IC IC137, analog/basic/buffered_nand_latch.hpp:36
        I(cpphdl_n1376, Vss) <+ 5e-15 * ddt(V(cpphdl_n1376, Vss)); // Bench initial voltage = 0.0 V.
        // device 804, IC IC137, analog/basic/buffered_nand_latch.hpp:37
        I(cpphdl_n1376, Vss) <+ 8.0000000000000006e-15 * ddt(V(cpphdl_n1376, Vss)); // Bench initial voltage = 0.0 V.
        // device 805, IC IC137, analog/basic/buffered_nand_latch.hpp:38
        I(cpphdl_n1392, Vss) <+ 1e-14 * ddt(V(cpphdl_n1392, Vss)); // Bench initial voltage = 0.0 V.
        // device 806, IC IC143, analog/basic/cmos_logic.hpp:17
        I(cpphdl_n2875, Vss) <+ 5.0000000000000002e-14 * ddt(V(cpphdl_n2875, Vss)); // Bench initial voltage = 0.0 V.
        // device 807, IC IC143, analog/basic/cmos_logic.hpp:18
        I(cpphdl_n2875, Vdd) <+ cpphdl_channel(V(cpphdl_n1386, Vdd), V(cpphdl_n2875, Vdd), 0.01, 0.69999999999999996, -1.0);
        // device 808, IC IC143, analog/basic/cmos_logic.hpp:19
        I(cpphdl_n2875, Vdd) <+ cpphdl_channel(V(cpphdl_n1394, Vdd), V(cpphdl_n2875, Vdd), 0.01, 0.69999999999999996, -1.0);
        // device 809, IC IC143, analog/basic/cmos_logic.hpp:20
        I(cpphdl_n2875, cpphdl_n1389) <+ cpphdl_channel(V(cpphdl_n1386, cpphdl_n1389), V(cpphdl_n2875, cpphdl_n1389), 0.01, 0.69999999999999996, 1.0);
        // device 810, IC IC143, analog/basic/cmos_logic.hpp:21
        I(cpphdl_n1389, Vss) <+ cpphdl_channel(V(cpphdl_n1394, Vss), V(cpphdl_n1389, Vss), 0.01, 0.69999999999999996, 1.0);
        // device 811, IC IC143, analog/basic/cmos_logic.hpp:23
        I(cpphdl_n2875, Vss) <+ V(cpphdl_n2875, Vss) / 1000000000.0;
        // device 812, IC IC143, analog/basic/cmos_logic.hpp:24
        I(cpphdl_n1389, Vss) <+ V(cpphdl_n1389, Vss) / 1000000000.0;
        // device 813, IC IC144, analog/basic/cmos_logic.hpp:17
        I(cpphdl_n1394, Vss) <+ 5.0000000000000002e-14 * ddt(V(cpphdl_n1394, Vss)); // Bench initial voltage = 0.0 V.
        // device 814, IC IC144, analog/basic/cmos_logic.hpp:18
        I(cpphdl_n1394, Vdd) <+ cpphdl_channel(V(cpphdl_n1392, Vdd), V(cpphdl_n1394, Vdd), 0.01, 0.69999999999999996, -1.0);
        // device 815, IC IC144, analog/basic/cmos_logic.hpp:19
        I(cpphdl_n1394, Vdd) <+ cpphdl_channel(V(cpphdl_n2875, Vdd), V(cpphdl_n1394, Vdd), 0.01, 0.69999999999999996, -1.0);
        // device 816, IC IC144, analog/basic/cmos_logic.hpp:20
        I(cpphdl_n1394, cpphdl_n1395) <+ cpphdl_channel(V(cpphdl_n1392, cpphdl_n1395), V(cpphdl_n1394, cpphdl_n1395), 0.01, 0.69999999999999996, 1.0);
        // device 817, IC IC144, analog/basic/cmos_logic.hpp:21
        I(cpphdl_n1395, Vss) <+ cpphdl_channel(V(cpphdl_n2875, Vss), V(cpphdl_n1395, Vss), 0.01, 0.69999999999999996, 1.0);
        // device 818, IC IC144, analog/basic/cmos_logic.hpp:23
        I(cpphdl_n1394, Vss) <+ V(cpphdl_n1394, Vss) / 1000000000.0;
        // device 819, IC IC144, analog/basic/cmos_logic.hpp:24
        I(cpphdl_n1395, Vss) <+ V(cpphdl_n1395, Vss) / 1000000000.0;
        // device 820, IC IC142, analog/basic/nand_latch.hpp:36
        I(cpphdl_n1386, Vss) <+ 2.9999999999999998e-15 * ddt(V(cpphdl_n1386, Vss)); // Bench initial voltage = 0.0 V.
        // device 821, IC IC142, analog/basic/nand_latch.hpp:37
        I(cpphdl_n1392, Vss) <+ 2.9999999999999998e-15 * ddt(V(cpphdl_n1392, Vss)); // Bench initial voltage = 0.0 V.
        // device 822, IC IC145, analog/basic/inverter.hpp:11
        I(cpphdl_n1400, Vdd) <+ cpphdl_channel(V(CLEAR, Vdd), V(cpphdl_n1400, Vdd), 0.01, 0.69999999999999996, -1.0);
        // device 823, IC IC145, analog/basic/inverter.hpp:12
        I(cpphdl_n1400, Vss) <+ cpphdl_channel(V(CLEAR, Vss), V(cpphdl_n1400, Vss), 0.01, 0.69999999999999996, 1.0);
        // device 824, IC IC142, analog/basic/nand_latch.hpp:58
        I(cpphdl_n1400, Vss) <+ 2.9999999999999998e-15 * ddt(V(cpphdl_n1400, Vss)); // Bench initial voltage = 0.0 V.
        // device 825, IC IC142, analog/basic/nand_latch.hpp:59
        I(cpphdl_n2875, Vss) <+ cpphdl_channel(V(CLEAR, Vss), V(cpphdl_n2875, Vss), 0.050000000000000003, 0.69999999999999996, 1.0);
        // device 826, IC IC142, analog/basic/nand_latch.hpp:60
        I(cpphdl_n1394, Vdd) <+ cpphdl_channel(V(cpphdl_n1400, Vdd), V(cpphdl_n1394, Vdd), 0.050000000000000003, 0.69999999999999996, -1.0);
        // device 827, IC IC148, analog/basic/inverter.hpp:11
        I(cpphdl_n1424, Vdd) <+ cpphdl_channel(V(TRACK6, Vdd), V(cpphdl_n1424, Vdd), 0.0040000000000000001, 0.69999999999999996, -1.0);
        // device 828, IC IC148, analog/basic/inverter.hpp:12
        I(cpphdl_n1424, Vss) <+ cpphdl_channel(V(TRACK6, Vss), V(cpphdl_n1424, Vss), 0.0040000000000000001, 0.69999999999999996, 1.0);
        // device 829, IC IC147, analog/basic/mos_track_hold.hpp:31
        I(cpphdl_n1424, Vss) <+ 2e-14 * ddt(V(cpphdl_n1424, Vss)); // Bench initial voltage = 3.2999999999999998 V.
        // device 830, IC IC147, analog/basic/mos_track_hold.hpp:32
        I(cpphdl_n2705, cpphdl_n1478) <+ cpphdl_channel(V(TRACK6, cpphdl_n1478), V(cpphdl_n2705, cpphdl_n1478), 0.080000000000000002, 0.69999999999999996, 1.0);
        // device 831, IC IC147, analog/basic/mos_track_hold.hpp:33
        I(cpphdl_n1478, cpphdl_n2705) <+ cpphdl_channel(V(cpphdl_n1424, cpphdl_n2705), V(cpphdl_n1478, cpphdl_n2705), 0.040000000000000001, 0.69999999999999996, -1.0);
        // device 832, IC IC147, analog/basic/mos_track_hold.hpp:37
        I(cpphdl_n1478, cpphdl_n1478) <+ cpphdl_channel(V(cpphdl_n1424, cpphdl_n1478), V(cpphdl_n1478, cpphdl_n1478), 0.040000000000000001, 0.69999999999999996, 1.0);
        // device 833, IC IC147, analog/basic/mos_track_hold.hpp:38
        I(cpphdl_n1478, cpphdl_n1478) <+ cpphdl_channel(V(TRACK6, cpphdl_n1478), V(cpphdl_n1478, cpphdl_n1478), 0.02, 0.69999999999999996, -1.0);
        // device 834, IC IC147, analog/basic/mos_track_hold.hpp:39
        I(cpphdl_n1478, Vss) <+ 2e-12 * ddt(V(cpphdl_n1478, Vss)); // Bench initial voltage = 1.6499999999999999 V.
        // device 835, IC IC147, analog/basic/mos_track_hold.hpp:41
        I(Vss, cpphdl_n1478) <+ V(Vss, cpphdl_n1478) / 1000000000.0;
        // device 836, IC IC147, analog/basic/mos_track_hold.hpp:42
        I(TRACK6, cpphdl_n1478) <+ 8.0000000000000006e-15 * ddt(V(TRACK6, cpphdl_n1478)); // Bench initial voltage = -1.6499999999999999 V.
        // device 837, IC IC147, analog/basic/mos_track_hold.hpp:43
        I(cpphdl_n1424, cpphdl_n1478) <+ 8.0000000000000006e-15 * ddt(V(cpphdl_n1424, cpphdl_n1478)); // Bench initial voltage = 1.6499999999999999 V.
        // device 838, IC IC147, analog/basic/mos_track_hold.hpp:44
        I(cpphdl_n2705, cpphdl_n1478) <+ 4.0000000000000003e-15 * ddt(V(cpphdl_n2705, cpphdl_n1478)); // Bench initial voltage = 0.0 V.
        // device 839, IC IC150, analog/basic/inverter.hpp:11
        I(cpphdl_n1439, Vdd) <+ cpphdl_channel(V(BIT_N6_0, Vdd), V(cpphdl_n1439, Vdd), 0.080000000000000002, 0.69999999999999996, -1.0);
        // device 840, IC IC150, analog/basic/inverter.hpp:12
        I(cpphdl_n1439, Vss) <+ cpphdl_channel(V(BIT_N6_0, Vss), V(cpphdl_n1439, Vss), 0.080000000000000002, 0.69999999999999996, 1.0);
        // device 841, IC IC149, analog/basic/mos_r2r_dac.hpp:27
        I(cpphdl_n1439, Vss) <+ 2.9999999999999998e-15 * ddt(V(cpphdl_n1439, Vss)); // Bench initial voltage = 0.0 V.
        // device 842, IC IC149, analog/basic/mos_r2r_dac.hpp:28
        I(cpphdl_n1439, cpphdl_n1468) <+ V(cpphdl_n1439, cpphdl_n1468) / 2000.0;
        // device 843, IC IC149, analog/basic/mos_r2r_dac.hpp:29
        I(cpphdl_n1468, Vss) <+ 2.9999999999999998e-15 * ddt(V(cpphdl_n1468, Vss)); // Bench initial voltage = 0.0 V.
        // device 844, IC IC151, analog/basic/inverter.hpp:11
        I(cpphdl_n1443, Vdd) <+ cpphdl_channel(V(BIT_N6_1, Vdd), V(cpphdl_n1443, Vdd), 0.080000000000000002, 0.69999999999999996, -1.0);
        // device 845, IC IC151, analog/basic/inverter.hpp:12
        I(cpphdl_n1443, Vss) <+ cpphdl_channel(V(BIT_N6_1, Vss), V(cpphdl_n1443, Vss), 0.080000000000000002, 0.69999999999999996, 1.0);
        // device 846, IC IC149, analog/basic/mos_r2r_dac.hpp:27
        I(cpphdl_n1443, Vss) <+ 2.9999999999999998e-15 * ddt(V(cpphdl_n1443, Vss)); // Bench initial voltage = 0.0 V.
        // device 847, IC IC149, analog/basic/mos_r2r_dac.hpp:28
        I(cpphdl_n1443, cpphdl_n1469) <+ V(cpphdl_n1443, cpphdl_n1469) / 2000.0;
        // device 848, IC IC149, analog/basic/mos_r2r_dac.hpp:29
        I(cpphdl_n1469, Vss) <+ 2.9999999999999998e-15 * ddt(V(cpphdl_n1469, Vss)); // Bench initial voltage = 0.0 V.
        // device 849, IC IC149, analog/basic/mos_r2r_dac.hpp:31
        I(cpphdl_n1468, cpphdl_n1469) <+ V(cpphdl_n1468, cpphdl_n1469) / 1000.0;
        // device 850, IC IC152, analog/basic/inverter.hpp:11
        I(cpphdl_n1447, Vdd) <+ cpphdl_channel(V(BIT_N6_2, Vdd), V(cpphdl_n1447, Vdd), 0.080000000000000002, 0.69999999999999996, -1.0);
        // device 851, IC IC152, analog/basic/inverter.hpp:12
        I(cpphdl_n1447, Vss) <+ cpphdl_channel(V(BIT_N6_2, Vss), V(cpphdl_n1447, Vss), 0.080000000000000002, 0.69999999999999996, 1.0);
        // device 852, IC IC149, analog/basic/mos_r2r_dac.hpp:27
        I(cpphdl_n1447, Vss) <+ 2.9999999999999998e-15 * ddt(V(cpphdl_n1447, Vss)); // Bench initial voltage = 0.0 V.
        // device 853, IC IC149, analog/basic/mos_r2r_dac.hpp:28
        I(cpphdl_n1447, cpphdl_n1470) <+ V(cpphdl_n1447, cpphdl_n1470) / 2000.0;
        // device 854, IC IC149, analog/basic/mos_r2r_dac.hpp:29
        I(cpphdl_n1470, Vss) <+ 2.9999999999999998e-15 * ddt(V(cpphdl_n1470, Vss)); // Bench initial voltage = 0.0 V.
        // device 855, IC IC149, analog/basic/mos_r2r_dac.hpp:31
        I(cpphdl_n1469, cpphdl_n1470) <+ V(cpphdl_n1469, cpphdl_n1470) / 1000.0;
        // device 856, IC IC153, analog/basic/inverter.hpp:11
        I(cpphdl_n1451, Vdd) <+ cpphdl_channel(V(BIT_N6_3, Vdd), V(cpphdl_n1451, Vdd), 0.080000000000000002, 0.69999999999999996, -1.0);
        // device 857, IC IC153, analog/basic/inverter.hpp:12
        I(cpphdl_n1451, Vss) <+ cpphdl_channel(V(BIT_N6_3, Vss), V(cpphdl_n1451, Vss), 0.080000000000000002, 0.69999999999999996, 1.0);
        // device 858, IC IC149, analog/basic/mos_r2r_dac.hpp:27
        I(cpphdl_n1451, Vss) <+ 2.9999999999999998e-15 * ddt(V(cpphdl_n1451, Vss)); // Bench initial voltage = 0.0 V.
        // device 859, IC IC149, analog/basic/mos_r2r_dac.hpp:28
        I(cpphdl_n1451, cpphdl_n1471) <+ V(cpphdl_n1451, cpphdl_n1471) / 2000.0;
        // device 860, IC IC149, analog/basic/mos_r2r_dac.hpp:29
        I(cpphdl_n1471, Vss) <+ 2.9999999999999998e-15 * ddt(V(cpphdl_n1471, Vss)); // Bench initial voltage = 0.0 V.
        // device 861, IC IC149, analog/basic/mos_r2r_dac.hpp:31
        I(cpphdl_n1470, cpphdl_n1471) <+ V(cpphdl_n1470, cpphdl_n1471) / 1000.0;
        // device 862, IC IC154, analog/basic/inverter.hpp:11
        I(cpphdl_n1455, Vdd) <+ cpphdl_channel(V(BIT_N6_4, Vdd), V(cpphdl_n1455, Vdd), 0.080000000000000002, 0.69999999999999996, -1.0);
        // device 863, IC IC154, analog/basic/inverter.hpp:12
        I(cpphdl_n1455, Vss) <+ cpphdl_channel(V(BIT_N6_4, Vss), V(cpphdl_n1455, Vss), 0.080000000000000002, 0.69999999999999996, 1.0);
        // device 864, IC IC149, analog/basic/mos_r2r_dac.hpp:27
        I(cpphdl_n1455, Vss) <+ 2.9999999999999998e-15 * ddt(V(cpphdl_n1455, Vss)); // Bench initial voltage = 0.0 V.
        // device 865, IC IC149, analog/basic/mos_r2r_dac.hpp:28
        I(cpphdl_n1455, cpphdl_n1472) <+ V(cpphdl_n1455, cpphdl_n1472) / 2000.0;
        // device 866, IC IC149, analog/basic/mos_r2r_dac.hpp:29
        I(cpphdl_n1472, Vss) <+ 2.9999999999999998e-15 * ddt(V(cpphdl_n1472, Vss)); // Bench initial voltage = 0.0 V.
        // device 867, IC IC149, analog/basic/mos_r2r_dac.hpp:31
        I(cpphdl_n1471, cpphdl_n1472) <+ V(cpphdl_n1471, cpphdl_n1472) / 1000.0;
        // device 868, IC IC155, analog/basic/inverter.hpp:11
        I(cpphdl_n1459, Vdd) <+ cpphdl_channel(V(BIT_N6_5, Vdd), V(cpphdl_n1459, Vdd), 0.080000000000000002, 0.69999999999999996, -1.0);
        // device 869, IC IC155, analog/basic/inverter.hpp:12
        I(cpphdl_n1459, Vss) <+ cpphdl_channel(V(BIT_N6_5, Vss), V(cpphdl_n1459, Vss), 0.080000000000000002, 0.69999999999999996, 1.0);
        // device 870, IC IC149, analog/basic/mos_r2r_dac.hpp:27
        I(cpphdl_n1459, Vss) <+ 2.9999999999999998e-15 * ddt(V(cpphdl_n1459, Vss)); // Bench initial voltage = 0.0 V.
        // device 871, IC IC149, analog/basic/mos_r2r_dac.hpp:28
        I(cpphdl_n1459, cpphdl_n1473) <+ V(cpphdl_n1459, cpphdl_n1473) / 2000.0;
        // device 872, IC IC149, analog/basic/mos_r2r_dac.hpp:29
        I(cpphdl_n1473, Vss) <+ 2.9999999999999998e-15 * ddt(V(cpphdl_n1473, Vss)); // Bench initial voltage = 0.0 V.
        // device 873, IC IC149, analog/basic/mos_r2r_dac.hpp:31
        I(cpphdl_n1472, cpphdl_n1473) <+ V(cpphdl_n1472, cpphdl_n1473) / 1000.0;
        // device 874, IC IC156, analog/basic/inverter.hpp:11
        I(cpphdl_n1463, Vdd) <+ cpphdl_channel(V(BIT_N6_6, Vdd), V(cpphdl_n1463, Vdd), 0.080000000000000002, 0.69999999999999996, -1.0);
        // device 875, IC IC156, analog/basic/inverter.hpp:12
        I(cpphdl_n1463, Vss) <+ cpphdl_channel(V(BIT_N6_6, Vss), V(cpphdl_n1463, Vss), 0.080000000000000002, 0.69999999999999996, 1.0);
        // device 876, IC IC149, analog/basic/mos_r2r_dac.hpp:27
        I(cpphdl_n1463, Vss) <+ 2.9999999999999998e-15 * ddt(V(cpphdl_n1463, Vss)); // Bench initial voltage = 0.0 V.
        // device 877, IC IC149, analog/basic/mos_r2r_dac.hpp:28
        I(cpphdl_n1463, cpphdl_n1474) <+ V(cpphdl_n1463, cpphdl_n1474) / 2000.0;
        // device 878, IC IC149, analog/basic/mos_r2r_dac.hpp:29
        I(cpphdl_n1474, Vss) <+ 2.9999999999999998e-15 * ddt(V(cpphdl_n1474, Vss)); // Bench initial voltage = 0.0 V.
        // device 879, IC IC149, analog/basic/mos_r2r_dac.hpp:31
        I(cpphdl_n1473, cpphdl_n1474) <+ V(cpphdl_n1473, cpphdl_n1474) / 1000.0;
        // device 880, IC IC157, analog/basic/inverter.hpp:11
        I(cpphdl_n1467, Vdd) <+ cpphdl_channel(V(BIT_N6_7, Vdd), V(cpphdl_n1467, Vdd), 0.080000000000000002, 0.69999999999999996, -1.0);
        // device 881, IC IC157, analog/basic/inverter.hpp:12
        I(cpphdl_n1467, Vss) <+ cpphdl_channel(V(BIT_N6_7, Vss), V(cpphdl_n1467, Vss), 0.080000000000000002, 0.69999999999999996, 1.0);
        // device 882, IC IC149, analog/basic/mos_r2r_dac.hpp:27
        I(cpphdl_n1467, Vss) <+ 2.9999999999999998e-15 * ddt(V(cpphdl_n1467, Vss)); // Bench initial voltage = 0.0 V.
        // device 883, IC IC149, analog/basic/mos_r2r_dac.hpp:28
        I(cpphdl_n1467, cpphdl_n1479) <+ V(cpphdl_n1467, cpphdl_n1479) / 2000.0;
        // device 884, IC IC149, analog/basic/mos_r2r_dac.hpp:29
        I(cpphdl_n1479, Vss) <+ 2.9999999999999998e-15 * ddt(V(cpphdl_n1479, Vss)); // Bench initial voltage = 0.0 V.
        // device 885, IC IC149, analog/basic/mos_r2r_dac.hpp:31
        I(cpphdl_n1474, cpphdl_n1479) <+ V(cpphdl_n1474, cpphdl_n1479) / 1000.0;
        // device 886, IC IC149, analog/basic/mos_r2r_dac.hpp:33
        I(Vss, cpphdl_n1468) <+ V(Vss, cpphdl_n1468) / 2000.0;
        // device 887, IC IC158, analog/basic/nmos_resistor_amplifier.hpp:23
        I(Vdd, cpphdl_n1488) <+ V(Vdd, cpphdl_n1488) / 1000.0;
        // device 888, IC IC158, analog/basic/nmos_resistor_amplifier.hpp:24
        I(Vdd, cpphdl_n1487) <+ V(Vdd, cpphdl_n1487) / 1000.0;
        // device 889, IC IC158, analog/basic/nmos_resistor_amplifier.hpp:25
        I(cpphdl_n1488, cpphdl_n1482) <+ cpphdl_channel(V(cpphdl_n1478, cpphdl_n1482), V(cpphdl_n1488, cpphdl_n1482), 0.014999999999999999, 0.69999999999999996, 1.0);
        // device 890, IC IC158, analog/basic/nmos_resistor_amplifier.hpp:26
        I(cpphdl_n1487, cpphdl_n1483) <+ cpphdl_channel(V(cpphdl_n1479, cpphdl_n1483), V(cpphdl_n1487, cpphdl_n1483), 0.014999999999999999, 0.69999999999999996, 1.0);
        // device 891, IC IC158, analog/basic/nmos_resistor_amplifier.hpp:27
        I(cpphdl_n1484, cpphdl_n1482) <+ V(cpphdl_n1484, cpphdl_n1482) / 50.0;
        // device 892, IC IC158, analog/basic/nmos_resistor_amplifier.hpp:28
        I(cpphdl_n1484, cpphdl_n1483) <+ V(cpphdl_n1484, cpphdl_n1483) / 50.0;
        // device 893, IC IC158, analog/basic/nmos_resistor_amplifier.hpp:29
        I(Vss, cpphdl_n1484) <+ V(Vss, cpphdl_n1484) / 150.0;
        // device 894, IC IC158, analog/basic/nmos_resistor_amplifier.hpp:30
        I(cpphdl_n1488, Vdd) <+ 2.9999999999999998e-13 * ddt(V(cpphdl_n1488, Vdd)); // Bench initial voltage = 0.0 V.
        // device 895, IC IC158, analog/basic/nmos_resistor_amplifier.hpp:31
        I(cpphdl_n1487, Vdd) <+ 2.9999999999999998e-13 * ddt(V(cpphdl_n1487, Vdd)); // Bench initial voltage = 0.0 V.
        // device 896, IC IC158, analog/basic/nmos_resistor_amplifier.hpp:32
        I(cpphdl_n1484, Vss) <+ 4e-14 * ddt(V(cpphdl_n1484, Vss)); // Bench initial voltage = 0.0 V.
        // device 897, IC IC158, analog/basic/nmos_resistor_amplifier.hpp:34
        I(cpphdl_n1478, cpphdl_n1482) <+ 2e-14 * ddt(V(cpphdl_n1478, cpphdl_n1482)); // Bench initial voltage = 1.6499999999999999 V.
        // device 898, IC IC158, analog/basic/nmos_resistor_amplifier.hpp:35
        I(cpphdl_n1479, cpphdl_n1483) <+ 2e-14 * ddt(V(cpphdl_n1479, cpphdl_n1483)); // Bench initial voltage = 0.0 V.
        // device 899, IC IC158, analog/basic/nmos_resistor_amplifier.hpp:36
        I(cpphdl_n1478, cpphdl_n1488) <+ 2.9999999999999998e-15 * ddt(V(cpphdl_n1478, cpphdl_n1488)); // Bench initial voltage = -1.6499999999999999 V.
        // device 900, IC IC158, analog/basic/nmos_resistor_amplifier.hpp:37
        I(cpphdl_n1479, cpphdl_n1487) <+ 2.9999999999999998e-15 * ddt(V(cpphdl_n1479, cpphdl_n1487)); // Bench initial voltage = -3.2999999999999998 V.
        // device 901, IC IC159, analog/basic/strongarm_comparator.hpp:28
        I(cpphdl_n1492, cpphdl_n1494) <+ cpphdl_channel(V(cpphdl_n1487, cpphdl_n1494), V(cpphdl_n1492, cpphdl_n1494), 0.0080000000000000002, 0.69999999999999996, 1.0);
        // device 902, IC IC159, analog/basic/strongarm_comparator.hpp:29
        I(cpphdl_n1493, cpphdl_n1494) <+ cpphdl_channel(V(cpphdl_n1488, cpphdl_n1494), V(cpphdl_n1493, cpphdl_n1494), 0.0080000000000000002, 0.69999999999999996, 1.0);
        // device 903, IC IC159, analog/basic/strongarm_comparator.hpp:30
        I(cpphdl_n1494, Vss) <+ cpphdl_channel(V(EVALUATE, Vss), V(cpphdl_n1494, Vss), 0.0080000000000000002, 0.69999999999999996, 1.0);
        // device 904, IC IC159, analog/basic/strongarm_comparator.hpp:33
        I(cpphdl_n1507, cpphdl_n1492) <+ cpphdl_channel(V(cpphdl_n1511, cpphdl_n1492), V(cpphdl_n1507, cpphdl_n1492), 0.0040000000000000001, 0.69999999999999996, 1.0);
        // device 905, IC IC159, analog/basic/strongarm_comparator.hpp:34
        I(cpphdl_n1511, cpphdl_n1493) <+ cpphdl_channel(V(cpphdl_n1507, cpphdl_n1493), V(cpphdl_n1511, cpphdl_n1493), 0.0040000000000000001, 0.69999999999999996, 1.0);
        // device 906, IC IC159, analog/basic/strongarm_comparator.hpp:35
        I(cpphdl_n1511, Vdd) <+ cpphdl_channel(V(cpphdl_n1507, Vdd), V(cpphdl_n1511, Vdd), 0.002, 0.69999999999999996, -1.0);
        // device 907, IC IC159, analog/basic/strongarm_comparator.hpp:36
        I(cpphdl_n1507, Vdd) <+ cpphdl_channel(V(cpphdl_n1511, Vdd), V(cpphdl_n1507, Vdd), 0.002, 0.69999999999999996, -1.0);
        // device 908, IC IC159, analog/basic/strongarm_comparator.hpp:38
        I(cpphdl_n1492, Vdd) <+ cpphdl_channel(V(EVALUATE, Vdd), V(cpphdl_n1492, Vdd), 0.002, 0.69999999999999996, -1.0);
        // device 909, IC IC159, analog/basic/strongarm_comparator.hpp:39
        I(cpphdl_n1493, Vdd) <+ cpphdl_channel(V(EVALUATE, Vdd), V(cpphdl_n1493, Vdd), 0.002, 0.69999999999999996, -1.0);
        // device 910, IC IC159, analog/basic/strongarm_comparator.hpp:40
        I(cpphdl_n1511, Vdd) <+ cpphdl_channel(V(EVALUATE, Vdd), V(cpphdl_n1511, Vdd), 0.002, 0.69999999999999996, -1.0);
        // device 911, IC IC159, analog/basic/strongarm_comparator.hpp:41
        I(cpphdl_n1507, Vdd) <+ cpphdl_channel(V(EVALUATE, Vdd), V(cpphdl_n1507, Vdd), 0.002, 0.69999999999999996, -1.0);
        // device 912, IC IC159, analog/basic/strongarm_comparator.hpp:42
        I(cpphdl_n1492, Vss) <+ 2.9999999999999998e-14 * ddt(V(cpphdl_n1492, Vss)); // Bench initial voltage = 0.0 V.
        // device 913, IC IC159, analog/basic/strongarm_comparator.hpp:43
        I(cpphdl_n1493, Vss) <+ 2.9999999999999998e-14 * ddt(V(cpphdl_n1493, Vss)); // Bench initial voltage = 0.0 V.
        // device 914, IC IC159, analog/basic/strongarm_comparator.hpp:44
        I(cpphdl_n1494, Vss) <+ 2.9999999999999998e-14 * ddt(V(cpphdl_n1494, Vss)); // Bench initial voltage = 0.0 V.
        // device 915, IC IC159, analog/basic/strongarm_comparator.hpp:45
        I(cpphdl_n1511, Vss) <+ 5.0000000000000002e-14 * ddt(V(cpphdl_n1511, Vss)); // Bench initial voltage = 0.0 V.
        // device 916, IC IC159, analog/basic/strongarm_comparator.hpp:46
        I(cpphdl_n1507, Vss) <+ 5.0000000000000002e-14 * ddt(V(cpphdl_n1507, Vss)); // Bench initial voltage = 0.0 V.
        // device 917, IC IC159, analog/basic/strongarm_comparator.hpp:47
        I(cpphdl_n1487, cpphdl_n1494) <+ 2e-14 * ddt(V(cpphdl_n1487, cpphdl_n1494)); // Bench initial voltage = 3.2999999999999998 V.
        // device 918, IC IC159, analog/basic/strongarm_comparator.hpp:48
        I(cpphdl_n1488, cpphdl_n1494) <+ 2e-14 * ddt(V(cpphdl_n1488, cpphdl_n1494)); // Bench initial voltage = 3.2999999999999998 V.
        // device 919, IC IC159, analog/basic/strongarm_comparator.hpp:49
        I(cpphdl_n1487, cpphdl_n1492) <+ 2.9999999999999998e-15 * ddt(V(cpphdl_n1487, cpphdl_n1492)); // Bench initial voltage = 3.2999999999999998 V.
        // device 920, IC IC159, analog/basic/strongarm_comparator.hpp:50
        I(cpphdl_n1488, cpphdl_n1493) <+ 2.9999999999999998e-15 * ddt(V(cpphdl_n1488, cpphdl_n1493)); // Bench initial voltage = 3.2999999999999998 V.
        // device 921, IC IC161, analog/basic/inverter.hpp:11
        I(cpphdl_n1515, Vdd) <+ cpphdl_channel(V(cpphdl_n1507, Vdd), V(cpphdl_n1515, Vdd), 0.001, 0.69999999999999996, -1.0);
        // device 922, IC IC161, analog/basic/inverter.hpp:12
        I(cpphdl_n1515, Vss) <+ cpphdl_channel(V(cpphdl_n1507, Vss), V(cpphdl_n1515, Vss), 0.001, 0.69999999999999996, 1.0);
        // device 923, IC IC163, analog/basic/inverter.hpp:11
        I(cpphdl_n1529, Vdd) <+ cpphdl_channel(V(cpphdl_n1515, Vdd), V(cpphdl_n1529, Vdd), 0.0040000000000000001, 0.69999999999999996, -1.0);
        // device 924, IC IC163, analog/basic/inverter.hpp:12
        I(cpphdl_n1529, Vss) <+ cpphdl_channel(V(cpphdl_n1515, Vss), V(cpphdl_n1529, Vss), 0.0040000000000000001, 0.69999999999999996, 1.0);
        // device 925, IC IC160, analog/basic/buffered_nand_latch.hpp:34
        I(cpphdl_n1507, Vss) <+ 2.0000000000000002e-15 * ddt(V(cpphdl_n1507, Vss)); // Bench initial voltage = 0.0 V.
        // device 926, IC IC160, analog/basic/buffered_nand_latch.hpp:35
        I(cpphdl_n1507, cpphdl_n1515) <+ 1.0000000000000001e-15 * ddt(V(cpphdl_n1507, cpphdl_n1515)); // Bench initial voltage = 0.0 V.
        // device 927, IC IC160, analog/basic/buffered_nand_latch.hpp:36
        I(cpphdl_n1515, Vss) <+ 5e-15 * ddt(V(cpphdl_n1515, Vss)); // Bench initial voltage = 0.0 V.
        // device 928, IC IC160, analog/basic/buffered_nand_latch.hpp:37
        I(cpphdl_n1515, Vss) <+ 8.0000000000000006e-15 * ddt(V(cpphdl_n1515, Vss)); // Bench initial voltage = 0.0 V.
        // device 929, IC IC160, analog/basic/buffered_nand_latch.hpp:38
        I(cpphdl_n1529, Vss) <+ 1e-14 * ddt(V(cpphdl_n1529, Vss)); // Bench initial voltage = 0.0 V.
        // device 930, IC IC162, analog/basic/inverter.hpp:11
        I(cpphdl_n1519, Vdd) <+ cpphdl_channel(V(cpphdl_n1511, Vdd), V(cpphdl_n1519, Vdd), 0.001, 0.69999999999999996, -1.0);
        // device 931, IC IC162, analog/basic/inverter.hpp:12
        I(cpphdl_n1519, Vss) <+ cpphdl_channel(V(cpphdl_n1511, Vss), V(cpphdl_n1519, Vss), 0.001, 0.69999999999999996, 1.0);
        // device 932, IC IC164, analog/basic/inverter.hpp:11
        I(cpphdl_n1535, Vdd) <+ cpphdl_channel(V(cpphdl_n1519, Vdd), V(cpphdl_n1535, Vdd), 0.0040000000000000001, 0.69999999999999996, -1.0);
        // device 933, IC IC164, analog/basic/inverter.hpp:12
        I(cpphdl_n1535, Vss) <+ cpphdl_channel(V(cpphdl_n1519, Vss), V(cpphdl_n1535, Vss), 0.0040000000000000001, 0.69999999999999996, 1.0);
        // device 934, IC IC160, analog/basic/buffered_nand_latch.hpp:34
        I(cpphdl_n1511, Vss) <+ 2.0000000000000002e-15 * ddt(V(cpphdl_n1511, Vss)); // Bench initial voltage = 0.0 V.
        // device 935, IC IC160, analog/basic/buffered_nand_latch.hpp:35
        I(cpphdl_n1511, cpphdl_n1519) <+ 1.0000000000000001e-15 * ddt(V(cpphdl_n1511, cpphdl_n1519)); // Bench initial voltage = 0.0 V.
        // device 936, IC IC160, analog/basic/buffered_nand_latch.hpp:36
        I(cpphdl_n1519, Vss) <+ 5e-15 * ddt(V(cpphdl_n1519, Vss)); // Bench initial voltage = 0.0 V.
        // device 937, IC IC160, analog/basic/buffered_nand_latch.hpp:37
        I(cpphdl_n1519, Vss) <+ 8.0000000000000006e-15 * ddt(V(cpphdl_n1519, Vss)); // Bench initial voltage = 0.0 V.
        // device 938, IC IC160, analog/basic/buffered_nand_latch.hpp:38
        I(cpphdl_n1535, Vss) <+ 1e-14 * ddt(V(cpphdl_n1535, Vss)); // Bench initial voltage = 0.0 V.
        // device 939, IC IC166, analog/basic/cmos_logic.hpp:17
        I(cpphdl_n2880, Vss) <+ 5.0000000000000002e-14 * ddt(V(cpphdl_n2880, Vss)); // Bench initial voltage = 0.0 V.
        // device 940, IC IC166, analog/basic/cmos_logic.hpp:18
        I(cpphdl_n2880, Vdd) <+ cpphdl_channel(V(cpphdl_n1529, Vdd), V(cpphdl_n2880, Vdd), 0.01, 0.69999999999999996, -1.0);
        // device 941, IC IC166, analog/basic/cmos_logic.hpp:19
        I(cpphdl_n2880, Vdd) <+ cpphdl_channel(V(cpphdl_n1537, Vdd), V(cpphdl_n2880, Vdd), 0.01, 0.69999999999999996, -1.0);
        // device 942, IC IC166, analog/basic/cmos_logic.hpp:20
        I(cpphdl_n2880, cpphdl_n1532) <+ cpphdl_channel(V(cpphdl_n1529, cpphdl_n1532), V(cpphdl_n2880, cpphdl_n1532), 0.01, 0.69999999999999996, 1.0);
        // device 943, IC IC166, analog/basic/cmos_logic.hpp:21
        I(cpphdl_n1532, Vss) <+ cpphdl_channel(V(cpphdl_n1537, Vss), V(cpphdl_n1532, Vss), 0.01, 0.69999999999999996, 1.0);
        // device 944, IC IC166, analog/basic/cmos_logic.hpp:23
        I(cpphdl_n2880, Vss) <+ V(cpphdl_n2880, Vss) / 1000000000.0;
        // device 945, IC IC166, analog/basic/cmos_logic.hpp:24
        I(cpphdl_n1532, Vss) <+ V(cpphdl_n1532, Vss) / 1000000000.0;
        // device 946, IC IC167, analog/basic/cmos_logic.hpp:17
        I(cpphdl_n1537, Vss) <+ 5.0000000000000002e-14 * ddt(V(cpphdl_n1537, Vss)); // Bench initial voltage = 0.0 V.
        // device 947, IC IC167, analog/basic/cmos_logic.hpp:18
        I(cpphdl_n1537, Vdd) <+ cpphdl_channel(V(cpphdl_n1535, Vdd), V(cpphdl_n1537, Vdd), 0.01, 0.69999999999999996, -1.0);
        // device 948, IC IC167, analog/basic/cmos_logic.hpp:19
        I(cpphdl_n1537, Vdd) <+ cpphdl_channel(V(cpphdl_n2880, Vdd), V(cpphdl_n1537, Vdd), 0.01, 0.69999999999999996, -1.0);
        // device 949, IC IC167, analog/basic/cmos_logic.hpp:20
        I(cpphdl_n1537, cpphdl_n1538) <+ cpphdl_channel(V(cpphdl_n1535, cpphdl_n1538), V(cpphdl_n1537, cpphdl_n1538), 0.01, 0.69999999999999996, 1.0);
        // device 950, IC IC167, analog/basic/cmos_logic.hpp:21
        I(cpphdl_n1538, Vss) <+ cpphdl_channel(V(cpphdl_n2880, Vss), V(cpphdl_n1538, Vss), 0.01, 0.69999999999999996, 1.0);
        // device 951, IC IC167, analog/basic/cmos_logic.hpp:23
        I(cpphdl_n1537, Vss) <+ V(cpphdl_n1537, Vss) / 1000000000.0;
        // device 952, IC IC167, analog/basic/cmos_logic.hpp:24
        I(cpphdl_n1538, Vss) <+ V(cpphdl_n1538, Vss) / 1000000000.0;
        // device 953, IC IC165, analog/basic/nand_latch.hpp:36
        I(cpphdl_n1529, Vss) <+ 2.9999999999999998e-15 * ddt(V(cpphdl_n1529, Vss)); // Bench initial voltage = 0.0 V.
        // device 954, IC IC165, analog/basic/nand_latch.hpp:37
        I(cpphdl_n1535, Vss) <+ 2.9999999999999998e-15 * ddt(V(cpphdl_n1535, Vss)); // Bench initial voltage = 0.0 V.
        // device 955, IC IC168, analog/basic/inverter.hpp:11
        I(cpphdl_n1543, Vdd) <+ cpphdl_channel(V(CLEAR, Vdd), V(cpphdl_n1543, Vdd), 0.01, 0.69999999999999996, -1.0);
        // device 956, IC IC168, analog/basic/inverter.hpp:12
        I(cpphdl_n1543, Vss) <+ cpphdl_channel(V(CLEAR, Vss), V(cpphdl_n1543, Vss), 0.01, 0.69999999999999996, 1.0);
        // device 957, IC IC165, analog/basic/nand_latch.hpp:58
        I(cpphdl_n1543, Vss) <+ 2.9999999999999998e-15 * ddt(V(cpphdl_n1543, Vss)); // Bench initial voltage = 0.0 V.
        // device 958, IC IC165, analog/basic/nand_latch.hpp:59
        I(cpphdl_n2880, Vss) <+ cpphdl_channel(V(CLEAR, Vss), V(cpphdl_n2880, Vss), 0.050000000000000003, 0.69999999999999996, 1.0);
        // device 959, IC IC165, analog/basic/nand_latch.hpp:60
        I(cpphdl_n1537, Vdd) <+ cpphdl_channel(V(cpphdl_n1543, Vdd), V(cpphdl_n1537, Vdd), 0.050000000000000003, 0.69999999999999996, -1.0);
        // device 960, IC IC171, analog/basic/inverter.hpp:11
        I(cpphdl_n1567, Vdd) <+ cpphdl_channel(V(TRACK7, Vdd), V(cpphdl_n1567, Vdd), 0.0040000000000000001, 0.69999999999999996, -1.0);
        // device 961, IC IC171, analog/basic/inverter.hpp:12
        I(cpphdl_n1567, Vss) <+ cpphdl_channel(V(TRACK7, Vss), V(cpphdl_n1567, Vss), 0.0040000000000000001, 0.69999999999999996, 1.0);
        // device 962, IC IC170, analog/basic/mos_track_hold.hpp:31
        I(cpphdl_n1567, Vss) <+ 2e-14 * ddt(V(cpphdl_n1567, Vss)); // Bench initial voltage = 3.2999999999999998 V.
        // device 963, IC IC170, analog/basic/mos_track_hold.hpp:32
        I(cpphdl_n2705, cpphdl_n1621) <+ cpphdl_channel(V(TRACK7, cpphdl_n1621), V(cpphdl_n2705, cpphdl_n1621), 0.080000000000000002, 0.69999999999999996, 1.0);
        // device 964, IC IC170, analog/basic/mos_track_hold.hpp:33
        I(cpphdl_n1621, cpphdl_n2705) <+ cpphdl_channel(V(cpphdl_n1567, cpphdl_n2705), V(cpphdl_n1621, cpphdl_n2705), 0.040000000000000001, 0.69999999999999996, -1.0);
        // device 965, IC IC170, analog/basic/mos_track_hold.hpp:37
        I(cpphdl_n1621, cpphdl_n1621) <+ cpphdl_channel(V(cpphdl_n1567, cpphdl_n1621), V(cpphdl_n1621, cpphdl_n1621), 0.040000000000000001, 0.69999999999999996, 1.0);
        // device 966, IC IC170, analog/basic/mos_track_hold.hpp:38
        I(cpphdl_n1621, cpphdl_n1621) <+ cpphdl_channel(V(TRACK7, cpphdl_n1621), V(cpphdl_n1621, cpphdl_n1621), 0.02, 0.69999999999999996, -1.0);
        // device 967, IC IC170, analog/basic/mos_track_hold.hpp:39
        I(cpphdl_n1621, Vss) <+ 2e-12 * ddt(V(cpphdl_n1621, Vss)); // Bench initial voltage = 1.6499999999999999 V.
        // device 968, IC IC170, analog/basic/mos_track_hold.hpp:41
        I(Vss, cpphdl_n1621) <+ V(Vss, cpphdl_n1621) / 1000000000.0;
        // device 969, IC IC170, analog/basic/mos_track_hold.hpp:42
        I(TRACK7, cpphdl_n1621) <+ 8.0000000000000006e-15 * ddt(V(TRACK7, cpphdl_n1621)); // Bench initial voltage = -1.6499999999999999 V.
        // device 970, IC IC170, analog/basic/mos_track_hold.hpp:43
        I(cpphdl_n1567, cpphdl_n1621) <+ 8.0000000000000006e-15 * ddt(V(cpphdl_n1567, cpphdl_n1621)); // Bench initial voltage = 1.6499999999999999 V.
        // device 971, IC IC170, analog/basic/mos_track_hold.hpp:44
        I(cpphdl_n2705, cpphdl_n1621) <+ 4.0000000000000003e-15 * ddt(V(cpphdl_n2705, cpphdl_n1621)); // Bench initial voltage = 0.0 V.
        // device 972, IC IC173, analog/basic/inverter.hpp:11
        I(cpphdl_n1582, Vdd) <+ cpphdl_channel(V(BIT_N7_0, Vdd), V(cpphdl_n1582, Vdd), 0.080000000000000002, 0.69999999999999996, -1.0);
        // device 973, IC IC173, analog/basic/inverter.hpp:12
        I(cpphdl_n1582, Vss) <+ cpphdl_channel(V(BIT_N7_0, Vss), V(cpphdl_n1582, Vss), 0.080000000000000002, 0.69999999999999996, 1.0);
        // device 974, IC IC172, analog/basic/mos_r2r_dac.hpp:27
        I(cpphdl_n1582, Vss) <+ 2.9999999999999998e-15 * ddt(V(cpphdl_n1582, Vss)); // Bench initial voltage = 0.0 V.
        // device 975, IC IC172, analog/basic/mos_r2r_dac.hpp:28
        I(cpphdl_n1582, cpphdl_n1611) <+ V(cpphdl_n1582, cpphdl_n1611) / 2000.0;
        // device 976, IC IC172, analog/basic/mos_r2r_dac.hpp:29
        I(cpphdl_n1611, Vss) <+ 2.9999999999999998e-15 * ddt(V(cpphdl_n1611, Vss)); // Bench initial voltage = 0.0 V.
        // device 977, IC IC174, analog/basic/inverter.hpp:11
        I(cpphdl_n1586, Vdd) <+ cpphdl_channel(V(BIT_N7_1, Vdd), V(cpphdl_n1586, Vdd), 0.080000000000000002, 0.69999999999999996, -1.0);
        // device 978, IC IC174, analog/basic/inverter.hpp:12
        I(cpphdl_n1586, Vss) <+ cpphdl_channel(V(BIT_N7_1, Vss), V(cpphdl_n1586, Vss), 0.080000000000000002, 0.69999999999999996, 1.0);
        // device 979, IC IC172, analog/basic/mos_r2r_dac.hpp:27
        I(cpphdl_n1586, Vss) <+ 2.9999999999999998e-15 * ddt(V(cpphdl_n1586, Vss)); // Bench initial voltage = 0.0 V.
        // device 980, IC IC172, analog/basic/mos_r2r_dac.hpp:28
        I(cpphdl_n1586, cpphdl_n1612) <+ V(cpphdl_n1586, cpphdl_n1612) / 2000.0;
        // device 981, IC IC172, analog/basic/mos_r2r_dac.hpp:29
        I(cpphdl_n1612, Vss) <+ 2.9999999999999998e-15 * ddt(V(cpphdl_n1612, Vss)); // Bench initial voltage = 0.0 V.
        // device 982, IC IC172, analog/basic/mos_r2r_dac.hpp:31
        I(cpphdl_n1611, cpphdl_n1612) <+ V(cpphdl_n1611, cpphdl_n1612) / 1000.0;
        // device 983, IC IC175, analog/basic/inverter.hpp:11
        I(cpphdl_n1590, Vdd) <+ cpphdl_channel(V(BIT_N7_2, Vdd), V(cpphdl_n1590, Vdd), 0.080000000000000002, 0.69999999999999996, -1.0);
        // device 984, IC IC175, analog/basic/inverter.hpp:12
        I(cpphdl_n1590, Vss) <+ cpphdl_channel(V(BIT_N7_2, Vss), V(cpphdl_n1590, Vss), 0.080000000000000002, 0.69999999999999996, 1.0);
        // device 985, IC IC172, analog/basic/mos_r2r_dac.hpp:27
        I(cpphdl_n1590, Vss) <+ 2.9999999999999998e-15 * ddt(V(cpphdl_n1590, Vss)); // Bench initial voltage = 0.0 V.
        // device 986, IC IC172, analog/basic/mos_r2r_dac.hpp:28
        I(cpphdl_n1590, cpphdl_n1613) <+ V(cpphdl_n1590, cpphdl_n1613) / 2000.0;
        // device 987, IC IC172, analog/basic/mos_r2r_dac.hpp:29
        I(cpphdl_n1613, Vss) <+ 2.9999999999999998e-15 * ddt(V(cpphdl_n1613, Vss)); // Bench initial voltage = 0.0 V.
        // device 988, IC IC172, analog/basic/mos_r2r_dac.hpp:31
        I(cpphdl_n1612, cpphdl_n1613) <+ V(cpphdl_n1612, cpphdl_n1613) / 1000.0;
        // device 989, IC IC176, analog/basic/inverter.hpp:11
        I(cpphdl_n1594, Vdd) <+ cpphdl_channel(V(BIT_N7_3, Vdd), V(cpphdl_n1594, Vdd), 0.080000000000000002, 0.69999999999999996, -1.0);
        // device 990, IC IC176, analog/basic/inverter.hpp:12
        I(cpphdl_n1594, Vss) <+ cpphdl_channel(V(BIT_N7_3, Vss), V(cpphdl_n1594, Vss), 0.080000000000000002, 0.69999999999999996, 1.0);
        // device 991, IC IC172, analog/basic/mos_r2r_dac.hpp:27
        I(cpphdl_n1594, Vss) <+ 2.9999999999999998e-15 * ddt(V(cpphdl_n1594, Vss)); // Bench initial voltage = 0.0 V.
        // device 992, IC IC172, analog/basic/mos_r2r_dac.hpp:28
        I(cpphdl_n1594, cpphdl_n1614) <+ V(cpphdl_n1594, cpphdl_n1614) / 2000.0;
        // device 993, IC IC172, analog/basic/mos_r2r_dac.hpp:29
        I(cpphdl_n1614, Vss) <+ 2.9999999999999998e-15 * ddt(V(cpphdl_n1614, Vss)); // Bench initial voltage = 0.0 V.
        // device 994, IC IC172, analog/basic/mos_r2r_dac.hpp:31
        I(cpphdl_n1613, cpphdl_n1614) <+ V(cpphdl_n1613, cpphdl_n1614) / 1000.0;
        // device 995, IC IC177, analog/basic/inverter.hpp:11
        I(cpphdl_n1598, Vdd) <+ cpphdl_channel(V(BIT_N7_4, Vdd), V(cpphdl_n1598, Vdd), 0.080000000000000002, 0.69999999999999996, -1.0);
        // device 996, IC IC177, analog/basic/inverter.hpp:12
        I(cpphdl_n1598, Vss) <+ cpphdl_channel(V(BIT_N7_4, Vss), V(cpphdl_n1598, Vss), 0.080000000000000002, 0.69999999999999996, 1.0);
        // device 997, IC IC172, analog/basic/mos_r2r_dac.hpp:27
        I(cpphdl_n1598, Vss) <+ 2.9999999999999998e-15 * ddt(V(cpphdl_n1598, Vss)); // Bench initial voltage = 0.0 V.
        // device 998, IC IC172, analog/basic/mos_r2r_dac.hpp:28
        I(cpphdl_n1598, cpphdl_n1615) <+ V(cpphdl_n1598, cpphdl_n1615) / 2000.0;
        // device 999, IC IC172, analog/basic/mos_r2r_dac.hpp:29
        I(cpphdl_n1615, Vss) <+ 2.9999999999999998e-15 * ddt(V(cpphdl_n1615, Vss)); // Bench initial voltage = 0.0 V.
        // device 1000, IC IC172, analog/basic/mos_r2r_dac.hpp:31
        I(cpphdl_n1614, cpphdl_n1615) <+ V(cpphdl_n1614, cpphdl_n1615) / 1000.0;
        // device 1001, IC IC178, analog/basic/inverter.hpp:11
        I(cpphdl_n1602, Vdd) <+ cpphdl_channel(V(BIT_N7_5, Vdd), V(cpphdl_n1602, Vdd), 0.080000000000000002, 0.69999999999999996, -1.0);
        // device 1002, IC IC178, analog/basic/inverter.hpp:12
        I(cpphdl_n1602, Vss) <+ cpphdl_channel(V(BIT_N7_5, Vss), V(cpphdl_n1602, Vss), 0.080000000000000002, 0.69999999999999996, 1.0);
        // device 1003, IC IC172, analog/basic/mos_r2r_dac.hpp:27
        I(cpphdl_n1602, Vss) <+ 2.9999999999999998e-15 * ddt(V(cpphdl_n1602, Vss)); // Bench initial voltage = 0.0 V.
        // device 1004, IC IC172, analog/basic/mos_r2r_dac.hpp:28
        I(cpphdl_n1602, cpphdl_n1616) <+ V(cpphdl_n1602, cpphdl_n1616) / 2000.0;
        // device 1005, IC IC172, analog/basic/mos_r2r_dac.hpp:29
        I(cpphdl_n1616, Vss) <+ 2.9999999999999998e-15 * ddt(V(cpphdl_n1616, Vss)); // Bench initial voltage = 0.0 V.
        // device 1006, IC IC172, analog/basic/mos_r2r_dac.hpp:31
        I(cpphdl_n1615, cpphdl_n1616) <+ V(cpphdl_n1615, cpphdl_n1616) / 1000.0;
        // device 1007, IC IC179, analog/basic/inverter.hpp:11
        I(cpphdl_n1606, Vdd) <+ cpphdl_channel(V(BIT_N7_6, Vdd), V(cpphdl_n1606, Vdd), 0.080000000000000002, 0.69999999999999996, -1.0);
        // device 1008, IC IC179, analog/basic/inverter.hpp:12
        I(cpphdl_n1606, Vss) <+ cpphdl_channel(V(BIT_N7_6, Vss), V(cpphdl_n1606, Vss), 0.080000000000000002, 0.69999999999999996, 1.0);
        // device 1009, IC IC172, analog/basic/mos_r2r_dac.hpp:27
        I(cpphdl_n1606, Vss) <+ 2.9999999999999998e-15 * ddt(V(cpphdl_n1606, Vss)); // Bench initial voltage = 0.0 V.
        // device 1010, IC IC172, analog/basic/mos_r2r_dac.hpp:28
        I(cpphdl_n1606, cpphdl_n1617) <+ V(cpphdl_n1606, cpphdl_n1617) / 2000.0;
        // device 1011, IC IC172, analog/basic/mos_r2r_dac.hpp:29
        I(cpphdl_n1617, Vss) <+ 2.9999999999999998e-15 * ddt(V(cpphdl_n1617, Vss)); // Bench initial voltage = 0.0 V.
        // device 1012, IC IC172, analog/basic/mos_r2r_dac.hpp:31
        I(cpphdl_n1616, cpphdl_n1617) <+ V(cpphdl_n1616, cpphdl_n1617) / 1000.0;
        // device 1013, IC IC180, analog/basic/inverter.hpp:11
        I(cpphdl_n1610, Vdd) <+ cpphdl_channel(V(BIT_N7_7, Vdd), V(cpphdl_n1610, Vdd), 0.080000000000000002, 0.69999999999999996, -1.0);
        // device 1014, IC IC180, analog/basic/inverter.hpp:12
        I(cpphdl_n1610, Vss) <+ cpphdl_channel(V(BIT_N7_7, Vss), V(cpphdl_n1610, Vss), 0.080000000000000002, 0.69999999999999996, 1.0);
        // device 1015, IC IC172, analog/basic/mos_r2r_dac.hpp:27
        I(cpphdl_n1610, Vss) <+ 2.9999999999999998e-15 * ddt(V(cpphdl_n1610, Vss)); // Bench initial voltage = 0.0 V.
        // device 1016, IC IC172, analog/basic/mos_r2r_dac.hpp:28
        I(cpphdl_n1610, cpphdl_n1622) <+ V(cpphdl_n1610, cpphdl_n1622) / 2000.0;
        // device 1017, IC IC172, analog/basic/mos_r2r_dac.hpp:29
        I(cpphdl_n1622, Vss) <+ 2.9999999999999998e-15 * ddt(V(cpphdl_n1622, Vss)); // Bench initial voltage = 0.0 V.
        // device 1018, IC IC172, analog/basic/mos_r2r_dac.hpp:31
        I(cpphdl_n1617, cpphdl_n1622) <+ V(cpphdl_n1617, cpphdl_n1622) / 1000.0;
        // device 1019, IC IC172, analog/basic/mos_r2r_dac.hpp:33
        I(Vss, cpphdl_n1611) <+ V(Vss, cpphdl_n1611) / 2000.0;
        // device 1020, IC IC181, analog/basic/nmos_resistor_amplifier.hpp:23
        I(Vdd, cpphdl_n1631) <+ V(Vdd, cpphdl_n1631) / 1000.0;
        // device 1021, IC IC181, analog/basic/nmos_resistor_amplifier.hpp:24
        I(Vdd, cpphdl_n1630) <+ V(Vdd, cpphdl_n1630) / 1000.0;
        // device 1022, IC IC181, analog/basic/nmos_resistor_amplifier.hpp:25
        I(cpphdl_n1631, cpphdl_n1625) <+ cpphdl_channel(V(cpphdl_n1621, cpphdl_n1625), V(cpphdl_n1631, cpphdl_n1625), 0.014999999999999999, 0.69999999999999996, 1.0);
        // device 1023, IC IC181, analog/basic/nmos_resistor_amplifier.hpp:26
        I(cpphdl_n1630, cpphdl_n1626) <+ cpphdl_channel(V(cpphdl_n1622, cpphdl_n1626), V(cpphdl_n1630, cpphdl_n1626), 0.014999999999999999, 0.69999999999999996, 1.0);
        // device 1024, IC IC181, analog/basic/nmos_resistor_amplifier.hpp:27
        I(cpphdl_n1627, cpphdl_n1625) <+ V(cpphdl_n1627, cpphdl_n1625) / 50.0;
        // device 1025, IC IC181, analog/basic/nmos_resistor_amplifier.hpp:28
        I(cpphdl_n1627, cpphdl_n1626) <+ V(cpphdl_n1627, cpphdl_n1626) / 50.0;
        // device 1026, IC IC181, analog/basic/nmos_resistor_amplifier.hpp:29
        I(Vss, cpphdl_n1627) <+ V(Vss, cpphdl_n1627) / 150.0;
        // device 1027, IC IC181, analog/basic/nmos_resistor_amplifier.hpp:30
        I(cpphdl_n1631, Vdd) <+ 2.9999999999999998e-13 * ddt(V(cpphdl_n1631, Vdd)); // Bench initial voltage = 0.0 V.
        // device 1028, IC IC181, analog/basic/nmos_resistor_amplifier.hpp:31
        I(cpphdl_n1630, Vdd) <+ 2.9999999999999998e-13 * ddt(V(cpphdl_n1630, Vdd)); // Bench initial voltage = 0.0 V.
        // device 1029, IC IC181, analog/basic/nmos_resistor_amplifier.hpp:32
        I(cpphdl_n1627, Vss) <+ 4e-14 * ddt(V(cpphdl_n1627, Vss)); // Bench initial voltage = 0.0 V.
        // device 1030, IC IC181, analog/basic/nmos_resistor_amplifier.hpp:34
        I(cpphdl_n1621, cpphdl_n1625) <+ 2e-14 * ddt(V(cpphdl_n1621, cpphdl_n1625)); // Bench initial voltage = 1.6499999999999999 V.
        // device 1031, IC IC181, analog/basic/nmos_resistor_amplifier.hpp:35
        I(cpphdl_n1622, cpphdl_n1626) <+ 2e-14 * ddt(V(cpphdl_n1622, cpphdl_n1626)); // Bench initial voltage = 0.0 V.
        // device 1032, IC IC181, analog/basic/nmos_resistor_amplifier.hpp:36
        I(cpphdl_n1621, cpphdl_n1631) <+ 2.9999999999999998e-15 * ddt(V(cpphdl_n1621, cpphdl_n1631)); // Bench initial voltage = -1.6499999999999999 V.
        // device 1033, IC IC181, analog/basic/nmos_resistor_amplifier.hpp:37
        I(cpphdl_n1622, cpphdl_n1630) <+ 2.9999999999999998e-15 * ddt(V(cpphdl_n1622, cpphdl_n1630)); // Bench initial voltage = -3.2999999999999998 V.
        // device 1034, IC IC182, analog/basic/strongarm_comparator.hpp:28
        I(cpphdl_n1635, cpphdl_n1637) <+ cpphdl_channel(V(cpphdl_n1630, cpphdl_n1637), V(cpphdl_n1635, cpphdl_n1637), 0.0080000000000000002, 0.69999999999999996, 1.0);
        // device 1035, IC IC182, analog/basic/strongarm_comparator.hpp:29
        I(cpphdl_n1636, cpphdl_n1637) <+ cpphdl_channel(V(cpphdl_n1631, cpphdl_n1637), V(cpphdl_n1636, cpphdl_n1637), 0.0080000000000000002, 0.69999999999999996, 1.0);
        // device 1036, IC IC182, analog/basic/strongarm_comparator.hpp:30
        I(cpphdl_n1637, Vss) <+ cpphdl_channel(V(EVALUATE, Vss), V(cpphdl_n1637, Vss), 0.0080000000000000002, 0.69999999999999996, 1.0);
        // device 1037, IC IC182, analog/basic/strongarm_comparator.hpp:33
        I(cpphdl_n1650, cpphdl_n1635) <+ cpphdl_channel(V(cpphdl_n1654, cpphdl_n1635), V(cpphdl_n1650, cpphdl_n1635), 0.0040000000000000001, 0.69999999999999996, 1.0);
        // device 1038, IC IC182, analog/basic/strongarm_comparator.hpp:34
        I(cpphdl_n1654, cpphdl_n1636) <+ cpphdl_channel(V(cpphdl_n1650, cpphdl_n1636), V(cpphdl_n1654, cpphdl_n1636), 0.0040000000000000001, 0.69999999999999996, 1.0);
        // device 1039, IC IC182, analog/basic/strongarm_comparator.hpp:35
        I(cpphdl_n1654, Vdd) <+ cpphdl_channel(V(cpphdl_n1650, Vdd), V(cpphdl_n1654, Vdd), 0.002, 0.69999999999999996, -1.0);
        // device 1040, IC IC182, analog/basic/strongarm_comparator.hpp:36
        I(cpphdl_n1650, Vdd) <+ cpphdl_channel(V(cpphdl_n1654, Vdd), V(cpphdl_n1650, Vdd), 0.002, 0.69999999999999996, -1.0);
        // device 1041, IC IC182, analog/basic/strongarm_comparator.hpp:38
        I(cpphdl_n1635, Vdd) <+ cpphdl_channel(V(EVALUATE, Vdd), V(cpphdl_n1635, Vdd), 0.002, 0.69999999999999996, -1.0);
        // device 1042, IC IC182, analog/basic/strongarm_comparator.hpp:39
        I(cpphdl_n1636, Vdd) <+ cpphdl_channel(V(EVALUATE, Vdd), V(cpphdl_n1636, Vdd), 0.002, 0.69999999999999996, -1.0);
        // device 1043, IC IC182, analog/basic/strongarm_comparator.hpp:40
        I(cpphdl_n1654, Vdd) <+ cpphdl_channel(V(EVALUATE, Vdd), V(cpphdl_n1654, Vdd), 0.002, 0.69999999999999996, -1.0);
        // device 1044, IC IC182, analog/basic/strongarm_comparator.hpp:41
        I(cpphdl_n1650, Vdd) <+ cpphdl_channel(V(EVALUATE, Vdd), V(cpphdl_n1650, Vdd), 0.002, 0.69999999999999996, -1.0);
        // device 1045, IC IC182, analog/basic/strongarm_comparator.hpp:42
        I(cpphdl_n1635, Vss) <+ 2.9999999999999998e-14 * ddt(V(cpphdl_n1635, Vss)); // Bench initial voltage = 0.0 V.
        // device 1046, IC IC182, analog/basic/strongarm_comparator.hpp:43
        I(cpphdl_n1636, Vss) <+ 2.9999999999999998e-14 * ddt(V(cpphdl_n1636, Vss)); // Bench initial voltage = 0.0 V.
        // device 1047, IC IC182, analog/basic/strongarm_comparator.hpp:44
        I(cpphdl_n1637, Vss) <+ 2.9999999999999998e-14 * ddt(V(cpphdl_n1637, Vss)); // Bench initial voltage = 0.0 V.
        // device 1048, IC IC182, analog/basic/strongarm_comparator.hpp:45
        I(cpphdl_n1654, Vss) <+ 5.0000000000000002e-14 * ddt(V(cpphdl_n1654, Vss)); // Bench initial voltage = 0.0 V.
        // device 1049, IC IC182, analog/basic/strongarm_comparator.hpp:46
        I(cpphdl_n1650, Vss) <+ 5.0000000000000002e-14 * ddt(V(cpphdl_n1650, Vss)); // Bench initial voltage = 0.0 V.
        // device 1050, IC IC182, analog/basic/strongarm_comparator.hpp:47
        I(cpphdl_n1630, cpphdl_n1637) <+ 2e-14 * ddt(V(cpphdl_n1630, cpphdl_n1637)); // Bench initial voltage = 3.2999999999999998 V.
        // device 1051, IC IC182, analog/basic/strongarm_comparator.hpp:48
        I(cpphdl_n1631, cpphdl_n1637) <+ 2e-14 * ddt(V(cpphdl_n1631, cpphdl_n1637)); // Bench initial voltage = 3.2999999999999998 V.
        // device 1052, IC IC182, analog/basic/strongarm_comparator.hpp:49
        I(cpphdl_n1630, cpphdl_n1635) <+ 2.9999999999999998e-15 * ddt(V(cpphdl_n1630, cpphdl_n1635)); // Bench initial voltage = 3.2999999999999998 V.
        // device 1053, IC IC182, analog/basic/strongarm_comparator.hpp:50
        I(cpphdl_n1631, cpphdl_n1636) <+ 2.9999999999999998e-15 * ddt(V(cpphdl_n1631, cpphdl_n1636)); // Bench initial voltage = 3.2999999999999998 V.
        // device 1054, IC IC184, analog/basic/inverter.hpp:11
        I(cpphdl_n1658, Vdd) <+ cpphdl_channel(V(cpphdl_n1650, Vdd), V(cpphdl_n1658, Vdd), 0.001, 0.69999999999999996, -1.0);
        // device 1055, IC IC184, analog/basic/inverter.hpp:12
        I(cpphdl_n1658, Vss) <+ cpphdl_channel(V(cpphdl_n1650, Vss), V(cpphdl_n1658, Vss), 0.001, 0.69999999999999996, 1.0);
        // device 1056, IC IC186, analog/basic/inverter.hpp:11
        I(cpphdl_n1672, Vdd) <+ cpphdl_channel(V(cpphdl_n1658, Vdd), V(cpphdl_n1672, Vdd), 0.0040000000000000001, 0.69999999999999996, -1.0);
        // device 1057, IC IC186, analog/basic/inverter.hpp:12
        I(cpphdl_n1672, Vss) <+ cpphdl_channel(V(cpphdl_n1658, Vss), V(cpphdl_n1672, Vss), 0.0040000000000000001, 0.69999999999999996, 1.0);
        // device 1058, IC IC183, analog/basic/buffered_nand_latch.hpp:34
        I(cpphdl_n1650, Vss) <+ 2.0000000000000002e-15 * ddt(V(cpphdl_n1650, Vss)); // Bench initial voltage = 0.0 V.
        // device 1059, IC IC183, analog/basic/buffered_nand_latch.hpp:35
        I(cpphdl_n1650, cpphdl_n1658) <+ 1.0000000000000001e-15 * ddt(V(cpphdl_n1650, cpphdl_n1658)); // Bench initial voltage = 0.0 V.
        // device 1060, IC IC183, analog/basic/buffered_nand_latch.hpp:36
        I(cpphdl_n1658, Vss) <+ 5e-15 * ddt(V(cpphdl_n1658, Vss)); // Bench initial voltage = 0.0 V.
        // device 1061, IC IC183, analog/basic/buffered_nand_latch.hpp:37
        I(cpphdl_n1658, Vss) <+ 8.0000000000000006e-15 * ddt(V(cpphdl_n1658, Vss)); // Bench initial voltage = 0.0 V.
        // device 1062, IC IC183, analog/basic/buffered_nand_latch.hpp:38
        I(cpphdl_n1672, Vss) <+ 1e-14 * ddt(V(cpphdl_n1672, Vss)); // Bench initial voltage = 0.0 V.
        // device 1063, IC IC185, analog/basic/inverter.hpp:11
        I(cpphdl_n1662, Vdd) <+ cpphdl_channel(V(cpphdl_n1654, Vdd), V(cpphdl_n1662, Vdd), 0.001, 0.69999999999999996, -1.0);
        // device 1064, IC IC185, analog/basic/inverter.hpp:12
        I(cpphdl_n1662, Vss) <+ cpphdl_channel(V(cpphdl_n1654, Vss), V(cpphdl_n1662, Vss), 0.001, 0.69999999999999996, 1.0);
        // device 1065, IC IC187, analog/basic/inverter.hpp:11
        I(cpphdl_n1678, Vdd) <+ cpphdl_channel(V(cpphdl_n1662, Vdd), V(cpphdl_n1678, Vdd), 0.0040000000000000001, 0.69999999999999996, -1.0);
        // device 1066, IC IC187, analog/basic/inverter.hpp:12
        I(cpphdl_n1678, Vss) <+ cpphdl_channel(V(cpphdl_n1662, Vss), V(cpphdl_n1678, Vss), 0.0040000000000000001, 0.69999999999999996, 1.0);
        // device 1067, IC IC183, analog/basic/buffered_nand_latch.hpp:34
        I(cpphdl_n1654, Vss) <+ 2.0000000000000002e-15 * ddt(V(cpphdl_n1654, Vss)); // Bench initial voltage = 0.0 V.
        // device 1068, IC IC183, analog/basic/buffered_nand_latch.hpp:35
        I(cpphdl_n1654, cpphdl_n1662) <+ 1.0000000000000001e-15 * ddt(V(cpphdl_n1654, cpphdl_n1662)); // Bench initial voltage = 0.0 V.
        // device 1069, IC IC183, analog/basic/buffered_nand_latch.hpp:36
        I(cpphdl_n1662, Vss) <+ 5e-15 * ddt(V(cpphdl_n1662, Vss)); // Bench initial voltage = 0.0 V.
        // device 1070, IC IC183, analog/basic/buffered_nand_latch.hpp:37
        I(cpphdl_n1662, Vss) <+ 8.0000000000000006e-15 * ddt(V(cpphdl_n1662, Vss)); // Bench initial voltage = 0.0 V.
        // device 1071, IC IC183, analog/basic/buffered_nand_latch.hpp:38
        I(cpphdl_n1678, Vss) <+ 1e-14 * ddt(V(cpphdl_n1678, Vss)); // Bench initial voltage = 0.0 V.
        // device 1072, IC IC189, analog/basic/cmos_logic.hpp:17
        I(cpphdl_n2885, Vss) <+ 5.0000000000000002e-14 * ddt(V(cpphdl_n2885, Vss)); // Bench initial voltage = 0.0 V.
        // device 1073, IC IC189, analog/basic/cmos_logic.hpp:18
        I(cpphdl_n2885, Vdd) <+ cpphdl_channel(V(cpphdl_n1672, Vdd), V(cpphdl_n2885, Vdd), 0.01, 0.69999999999999996, -1.0);
        // device 1074, IC IC189, analog/basic/cmos_logic.hpp:19
        I(cpphdl_n2885, Vdd) <+ cpphdl_channel(V(cpphdl_n1680, Vdd), V(cpphdl_n2885, Vdd), 0.01, 0.69999999999999996, -1.0);
        // device 1075, IC IC189, analog/basic/cmos_logic.hpp:20
        I(cpphdl_n2885, cpphdl_n1675) <+ cpphdl_channel(V(cpphdl_n1672, cpphdl_n1675), V(cpphdl_n2885, cpphdl_n1675), 0.01, 0.69999999999999996, 1.0);
        // device 1076, IC IC189, analog/basic/cmos_logic.hpp:21
        I(cpphdl_n1675, Vss) <+ cpphdl_channel(V(cpphdl_n1680, Vss), V(cpphdl_n1675, Vss), 0.01, 0.69999999999999996, 1.0);
        // device 1077, IC IC189, analog/basic/cmos_logic.hpp:23
        I(cpphdl_n2885, Vss) <+ V(cpphdl_n2885, Vss) / 1000000000.0;
        // device 1078, IC IC189, analog/basic/cmos_logic.hpp:24
        I(cpphdl_n1675, Vss) <+ V(cpphdl_n1675, Vss) / 1000000000.0;
        // device 1079, IC IC190, analog/basic/cmos_logic.hpp:17
        I(cpphdl_n1680, Vss) <+ 5.0000000000000002e-14 * ddt(V(cpphdl_n1680, Vss)); // Bench initial voltage = 0.0 V.
        // device 1080, IC IC190, analog/basic/cmos_logic.hpp:18
        I(cpphdl_n1680, Vdd) <+ cpphdl_channel(V(cpphdl_n1678, Vdd), V(cpphdl_n1680, Vdd), 0.01, 0.69999999999999996, -1.0);
        // device 1081, IC IC190, analog/basic/cmos_logic.hpp:19
        I(cpphdl_n1680, Vdd) <+ cpphdl_channel(V(cpphdl_n2885, Vdd), V(cpphdl_n1680, Vdd), 0.01, 0.69999999999999996, -1.0);
        // device 1082, IC IC190, analog/basic/cmos_logic.hpp:20
        I(cpphdl_n1680, cpphdl_n1681) <+ cpphdl_channel(V(cpphdl_n1678, cpphdl_n1681), V(cpphdl_n1680, cpphdl_n1681), 0.01, 0.69999999999999996, 1.0);
        // device 1083, IC IC190, analog/basic/cmos_logic.hpp:21
        I(cpphdl_n1681, Vss) <+ cpphdl_channel(V(cpphdl_n2885, Vss), V(cpphdl_n1681, Vss), 0.01, 0.69999999999999996, 1.0);
        // device 1084, IC IC190, analog/basic/cmos_logic.hpp:23
        I(cpphdl_n1680, Vss) <+ V(cpphdl_n1680, Vss) / 1000000000.0;
        // device 1085, IC IC190, analog/basic/cmos_logic.hpp:24
        I(cpphdl_n1681, Vss) <+ V(cpphdl_n1681, Vss) / 1000000000.0;
        // device 1086, IC IC188, analog/basic/nand_latch.hpp:36
        I(cpphdl_n1672, Vss) <+ 2.9999999999999998e-15 * ddt(V(cpphdl_n1672, Vss)); // Bench initial voltage = 0.0 V.
        // device 1087, IC IC188, analog/basic/nand_latch.hpp:37
        I(cpphdl_n1678, Vss) <+ 2.9999999999999998e-15 * ddt(V(cpphdl_n1678, Vss)); // Bench initial voltage = 0.0 V.
        // device 1088, IC IC191, analog/basic/inverter.hpp:11
        I(cpphdl_n1686, Vdd) <+ cpphdl_channel(V(CLEAR, Vdd), V(cpphdl_n1686, Vdd), 0.01, 0.69999999999999996, -1.0);
        // device 1089, IC IC191, analog/basic/inverter.hpp:12
        I(cpphdl_n1686, Vss) <+ cpphdl_channel(V(CLEAR, Vss), V(cpphdl_n1686, Vss), 0.01, 0.69999999999999996, 1.0);
        // device 1090, IC IC188, analog/basic/nand_latch.hpp:58
        I(cpphdl_n1686, Vss) <+ 2.9999999999999998e-15 * ddt(V(cpphdl_n1686, Vss)); // Bench initial voltage = 0.0 V.
        // device 1091, IC IC188, analog/basic/nand_latch.hpp:59
        I(cpphdl_n2885, Vss) <+ cpphdl_channel(V(CLEAR, Vss), V(cpphdl_n2885, Vss), 0.050000000000000003, 0.69999999999999996, 1.0);
        // device 1092, IC IC188, analog/basic/nand_latch.hpp:60
        I(cpphdl_n1680, Vdd) <+ cpphdl_channel(V(cpphdl_n1686, Vdd), V(cpphdl_n1680, Vdd), 0.050000000000000003, 0.69999999999999996, -1.0);
        // device 1093, IC IC194, analog/basic/inverter.hpp:11
        I(cpphdl_n1710, Vdd) <+ cpphdl_channel(V(TRACK8, Vdd), V(cpphdl_n1710, Vdd), 0.0040000000000000001, 0.69999999999999996, -1.0);
        // device 1094, IC IC194, analog/basic/inverter.hpp:12
        I(cpphdl_n1710, Vss) <+ cpphdl_channel(V(TRACK8, Vss), V(cpphdl_n1710, Vss), 0.0040000000000000001, 0.69999999999999996, 1.0);
        // device 1095, IC IC193, analog/basic/mos_track_hold.hpp:31
        I(cpphdl_n1710, Vss) <+ 2e-14 * ddt(V(cpphdl_n1710, Vss)); // Bench initial voltage = 3.2999999999999998 V.
        // device 1096, IC IC193, analog/basic/mos_track_hold.hpp:32
        I(cpphdl_n2705, cpphdl_n1764) <+ cpphdl_channel(V(TRACK8, cpphdl_n1764), V(cpphdl_n2705, cpphdl_n1764), 0.080000000000000002, 0.69999999999999996, 1.0);
        // device 1097, IC IC193, analog/basic/mos_track_hold.hpp:33
        I(cpphdl_n1764, cpphdl_n2705) <+ cpphdl_channel(V(cpphdl_n1710, cpphdl_n2705), V(cpphdl_n1764, cpphdl_n2705), 0.040000000000000001, 0.69999999999999996, -1.0);
        // device 1098, IC IC193, analog/basic/mos_track_hold.hpp:37
        I(cpphdl_n1764, cpphdl_n1764) <+ cpphdl_channel(V(cpphdl_n1710, cpphdl_n1764), V(cpphdl_n1764, cpphdl_n1764), 0.040000000000000001, 0.69999999999999996, 1.0);
        // device 1099, IC IC193, analog/basic/mos_track_hold.hpp:38
        I(cpphdl_n1764, cpphdl_n1764) <+ cpphdl_channel(V(TRACK8, cpphdl_n1764), V(cpphdl_n1764, cpphdl_n1764), 0.02, 0.69999999999999996, -1.0);
        // device 1100, IC IC193, analog/basic/mos_track_hold.hpp:39
        I(cpphdl_n1764, Vss) <+ 2e-12 * ddt(V(cpphdl_n1764, Vss)); // Bench initial voltage = 1.6499999999999999 V.
        // device 1101, IC IC193, analog/basic/mos_track_hold.hpp:41
        I(Vss, cpphdl_n1764) <+ V(Vss, cpphdl_n1764) / 1000000000.0;
        // device 1102, IC IC193, analog/basic/mos_track_hold.hpp:42
        I(TRACK8, cpphdl_n1764) <+ 8.0000000000000006e-15 * ddt(V(TRACK8, cpphdl_n1764)); // Bench initial voltage = -1.6499999999999999 V.
        // device 1103, IC IC193, analog/basic/mos_track_hold.hpp:43
        I(cpphdl_n1710, cpphdl_n1764) <+ 8.0000000000000006e-15 * ddt(V(cpphdl_n1710, cpphdl_n1764)); // Bench initial voltage = 1.6499999999999999 V.
        // device 1104, IC IC193, analog/basic/mos_track_hold.hpp:44
        I(cpphdl_n2705, cpphdl_n1764) <+ 4.0000000000000003e-15 * ddt(V(cpphdl_n2705, cpphdl_n1764)); // Bench initial voltage = 0.0 V.
        // device 1105, IC IC196, analog/basic/inverter.hpp:11
        I(cpphdl_n1725, Vdd) <+ cpphdl_channel(V(BIT_N8_0, Vdd), V(cpphdl_n1725, Vdd), 0.080000000000000002, 0.69999999999999996, -1.0);
        // device 1106, IC IC196, analog/basic/inverter.hpp:12
        I(cpphdl_n1725, Vss) <+ cpphdl_channel(V(BIT_N8_0, Vss), V(cpphdl_n1725, Vss), 0.080000000000000002, 0.69999999999999996, 1.0);
        // device 1107, IC IC195, analog/basic/mos_r2r_dac.hpp:27
        I(cpphdl_n1725, Vss) <+ 2.9999999999999998e-15 * ddt(V(cpphdl_n1725, Vss)); // Bench initial voltage = 0.0 V.
        // device 1108, IC IC195, analog/basic/mos_r2r_dac.hpp:28
        I(cpphdl_n1725, cpphdl_n1754) <+ V(cpphdl_n1725, cpphdl_n1754) / 2000.0;
        // device 1109, IC IC195, analog/basic/mos_r2r_dac.hpp:29
        I(cpphdl_n1754, Vss) <+ 2.9999999999999998e-15 * ddt(V(cpphdl_n1754, Vss)); // Bench initial voltage = 0.0 V.
        // device 1110, IC IC197, analog/basic/inverter.hpp:11
        I(cpphdl_n1729, Vdd) <+ cpphdl_channel(V(BIT_N8_1, Vdd), V(cpphdl_n1729, Vdd), 0.080000000000000002, 0.69999999999999996, -1.0);
        // device 1111, IC IC197, analog/basic/inverter.hpp:12
        I(cpphdl_n1729, Vss) <+ cpphdl_channel(V(BIT_N8_1, Vss), V(cpphdl_n1729, Vss), 0.080000000000000002, 0.69999999999999996, 1.0);
        // device 1112, IC IC195, analog/basic/mos_r2r_dac.hpp:27
        I(cpphdl_n1729, Vss) <+ 2.9999999999999998e-15 * ddt(V(cpphdl_n1729, Vss)); // Bench initial voltage = 0.0 V.
        // device 1113, IC IC195, analog/basic/mos_r2r_dac.hpp:28
        I(cpphdl_n1729, cpphdl_n1755) <+ V(cpphdl_n1729, cpphdl_n1755) / 2000.0;
        // device 1114, IC IC195, analog/basic/mos_r2r_dac.hpp:29
        I(cpphdl_n1755, Vss) <+ 2.9999999999999998e-15 * ddt(V(cpphdl_n1755, Vss)); // Bench initial voltage = 0.0 V.
        // device 1115, IC IC195, analog/basic/mos_r2r_dac.hpp:31
        I(cpphdl_n1754, cpphdl_n1755) <+ V(cpphdl_n1754, cpphdl_n1755) / 1000.0;
        // device 1116, IC IC198, analog/basic/inverter.hpp:11
        I(cpphdl_n1733, Vdd) <+ cpphdl_channel(V(BIT_N8_2, Vdd), V(cpphdl_n1733, Vdd), 0.080000000000000002, 0.69999999999999996, -1.0);
        // device 1117, IC IC198, analog/basic/inverter.hpp:12
        I(cpphdl_n1733, Vss) <+ cpphdl_channel(V(BIT_N8_2, Vss), V(cpphdl_n1733, Vss), 0.080000000000000002, 0.69999999999999996, 1.0);
        // device 1118, IC IC195, analog/basic/mos_r2r_dac.hpp:27
        I(cpphdl_n1733, Vss) <+ 2.9999999999999998e-15 * ddt(V(cpphdl_n1733, Vss)); // Bench initial voltage = 0.0 V.
        // device 1119, IC IC195, analog/basic/mos_r2r_dac.hpp:28
        I(cpphdl_n1733, cpphdl_n1756) <+ V(cpphdl_n1733, cpphdl_n1756) / 2000.0;
        // device 1120, IC IC195, analog/basic/mos_r2r_dac.hpp:29
        I(cpphdl_n1756, Vss) <+ 2.9999999999999998e-15 * ddt(V(cpphdl_n1756, Vss)); // Bench initial voltage = 0.0 V.
        // device 1121, IC IC195, analog/basic/mos_r2r_dac.hpp:31
        I(cpphdl_n1755, cpphdl_n1756) <+ V(cpphdl_n1755, cpphdl_n1756) / 1000.0;
        // device 1122, IC IC199, analog/basic/inverter.hpp:11
        I(cpphdl_n1737, Vdd) <+ cpphdl_channel(V(BIT_N8_3, Vdd), V(cpphdl_n1737, Vdd), 0.080000000000000002, 0.69999999999999996, -1.0);
        // device 1123, IC IC199, analog/basic/inverter.hpp:12
        I(cpphdl_n1737, Vss) <+ cpphdl_channel(V(BIT_N8_3, Vss), V(cpphdl_n1737, Vss), 0.080000000000000002, 0.69999999999999996, 1.0);
        // device 1124, IC IC195, analog/basic/mos_r2r_dac.hpp:27
        I(cpphdl_n1737, Vss) <+ 2.9999999999999998e-15 * ddt(V(cpphdl_n1737, Vss)); // Bench initial voltage = 0.0 V.
        // device 1125, IC IC195, analog/basic/mos_r2r_dac.hpp:28
        I(cpphdl_n1737, cpphdl_n1757) <+ V(cpphdl_n1737, cpphdl_n1757) / 2000.0;
        // device 1126, IC IC195, analog/basic/mos_r2r_dac.hpp:29
        I(cpphdl_n1757, Vss) <+ 2.9999999999999998e-15 * ddt(V(cpphdl_n1757, Vss)); // Bench initial voltage = 0.0 V.
        // device 1127, IC IC195, analog/basic/mos_r2r_dac.hpp:31
        I(cpphdl_n1756, cpphdl_n1757) <+ V(cpphdl_n1756, cpphdl_n1757) / 1000.0;
        // device 1128, IC IC200, analog/basic/inverter.hpp:11
        I(cpphdl_n1741, Vdd) <+ cpphdl_channel(V(BIT_N8_4, Vdd), V(cpphdl_n1741, Vdd), 0.080000000000000002, 0.69999999999999996, -1.0);
        // device 1129, IC IC200, analog/basic/inverter.hpp:12
        I(cpphdl_n1741, Vss) <+ cpphdl_channel(V(BIT_N8_4, Vss), V(cpphdl_n1741, Vss), 0.080000000000000002, 0.69999999999999996, 1.0);
        // device 1130, IC IC195, analog/basic/mos_r2r_dac.hpp:27
        I(cpphdl_n1741, Vss) <+ 2.9999999999999998e-15 * ddt(V(cpphdl_n1741, Vss)); // Bench initial voltage = 0.0 V.
        // device 1131, IC IC195, analog/basic/mos_r2r_dac.hpp:28
        I(cpphdl_n1741, cpphdl_n1758) <+ V(cpphdl_n1741, cpphdl_n1758) / 2000.0;
        // device 1132, IC IC195, analog/basic/mos_r2r_dac.hpp:29
        I(cpphdl_n1758, Vss) <+ 2.9999999999999998e-15 * ddt(V(cpphdl_n1758, Vss)); // Bench initial voltage = 0.0 V.
        // device 1133, IC IC195, analog/basic/mos_r2r_dac.hpp:31
        I(cpphdl_n1757, cpphdl_n1758) <+ V(cpphdl_n1757, cpphdl_n1758) / 1000.0;
        // device 1134, IC IC201, analog/basic/inverter.hpp:11
        I(cpphdl_n1745, Vdd) <+ cpphdl_channel(V(BIT_N8_5, Vdd), V(cpphdl_n1745, Vdd), 0.080000000000000002, 0.69999999999999996, -1.0);
        // device 1135, IC IC201, analog/basic/inverter.hpp:12
        I(cpphdl_n1745, Vss) <+ cpphdl_channel(V(BIT_N8_5, Vss), V(cpphdl_n1745, Vss), 0.080000000000000002, 0.69999999999999996, 1.0);
        // device 1136, IC IC195, analog/basic/mos_r2r_dac.hpp:27
        I(cpphdl_n1745, Vss) <+ 2.9999999999999998e-15 * ddt(V(cpphdl_n1745, Vss)); // Bench initial voltage = 0.0 V.
        // device 1137, IC IC195, analog/basic/mos_r2r_dac.hpp:28
        I(cpphdl_n1745, cpphdl_n1759) <+ V(cpphdl_n1745, cpphdl_n1759) / 2000.0;
        // device 1138, IC IC195, analog/basic/mos_r2r_dac.hpp:29
        I(cpphdl_n1759, Vss) <+ 2.9999999999999998e-15 * ddt(V(cpphdl_n1759, Vss)); // Bench initial voltage = 0.0 V.
        // device 1139, IC IC195, analog/basic/mos_r2r_dac.hpp:31
        I(cpphdl_n1758, cpphdl_n1759) <+ V(cpphdl_n1758, cpphdl_n1759) / 1000.0;
        // device 1140, IC IC202, analog/basic/inverter.hpp:11
        I(cpphdl_n1749, Vdd) <+ cpphdl_channel(V(BIT_N8_6, Vdd), V(cpphdl_n1749, Vdd), 0.080000000000000002, 0.69999999999999996, -1.0);
        // device 1141, IC IC202, analog/basic/inverter.hpp:12
        I(cpphdl_n1749, Vss) <+ cpphdl_channel(V(BIT_N8_6, Vss), V(cpphdl_n1749, Vss), 0.080000000000000002, 0.69999999999999996, 1.0);
        // device 1142, IC IC195, analog/basic/mos_r2r_dac.hpp:27
        I(cpphdl_n1749, Vss) <+ 2.9999999999999998e-15 * ddt(V(cpphdl_n1749, Vss)); // Bench initial voltage = 0.0 V.
        // device 1143, IC IC195, analog/basic/mos_r2r_dac.hpp:28
        I(cpphdl_n1749, cpphdl_n1760) <+ V(cpphdl_n1749, cpphdl_n1760) / 2000.0;
        // device 1144, IC IC195, analog/basic/mos_r2r_dac.hpp:29
        I(cpphdl_n1760, Vss) <+ 2.9999999999999998e-15 * ddt(V(cpphdl_n1760, Vss)); // Bench initial voltage = 0.0 V.
        // device 1145, IC IC195, analog/basic/mos_r2r_dac.hpp:31
        I(cpphdl_n1759, cpphdl_n1760) <+ V(cpphdl_n1759, cpphdl_n1760) / 1000.0;
        // device 1146, IC IC203, analog/basic/inverter.hpp:11
        I(cpphdl_n1753, Vdd) <+ cpphdl_channel(V(BIT_N8_7, Vdd), V(cpphdl_n1753, Vdd), 0.080000000000000002, 0.69999999999999996, -1.0);
        // device 1147, IC IC203, analog/basic/inverter.hpp:12
        I(cpphdl_n1753, Vss) <+ cpphdl_channel(V(BIT_N8_7, Vss), V(cpphdl_n1753, Vss), 0.080000000000000002, 0.69999999999999996, 1.0);
        // device 1148, IC IC195, analog/basic/mos_r2r_dac.hpp:27
        I(cpphdl_n1753, Vss) <+ 2.9999999999999998e-15 * ddt(V(cpphdl_n1753, Vss)); // Bench initial voltage = 0.0 V.
        // device 1149, IC IC195, analog/basic/mos_r2r_dac.hpp:28
        I(cpphdl_n1753, cpphdl_n1765) <+ V(cpphdl_n1753, cpphdl_n1765) / 2000.0;
        // device 1150, IC IC195, analog/basic/mos_r2r_dac.hpp:29
        I(cpphdl_n1765, Vss) <+ 2.9999999999999998e-15 * ddt(V(cpphdl_n1765, Vss)); // Bench initial voltage = 0.0 V.
        // device 1151, IC IC195, analog/basic/mos_r2r_dac.hpp:31
        I(cpphdl_n1760, cpphdl_n1765) <+ V(cpphdl_n1760, cpphdl_n1765) / 1000.0;
        // device 1152, IC IC195, analog/basic/mos_r2r_dac.hpp:33
        I(Vss, cpphdl_n1754) <+ V(Vss, cpphdl_n1754) / 2000.0;
        // device 1153, IC IC204, analog/basic/nmos_resistor_amplifier.hpp:23
        I(Vdd, cpphdl_n1774) <+ V(Vdd, cpphdl_n1774) / 1000.0;
        // device 1154, IC IC204, analog/basic/nmos_resistor_amplifier.hpp:24
        I(Vdd, cpphdl_n1773) <+ V(Vdd, cpphdl_n1773) / 1000.0;
        // device 1155, IC IC204, analog/basic/nmos_resistor_amplifier.hpp:25
        I(cpphdl_n1774, cpphdl_n1768) <+ cpphdl_channel(V(cpphdl_n1764, cpphdl_n1768), V(cpphdl_n1774, cpphdl_n1768), 0.014999999999999999, 0.69999999999999996, 1.0);
        // device 1156, IC IC204, analog/basic/nmos_resistor_amplifier.hpp:26
        I(cpphdl_n1773, cpphdl_n1769) <+ cpphdl_channel(V(cpphdl_n1765, cpphdl_n1769), V(cpphdl_n1773, cpphdl_n1769), 0.014999999999999999, 0.69999999999999996, 1.0);
        // device 1157, IC IC204, analog/basic/nmos_resistor_amplifier.hpp:27
        I(cpphdl_n1770, cpphdl_n1768) <+ V(cpphdl_n1770, cpphdl_n1768) / 50.0;
        // device 1158, IC IC204, analog/basic/nmos_resistor_amplifier.hpp:28
        I(cpphdl_n1770, cpphdl_n1769) <+ V(cpphdl_n1770, cpphdl_n1769) / 50.0;
        // device 1159, IC IC204, analog/basic/nmos_resistor_amplifier.hpp:29
        I(Vss, cpphdl_n1770) <+ V(Vss, cpphdl_n1770) / 150.0;
        // device 1160, IC IC204, analog/basic/nmos_resistor_amplifier.hpp:30
        I(cpphdl_n1774, Vdd) <+ 2.9999999999999998e-13 * ddt(V(cpphdl_n1774, Vdd)); // Bench initial voltage = 0.0 V.
        // device 1161, IC IC204, analog/basic/nmos_resistor_amplifier.hpp:31
        I(cpphdl_n1773, Vdd) <+ 2.9999999999999998e-13 * ddt(V(cpphdl_n1773, Vdd)); // Bench initial voltage = 0.0 V.
        // device 1162, IC IC204, analog/basic/nmos_resistor_amplifier.hpp:32
        I(cpphdl_n1770, Vss) <+ 4e-14 * ddt(V(cpphdl_n1770, Vss)); // Bench initial voltage = 0.0 V.
        // device 1163, IC IC204, analog/basic/nmos_resistor_amplifier.hpp:34
        I(cpphdl_n1764, cpphdl_n1768) <+ 2e-14 * ddt(V(cpphdl_n1764, cpphdl_n1768)); // Bench initial voltage = 1.6499999999999999 V.
        // device 1164, IC IC204, analog/basic/nmos_resistor_amplifier.hpp:35
        I(cpphdl_n1765, cpphdl_n1769) <+ 2e-14 * ddt(V(cpphdl_n1765, cpphdl_n1769)); // Bench initial voltage = 0.0 V.
        // device 1165, IC IC204, analog/basic/nmos_resistor_amplifier.hpp:36
        I(cpphdl_n1764, cpphdl_n1774) <+ 2.9999999999999998e-15 * ddt(V(cpphdl_n1764, cpphdl_n1774)); // Bench initial voltage = -1.6499999999999999 V.
        // device 1166, IC IC204, analog/basic/nmos_resistor_amplifier.hpp:37
        I(cpphdl_n1765, cpphdl_n1773) <+ 2.9999999999999998e-15 * ddt(V(cpphdl_n1765, cpphdl_n1773)); // Bench initial voltage = -3.2999999999999998 V.
        // device 1167, IC IC205, analog/basic/strongarm_comparator.hpp:28
        I(cpphdl_n1778, cpphdl_n1780) <+ cpphdl_channel(V(cpphdl_n1773, cpphdl_n1780), V(cpphdl_n1778, cpphdl_n1780), 0.0080000000000000002, 0.69999999999999996, 1.0);
        // device 1168, IC IC205, analog/basic/strongarm_comparator.hpp:29
        I(cpphdl_n1779, cpphdl_n1780) <+ cpphdl_channel(V(cpphdl_n1774, cpphdl_n1780), V(cpphdl_n1779, cpphdl_n1780), 0.0080000000000000002, 0.69999999999999996, 1.0);
        // device 1169, IC IC205, analog/basic/strongarm_comparator.hpp:30
        I(cpphdl_n1780, Vss) <+ cpphdl_channel(V(EVALUATE, Vss), V(cpphdl_n1780, Vss), 0.0080000000000000002, 0.69999999999999996, 1.0);
        // device 1170, IC IC205, analog/basic/strongarm_comparator.hpp:33
        I(cpphdl_n1793, cpphdl_n1778) <+ cpphdl_channel(V(cpphdl_n1797, cpphdl_n1778), V(cpphdl_n1793, cpphdl_n1778), 0.0040000000000000001, 0.69999999999999996, 1.0);
        // device 1171, IC IC205, analog/basic/strongarm_comparator.hpp:34
        I(cpphdl_n1797, cpphdl_n1779) <+ cpphdl_channel(V(cpphdl_n1793, cpphdl_n1779), V(cpphdl_n1797, cpphdl_n1779), 0.0040000000000000001, 0.69999999999999996, 1.0);
        // device 1172, IC IC205, analog/basic/strongarm_comparator.hpp:35
        I(cpphdl_n1797, Vdd) <+ cpphdl_channel(V(cpphdl_n1793, Vdd), V(cpphdl_n1797, Vdd), 0.002, 0.69999999999999996, -1.0);
        // device 1173, IC IC205, analog/basic/strongarm_comparator.hpp:36
        I(cpphdl_n1793, Vdd) <+ cpphdl_channel(V(cpphdl_n1797, Vdd), V(cpphdl_n1793, Vdd), 0.002, 0.69999999999999996, -1.0);
        // device 1174, IC IC205, analog/basic/strongarm_comparator.hpp:38
        I(cpphdl_n1778, Vdd) <+ cpphdl_channel(V(EVALUATE, Vdd), V(cpphdl_n1778, Vdd), 0.002, 0.69999999999999996, -1.0);
        // device 1175, IC IC205, analog/basic/strongarm_comparator.hpp:39
        I(cpphdl_n1779, Vdd) <+ cpphdl_channel(V(EVALUATE, Vdd), V(cpphdl_n1779, Vdd), 0.002, 0.69999999999999996, -1.0);
        // device 1176, IC IC205, analog/basic/strongarm_comparator.hpp:40
        I(cpphdl_n1797, Vdd) <+ cpphdl_channel(V(EVALUATE, Vdd), V(cpphdl_n1797, Vdd), 0.002, 0.69999999999999996, -1.0);
        // device 1177, IC IC205, analog/basic/strongarm_comparator.hpp:41
        I(cpphdl_n1793, Vdd) <+ cpphdl_channel(V(EVALUATE, Vdd), V(cpphdl_n1793, Vdd), 0.002, 0.69999999999999996, -1.0);
        // device 1178, IC IC205, analog/basic/strongarm_comparator.hpp:42
        I(cpphdl_n1778, Vss) <+ 2.9999999999999998e-14 * ddt(V(cpphdl_n1778, Vss)); // Bench initial voltage = 0.0 V.
        // device 1179, IC IC205, analog/basic/strongarm_comparator.hpp:43
        I(cpphdl_n1779, Vss) <+ 2.9999999999999998e-14 * ddt(V(cpphdl_n1779, Vss)); // Bench initial voltage = 0.0 V.
        // device 1180, IC IC205, analog/basic/strongarm_comparator.hpp:44
        I(cpphdl_n1780, Vss) <+ 2.9999999999999998e-14 * ddt(V(cpphdl_n1780, Vss)); // Bench initial voltage = 0.0 V.
        // device 1181, IC IC205, analog/basic/strongarm_comparator.hpp:45
        I(cpphdl_n1797, Vss) <+ 5.0000000000000002e-14 * ddt(V(cpphdl_n1797, Vss)); // Bench initial voltage = 0.0 V.
        // device 1182, IC IC205, analog/basic/strongarm_comparator.hpp:46
        I(cpphdl_n1793, Vss) <+ 5.0000000000000002e-14 * ddt(V(cpphdl_n1793, Vss)); // Bench initial voltage = 0.0 V.
        // device 1183, IC IC205, analog/basic/strongarm_comparator.hpp:47
        I(cpphdl_n1773, cpphdl_n1780) <+ 2e-14 * ddt(V(cpphdl_n1773, cpphdl_n1780)); // Bench initial voltage = 3.2999999999999998 V.
        // device 1184, IC IC205, analog/basic/strongarm_comparator.hpp:48
        I(cpphdl_n1774, cpphdl_n1780) <+ 2e-14 * ddt(V(cpphdl_n1774, cpphdl_n1780)); // Bench initial voltage = 3.2999999999999998 V.
        // device 1185, IC IC205, analog/basic/strongarm_comparator.hpp:49
        I(cpphdl_n1773, cpphdl_n1778) <+ 2.9999999999999998e-15 * ddt(V(cpphdl_n1773, cpphdl_n1778)); // Bench initial voltage = 3.2999999999999998 V.
        // device 1186, IC IC205, analog/basic/strongarm_comparator.hpp:50
        I(cpphdl_n1774, cpphdl_n1779) <+ 2.9999999999999998e-15 * ddt(V(cpphdl_n1774, cpphdl_n1779)); // Bench initial voltage = 3.2999999999999998 V.
        // device 1187, IC IC207, analog/basic/inverter.hpp:11
        I(cpphdl_n1801, Vdd) <+ cpphdl_channel(V(cpphdl_n1793, Vdd), V(cpphdl_n1801, Vdd), 0.001, 0.69999999999999996, -1.0);
        // device 1188, IC IC207, analog/basic/inverter.hpp:12
        I(cpphdl_n1801, Vss) <+ cpphdl_channel(V(cpphdl_n1793, Vss), V(cpphdl_n1801, Vss), 0.001, 0.69999999999999996, 1.0);
        // device 1189, IC IC209, analog/basic/inverter.hpp:11
        I(cpphdl_n1815, Vdd) <+ cpphdl_channel(V(cpphdl_n1801, Vdd), V(cpphdl_n1815, Vdd), 0.0040000000000000001, 0.69999999999999996, -1.0);
        // device 1190, IC IC209, analog/basic/inverter.hpp:12
        I(cpphdl_n1815, Vss) <+ cpphdl_channel(V(cpphdl_n1801, Vss), V(cpphdl_n1815, Vss), 0.0040000000000000001, 0.69999999999999996, 1.0);
        // device 1191, IC IC206, analog/basic/buffered_nand_latch.hpp:34
        I(cpphdl_n1793, Vss) <+ 2.0000000000000002e-15 * ddt(V(cpphdl_n1793, Vss)); // Bench initial voltage = 0.0 V.
        // device 1192, IC IC206, analog/basic/buffered_nand_latch.hpp:35
        I(cpphdl_n1793, cpphdl_n1801) <+ 1.0000000000000001e-15 * ddt(V(cpphdl_n1793, cpphdl_n1801)); // Bench initial voltage = 0.0 V.
        // device 1193, IC IC206, analog/basic/buffered_nand_latch.hpp:36
        I(cpphdl_n1801, Vss) <+ 5e-15 * ddt(V(cpphdl_n1801, Vss)); // Bench initial voltage = 0.0 V.
        // device 1194, IC IC206, analog/basic/buffered_nand_latch.hpp:37
        I(cpphdl_n1801, Vss) <+ 8.0000000000000006e-15 * ddt(V(cpphdl_n1801, Vss)); // Bench initial voltage = 0.0 V.
        // device 1195, IC IC206, analog/basic/buffered_nand_latch.hpp:38
        I(cpphdl_n1815, Vss) <+ 1e-14 * ddt(V(cpphdl_n1815, Vss)); // Bench initial voltage = 0.0 V.
        // device 1196, IC IC208, analog/basic/inverter.hpp:11
        I(cpphdl_n1805, Vdd) <+ cpphdl_channel(V(cpphdl_n1797, Vdd), V(cpphdl_n1805, Vdd), 0.001, 0.69999999999999996, -1.0);
        // device 1197, IC IC208, analog/basic/inverter.hpp:12
        I(cpphdl_n1805, Vss) <+ cpphdl_channel(V(cpphdl_n1797, Vss), V(cpphdl_n1805, Vss), 0.001, 0.69999999999999996, 1.0);
        // device 1198, IC IC210, analog/basic/inverter.hpp:11
        I(cpphdl_n1821, Vdd) <+ cpphdl_channel(V(cpphdl_n1805, Vdd), V(cpphdl_n1821, Vdd), 0.0040000000000000001, 0.69999999999999996, -1.0);
        // device 1199, IC IC210, analog/basic/inverter.hpp:12
        I(cpphdl_n1821, Vss) <+ cpphdl_channel(V(cpphdl_n1805, Vss), V(cpphdl_n1821, Vss), 0.0040000000000000001, 0.69999999999999996, 1.0);
        // device 1200, IC IC206, analog/basic/buffered_nand_latch.hpp:34
        I(cpphdl_n1797, Vss) <+ 2.0000000000000002e-15 * ddt(V(cpphdl_n1797, Vss)); // Bench initial voltage = 0.0 V.
        // device 1201, IC IC206, analog/basic/buffered_nand_latch.hpp:35
        I(cpphdl_n1797, cpphdl_n1805) <+ 1.0000000000000001e-15 * ddt(V(cpphdl_n1797, cpphdl_n1805)); // Bench initial voltage = 0.0 V.
        // device 1202, IC IC206, analog/basic/buffered_nand_latch.hpp:36
        I(cpphdl_n1805, Vss) <+ 5e-15 * ddt(V(cpphdl_n1805, Vss)); // Bench initial voltage = 0.0 V.
        // device 1203, IC IC206, analog/basic/buffered_nand_latch.hpp:37
        I(cpphdl_n1805, Vss) <+ 8.0000000000000006e-15 * ddt(V(cpphdl_n1805, Vss)); // Bench initial voltage = 0.0 V.
        // device 1204, IC IC206, analog/basic/buffered_nand_latch.hpp:38
        I(cpphdl_n1821, Vss) <+ 1e-14 * ddt(V(cpphdl_n1821, Vss)); // Bench initial voltage = 0.0 V.
        // device 1205, IC IC212, analog/basic/cmos_logic.hpp:17
        I(cpphdl_n2890, Vss) <+ 5.0000000000000002e-14 * ddt(V(cpphdl_n2890, Vss)); // Bench initial voltage = 0.0 V.
        // device 1206, IC IC212, analog/basic/cmos_logic.hpp:18
        I(cpphdl_n2890, Vdd) <+ cpphdl_channel(V(cpphdl_n1815, Vdd), V(cpphdl_n2890, Vdd), 0.01, 0.69999999999999996, -1.0);
        // device 1207, IC IC212, analog/basic/cmos_logic.hpp:19
        I(cpphdl_n2890, Vdd) <+ cpphdl_channel(V(cpphdl_n1823, Vdd), V(cpphdl_n2890, Vdd), 0.01, 0.69999999999999996, -1.0);
        // device 1208, IC IC212, analog/basic/cmos_logic.hpp:20
        I(cpphdl_n2890, cpphdl_n1818) <+ cpphdl_channel(V(cpphdl_n1815, cpphdl_n1818), V(cpphdl_n2890, cpphdl_n1818), 0.01, 0.69999999999999996, 1.0);
        // device 1209, IC IC212, analog/basic/cmos_logic.hpp:21
        I(cpphdl_n1818, Vss) <+ cpphdl_channel(V(cpphdl_n1823, Vss), V(cpphdl_n1818, Vss), 0.01, 0.69999999999999996, 1.0);
        // device 1210, IC IC212, analog/basic/cmos_logic.hpp:23
        I(cpphdl_n2890, Vss) <+ V(cpphdl_n2890, Vss) / 1000000000.0;
        // device 1211, IC IC212, analog/basic/cmos_logic.hpp:24
        I(cpphdl_n1818, Vss) <+ V(cpphdl_n1818, Vss) / 1000000000.0;
        // device 1212, IC IC213, analog/basic/cmos_logic.hpp:17
        I(cpphdl_n1823, Vss) <+ 5.0000000000000002e-14 * ddt(V(cpphdl_n1823, Vss)); // Bench initial voltage = 0.0 V.
        // device 1213, IC IC213, analog/basic/cmos_logic.hpp:18
        I(cpphdl_n1823, Vdd) <+ cpphdl_channel(V(cpphdl_n1821, Vdd), V(cpphdl_n1823, Vdd), 0.01, 0.69999999999999996, -1.0);
        // device 1214, IC IC213, analog/basic/cmos_logic.hpp:19
        I(cpphdl_n1823, Vdd) <+ cpphdl_channel(V(cpphdl_n2890, Vdd), V(cpphdl_n1823, Vdd), 0.01, 0.69999999999999996, -1.0);
        // device 1215, IC IC213, analog/basic/cmos_logic.hpp:20
        I(cpphdl_n1823, cpphdl_n1824) <+ cpphdl_channel(V(cpphdl_n1821, cpphdl_n1824), V(cpphdl_n1823, cpphdl_n1824), 0.01, 0.69999999999999996, 1.0);
        // device 1216, IC IC213, analog/basic/cmos_logic.hpp:21
        I(cpphdl_n1824, Vss) <+ cpphdl_channel(V(cpphdl_n2890, Vss), V(cpphdl_n1824, Vss), 0.01, 0.69999999999999996, 1.0);
        // device 1217, IC IC213, analog/basic/cmos_logic.hpp:23
        I(cpphdl_n1823, Vss) <+ V(cpphdl_n1823, Vss) / 1000000000.0;
        // device 1218, IC IC213, analog/basic/cmos_logic.hpp:24
        I(cpphdl_n1824, Vss) <+ V(cpphdl_n1824, Vss) / 1000000000.0;
        // device 1219, IC IC211, analog/basic/nand_latch.hpp:36
        I(cpphdl_n1815, Vss) <+ 2.9999999999999998e-15 * ddt(V(cpphdl_n1815, Vss)); // Bench initial voltage = 0.0 V.
        // device 1220, IC IC211, analog/basic/nand_latch.hpp:37
        I(cpphdl_n1821, Vss) <+ 2.9999999999999998e-15 * ddt(V(cpphdl_n1821, Vss)); // Bench initial voltage = 0.0 V.
        // device 1221, IC IC214, analog/basic/inverter.hpp:11
        I(cpphdl_n1829, Vdd) <+ cpphdl_channel(V(CLEAR, Vdd), V(cpphdl_n1829, Vdd), 0.01, 0.69999999999999996, -1.0);
        // device 1222, IC IC214, analog/basic/inverter.hpp:12
        I(cpphdl_n1829, Vss) <+ cpphdl_channel(V(CLEAR, Vss), V(cpphdl_n1829, Vss), 0.01, 0.69999999999999996, 1.0);
        // device 1223, IC IC211, analog/basic/nand_latch.hpp:58
        I(cpphdl_n1829, Vss) <+ 2.9999999999999998e-15 * ddt(V(cpphdl_n1829, Vss)); // Bench initial voltage = 0.0 V.
        // device 1224, IC IC211, analog/basic/nand_latch.hpp:59
        I(cpphdl_n2890, Vss) <+ cpphdl_channel(V(CLEAR, Vss), V(cpphdl_n2890, Vss), 0.050000000000000003, 0.69999999999999996, 1.0);
        // device 1225, IC IC211, analog/basic/nand_latch.hpp:60
        I(cpphdl_n1823, Vdd) <+ cpphdl_channel(V(cpphdl_n1829, Vdd), V(cpphdl_n1823, Vdd), 0.050000000000000003, 0.69999999999999996, -1.0);
        // device 1226, IC IC217, analog/basic/inverter.hpp:11
        I(cpphdl_n1853, Vdd) <+ cpphdl_channel(V(TRACK9, Vdd), V(cpphdl_n1853, Vdd), 0.0040000000000000001, 0.69999999999999996, -1.0);
        // device 1227, IC IC217, analog/basic/inverter.hpp:12
        I(cpphdl_n1853, Vss) <+ cpphdl_channel(V(TRACK9, Vss), V(cpphdl_n1853, Vss), 0.0040000000000000001, 0.69999999999999996, 1.0);
        // device 1228, IC IC216, analog/basic/mos_track_hold.hpp:31
        I(cpphdl_n1853, Vss) <+ 2e-14 * ddt(V(cpphdl_n1853, Vss)); // Bench initial voltage = 3.2999999999999998 V.
        // device 1229, IC IC216, analog/basic/mos_track_hold.hpp:32
        I(cpphdl_n2705, cpphdl_n1907) <+ cpphdl_channel(V(TRACK9, cpphdl_n1907), V(cpphdl_n2705, cpphdl_n1907), 0.080000000000000002, 0.69999999999999996, 1.0);
        // device 1230, IC IC216, analog/basic/mos_track_hold.hpp:33
        I(cpphdl_n1907, cpphdl_n2705) <+ cpphdl_channel(V(cpphdl_n1853, cpphdl_n2705), V(cpphdl_n1907, cpphdl_n2705), 0.040000000000000001, 0.69999999999999996, -1.0);
        // device 1231, IC IC216, analog/basic/mos_track_hold.hpp:37
        I(cpphdl_n1907, cpphdl_n1907) <+ cpphdl_channel(V(cpphdl_n1853, cpphdl_n1907), V(cpphdl_n1907, cpphdl_n1907), 0.040000000000000001, 0.69999999999999996, 1.0);
        // device 1232, IC IC216, analog/basic/mos_track_hold.hpp:38
        I(cpphdl_n1907, cpphdl_n1907) <+ cpphdl_channel(V(TRACK9, cpphdl_n1907), V(cpphdl_n1907, cpphdl_n1907), 0.02, 0.69999999999999996, -1.0);
        // device 1233, IC IC216, analog/basic/mos_track_hold.hpp:39
        I(cpphdl_n1907, Vss) <+ 2e-12 * ddt(V(cpphdl_n1907, Vss)); // Bench initial voltage = 1.6499999999999999 V.
        // device 1234, IC IC216, analog/basic/mos_track_hold.hpp:41
        I(Vss, cpphdl_n1907) <+ V(Vss, cpphdl_n1907) / 1000000000.0;
        // device 1235, IC IC216, analog/basic/mos_track_hold.hpp:42
        I(TRACK9, cpphdl_n1907) <+ 8.0000000000000006e-15 * ddt(V(TRACK9, cpphdl_n1907)); // Bench initial voltage = -1.6499999999999999 V.
        // device 1236, IC IC216, analog/basic/mos_track_hold.hpp:43
        I(cpphdl_n1853, cpphdl_n1907) <+ 8.0000000000000006e-15 * ddt(V(cpphdl_n1853, cpphdl_n1907)); // Bench initial voltage = 1.6499999999999999 V.
        // device 1237, IC IC216, analog/basic/mos_track_hold.hpp:44
        I(cpphdl_n2705, cpphdl_n1907) <+ 4.0000000000000003e-15 * ddt(V(cpphdl_n2705, cpphdl_n1907)); // Bench initial voltage = 0.0 V.
        // device 1238, IC IC219, analog/basic/inverter.hpp:11
        I(cpphdl_n1868, Vdd) <+ cpphdl_channel(V(BIT_N9_0, Vdd), V(cpphdl_n1868, Vdd), 0.080000000000000002, 0.69999999999999996, -1.0);
        // device 1239, IC IC219, analog/basic/inverter.hpp:12
        I(cpphdl_n1868, Vss) <+ cpphdl_channel(V(BIT_N9_0, Vss), V(cpphdl_n1868, Vss), 0.080000000000000002, 0.69999999999999996, 1.0);
        // device 1240, IC IC218, analog/basic/mos_r2r_dac.hpp:27
        I(cpphdl_n1868, Vss) <+ 2.9999999999999998e-15 * ddt(V(cpphdl_n1868, Vss)); // Bench initial voltage = 0.0 V.
        // device 1241, IC IC218, analog/basic/mos_r2r_dac.hpp:28
        I(cpphdl_n1868, cpphdl_n1897) <+ V(cpphdl_n1868, cpphdl_n1897) / 2000.0;
        // device 1242, IC IC218, analog/basic/mos_r2r_dac.hpp:29
        I(cpphdl_n1897, Vss) <+ 2.9999999999999998e-15 * ddt(V(cpphdl_n1897, Vss)); // Bench initial voltage = 0.0 V.
        // device 1243, IC IC220, analog/basic/inverter.hpp:11
        I(cpphdl_n1872, Vdd) <+ cpphdl_channel(V(BIT_N9_1, Vdd), V(cpphdl_n1872, Vdd), 0.080000000000000002, 0.69999999999999996, -1.0);
        // device 1244, IC IC220, analog/basic/inverter.hpp:12
        I(cpphdl_n1872, Vss) <+ cpphdl_channel(V(BIT_N9_1, Vss), V(cpphdl_n1872, Vss), 0.080000000000000002, 0.69999999999999996, 1.0);
        // device 1245, IC IC218, analog/basic/mos_r2r_dac.hpp:27
        I(cpphdl_n1872, Vss) <+ 2.9999999999999998e-15 * ddt(V(cpphdl_n1872, Vss)); // Bench initial voltage = 0.0 V.
        // device 1246, IC IC218, analog/basic/mos_r2r_dac.hpp:28
        I(cpphdl_n1872, cpphdl_n1898) <+ V(cpphdl_n1872, cpphdl_n1898) / 2000.0;
        // device 1247, IC IC218, analog/basic/mos_r2r_dac.hpp:29
        I(cpphdl_n1898, Vss) <+ 2.9999999999999998e-15 * ddt(V(cpphdl_n1898, Vss)); // Bench initial voltage = 0.0 V.
        // device 1248, IC IC218, analog/basic/mos_r2r_dac.hpp:31
        I(cpphdl_n1897, cpphdl_n1898) <+ V(cpphdl_n1897, cpphdl_n1898) / 1000.0;
        // device 1249, IC IC221, analog/basic/inverter.hpp:11
        I(cpphdl_n1876, Vdd) <+ cpphdl_channel(V(BIT_N9_2, Vdd), V(cpphdl_n1876, Vdd), 0.080000000000000002, 0.69999999999999996, -1.0);
        // device 1250, IC IC221, analog/basic/inverter.hpp:12
        I(cpphdl_n1876, Vss) <+ cpphdl_channel(V(BIT_N9_2, Vss), V(cpphdl_n1876, Vss), 0.080000000000000002, 0.69999999999999996, 1.0);
        // device 1251, IC IC218, analog/basic/mos_r2r_dac.hpp:27
        I(cpphdl_n1876, Vss) <+ 2.9999999999999998e-15 * ddt(V(cpphdl_n1876, Vss)); // Bench initial voltage = 0.0 V.
        // device 1252, IC IC218, analog/basic/mos_r2r_dac.hpp:28
        I(cpphdl_n1876, cpphdl_n1899) <+ V(cpphdl_n1876, cpphdl_n1899) / 2000.0;
        // device 1253, IC IC218, analog/basic/mos_r2r_dac.hpp:29
        I(cpphdl_n1899, Vss) <+ 2.9999999999999998e-15 * ddt(V(cpphdl_n1899, Vss)); // Bench initial voltage = 0.0 V.
        // device 1254, IC IC218, analog/basic/mos_r2r_dac.hpp:31
        I(cpphdl_n1898, cpphdl_n1899) <+ V(cpphdl_n1898, cpphdl_n1899) / 1000.0;
        // device 1255, IC IC222, analog/basic/inverter.hpp:11
        I(cpphdl_n1880, Vdd) <+ cpphdl_channel(V(BIT_N9_3, Vdd), V(cpphdl_n1880, Vdd), 0.080000000000000002, 0.69999999999999996, -1.0);
        // device 1256, IC IC222, analog/basic/inverter.hpp:12
        I(cpphdl_n1880, Vss) <+ cpphdl_channel(V(BIT_N9_3, Vss), V(cpphdl_n1880, Vss), 0.080000000000000002, 0.69999999999999996, 1.0);
        // device 1257, IC IC218, analog/basic/mos_r2r_dac.hpp:27
        I(cpphdl_n1880, Vss) <+ 2.9999999999999998e-15 * ddt(V(cpphdl_n1880, Vss)); // Bench initial voltage = 0.0 V.
        // device 1258, IC IC218, analog/basic/mos_r2r_dac.hpp:28
        I(cpphdl_n1880, cpphdl_n1900) <+ V(cpphdl_n1880, cpphdl_n1900) / 2000.0;
        // device 1259, IC IC218, analog/basic/mos_r2r_dac.hpp:29
        I(cpphdl_n1900, Vss) <+ 2.9999999999999998e-15 * ddt(V(cpphdl_n1900, Vss)); // Bench initial voltage = 0.0 V.
        // device 1260, IC IC218, analog/basic/mos_r2r_dac.hpp:31
        I(cpphdl_n1899, cpphdl_n1900) <+ V(cpphdl_n1899, cpphdl_n1900) / 1000.0;
        // device 1261, IC IC223, analog/basic/inverter.hpp:11
        I(cpphdl_n1884, Vdd) <+ cpphdl_channel(V(BIT_N9_4, Vdd), V(cpphdl_n1884, Vdd), 0.080000000000000002, 0.69999999999999996, -1.0);
        // device 1262, IC IC223, analog/basic/inverter.hpp:12
        I(cpphdl_n1884, Vss) <+ cpphdl_channel(V(BIT_N9_4, Vss), V(cpphdl_n1884, Vss), 0.080000000000000002, 0.69999999999999996, 1.0);
        // device 1263, IC IC218, analog/basic/mos_r2r_dac.hpp:27
        I(cpphdl_n1884, Vss) <+ 2.9999999999999998e-15 * ddt(V(cpphdl_n1884, Vss)); // Bench initial voltage = 0.0 V.
        // device 1264, IC IC218, analog/basic/mos_r2r_dac.hpp:28
        I(cpphdl_n1884, cpphdl_n1901) <+ V(cpphdl_n1884, cpphdl_n1901) / 2000.0;
        // device 1265, IC IC218, analog/basic/mos_r2r_dac.hpp:29
        I(cpphdl_n1901, Vss) <+ 2.9999999999999998e-15 * ddt(V(cpphdl_n1901, Vss)); // Bench initial voltage = 0.0 V.
        // device 1266, IC IC218, analog/basic/mos_r2r_dac.hpp:31
        I(cpphdl_n1900, cpphdl_n1901) <+ V(cpphdl_n1900, cpphdl_n1901) / 1000.0;
        // device 1267, IC IC224, analog/basic/inverter.hpp:11
        I(cpphdl_n1888, Vdd) <+ cpphdl_channel(V(BIT_N9_5, Vdd), V(cpphdl_n1888, Vdd), 0.080000000000000002, 0.69999999999999996, -1.0);
        // device 1268, IC IC224, analog/basic/inverter.hpp:12
        I(cpphdl_n1888, Vss) <+ cpphdl_channel(V(BIT_N9_5, Vss), V(cpphdl_n1888, Vss), 0.080000000000000002, 0.69999999999999996, 1.0);
        // device 1269, IC IC218, analog/basic/mos_r2r_dac.hpp:27
        I(cpphdl_n1888, Vss) <+ 2.9999999999999998e-15 * ddt(V(cpphdl_n1888, Vss)); // Bench initial voltage = 0.0 V.
        // device 1270, IC IC218, analog/basic/mos_r2r_dac.hpp:28
        I(cpphdl_n1888, cpphdl_n1902) <+ V(cpphdl_n1888, cpphdl_n1902) / 2000.0;
        // device 1271, IC IC218, analog/basic/mos_r2r_dac.hpp:29
        I(cpphdl_n1902, Vss) <+ 2.9999999999999998e-15 * ddt(V(cpphdl_n1902, Vss)); // Bench initial voltage = 0.0 V.
        // device 1272, IC IC218, analog/basic/mos_r2r_dac.hpp:31
        I(cpphdl_n1901, cpphdl_n1902) <+ V(cpphdl_n1901, cpphdl_n1902) / 1000.0;
        // device 1273, IC IC225, analog/basic/inverter.hpp:11
        I(cpphdl_n1892, Vdd) <+ cpphdl_channel(V(BIT_N9_6, Vdd), V(cpphdl_n1892, Vdd), 0.080000000000000002, 0.69999999999999996, -1.0);
        // device 1274, IC IC225, analog/basic/inverter.hpp:12
        I(cpphdl_n1892, Vss) <+ cpphdl_channel(V(BIT_N9_6, Vss), V(cpphdl_n1892, Vss), 0.080000000000000002, 0.69999999999999996, 1.0);
        // device 1275, IC IC218, analog/basic/mos_r2r_dac.hpp:27
        I(cpphdl_n1892, Vss) <+ 2.9999999999999998e-15 * ddt(V(cpphdl_n1892, Vss)); // Bench initial voltage = 0.0 V.
        // device 1276, IC IC218, analog/basic/mos_r2r_dac.hpp:28
        I(cpphdl_n1892, cpphdl_n1903) <+ V(cpphdl_n1892, cpphdl_n1903) / 2000.0;
        // device 1277, IC IC218, analog/basic/mos_r2r_dac.hpp:29
        I(cpphdl_n1903, Vss) <+ 2.9999999999999998e-15 * ddt(V(cpphdl_n1903, Vss)); // Bench initial voltage = 0.0 V.
        // device 1278, IC IC218, analog/basic/mos_r2r_dac.hpp:31
        I(cpphdl_n1902, cpphdl_n1903) <+ V(cpphdl_n1902, cpphdl_n1903) / 1000.0;
        // device 1279, IC IC226, analog/basic/inverter.hpp:11
        I(cpphdl_n1896, Vdd) <+ cpphdl_channel(V(BIT_N9_7, Vdd), V(cpphdl_n1896, Vdd), 0.080000000000000002, 0.69999999999999996, -1.0);
        // device 1280, IC IC226, analog/basic/inverter.hpp:12
        I(cpphdl_n1896, Vss) <+ cpphdl_channel(V(BIT_N9_7, Vss), V(cpphdl_n1896, Vss), 0.080000000000000002, 0.69999999999999996, 1.0);
        // device 1281, IC IC218, analog/basic/mos_r2r_dac.hpp:27
        I(cpphdl_n1896, Vss) <+ 2.9999999999999998e-15 * ddt(V(cpphdl_n1896, Vss)); // Bench initial voltage = 0.0 V.
        // device 1282, IC IC218, analog/basic/mos_r2r_dac.hpp:28
        I(cpphdl_n1896, cpphdl_n1908) <+ V(cpphdl_n1896, cpphdl_n1908) / 2000.0;
        // device 1283, IC IC218, analog/basic/mos_r2r_dac.hpp:29
        I(cpphdl_n1908, Vss) <+ 2.9999999999999998e-15 * ddt(V(cpphdl_n1908, Vss)); // Bench initial voltage = 0.0 V.
        // device 1284, IC IC218, analog/basic/mos_r2r_dac.hpp:31
        I(cpphdl_n1903, cpphdl_n1908) <+ V(cpphdl_n1903, cpphdl_n1908) / 1000.0;
        // device 1285, IC IC218, analog/basic/mos_r2r_dac.hpp:33
        I(Vss, cpphdl_n1897) <+ V(Vss, cpphdl_n1897) / 2000.0;
        // device 1286, IC IC227, analog/basic/nmos_resistor_amplifier.hpp:23
        I(Vdd, cpphdl_n1917) <+ V(Vdd, cpphdl_n1917) / 1000.0;
        // device 1287, IC IC227, analog/basic/nmos_resistor_amplifier.hpp:24
        I(Vdd, cpphdl_n1916) <+ V(Vdd, cpphdl_n1916) / 1000.0;
        // device 1288, IC IC227, analog/basic/nmos_resistor_amplifier.hpp:25
        I(cpphdl_n1917, cpphdl_n1911) <+ cpphdl_channel(V(cpphdl_n1907, cpphdl_n1911), V(cpphdl_n1917, cpphdl_n1911), 0.014999999999999999, 0.69999999999999996, 1.0);
        // device 1289, IC IC227, analog/basic/nmos_resistor_amplifier.hpp:26
        I(cpphdl_n1916, cpphdl_n1912) <+ cpphdl_channel(V(cpphdl_n1908, cpphdl_n1912), V(cpphdl_n1916, cpphdl_n1912), 0.014999999999999999, 0.69999999999999996, 1.0);
        // device 1290, IC IC227, analog/basic/nmos_resistor_amplifier.hpp:27
        I(cpphdl_n1913, cpphdl_n1911) <+ V(cpphdl_n1913, cpphdl_n1911) / 50.0;
        // device 1291, IC IC227, analog/basic/nmos_resistor_amplifier.hpp:28
        I(cpphdl_n1913, cpphdl_n1912) <+ V(cpphdl_n1913, cpphdl_n1912) / 50.0;
        // device 1292, IC IC227, analog/basic/nmos_resistor_amplifier.hpp:29
        I(Vss, cpphdl_n1913) <+ V(Vss, cpphdl_n1913) / 150.0;
        // device 1293, IC IC227, analog/basic/nmos_resistor_amplifier.hpp:30
        I(cpphdl_n1917, Vdd) <+ 2.9999999999999998e-13 * ddt(V(cpphdl_n1917, Vdd)); // Bench initial voltage = 0.0 V.
        // device 1294, IC IC227, analog/basic/nmos_resistor_amplifier.hpp:31
        I(cpphdl_n1916, Vdd) <+ 2.9999999999999998e-13 * ddt(V(cpphdl_n1916, Vdd)); // Bench initial voltage = 0.0 V.
        // device 1295, IC IC227, analog/basic/nmos_resistor_amplifier.hpp:32
        I(cpphdl_n1913, Vss) <+ 4e-14 * ddt(V(cpphdl_n1913, Vss)); // Bench initial voltage = 0.0 V.
        // device 1296, IC IC227, analog/basic/nmos_resistor_amplifier.hpp:34
        I(cpphdl_n1907, cpphdl_n1911) <+ 2e-14 * ddt(V(cpphdl_n1907, cpphdl_n1911)); // Bench initial voltage = 1.6499999999999999 V.
        // device 1297, IC IC227, analog/basic/nmos_resistor_amplifier.hpp:35
        I(cpphdl_n1908, cpphdl_n1912) <+ 2e-14 * ddt(V(cpphdl_n1908, cpphdl_n1912)); // Bench initial voltage = 0.0 V.
        // device 1298, IC IC227, analog/basic/nmos_resistor_amplifier.hpp:36
        I(cpphdl_n1907, cpphdl_n1917) <+ 2.9999999999999998e-15 * ddt(V(cpphdl_n1907, cpphdl_n1917)); // Bench initial voltage = -1.6499999999999999 V.
        // device 1299, IC IC227, analog/basic/nmos_resistor_amplifier.hpp:37
        I(cpphdl_n1908, cpphdl_n1916) <+ 2.9999999999999998e-15 * ddt(V(cpphdl_n1908, cpphdl_n1916)); // Bench initial voltage = -3.2999999999999998 V.
        // device 1300, IC IC228, analog/basic/strongarm_comparator.hpp:28
        I(cpphdl_n1921, cpphdl_n1923) <+ cpphdl_channel(V(cpphdl_n1916, cpphdl_n1923), V(cpphdl_n1921, cpphdl_n1923), 0.0080000000000000002, 0.69999999999999996, 1.0);
        // device 1301, IC IC228, analog/basic/strongarm_comparator.hpp:29
        I(cpphdl_n1922, cpphdl_n1923) <+ cpphdl_channel(V(cpphdl_n1917, cpphdl_n1923), V(cpphdl_n1922, cpphdl_n1923), 0.0080000000000000002, 0.69999999999999996, 1.0);
        // device 1302, IC IC228, analog/basic/strongarm_comparator.hpp:30
        I(cpphdl_n1923, Vss) <+ cpphdl_channel(V(EVALUATE, Vss), V(cpphdl_n1923, Vss), 0.0080000000000000002, 0.69999999999999996, 1.0);
        // device 1303, IC IC228, analog/basic/strongarm_comparator.hpp:33
        I(cpphdl_n1936, cpphdl_n1921) <+ cpphdl_channel(V(cpphdl_n1940, cpphdl_n1921), V(cpphdl_n1936, cpphdl_n1921), 0.0040000000000000001, 0.69999999999999996, 1.0);
        // device 1304, IC IC228, analog/basic/strongarm_comparator.hpp:34
        I(cpphdl_n1940, cpphdl_n1922) <+ cpphdl_channel(V(cpphdl_n1936, cpphdl_n1922), V(cpphdl_n1940, cpphdl_n1922), 0.0040000000000000001, 0.69999999999999996, 1.0);
        // device 1305, IC IC228, analog/basic/strongarm_comparator.hpp:35
        I(cpphdl_n1940, Vdd) <+ cpphdl_channel(V(cpphdl_n1936, Vdd), V(cpphdl_n1940, Vdd), 0.002, 0.69999999999999996, -1.0);
        // device 1306, IC IC228, analog/basic/strongarm_comparator.hpp:36
        I(cpphdl_n1936, Vdd) <+ cpphdl_channel(V(cpphdl_n1940, Vdd), V(cpphdl_n1936, Vdd), 0.002, 0.69999999999999996, -1.0);
        // device 1307, IC IC228, analog/basic/strongarm_comparator.hpp:38
        I(cpphdl_n1921, Vdd) <+ cpphdl_channel(V(EVALUATE, Vdd), V(cpphdl_n1921, Vdd), 0.002, 0.69999999999999996, -1.0);
        // device 1308, IC IC228, analog/basic/strongarm_comparator.hpp:39
        I(cpphdl_n1922, Vdd) <+ cpphdl_channel(V(EVALUATE, Vdd), V(cpphdl_n1922, Vdd), 0.002, 0.69999999999999996, -1.0);
        // device 1309, IC IC228, analog/basic/strongarm_comparator.hpp:40
        I(cpphdl_n1940, Vdd) <+ cpphdl_channel(V(EVALUATE, Vdd), V(cpphdl_n1940, Vdd), 0.002, 0.69999999999999996, -1.0);
        // device 1310, IC IC228, analog/basic/strongarm_comparator.hpp:41
        I(cpphdl_n1936, Vdd) <+ cpphdl_channel(V(EVALUATE, Vdd), V(cpphdl_n1936, Vdd), 0.002, 0.69999999999999996, -1.0);
        // device 1311, IC IC228, analog/basic/strongarm_comparator.hpp:42
        I(cpphdl_n1921, Vss) <+ 2.9999999999999998e-14 * ddt(V(cpphdl_n1921, Vss)); // Bench initial voltage = 0.0 V.
        // device 1312, IC IC228, analog/basic/strongarm_comparator.hpp:43
        I(cpphdl_n1922, Vss) <+ 2.9999999999999998e-14 * ddt(V(cpphdl_n1922, Vss)); // Bench initial voltage = 0.0 V.
        // device 1313, IC IC228, analog/basic/strongarm_comparator.hpp:44
        I(cpphdl_n1923, Vss) <+ 2.9999999999999998e-14 * ddt(V(cpphdl_n1923, Vss)); // Bench initial voltage = 0.0 V.
        // device 1314, IC IC228, analog/basic/strongarm_comparator.hpp:45
        I(cpphdl_n1940, Vss) <+ 5.0000000000000002e-14 * ddt(V(cpphdl_n1940, Vss)); // Bench initial voltage = 0.0 V.
        // device 1315, IC IC228, analog/basic/strongarm_comparator.hpp:46
        I(cpphdl_n1936, Vss) <+ 5.0000000000000002e-14 * ddt(V(cpphdl_n1936, Vss)); // Bench initial voltage = 0.0 V.
        // device 1316, IC IC228, analog/basic/strongarm_comparator.hpp:47
        I(cpphdl_n1916, cpphdl_n1923) <+ 2e-14 * ddt(V(cpphdl_n1916, cpphdl_n1923)); // Bench initial voltage = 3.2999999999999998 V.
        // device 1317, IC IC228, analog/basic/strongarm_comparator.hpp:48
        I(cpphdl_n1917, cpphdl_n1923) <+ 2e-14 * ddt(V(cpphdl_n1917, cpphdl_n1923)); // Bench initial voltage = 3.2999999999999998 V.
        // device 1318, IC IC228, analog/basic/strongarm_comparator.hpp:49
        I(cpphdl_n1916, cpphdl_n1921) <+ 2.9999999999999998e-15 * ddt(V(cpphdl_n1916, cpphdl_n1921)); // Bench initial voltage = 3.2999999999999998 V.
        // device 1319, IC IC228, analog/basic/strongarm_comparator.hpp:50
        I(cpphdl_n1917, cpphdl_n1922) <+ 2.9999999999999998e-15 * ddt(V(cpphdl_n1917, cpphdl_n1922)); // Bench initial voltage = 3.2999999999999998 V.
        // device 1320, IC IC230, analog/basic/inverter.hpp:11
        I(cpphdl_n1944, Vdd) <+ cpphdl_channel(V(cpphdl_n1936, Vdd), V(cpphdl_n1944, Vdd), 0.001, 0.69999999999999996, -1.0);
        // device 1321, IC IC230, analog/basic/inverter.hpp:12
        I(cpphdl_n1944, Vss) <+ cpphdl_channel(V(cpphdl_n1936, Vss), V(cpphdl_n1944, Vss), 0.001, 0.69999999999999996, 1.0);
        // device 1322, IC IC232, analog/basic/inverter.hpp:11
        I(cpphdl_n1958, Vdd) <+ cpphdl_channel(V(cpphdl_n1944, Vdd), V(cpphdl_n1958, Vdd), 0.0040000000000000001, 0.69999999999999996, -1.0);
        // device 1323, IC IC232, analog/basic/inverter.hpp:12
        I(cpphdl_n1958, Vss) <+ cpphdl_channel(V(cpphdl_n1944, Vss), V(cpphdl_n1958, Vss), 0.0040000000000000001, 0.69999999999999996, 1.0);
        // device 1324, IC IC229, analog/basic/buffered_nand_latch.hpp:34
        I(cpphdl_n1936, Vss) <+ 2.0000000000000002e-15 * ddt(V(cpphdl_n1936, Vss)); // Bench initial voltage = 0.0 V.
        // device 1325, IC IC229, analog/basic/buffered_nand_latch.hpp:35
        I(cpphdl_n1936, cpphdl_n1944) <+ 1.0000000000000001e-15 * ddt(V(cpphdl_n1936, cpphdl_n1944)); // Bench initial voltage = 0.0 V.
        // device 1326, IC IC229, analog/basic/buffered_nand_latch.hpp:36
        I(cpphdl_n1944, Vss) <+ 5e-15 * ddt(V(cpphdl_n1944, Vss)); // Bench initial voltage = 0.0 V.
        // device 1327, IC IC229, analog/basic/buffered_nand_latch.hpp:37
        I(cpphdl_n1944, Vss) <+ 8.0000000000000006e-15 * ddt(V(cpphdl_n1944, Vss)); // Bench initial voltage = 0.0 V.
        // device 1328, IC IC229, analog/basic/buffered_nand_latch.hpp:38
        I(cpphdl_n1958, Vss) <+ 1e-14 * ddt(V(cpphdl_n1958, Vss)); // Bench initial voltage = 0.0 V.
        // device 1329, IC IC231, analog/basic/inverter.hpp:11
        I(cpphdl_n1948, Vdd) <+ cpphdl_channel(V(cpphdl_n1940, Vdd), V(cpphdl_n1948, Vdd), 0.001, 0.69999999999999996, -1.0);
        // device 1330, IC IC231, analog/basic/inverter.hpp:12
        I(cpphdl_n1948, Vss) <+ cpphdl_channel(V(cpphdl_n1940, Vss), V(cpphdl_n1948, Vss), 0.001, 0.69999999999999996, 1.0);
        // device 1331, IC IC233, analog/basic/inverter.hpp:11
        I(cpphdl_n1964, Vdd) <+ cpphdl_channel(V(cpphdl_n1948, Vdd), V(cpphdl_n1964, Vdd), 0.0040000000000000001, 0.69999999999999996, -1.0);
        // device 1332, IC IC233, analog/basic/inverter.hpp:12
        I(cpphdl_n1964, Vss) <+ cpphdl_channel(V(cpphdl_n1948, Vss), V(cpphdl_n1964, Vss), 0.0040000000000000001, 0.69999999999999996, 1.0);
        // device 1333, IC IC229, analog/basic/buffered_nand_latch.hpp:34
        I(cpphdl_n1940, Vss) <+ 2.0000000000000002e-15 * ddt(V(cpphdl_n1940, Vss)); // Bench initial voltage = 0.0 V.
        // device 1334, IC IC229, analog/basic/buffered_nand_latch.hpp:35
        I(cpphdl_n1940, cpphdl_n1948) <+ 1.0000000000000001e-15 * ddt(V(cpphdl_n1940, cpphdl_n1948)); // Bench initial voltage = 0.0 V.
        // device 1335, IC IC229, analog/basic/buffered_nand_latch.hpp:36
        I(cpphdl_n1948, Vss) <+ 5e-15 * ddt(V(cpphdl_n1948, Vss)); // Bench initial voltage = 0.0 V.
        // device 1336, IC IC229, analog/basic/buffered_nand_latch.hpp:37
        I(cpphdl_n1948, Vss) <+ 8.0000000000000006e-15 * ddt(V(cpphdl_n1948, Vss)); // Bench initial voltage = 0.0 V.
        // device 1337, IC IC229, analog/basic/buffered_nand_latch.hpp:38
        I(cpphdl_n1964, Vss) <+ 1e-14 * ddt(V(cpphdl_n1964, Vss)); // Bench initial voltage = 0.0 V.
        // device 1338, IC IC235, analog/basic/cmos_logic.hpp:17
        I(cpphdl_n2895, Vss) <+ 5.0000000000000002e-14 * ddt(V(cpphdl_n2895, Vss)); // Bench initial voltage = 0.0 V.
        // device 1339, IC IC235, analog/basic/cmos_logic.hpp:18
        I(cpphdl_n2895, Vdd) <+ cpphdl_channel(V(cpphdl_n1958, Vdd), V(cpphdl_n2895, Vdd), 0.01, 0.69999999999999996, -1.0);
        // device 1340, IC IC235, analog/basic/cmos_logic.hpp:19
        I(cpphdl_n2895, Vdd) <+ cpphdl_channel(V(cpphdl_n1966, Vdd), V(cpphdl_n2895, Vdd), 0.01, 0.69999999999999996, -1.0);
        // device 1341, IC IC235, analog/basic/cmos_logic.hpp:20
        I(cpphdl_n2895, cpphdl_n1961) <+ cpphdl_channel(V(cpphdl_n1958, cpphdl_n1961), V(cpphdl_n2895, cpphdl_n1961), 0.01, 0.69999999999999996, 1.0);
        // device 1342, IC IC235, analog/basic/cmos_logic.hpp:21
        I(cpphdl_n1961, Vss) <+ cpphdl_channel(V(cpphdl_n1966, Vss), V(cpphdl_n1961, Vss), 0.01, 0.69999999999999996, 1.0);
        // device 1343, IC IC235, analog/basic/cmos_logic.hpp:23
        I(cpphdl_n2895, Vss) <+ V(cpphdl_n2895, Vss) / 1000000000.0;
        // device 1344, IC IC235, analog/basic/cmos_logic.hpp:24
        I(cpphdl_n1961, Vss) <+ V(cpphdl_n1961, Vss) / 1000000000.0;
        // device 1345, IC IC236, analog/basic/cmos_logic.hpp:17
        I(cpphdl_n1966, Vss) <+ 5.0000000000000002e-14 * ddt(V(cpphdl_n1966, Vss)); // Bench initial voltage = 0.0 V.
        // device 1346, IC IC236, analog/basic/cmos_logic.hpp:18
        I(cpphdl_n1966, Vdd) <+ cpphdl_channel(V(cpphdl_n1964, Vdd), V(cpphdl_n1966, Vdd), 0.01, 0.69999999999999996, -1.0);
        // device 1347, IC IC236, analog/basic/cmos_logic.hpp:19
        I(cpphdl_n1966, Vdd) <+ cpphdl_channel(V(cpphdl_n2895, Vdd), V(cpphdl_n1966, Vdd), 0.01, 0.69999999999999996, -1.0);
        // device 1348, IC IC236, analog/basic/cmos_logic.hpp:20
        I(cpphdl_n1966, cpphdl_n1967) <+ cpphdl_channel(V(cpphdl_n1964, cpphdl_n1967), V(cpphdl_n1966, cpphdl_n1967), 0.01, 0.69999999999999996, 1.0);
        // device 1349, IC IC236, analog/basic/cmos_logic.hpp:21
        I(cpphdl_n1967, Vss) <+ cpphdl_channel(V(cpphdl_n2895, Vss), V(cpphdl_n1967, Vss), 0.01, 0.69999999999999996, 1.0);
        // device 1350, IC IC236, analog/basic/cmos_logic.hpp:23
        I(cpphdl_n1966, Vss) <+ V(cpphdl_n1966, Vss) / 1000000000.0;
        // device 1351, IC IC236, analog/basic/cmos_logic.hpp:24
        I(cpphdl_n1967, Vss) <+ V(cpphdl_n1967, Vss) / 1000000000.0;
        // device 1352, IC IC234, analog/basic/nand_latch.hpp:36
        I(cpphdl_n1958, Vss) <+ 2.9999999999999998e-15 * ddt(V(cpphdl_n1958, Vss)); // Bench initial voltage = 0.0 V.
        // device 1353, IC IC234, analog/basic/nand_latch.hpp:37
        I(cpphdl_n1964, Vss) <+ 2.9999999999999998e-15 * ddt(V(cpphdl_n1964, Vss)); // Bench initial voltage = 0.0 V.
        // device 1354, IC IC237, analog/basic/inverter.hpp:11
        I(cpphdl_n1972, Vdd) <+ cpphdl_channel(V(CLEAR, Vdd), V(cpphdl_n1972, Vdd), 0.01, 0.69999999999999996, -1.0);
        // device 1355, IC IC237, analog/basic/inverter.hpp:12
        I(cpphdl_n1972, Vss) <+ cpphdl_channel(V(CLEAR, Vss), V(cpphdl_n1972, Vss), 0.01, 0.69999999999999996, 1.0);
        // device 1356, IC IC234, analog/basic/nand_latch.hpp:58
        I(cpphdl_n1972, Vss) <+ 2.9999999999999998e-15 * ddt(V(cpphdl_n1972, Vss)); // Bench initial voltage = 0.0 V.
        // device 1357, IC IC234, analog/basic/nand_latch.hpp:59
        I(cpphdl_n2895, Vss) <+ cpphdl_channel(V(CLEAR, Vss), V(cpphdl_n2895, Vss), 0.050000000000000003, 0.69999999999999996, 1.0);
        // device 1358, IC IC234, analog/basic/nand_latch.hpp:60
        I(cpphdl_n1966, Vdd) <+ cpphdl_channel(V(cpphdl_n1972, Vdd), V(cpphdl_n1966, Vdd), 0.050000000000000003, 0.69999999999999996, -1.0);
        // device 1359, IC IC240, analog/basic/inverter.hpp:11
        I(cpphdl_n1996, Vdd) <+ cpphdl_channel(V(TRACK10, Vdd), V(cpphdl_n1996, Vdd), 0.0040000000000000001, 0.69999999999999996, -1.0);
        // device 1360, IC IC240, analog/basic/inverter.hpp:12
        I(cpphdl_n1996, Vss) <+ cpphdl_channel(V(TRACK10, Vss), V(cpphdl_n1996, Vss), 0.0040000000000000001, 0.69999999999999996, 1.0);
        // device 1361, IC IC239, analog/basic/mos_track_hold.hpp:31
        I(cpphdl_n1996, Vss) <+ 2e-14 * ddt(V(cpphdl_n1996, Vss)); // Bench initial voltage = 3.2999999999999998 V.
        // device 1362, IC IC239, analog/basic/mos_track_hold.hpp:32
        I(cpphdl_n2705, cpphdl_n2050) <+ cpphdl_channel(V(TRACK10, cpphdl_n2050), V(cpphdl_n2705, cpphdl_n2050), 0.080000000000000002, 0.69999999999999996, 1.0);
        // device 1363, IC IC239, analog/basic/mos_track_hold.hpp:33
        I(cpphdl_n2050, cpphdl_n2705) <+ cpphdl_channel(V(cpphdl_n1996, cpphdl_n2705), V(cpphdl_n2050, cpphdl_n2705), 0.040000000000000001, 0.69999999999999996, -1.0);
        // device 1364, IC IC239, analog/basic/mos_track_hold.hpp:37
        I(cpphdl_n2050, cpphdl_n2050) <+ cpphdl_channel(V(cpphdl_n1996, cpphdl_n2050), V(cpphdl_n2050, cpphdl_n2050), 0.040000000000000001, 0.69999999999999996, 1.0);
        // device 1365, IC IC239, analog/basic/mos_track_hold.hpp:38
        I(cpphdl_n2050, cpphdl_n2050) <+ cpphdl_channel(V(TRACK10, cpphdl_n2050), V(cpphdl_n2050, cpphdl_n2050), 0.02, 0.69999999999999996, -1.0);
        // device 1366, IC IC239, analog/basic/mos_track_hold.hpp:39
        I(cpphdl_n2050, Vss) <+ 2e-12 * ddt(V(cpphdl_n2050, Vss)); // Bench initial voltage = 1.6499999999999999 V.
        // device 1367, IC IC239, analog/basic/mos_track_hold.hpp:41
        I(Vss, cpphdl_n2050) <+ V(Vss, cpphdl_n2050) / 1000000000.0;
        // device 1368, IC IC239, analog/basic/mos_track_hold.hpp:42
        I(TRACK10, cpphdl_n2050) <+ 8.0000000000000006e-15 * ddt(V(TRACK10, cpphdl_n2050)); // Bench initial voltage = -1.6499999999999999 V.
        // device 1369, IC IC239, analog/basic/mos_track_hold.hpp:43
        I(cpphdl_n1996, cpphdl_n2050) <+ 8.0000000000000006e-15 * ddt(V(cpphdl_n1996, cpphdl_n2050)); // Bench initial voltage = 1.6499999999999999 V.
        // device 1370, IC IC239, analog/basic/mos_track_hold.hpp:44
        I(cpphdl_n2705, cpphdl_n2050) <+ 4.0000000000000003e-15 * ddt(V(cpphdl_n2705, cpphdl_n2050)); // Bench initial voltage = 0.0 V.
        // device 1371, IC IC242, analog/basic/inverter.hpp:11
        I(cpphdl_n2011, Vdd) <+ cpphdl_channel(V(BIT_N10_0, Vdd), V(cpphdl_n2011, Vdd), 0.080000000000000002, 0.69999999999999996, -1.0);
        // device 1372, IC IC242, analog/basic/inverter.hpp:12
        I(cpphdl_n2011, Vss) <+ cpphdl_channel(V(BIT_N10_0, Vss), V(cpphdl_n2011, Vss), 0.080000000000000002, 0.69999999999999996, 1.0);
        // device 1373, IC IC241, analog/basic/mos_r2r_dac.hpp:27
        I(cpphdl_n2011, Vss) <+ 2.9999999999999998e-15 * ddt(V(cpphdl_n2011, Vss)); // Bench initial voltage = 0.0 V.
        // device 1374, IC IC241, analog/basic/mos_r2r_dac.hpp:28
        I(cpphdl_n2011, cpphdl_n2040) <+ V(cpphdl_n2011, cpphdl_n2040) / 2000.0;
        // device 1375, IC IC241, analog/basic/mos_r2r_dac.hpp:29
        I(cpphdl_n2040, Vss) <+ 2.9999999999999998e-15 * ddt(V(cpphdl_n2040, Vss)); // Bench initial voltage = 0.0 V.
        // device 1376, IC IC243, analog/basic/inverter.hpp:11
        I(cpphdl_n2015, Vdd) <+ cpphdl_channel(V(BIT_N10_1, Vdd), V(cpphdl_n2015, Vdd), 0.080000000000000002, 0.69999999999999996, -1.0);
        // device 1377, IC IC243, analog/basic/inverter.hpp:12
        I(cpphdl_n2015, Vss) <+ cpphdl_channel(V(BIT_N10_1, Vss), V(cpphdl_n2015, Vss), 0.080000000000000002, 0.69999999999999996, 1.0);
        // device 1378, IC IC241, analog/basic/mos_r2r_dac.hpp:27
        I(cpphdl_n2015, Vss) <+ 2.9999999999999998e-15 * ddt(V(cpphdl_n2015, Vss)); // Bench initial voltage = 0.0 V.
        // device 1379, IC IC241, analog/basic/mos_r2r_dac.hpp:28
        I(cpphdl_n2015, cpphdl_n2041) <+ V(cpphdl_n2015, cpphdl_n2041) / 2000.0;
        // device 1380, IC IC241, analog/basic/mos_r2r_dac.hpp:29
        I(cpphdl_n2041, Vss) <+ 2.9999999999999998e-15 * ddt(V(cpphdl_n2041, Vss)); // Bench initial voltage = 0.0 V.
        // device 1381, IC IC241, analog/basic/mos_r2r_dac.hpp:31
        I(cpphdl_n2040, cpphdl_n2041) <+ V(cpphdl_n2040, cpphdl_n2041) / 1000.0;
        // device 1382, IC IC244, analog/basic/inverter.hpp:11
        I(cpphdl_n2019, Vdd) <+ cpphdl_channel(V(BIT_N10_2, Vdd), V(cpphdl_n2019, Vdd), 0.080000000000000002, 0.69999999999999996, -1.0);
        // device 1383, IC IC244, analog/basic/inverter.hpp:12
        I(cpphdl_n2019, Vss) <+ cpphdl_channel(V(BIT_N10_2, Vss), V(cpphdl_n2019, Vss), 0.080000000000000002, 0.69999999999999996, 1.0);
        // device 1384, IC IC241, analog/basic/mos_r2r_dac.hpp:27
        I(cpphdl_n2019, Vss) <+ 2.9999999999999998e-15 * ddt(V(cpphdl_n2019, Vss)); // Bench initial voltage = 0.0 V.
        // device 1385, IC IC241, analog/basic/mos_r2r_dac.hpp:28
        I(cpphdl_n2019, cpphdl_n2042) <+ V(cpphdl_n2019, cpphdl_n2042) / 2000.0;
        // device 1386, IC IC241, analog/basic/mos_r2r_dac.hpp:29
        I(cpphdl_n2042, Vss) <+ 2.9999999999999998e-15 * ddt(V(cpphdl_n2042, Vss)); // Bench initial voltage = 0.0 V.
        // device 1387, IC IC241, analog/basic/mos_r2r_dac.hpp:31
        I(cpphdl_n2041, cpphdl_n2042) <+ V(cpphdl_n2041, cpphdl_n2042) / 1000.0;
        // device 1388, IC IC245, analog/basic/inverter.hpp:11
        I(cpphdl_n2023, Vdd) <+ cpphdl_channel(V(BIT_N10_3, Vdd), V(cpphdl_n2023, Vdd), 0.080000000000000002, 0.69999999999999996, -1.0);
        // device 1389, IC IC245, analog/basic/inverter.hpp:12
        I(cpphdl_n2023, Vss) <+ cpphdl_channel(V(BIT_N10_3, Vss), V(cpphdl_n2023, Vss), 0.080000000000000002, 0.69999999999999996, 1.0);
        // device 1390, IC IC241, analog/basic/mos_r2r_dac.hpp:27
        I(cpphdl_n2023, Vss) <+ 2.9999999999999998e-15 * ddt(V(cpphdl_n2023, Vss)); // Bench initial voltage = 0.0 V.
        // device 1391, IC IC241, analog/basic/mos_r2r_dac.hpp:28
        I(cpphdl_n2023, cpphdl_n2043) <+ V(cpphdl_n2023, cpphdl_n2043) / 2000.0;
        // device 1392, IC IC241, analog/basic/mos_r2r_dac.hpp:29
        I(cpphdl_n2043, Vss) <+ 2.9999999999999998e-15 * ddt(V(cpphdl_n2043, Vss)); // Bench initial voltage = 0.0 V.
        // device 1393, IC IC241, analog/basic/mos_r2r_dac.hpp:31
        I(cpphdl_n2042, cpphdl_n2043) <+ V(cpphdl_n2042, cpphdl_n2043) / 1000.0;
        // device 1394, IC IC246, analog/basic/inverter.hpp:11
        I(cpphdl_n2027, Vdd) <+ cpphdl_channel(V(BIT_N10_4, Vdd), V(cpphdl_n2027, Vdd), 0.080000000000000002, 0.69999999999999996, -1.0);
        // device 1395, IC IC246, analog/basic/inverter.hpp:12
        I(cpphdl_n2027, Vss) <+ cpphdl_channel(V(BIT_N10_4, Vss), V(cpphdl_n2027, Vss), 0.080000000000000002, 0.69999999999999996, 1.0);
        // device 1396, IC IC241, analog/basic/mos_r2r_dac.hpp:27
        I(cpphdl_n2027, Vss) <+ 2.9999999999999998e-15 * ddt(V(cpphdl_n2027, Vss)); // Bench initial voltage = 0.0 V.
        // device 1397, IC IC241, analog/basic/mos_r2r_dac.hpp:28
        I(cpphdl_n2027, cpphdl_n2044) <+ V(cpphdl_n2027, cpphdl_n2044) / 2000.0;
        // device 1398, IC IC241, analog/basic/mos_r2r_dac.hpp:29
        I(cpphdl_n2044, Vss) <+ 2.9999999999999998e-15 * ddt(V(cpphdl_n2044, Vss)); // Bench initial voltage = 0.0 V.
        // device 1399, IC IC241, analog/basic/mos_r2r_dac.hpp:31
        I(cpphdl_n2043, cpphdl_n2044) <+ V(cpphdl_n2043, cpphdl_n2044) / 1000.0;
        // device 1400, IC IC247, analog/basic/inverter.hpp:11
        I(cpphdl_n2031, Vdd) <+ cpphdl_channel(V(BIT_N10_5, Vdd), V(cpphdl_n2031, Vdd), 0.080000000000000002, 0.69999999999999996, -1.0);
        // device 1401, IC IC247, analog/basic/inverter.hpp:12
        I(cpphdl_n2031, Vss) <+ cpphdl_channel(V(BIT_N10_5, Vss), V(cpphdl_n2031, Vss), 0.080000000000000002, 0.69999999999999996, 1.0);
        // device 1402, IC IC241, analog/basic/mos_r2r_dac.hpp:27
        I(cpphdl_n2031, Vss) <+ 2.9999999999999998e-15 * ddt(V(cpphdl_n2031, Vss)); // Bench initial voltage = 0.0 V.
        // device 1403, IC IC241, analog/basic/mos_r2r_dac.hpp:28
        I(cpphdl_n2031, cpphdl_n2045) <+ V(cpphdl_n2031, cpphdl_n2045) / 2000.0;
        // device 1404, IC IC241, analog/basic/mos_r2r_dac.hpp:29
        I(cpphdl_n2045, Vss) <+ 2.9999999999999998e-15 * ddt(V(cpphdl_n2045, Vss)); // Bench initial voltage = 0.0 V.
        // device 1405, IC IC241, analog/basic/mos_r2r_dac.hpp:31
        I(cpphdl_n2044, cpphdl_n2045) <+ V(cpphdl_n2044, cpphdl_n2045) / 1000.0;
        // device 1406, IC IC248, analog/basic/inverter.hpp:11
        I(cpphdl_n2035, Vdd) <+ cpphdl_channel(V(BIT_N10_6, Vdd), V(cpphdl_n2035, Vdd), 0.080000000000000002, 0.69999999999999996, -1.0);
        // device 1407, IC IC248, analog/basic/inverter.hpp:12
        I(cpphdl_n2035, Vss) <+ cpphdl_channel(V(BIT_N10_6, Vss), V(cpphdl_n2035, Vss), 0.080000000000000002, 0.69999999999999996, 1.0);
        // device 1408, IC IC241, analog/basic/mos_r2r_dac.hpp:27
        I(cpphdl_n2035, Vss) <+ 2.9999999999999998e-15 * ddt(V(cpphdl_n2035, Vss)); // Bench initial voltage = 0.0 V.
        // device 1409, IC IC241, analog/basic/mos_r2r_dac.hpp:28
        I(cpphdl_n2035, cpphdl_n2046) <+ V(cpphdl_n2035, cpphdl_n2046) / 2000.0;
        // device 1410, IC IC241, analog/basic/mos_r2r_dac.hpp:29
        I(cpphdl_n2046, Vss) <+ 2.9999999999999998e-15 * ddt(V(cpphdl_n2046, Vss)); // Bench initial voltage = 0.0 V.
        // device 1411, IC IC241, analog/basic/mos_r2r_dac.hpp:31
        I(cpphdl_n2045, cpphdl_n2046) <+ V(cpphdl_n2045, cpphdl_n2046) / 1000.0;
        // device 1412, IC IC249, analog/basic/inverter.hpp:11
        I(cpphdl_n2039, Vdd) <+ cpphdl_channel(V(BIT_N10_7, Vdd), V(cpphdl_n2039, Vdd), 0.080000000000000002, 0.69999999999999996, -1.0);
        // device 1413, IC IC249, analog/basic/inverter.hpp:12
        I(cpphdl_n2039, Vss) <+ cpphdl_channel(V(BIT_N10_7, Vss), V(cpphdl_n2039, Vss), 0.080000000000000002, 0.69999999999999996, 1.0);
        // device 1414, IC IC241, analog/basic/mos_r2r_dac.hpp:27
        I(cpphdl_n2039, Vss) <+ 2.9999999999999998e-15 * ddt(V(cpphdl_n2039, Vss)); // Bench initial voltage = 0.0 V.
        // device 1415, IC IC241, analog/basic/mos_r2r_dac.hpp:28
        I(cpphdl_n2039, cpphdl_n2051) <+ V(cpphdl_n2039, cpphdl_n2051) / 2000.0;
        // device 1416, IC IC241, analog/basic/mos_r2r_dac.hpp:29
        I(cpphdl_n2051, Vss) <+ 2.9999999999999998e-15 * ddt(V(cpphdl_n2051, Vss)); // Bench initial voltage = 0.0 V.
        // device 1417, IC IC241, analog/basic/mos_r2r_dac.hpp:31
        I(cpphdl_n2046, cpphdl_n2051) <+ V(cpphdl_n2046, cpphdl_n2051) / 1000.0;
        // device 1418, IC IC241, analog/basic/mos_r2r_dac.hpp:33
        I(Vss, cpphdl_n2040) <+ V(Vss, cpphdl_n2040) / 2000.0;
        // device 1419, IC IC250, analog/basic/nmos_resistor_amplifier.hpp:23
        I(Vdd, cpphdl_n2060) <+ V(Vdd, cpphdl_n2060) / 1000.0;
        // device 1420, IC IC250, analog/basic/nmos_resistor_amplifier.hpp:24
        I(Vdd, cpphdl_n2059) <+ V(Vdd, cpphdl_n2059) / 1000.0;
        // device 1421, IC IC250, analog/basic/nmos_resistor_amplifier.hpp:25
        I(cpphdl_n2060, cpphdl_n2054) <+ cpphdl_channel(V(cpphdl_n2050, cpphdl_n2054), V(cpphdl_n2060, cpphdl_n2054), 0.014999999999999999, 0.69999999999999996, 1.0);
        // device 1422, IC IC250, analog/basic/nmos_resistor_amplifier.hpp:26
        I(cpphdl_n2059, cpphdl_n2055) <+ cpphdl_channel(V(cpphdl_n2051, cpphdl_n2055), V(cpphdl_n2059, cpphdl_n2055), 0.014999999999999999, 0.69999999999999996, 1.0);
        // device 1423, IC IC250, analog/basic/nmos_resistor_amplifier.hpp:27
        I(cpphdl_n2056, cpphdl_n2054) <+ V(cpphdl_n2056, cpphdl_n2054) / 50.0;
        // device 1424, IC IC250, analog/basic/nmos_resistor_amplifier.hpp:28
        I(cpphdl_n2056, cpphdl_n2055) <+ V(cpphdl_n2056, cpphdl_n2055) / 50.0;
        // device 1425, IC IC250, analog/basic/nmos_resistor_amplifier.hpp:29
        I(Vss, cpphdl_n2056) <+ V(Vss, cpphdl_n2056) / 150.0;
        // device 1426, IC IC250, analog/basic/nmos_resistor_amplifier.hpp:30
        I(cpphdl_n2060, Vdd) <+ 2.9999999999999998e-13 * ddt(V(cpphdl_n2060, Vdd)); // Bench initial voltage = 0.0 V.
        // device 1427, IC IC250, analog/basic/nmos_resistor_amplifier.hpp:31
        I(cpphdl_n2059, Vdd) <+ 2.9999999999999998e-13 * ddt(V(cpphdl_n2059, Vdd)); // Bench initial voltage = 0.0 V.
        // device 1428, IC IC250, analog/basic/nmos_resistor_amplifier.hpp:32
        I(cpphdl_n2056, Vss) <+ 4e-14 * ddt(V(cpphdl_n2056, Vss)); // Bench initial voltage = 0.0 V.
        // device 1429, IC IC250, analog/basic/nmos_resistor_amplifier.hpp:34
        I(cpphdl_n2050, cpphdl_n2054) <+ 2e-14 * ddt(V(cpphdl_n2050, cpphdl_n2054)); // Bench initial voltage = 1.6499999999999999 V.
        // device 1430, IC IC250, analog/basic/nmos_resistor_amplifier.hpp:35
        I(cpphdl_n2051, cpphdl_n2055) <+ 2e-14 * ddt(V(cpphdl_n2051, cpphdl_n2055)); // Bench initial voltage = 0.0 V.
        // device 1431, IC IC250, analog/basic/nmos_resistor_amplifier.hpp:36
        I(cpphdl_n2050, cpphdl_n2060) <+ 2.9999999999999998e-15 * ddt(V(cpphdl_n2050, cpphdl_n2060)); // Bench initial voltage = -1.6499999999999999 V.
        // device 1432, IC IC250, analog/basic/nmos_resistor_amplifier.hpp:37
        I(cpphdl_n2051, cpphdl_n2059) <+ 2.9999999999999998e-15 * ddt(V(cpphdl_n2051, cpphdl_n2059)); // Bench initial voltage = -3.2999999999999998 V.
        // device 1433, IC IC251, analog/basic/strongarm_comparator.hpp:28
        I(cpphdl_n2064, cpphdl_n2066) <+ cpphdl_channel(V(cpphdl_n2059, cpphdl_n2066), V(cpphdl_n2064, cpphdl_n2066), 0.0080000000000000002, 0.69999999999999996, 1.0);
        // device 1434, IC IC251, analog/basic/strongarm_comparator.hpp:29
        I(cpphdl_n2065, cpphdl_n2066) <+ cpphdl_channel(V(cpphdl_n2060, cpphdl_n2066), V(cpphdl_n2065, cpphdl_n2066), 0.0080000000000000002, 0.69999999999999996, 1.0);
        // device 1435, IC IC251, analog/basic/strongarm_comparator.hpp:30
        I(cpphdl_n2066, Vss) <+ cpphdl_channel(V(EVALUATE, Vss), V(cpphdl_n2066, Vss), 0.0080000000000000002, 0.69999999999999996, 1.0);
        // device 1436, IC IC251, analog/basic/strongarm_comparator.hpp:33
        I(cpphdl_n2079, cpphdl_n2064) <+ cpphdl_channel(V(cpphdl_n2083, cpphdl_n2064), V(cpphdl_n2079, cpphdl_n2064), 0.0040000000000000001, 0.69999999999999996, 1.0);
        // device 1437, IC IC251, analog/basic/strongarm_comparator.hpp:34
        I(cpphdl_n2083, cpphdl_n2065) <+ cpphdl_channel(V(cpphdl_n2079, cpphdl_n2065), V(cpphdl_n2083, cpphdl_n2065), 0.0040000000000000001, 0.69999999999999996, 1.0);
        // device 1438, IC IC251, analog/basic/strongarm_comparator.hpp:35
        I(cpphdl_n2083, Vdd) <+ cpphdl_channel(V(cpphdl_n2079, Vdd), V(cpphdl_n2083, Vdd), 0.002, 0.69999999999999996, -1.0);
        // device 1439, IC IC251, analog/basic/strongarm_comparator.hpp:36
        I(cpphdl_n2079, Vdd) <+ cpphdl_channel(V(cpphdl_n2083, Vdd), V(cpphdl_n2079, Vdd), 0.002, 0.69999999999999996, -1.0);
        // device 1440, IC IC251, analog/basic/strongarm_comparator.hpp:38
        I(cpphdl_n2064, Vdd) <+ cpphdl_channel(V(EVALUATE, Vdd), V(cpphdl_n2064, Vdd), 0.002, 0.69999999999999996, -1.0);
        // device 1441, IC IC251, analog/basic/strongarm_comparator.hpp:39
        I(cpphdl_n2065, Vdd) <+ cpphdl_channel(V(EVALUATE, Vdd), V(cpphdl_n2065, Vdd), 0.002, 0.69999999999999996, -1.0);
        // device 1442, IC IC251, analog/basic/strongarm_comparator.hpp:40
        I(cpphdl_n2083, Vdd) <+ cpphdl_channel(V(EVALUATE, Vdd), V(cpphdl_n2083, Vdd), 0.002, 0.69999999999999996, -1.0);
        // device 1443, IC IC251, analog/basic/strongarm_comparator.hpp:41
        I(cpphdl_n2079, Vdd) <+ cpphdl_channel(V(EVALUATE, Vdd), V(cpphdl_n2079, Vdd), 0.002, 0.69999999999999996, -1.0);
        // device 1444, IC IC251, analog/basic/strongarm_comparator.hpp:42
        I(cpphdl_n2064, Vss) <+ 2.9999999999999998e-14 * ddt(V(cpphdl_n2064, Vss)); // Bench initial voltage = 0.0 V.
        // device 1445, IC IC251, analog/basic/strongarm_comparator.hpp:43
        I(cpphdl_n2065, Vss) <+ 2.9999999999999998e-14 * ddt(V(cpphdl_n2065, Vss)); // Bench initial voltage = 0.0 V.
        // device 1446, IC IC251, analog/basic/strongarm_comparator.hpp:44
        I(cpphdl_n2066, Vss) <+ 2.9999999999999998e-14 * ddt(V(cpphdl_n2066, Vss)); // Bench initial voltage = 0.0 V.
        // device 1447, IC IC251, analog/basic/strongarm_comparator.hpp:45
        I(cpphdl_n2083, Vss) <+ 5.0000000000000002e-14 * ddt(V(cpphdl_n2083, Vss)); // Bench initial voltage = 0.0 V.
        // device 1448, IC IC251, analog/basic/strongarm_comparator.hpp:46
        I(cpphdl_n2079, Vss) <+ 5.0000000000000002e-14 * ddt(V(cpphdl_n2079, Vss)); // Bench initial voltage = 0.0 V.
        // device 1449, IC IC251, analog/basic/strongarm_comparator.hpp:47
        I(cpphdl_n2059, cpphdl_n2066) <+ 2e-14 * ddt(V(cpphdl_n2059, cpphdl_n2066)); // Bench initial voltage = 3.2999999999999998 V.
        // device 1450, IC IC251, analog/basic/strongarm_comparator.hpp:48
        I(cpphdl_n2060, cpphdl_n2066) <+ 2e-14 * ddt(V(cpphdl_n2060, cpphdl_n2066)); // Bench initial voltage = 3.2999999999999998 V.
        // device 1451, IC IC251, analog/basic/strongarm_comparator.hpp:49
        I(cpphdl_n2059, cpphdl_n2064) <+ 2.9999999999999998e-15 * ddt(V(cpphdl_n2059, cpphdl_n2064)); // Bench initial voltage = 3.2999999999999998 V.
        // device 1452, IC IC251, analog/basic/strongarm_comparator.hpp:50
        I(cpphdl_n2060, cpphdl_n2065) <+ 2.9999999999999998e-15 * ddt(V(cpphdl_n2060, cpphdl_n2065)); // Bench initial voltage = 3.2999999999999998 V.
        // device 1453, IC IC253, analog/basic/inverter.hpp:11
        I(cpphdl_n2087, Vdd) <+ cpphdl_channel(V(cpphdl_n2079, Vdd), V(cpphdl_n2087, Vdd), 0.001, 0.69999999999999996, -1.0);
        // device 1454, IC IC253, analog/basic/inverter.hpp:12
        I(cpphdl_n2087, Vss) <+ cpphdl_channel(V(cpphdl_n2079, Vss), V(cpphdl_n2087, Vss), 0.001, 0.69999999999999996, 1.0);
        // device 1455, IC IC255, analog/basic/inverter.hpp:11
        I(cpphdl_n2101, Vdd) <+ cpphdl_channel(V(cpphdl_n2087, Vdd), V(cpphdl_n2101, Vdd), 0.0040000000000000001, 0.69999999999999996, -1.0);
        // device 1456, IC IC255, analog/basic/inverter.hpp:12
        I(cpphdl_n2101, Vss) <+ cpphdl_channel(V(cpphdl_n2087, Vss), V(cpphdl_n2101, Vss), 0.0040000000000000001, 0.69999999999999996, 1.0);
        // device 1457, IC IC252, analog/basic/buffered_nand_latch.hpp:34
        I(cpphdl_n2079, Vss) <+ 2.0000000000000002e-15 * ddt(V(cpphdl_n2079, Vss)); // Bench initial voltage = 0.0 V.
        // device 1458, IC IC252, analog/basic/buffered_nand_latch.hpp:35
        I(cpphdl_n2079, cpphdl_n2087) <+ 1.0000000000000001e-15 * ddt(V(cpphdl_n2079, cpphdl_n2087)); // Bench initial voltage = 0.0 V.
        // device 1459, IC IC252, analog/basic/buffered_nand_latch.hpp:36
        I(cpphdl_n2087, Vss) <+ 5e-15 * ddt(V(cpphdl_n2087, Vss)); // Bench initial voltage = 0.0 V.
        // device 1460, IC IC252, analog/basic/buffered_nand_latch.hpp:37
        I(cpphdl_n2087, Vss) <+ 8.0000000000000006e-15 * ddt(V(cpphdl_n2087, Vss)); // Bench initial voltage = 0.0 V.
        // device 1461, IC IC252, analog/basic/buffered_nand_latch.hpp:38
        I(cpphdl_n2101, Vss) <+ 1e-14 * ddt(V(cpphdl_n2101, Vss)); // Bench initial voltage = 0.0 V.
        // device 1462, IC IC254, analog/basic/inverter.hpp:11
        I(cpphdl_n2091, Vdd) <+ cpphdl_channel(V(cpphdl_n2083, Vdd), V(cpphdl_n2091, Vdd), 0.001, 0.69999999999999996, -1.0);
        // device 1463, IC IC254, analog/basic/inverter.hpp:12
        I(cpphdl_n2091, Vss) <+ cpphdl_channel(V(cpphdl_n2083, Vss), V(cpphdl_n2091, Vss), 0.001, 0.69999999999999996, 1.0);
        // device 1464, IC IC256, analog/basic/inverter.hpp:11
        I(cpphdl_n2107, Vdd) <+ cpphdl_channel(V(cpphdl_n2091, Vdd), V(cpphdl_n2107, Vdd), 0.0040000000000000001, 0.69999999999999996, -1.0);
        // device 1465, IC IC256, analog/basic/inverter.hpp:12
        I(cpphdl_n2107, Vss) <+ cpphdl_channel(V(cpphdl_n2091, Vss), V(cpphdl_n2107, Vss), 0.0040000000000000001, 0.69999999999999996, 1.0);
        // device 1466, IC IC252, analog/basic/buffered_nand_latch.hpp:34
        I(cpphdl_n2083, Vss) <+ 2.0000000000000002e-15 * ddt(V(cpphdl_n2083, Vss)); // Bench initial voltage = 0.0 V.
        // device 1467, IC IC252, analog/basic/buffered_nand_latch.hpp:35
        I(cpphdl_n2083, cpphdl_n2091) <+ 1.0000000000000001e-15 * ddt(V(cpphdl_n2083, cpphdl_n2091)); // Bench initial voltage = 0.0 V.
        // device 1468, IC IC252, analog/basic/buffered_nand_latch.hpp:36
        I(cpphdl_n2091, Vss) <+ 5e-15 * ddt(V(cpphdl_n2091, Vss)); // Bench initial voltage = 0.0 V.
        // device 1469, IC IC252, analog/basic/buffered_nand_latch.hpp:37
        I(cpphdl_n2091, Vss) <+ 8.0000000000000006e-15 * ddt(V(cpphdl_n2091, Vss)); // Bench initial voltage = 0.0 V.
        // device 1470, IC IC252, analog/basic/buffered_nand_latch.hpp:38
        I(cpphdl_n2107, Vss) <+ 1e-14 * ddt(V(cpphdl_n2107, Vss)); // Bench initial voltage = 0.0 V.
        // device 1471, IC IC258, analog/basic/cmos_logic.hpp:17
        I(cpphdl_n2900, Vss) <+ 5.0000000000000002e-14 * ddt(V(cpphdl_n2900, Vss)); // Bench initial voltage = 0.0 V.
        // device 1472, IC IC258, analog/basic/cmos_logic.hpp:18
        I(cpphdl_n2900, Vdd) <+ cpphdl_channel(V(cpphdl_n2101, Vdd), V(cpphdl_n2900, Vdd), 0.01, 0.69999999999999996, -1.0);
        // device 1473, IC IC258, analog/basic/cmos_logic.hpp:19
        I(cpphdl_n2900, Vdd) <+ cpphdl_channel(V(cpphdl_n2109, Vdd), V(cpphdl_n2900, Vdd), 0.01, 0.69999999999999996, -1.0);
        // device 1474, IC IC258, analog/basic/cmos_logic.hpp:20
        I(cpphdl_n2900, cpphdl_n2104) <+ cpphdl_channel(V(cpphdl_n2101, cpphdl_n2104), V(cpphdl_n2900, cpphdl_n2104), 0.01, 0.69999999999999996, 1.0);
        // device 1475, IC IC258, analog/basic/cmos_logic.hpp:21
        I(cpphdl_n2104, Vss) <+ cpphdl_channel(V(cpphdl_n2109, Vss), V(cpphdl_n2104, Vss), 0.01, 0.69999999999999996, 1.0);
        // device 1476, IC IC258, analog/basic/cmos_logic.hpp:23
        I(cpphdl_n2900, Vss) <+ V(cpphdl_n2900, Vss) / 1000000000.0;
        // device 1477, IC IC258, analog/basic/cmos_logic.hpp:24
        I(cpphdl_n2104, Vss) <+ V(cpphdl_n2104, Vss) / 1000000000.0;
        // device 1478, IC IC259, analog/basic/cmos_logic.hpp:17
        I(cpphdl_n2109, Vss) <+ 5.0000000000000002e-14 * ddt(V(cpphdl_n2109, Vss)); // Bench initial voltage = 0.0 V.
        // device 1479, IC IC259, analog/basic/cmos_logic.hpp:18
        I(cpphdl_n2109, Vdd) <+ cpphdl_channel(V(cpphdl_n2107, Vdd), V(cpphdl_n2109, Vdd), 0.01, 0.69999999999999996, -1.0);
        // device 1480, IC IC259, analog/basic/cmos_logic.hpp:19
        I(cpphdl_n2109, Vdd) <+ cpphdl_channel(V(cpphdl_n2900, Vdd), V(cpphdl_n2109, Vdd), 0.01, 0.69999999999999996, -1.0);
        // device 1481, IC IC259, analog/basic/cmos_logic.hpp:20
        I(cpphdl_n2109, cpphdl_n2110) <+ cpphdl_channel(V(cpphdl_n2107, cpphdl_n2110), V(cpphdl_n2109, cpphdl_n2110), 0.01, 0.69999999999999996, 1.0);
        // device 1482, IC IC259, analog/basic/cmos_logic.hpp:21
        I(cpphdl_n2110, Vss) <+ cpphdl_channel(V(cpphdl_n2900, Vss), V(cpphdl_n2110, Vss), 0.01, 0.69999999999999996, 1.0);
        // device 1483, IC IC259, analog/basic/cmos_logic.hpp:23
        I(cpphdl_n2109, Vss) <+ V(cpphdl_n2109, Vss) / 1000000000.0;
        // device 1484, IC IC259, analog/basic/cmos_logic.hpp:24
        I(cpphdl_n2110, Vss) <+ V(cpphdl_n2110, Vss) / 1000000000.0;
        // device 1485, IC IC257, analog/basic/nand_latch.hpp:36
        I(cpphdl_n2101, Vss) <+ 2.9999999999999998e-15 * ddt(V(cpphdl_n2101, Vss)); // Bench initial voltage = 0.0 V.
        // device 1486, IC IC257, analog/basic/nand_latch.hpp:37
        I(cpphdl_n2107, Vss) <+ 2.9999999999999998e-15 * ddt(V(cpphdl_n2107, Vss)); // Bench initial voltage = 0.0 V.
        // device 1487, IC IC260, analog/basic/inverter.hpp:11
        I(cpphdl_n2115, Vdd) <+ cpphdl_channel(V(CLEAR, Vdd), V(cpphdl_n2115, Vdd), 0.01, 0.69999999999999996, -1.0);
        // device 1488, IC IC260, analog/basic/inverter.hpp:12
        I(cpphdl_n2115, Vss) <+ cpphdl_channel(V(CLEAR, Vss), V(cpphdl_n2115, Vss), 0.01, 0.69999999999999996, 1.0);
        // device 1489, IC IC257, analog/basic/nand_latch.hpp:58
        I(cpphdl_n2115, Vss) <+ 2.9999999999999998e-15 * ddt(V(cpphdl_n2115, Vss)); // Bench initial voltage = 0.0 V.
        // device 1490, IC IC257, analog/basic/nand_latch.hpp:59
        I(cpphdl_n2900, Vss) <+ cpphdl_channel(V(CLEAR, Vss), V(cpphdl_n2900, Vss), 0.050000000000000003, 0.69999999999999996, 1.0);
        // device 1491, IC IC257, analog/basic/nand_latch.hpp:60
        I(cpphdl_n2109, Vdd) <+ cpphdl_channel(V(cpphdl_n2115, Vdd), V(cpphdl_n2109, Vdd), 0.050000000000000003, 0.69999999999999996, -1.0);
        // device 1492, IC IC263, analog/basic/inverter.hpp:11
        I(cpphdl_n2139, Vdd) <+ cpphdl_channel(V(TRACK11, Vdd), V(cpphdl_n2139, Vdd), 0.0040000000000000001, 0.69999999999999996, -1.0);
        // device 1493, IC IC263, analog/basic/inverter.hpp:12
        I(cpphdl_n2139, Vss) <+ cpphdl_channel(V(TRACK11, Vss), V(cpphdl_n2139, Vss), 0.0040000000000000001, 0.69999999999999996, 1.0);
        // device 1494, IC IC262, analog/basic/mos_track_hold.hpp:31
        I(cpphdl_n2139, Vss) <+ 2e-14 * ddt(V(cpphdl_n2139, Vss)); // Bench initial voltage = 3.2999999999999998 V.
        // device 1495, IC IC262, analog/basic/mos_track_hold.hpp:32
        I(cpphdl_n2705, cpphdl_n2193) <+ cpphdl_channel(V(TRACK11, cpphdl_n2193), V(cpphdl_n2705, cpphdl_n2193), 0.080000000000000002, 0.69999999999999996, 1.0);
        // device 1496, IC IC262, analog/basic/mos_track_hold.hpp:33
        I(cpphdl_n2193, cpphdl_n2705) <+ cpphdl_channel(V(cpphdl_n2139, cpphdl_n2705), V(cpphdl_n2193, cpphdl_n2705), 0.040000000000000001, 0.69999999999999996, -1.0);
        // device 1497, IC IC262, analog/basic/mos_track_hold.hpp:37
        I(cpphdl_n2193, cpphdl_n2193) <+ cpphdl_channel(V(cpphdl_n2139, cpphdl_n2193), V(cpphdl_n2193, cpphdl_n2193), 0.040000000000000001, 0.69999999999999996, 1.0);
        // device 1498, IC IC262, analog/basic/mos_track_hold.hpp:38
        I(cpphdl_n2193, cpphdl_n2193) <+ cpphdl_channel(V(TRACK11, cpphdl_n2193), V(cpphdl_n2193, cpphdl_n2193), 0.02, 0.69999999999999996, -1.0);
        // device 1499, IC IC262, analog/basic/mos_track_hold.hpp:39
        I(cpphdl_n2193, Vss) <+ 2e-12 * ddt(V(cpphdl_n2193, Vss)); // Bench initial voltage = 1.6499999999999999 V.
        // device 1500, IC IC262, analog/basic/mos_track_hold.hpp:41
        I(Vss, cpphdl_n2193) <+ V(Vss, cpphdl_n2193) / 1000000000.0;
        // device 1501, IC IC262, analog/basic/mos_track_hold.hpp:42
        I(TRACK11, cpphdl_n2193) <+ 8.0000000000000006e-15 * ddt(V(TRACK11, cpphdl_n2193)); // Bench initial voltage = -1.6499999999999999 V.
        // device 1502, IC IC262, analog/basic/mos_track_hold.hpp:43
        I(cpphdl_n2139, cpphdl_n2193) <+ 8.0000000000000006e-15 * ddt(V(cpphdl_n2139, cpphdl_n2193)); // Bench initial voltage = 1.6499999999999999 V.
        // device 1503, IC IC262, analog/basic/mos_track_hold.hpp:44
        I(cpphdl_n2705, cpphdl_n2193) <+ 4.0000000000000003e-15 * ddt(V(cpphdl_n2705, cpphdl_n2193)); // Bench initial voltage = 0.0 V.
        // device 1504, IC IC265, analog/basic/inverter.hpp:11
        I(cpphdl_n2154, Vdd) <+ cpphdl_channel(V(BIT_N11_0, Vdd), V(cpphdl_n2154, Vdd), 0.080000000000000002, 0.69999999999999996, -1.0);
        // device 1505, IC IC265, analog/basic/inverter.hpp:12
        I(cpphdl_n2154, Vss) <+ cpphdl_channel(V(BIT_N11_0, Vss), V(cpphdl_n2154, Vss), 0.080000000000000002, 0.69999999999999996, 1.0);
        // device 1506, IC IC264, analog/basic/mos_r2r_dac.hpp:27
        I(cpphdl_n2154, Vss) <+ 2.9999999999999998e-15 * ddt(V(cpphdl_n2154, Vss)); // Bench initial voltage = 0.0 V.
        // device 1507, IC IC264, analog/basic/mos_r2r_dac.hpp:28
        I(cpphdl_n2154, cpphdl_n2183) <+ V(cpphdl_n2154, cpphdl_n2183) / 2000.0;
        // device 1508, IC IC264, analog/basic/mos_r2r_dac.hpp:29
        I(cpphdl_n2183, Vss) <+ 2.9999999999999998e-15 * ddt(V(cpphdl_n2183, Vss)); // Bench initial voltage = 0.0 V.
        // device 1509, IC IC266, analog/basic/inverter.hpp:11
        I(cpphdl_n2158, Vdd) <+ cpphdl_channel(V(BIT_N11_1, Vdd), V(cpphdl_n2158, Vdd), 0.080000000000000002, 0.69999999999999996, -1.0);
        // device 1510, IC IC266, analog/basic/inverter.hpp:12
        I(cpphdl_n2158, Vss) <+ cpphdl_channel(V(BIT_N11_1, Vss), V(cpphdl_n2158, Vss), 0.080000000000000002, 0.69999999999999996, 1.0);
        // device 1511, IC IC264, analog/basic/mos_r2r_dac.hpp:27
        I(cpphdl_n2158, Vss) <+ 2.9999999999999998e-15 * ddt(V(cpphdl_n2158, Vss)); // Bench initial voltage = 0.0 V.
        // device 1512, IC IC264, analog/basic/mos_r2r_dac.hpp:28
        I(cpphdl_n2158, cpphdl_n2184) <+ V(cpphdl_n2158, cpphdl_n2184) / 2000.0;
        // device 1513, IC IC264, analog/basic/mos_r2r_dac.hpp:29
        I(cpphdl_n2184, Vss) <+ 2.9999999999999998e-15 * ddt(V(cpphdl_n2184, Vss)); // Bench initial voltage = 0.0 V.
        // device 1514, IC IC264, analog/basic/mos_r2r_dac.hpp:31
        I(cpphdl_n2183, cpphdl_n2184) <+ V(cpphdl_n2183, cpphdl_n2184) / 1000.0;
        // device 1515, IC IC267, analog/basic/inverter.hpp:11
        I(cpphdl_n2162, Vdd) <+ cpphdl_channel(V(BIT_N11_2, Vdd), V(cpphdl_n2162, Vdd), 0.080000000000000002, 0.69999999999999996, -1.0);
        // device 1516, IC IC267, analog/basic/inverter.hpp:12
        I(cpphdl_n2162, Vss) <+ cpphdl_channel(V(BIT_N11_2, Vss), V(cpphdl_n2162, Vss), 0.080000000000000002, 0.69999999999999996, 1.0);
        // device 1517, IC IC264, analog/basic/mos_r2r_dac.hpp:27
        I(cpphdl_n2162, Vss) <+ 2.9999999999999998e-15 * ddt(V(cpphdl_n2162, Vss)); // Bench initial voltage = 0.0 V.
        // device 1518, IC IC264, analog/basic/mos_r2r_dac.hpp:28
        I(cpphdl_n2162, cpphdl_n2185) <+ V(cpphdl_n2162, cpphdl_n2185) / 2000.0;
        // device 1519, IC IC264, analog/basic/mos_r2r_dac.hpp:29
        I(cpphdl_n2185, Vss) <+ 2.9999999999999998e-15 * ddt(V(cpphdl_n2185, Vss)); // Bench initial voltage = 0.0 V.
        // device 1520, IC IC264, analog/basic/mos_r2r_dac.hpp:31
        I(cpphdl_n2184, cpphdl_n2185) <+ V(cpphdl_n2184, cpphdl_n2185) / 1000.0;
        // device 1521, IC IC268, analog/basic/inverter.hpp:11
        I(cpphdl_n2166, Vdd) <+ cpphdl_channel(V(BIT_N11_3, Vdd), V(cpphdl_n2166, Vdd), 0.080000000000000002, 0.69999999999999996, -1.0);
        // device 1522, IC IC268, analog/basic/inverter.hpp:12
        I(cpphdl_n2166, Vss) <+ cpphdl_channel(V(BIT_N11_3, Vss), V(cpphdl_n2166, Vss), 0.080000000000000002, 0.69999999999999996, 1.0);
        // device 1523, IC IC264, analog/basic/mos_r2r_dac.hpp:27
        I(cpphdl_n2166, Vss) <+ 2.9999999999999998e-15 * ddt(V(cpphdl_n2166, Vss)); // Bench initial voltage = 0.0 V.
        // device 1524, IC IC264, analog/basic/mos_r2r_dac.hpp:28
        I(cpphdl_n2166, cpphdl_n2186) <+ V(cpphdl_n2166, cpphdl_n2186) / 2000.0;
        // device 1525, IC IC264, analog/basic/mos_r2r_dac.hpp:29
        I(cpphdl_n2186, Vss) <+ 2.9999999999999998e-15 * ddt(V(cpphdl_n2186, Vss)); // Bench initial voltage = 0.0 V.
        // device 1526, IC IC264, analog/basic/mos_r2r_dac.hpp:31
        I(cpphdl_n2185, cpphdl_n2186) <+ V(cpphdl_n2185, cpphdl_n2186) / 1000.0;
        // device 1527, IC IC269, analog/basic/inverter.hpp:11
        I(cpphdl_n2170, Vdd) <+ cpphdl_channel(V(BIT_N11_4, Vdd), V(cpphdl_n2170, Vdd), 0.080000000000000002, 0.69999999999999996, -1.0);
        // device 1528, IC IC269, analog/basic/inverter.hpp:12
        I(cpphdl_n2170, Vss) <+ cpphdl_channel(V(BIT_N11_4, Vss), V(cpphdl_n2170, Vss), 0.080000000000000002, 0.69999999999999996, 1.0);
        // device 1529, IC IC264, analog/basic/mos_r2r_dac.hpp:27
        I(cpphdl_n2170, Vss) <+ 2.9999999999999998e-15 * ddt(V(cpphdl_n2170, Vss)); // Bench initial voltage = 0.0 V.
        // device 1530, IC IC264, analog/basic/mos_r2r_dac.hpp:28
        I(cpphdl_n2170, cpphdl_n2187) <+ V(cpphdl_n2170, cpphdl_n2187) / 2000.0;
        // device 1531, IC IC264, analog/basic/mos_r2r_dac.hpp:29
        I(cpphdl_n2187, Vss) <+ 2.9999999999999998e-15 * ddt(V(cpphdl_n2187, Vss)); // Bench initial voltage = 0.0 V.
        // device 1532, IC IC264, analog/basic/mos_r2r_dac.hpp:31
        I(cpphdl_n2186, cpphdl_n2187) <+ V(cpphdl_n2186, cpphdl_n2187) / 1000.0;
        // device 1533, IC IC270, analog/basic/inverter.hpp:11
        I(cpphdl_n2174, Vdd) <+ cpphdl_channel(V(BIT_N11_5, Vdd), V(cpphdl_n2174, Vdd), 0.080000000000000002, 0.69999999999999996, -1.0);
        // device 1534, IC IC270, analog/basic/inverter.hpp:12
        I(cpphdl_n2174, Vss) <+ cpphdl_channel(V(BIT_N11_5, Vss), V(cpphdl_n2174, Vss), 0.080000000000000002, 0.69999999999999996, 1.0);
        // device 1535, IC IC264, analog/basic/mos_r2r_dac.hpp:27
        I(cpphdl_n2174, Vss) <+ 2.9999999999999998e-15 * ddt(V(cpphdl_n2174, Vss)); // Bench initial voltage = 0.0 V.
        // device 1536, IC IC264, analog/basic/mos_r2r_dac.hpp:28
        I(cpphdl_n2174, cpphdl_n2188) <+ V(cpphdl_n2174, cpphdl_n2188) / 2000.0;
        // device 1537, IC IC264, analog/basic/mos_r2r_dac.hpp:29
        I(cpphdl_n2188, Vss) <+ 2.9999999999999998e-15 * ddt(V(cpphdl_n2188, Vss)); // Bench initial voltage = 0.0 V.
        // device 1538, IC IC264, analog/basic/mos_r2r_dac.hpp:31
        I(cpphdl_n2187, cpphdl_n2188) <+ V(cpphdl_n2187, cpphdl_n2188) / 1000.0;
        // device 1539, IC IC271, analog/basic/inverter.hpp:11
        I(cpphdl_n2178, Vdd) <+ cpphdl_channel(V(BIT_N11_6, Vdd), V(cpphdl_n2178, Vdd), 0.080000000000000002, 0.69999999999999996, -1.0);
        // device 1540, IC IC271, analog/basic/inverter.hpp:12
        I(cpphdl_n2178, Vss) <+ cpphdl_channel(V(BIT_N11_6, Vss), V(cpphdl_n2178, Vss), 0.080000000000000002, 0.69999999999999996, 1.0);
        // device 1541, IC IC264, analog/basic/mos_r2r_dac.hpp:27
        I(cpphdl_n2178, Vss) <+ 2.9999999999999998e-15 * ddt(V(cpphdl_n2178, Vss)); // Bench initial voltage = 0.0 V.
        // device 1542, IC IC264, analog/basic/mos_r2r_dac.hpp:28
        I(cpphdl_n2178, cpphdl_n2189) <+ V(cpphdl_n2178, cpphdl_n2189) / 2000.0;
        // device 1543, IC IC264, analog/basic/mos_r2r_dac.hpp:29
        I(cpphdl_n2189, Vss) <+ 2.9999999999999998e-15 * ddt(V(cpphdl_n2189, Vss)); // Bench initial voltage = 0.0 V.
        // device 1544, IC IC264, analog/basic/mos_r2r_dac.hpp:31
        I(cpphdl_n2188, cpphdl_n2189) <+ V(cpphdl_n2188, cpphdl_n2189) / 1000.0;
        // device 1545, IC IC272, analog/basic/inverter.hpp:11
        I(cpphdl_n2182, Vdd) <+ cpphdl_channel(V(BIT_N11_7, Vdd), V(cpphdl_n2182, Vdd), 0.080000000000000002, 0.69999999999999996, -1.0);
        // device 1546, IC IC272, analog/basic/inverter.hpp:12
        I(cpphdl_n2182, Vss) <+ cpphdl_channel(V(BIT_N11_7, Vss), V(cpphdl_n2182, Vss), 0.080000000000000002, 0.69999999999999996, 1.0);
        // device 1547, IC IC264, analog/basic/mos_r2r_dac.hpp:27
        I(cpphdl_n2182, Vss) <+ 2.9999999999999998e-15 * ddt(V(cpphdl_n2182, Vss)); // Bench initial voltage = 0.0 V.
        // device 1548, IC IC264, analog/basic/mos_r2r_dac.hpp:28
        I(cpphdl_n2182, cpphdl_n2194) <+ V(cpphdl_n2182, cpphdl_n2194) / 2000.0;
        // device 1549, IC IC264, analog/basic/mos_r2r_dac.hpp:29
        I(cpphdl_n2194, Vss) <+ 2.9999999999999998e-15 * ddt(V(cpphdl_n2194, Vss)); // Bench initial voltage = 0.0 V.
        // device 1550, IC IC264, analog/basic/mos_r2r_dac.hpp:31
        I(cpphdl_n2189, cpphdl_n2194) <+ V(cpphdl_n2189, cpphdl_n2194) / 1000.0;
        // device 1551, IC IC264, analog/basic/mos_r2r_dac.hpp:33
        I(Vss, cpphdl_n2183) <+ V(Vss, cpphdl_n2183) / 2000.0;
        // device 1552, IC IC273, analog/basic/nmos_resistor_amplifier.hpp:23
        I(Vdd, cpphdl_n2203) <+ V(Vdd, cpphdl_n2203) / 1000.0;
        // device 1553, IC IC273, analog/basic/nmos_resistor_amplifier.hpp:24
        I(Vdd, cpphdl_n2202) <+ V(Vdd, cpphdl_n2202) / 1000.0;
        // device 1554, IC IC273, analog/basic/nmos_resistor_amplifier.hpp:25
        I(cpphdl_n2203, cpphdl_n2197) <+ cpphdl_channel(V(cpphdl_n2193, cpphdl_n2197), V(cpphdl_n2203, cpphdl_n2197), 0.014999999999999999, 0.69999999999999996, 1.0);
        // device 1555, IC IC273, analog/basic/nmos_resistor_amplifier.hpp:26
        I(cpphdl_n2202, cpphdl_n2198) <+ cpphdl_channel(V(cpphdl_n2194, cpphdl_n2198), V(cpphdl_n2202, cpphdl_n2198), 0.014999999999999999, 0.69999999999999996, 1.0);
        // device 1556, IC IC273, analog/basic/nmos_resistor_amplifier.hpp:27
        I(cpphdl_n2199, cpphdl_n2197) <+ V(cpphdl_n2199, cpphdl_n2197) / 50.0;
        // device 1557, IC IC273, analog/basic/nmos_resistor_amplifier.hpp:28
        I(cpphdl_n2199, cpphdl_n2198) <+ V(cpphdl_n2199, cpphdl_n2198) / 50.0;
        // device 1558, IC IC273, analog/basic/nmos_resistor_amplifier.hpp:29
        I(Vss, cpphdl_n2199) <+ V(Vss, cpphdl_n2199) / 150.0;
        // device 1559, IC IC273, analog/basic/nmos_resistor_amplifier.hpp:30
        I(cpphdl_n2203, Vdd) <+ 2.9999999999999998e-13 * ddt(V(cpphdl_n2203, Vdd)); // Bench initial voltage = 0.0 V.
        // device 1560, IC IC273, analog/basic/nmos_resistor_amplifier.hpp:31
        I(cpphdl_n2202, Vdd) <+ 2.9999999999999998e-13 * ddt(V(cpphdl_n2202, Vdd)); // Bench initial voltage = 0.0 V.
        // device 1561, IC IC273, analog/basic/nmos_resistor_amplifier.hpp:32
        I(cpphdl_n2199, Vss) <+ 4e-14 * ddt(V(cpphdl_n2199, Vss)); // Bench initial voltage = 0.0 V.
        // device 1562, IC IC273, analog/basic/nmos_resistor_amplifier.hpp:34
        I(cpphdl_n2193, cpphdl_n2197) <+ 2e-14 * ddt(V(cpphdl_n2193, cpphdl_n2197)); // Bench initial voltage = 1.6499999999999999 V.
        // device 1563, IC IC273, analog/basic/nmos_resistor_amplifier.hpp:35
        I(cpphdl_n2194, cpphdl_n2198) <+ 2e-14 * ddt(V(cpphdl_n2194, cpphdl_n2198)); // Bench initial voltage = 0.0 V.
        // device 1564, IC IC273, analog/basic/nmos_resistor_amplifier.hpp:36
        I(cpphdl_n2193, cpphdl_n2203) <+ 2.9999999999999998e-15 * ddt(V(cpphdl_n2193, cpphdl_n2203)); // Bench initial voltage = -1.6499999999999999 V.
        // device 1565, IC IC273, analog/basic/nmos_resistor_amplifier.hpp:37
        I(cpphdl_n2194, cpphdl_n2202) <+ 2.9999999999999998e-15 * ddt(V(cpphdl_n2194, cpphdl_n2202)); // Bench initial voltage = -3.2999999999999998 V.
        // device 1566, IC IC274, analog/basic/strongarm_comparator.hpp:28
        I(cpphdl_n2207, cpphdl_n2209) <+ cpphdl_channel(V(cpphdl_n2202, cpphdl_n2209), V(cpphdl_n2207, cpphdl_n2209), 0.0080000000000000002, 0.69999999999999996, 1.0);
        // device 1567, IC IC274, analog/basic/strongarm_comparator.hpp:29
        I(cpphdl_n2208, cpphdl_n2209) <+ cpphdl_channel(V(cpphdl_n2203, cpphdl_n2209), V(cpphdl_n2208, cpphdl_n2209), 0.0080000000000000002, 0.69999999999999996, 1.0);
        // device 1568, IC IC274, analog/basic/strongarm_comparator.hpp:30
        I(cpphdl_n2209, Vss) <+ cpphdl_channel(V(EVALUATE, Vss), V(cpphdl_n2209, Vss), 0.0080000000000000002, 0.69999999999999996, 1.0);
        // device 1569, IC IC274, analog/basic/strongarm_comparator.hpp:33
        I(cpphdl_n2222, cpphdl_n2207) <+ cpphdl_channel(V(cpphdl_n2226, cpphdl_n2207), V(cpphdl_n2222, cpphdl_n2207), 0.0040000000000000001, 0.69999999999999996, 1.0);
        // device 1570, IC IC274, analog/basic/strongarm_comparator.hpp:34
        I(cpphdl_n2226, cpphdl_n2208) <+ cpphdl_channel(V(cpphdl_n2222, cpphdl_n2208), V(cpphdl_n2226, cpphdl_n2208), 0.0040000000000000001, 0.69999999999999996, 1.0);
        // device 1571, IC IC274, analog/basic/strongarm_comparator.hpp:35
        I(cpphdl_n2226, Vdd) <+ cpphdl_channel(V(cpphdl_n2222, Vdd), V(cpphdl_n2226, Vdd), 0.002, 0.69999999999999996, -1.0);
        // device 1572, IC IC274, analog/basic/strongarm_comparator.hpp:36
        I(cpphdl_n2222, Vdd) <+ cpphdl_channel(V(cpphdl_n2226, Vdd), V(cpphdl_n2222, Vdd), 0.002, 0.69999999999999996, -1.0);
        // device 1573, IC IC274, analog/basic/strongarm_comparator.hpp:38
        I(cpphdl_n2207, Vdd) <+ cpphdl_channel(V(EVALUATE, Vdd), V(cpphdl_n2207, Vdd), 0.002, 0.69999999999999996, -1.0);
        // device 1574, IC IC274, analog/basic/strongarm_comparator.hpp:39
        I(cpphdl_n2208, Vdd) <+ cpphdl_channel(V(EVALUATE, Vdd), V(cpphdl_n2208, Vdd), 0.002, 0.69999999999999996, -1.0);
        // device 1575, IC IC274, analog/basic/strongarm_comparator.hpp:40
        I(cpphdl_n2226, Vdd) <+ cpphdl_channel(V(EVALUATE, Vdd), V(cpphdl_n2226, Vdd), 0.002, 0.69999999999999996, -1.0);
        // device 1576, IC IC274, analog/basic/strongarm_comparator.hpp:41
        I(cpphdl_n2222, Vdd) <+ cpphdl_channel(V(EVALUATE, Vdd), V(cpphdl_n2222, Vdd), 0.002, 0.69999999999999996, -1.0);
        // device 1577, IC IC274, analog/basic/strongarm_comparator.hpp:42
        I(cpphdl_n2207, Vss) <+ 2.9999999999999998e-14 * ddt(V(cpphdl_n2207, Vss)); // Bench initial voltage = 0.0 V.
        // device 1578, IC IC274, analog/basic/strongarm_comparator.hpp:43
        I(cpphdl_n2208, Vss) <+ 2.9999999999999998e-14 * ddt(V(cpphdl_n2208, Vss)); // Bench initial voltage = 0.0 V.
        // device 1579, IC IC274, analog/basic/strongarm_comparator.hpp:44
        I(cpphdl_n2209, Vss) <+ 2.9999999999999998e-14 * ddt(V(cpphdl_n2209, Vss)); // Bench initial voltage = 0.0 V.
        // device 1580, IC IC274, analog/basic/strongarm_comparator.hpp:45
        I(cpphdl_n2226, Vss) <+ 5.0000000000000002e-14 * ddt(V(cpphdl_n2226, Vss)); // Bench initial voltage = 0.0 V.
        // device 1581, IC IC274, analog/basic/strongarm_comparator.hpp:46
        I(cpphdl_n2222, Vss) <+ 5.0000000000000002e-14 * ddt(V(cpphdl_n2222, Vss)); // Bench initial voltage = 0.0 V.
        // device 1582, IC IC274, analog/basic/strongarm_comparator.hpp:47
        I(cpphdl_n2202, cpphdl_n2209) <+ 2e-14 * ddt(V(cpphdl_n2202, cpphdl_n2209)); // Bench initial voltage = 3.2999999999999998 V.
        // device 1583, IC IC274, analog/basic/strongarm_comparator.hpp:48
        I(cpphdl_n2203, cpphdl_n2209) <+ 2e-14 * ddt(V(cpphdl_n2203, cpphdl_n2209)); // Bench initial voltage = 3.2999999999999998 V.
        // device 1584, IC IC274, analog/basic/strongarm_comparator.hpp:49
        I(cpphdl_n2202, cpphdl_n2207) <+ 2.9999999999999998e-15 * ddt(V(cpphdl_n2202, cpphdl_n2207)); // Bench initial voltage = 3.2999999999999998 V.
        // device 1585, IC IC274, analog/basic/strongarm_comparator.hpp:50
        I(cpphdl_n2203, cpphdl_n2208) <+ 2.9999999999999998e-15 * ddt(V(cpphdl_n2203, cpphdl_n2208)); // Bench initial voltage = 3.2999999999999998 V.
        // device 1586, IC IC276, analog/basic/inverter.hpp:11
        I(cpphdl_n2230, Vdd) <+ cpphdl_channel(V(cpphdl_n2222, Vdd), V(cpphdl_n2230, Vdd), 0.001, 0.69999999999999996, -1.0);
        // device 1587, IC IC276, analog/basic/inverter.hpp:12
        I(cpphdl_n2230, Vss) <+ cpphdl_channel(V(cpphdl_n2222, Vss), V(cpphdl_n2230, Vss), 0.001, 0.69999999999999996, 1.0);
        // device 1588, IC IC278, analog/basic/inverter.hpp:11
        I(cpphdl_n2244, Vdd) <+ cpphdl_channel(V(cpphdl_n2230, Vdd), V(cpphdl_n2244, Vdd), 0.0040000000000000001, 0.69999999999999996, -1.0);
        // device 1589, IC IC278, analog/basic/inverter.hpp:12
        I(cpphdl_n2244, Vss) <+ cpphdl_channel(V(cpphdl_n2230, Vss), V(cpphdl_n2244, Vss), 0.0040000000000000001, 0.69999999999999996, 1.0);
        // device 1590, IC IC275, analog/basic/buffered_nand_latch.hpp:34
        I(cpphdl_n2222, Vss) <+ 2.0000000000000002e-15 * ddt(V(cpphdl_n2222, Vss)); // Bench initial voltage = 0.0 V.
        // device 1591, IC IC275, analog/basic/buffered_nand_latch.hpp:35
        I(cpphdl_n2222, cpphdl_n2230) <+ 1.0000000000000001e-15 * ddt(V(cpphdl_n2222, cpphdl_n2230)); // Bench initial voltage = 0.0 V.
        // device 1592, IC IC275, analog/basic/buffered_nand_latch.hpp:36
        I(cpphdl_n2230, Vss) <+ 5e-15 * ddt(V(cpphdl_n2230, Vss)); // Bench initial voltage = 0.0 V.
        // device 1593, IC IC275, analog/basic/buffered_nand_latch.hpp:37
        I(cpphdl_n2230, Vss) <+ 8.0000000000000006e-15 * ddt(V(cpphdl_n2230, Vss)); // Bench initial voltage = 0.0 V.
        // device 1594, IC IC275, analog/basic/buffered_nand_latch.hpp:38
        I(cpphdl_n2244, Vss) <+ 1e-14 * ddt(V(cpphdl_n2244, Vss)); // Bench initial voltage = 0.0 V.
        // device 1595, IC IC277, analog/basic/inverter.hpp:11
        I(cpphdl_n2234, Vdd) <+ cpphdl_channel(V(cpphdl_n2226, Vdd), V(cpphdl_n2234, Vdd), 0.001, 0.69999999999999996, -1.0);
        // device 1596, IC IC277, analog/basic/inverter.hpp:12
        I(cpphdl_n2234, Vss) <+ cpphdl_channel(V(cpphdl_n2226, Vss), V(cpphdl_n2234, Vss), 0.001, 0.69999999999999996, 1.0);
        // device 1597, IC IC279, analog/basic/inverter.hpp:11
        I(cpphdl_n2250, Vdd) <+ cpphdl_channel(V(cpphdl_n2234, Vdd), V(cpphdl_n2250, Vdd), 0.0040000000000000001, 0.69999999999999996, -1.0);
        // device 1598, IC IC279, analog/basic/inverter.hpp:12
        I(cpphdl_n2250, Vss) <+ cpphdl_channel(V(cpphdl_n2234, Vss), V(cpphdl_n2250, Vss), 0.0040000000000000001, 0.69999999999999996, 1.0);
        // device 1599, IC IC275, analog/basic/buffered_nand_latch.hpp:34
        I(cpphdl_n2226, Vss) <+ 2.0000000000000002e-15 * ddt(V(cpphdl_n2226, Vss)); // Bench initial voltage = 0.0 V.
        // device 1600, IC IC275, analog/basic/buffered_nand_latch.hpp:35
        I(cpphdl_n2226, cpphdl_n2234) <+ 1.0000000000000001e-15 * ddt(V(cpphdl_n2226, cpphdl_n2234)); // Bench initial voltage = 0.0 V.
        // device 1601, IC IC275, analog/basic/buffered_nand_latch.hpp:36
        I(cpphdl_n2234, Vss) <+ 5e-15 * ddt(V(cpphdl_n2234, Vss)); // Bench initial voltage = 0.0 V.
        // device 1602, IC IC275, analog/basic/buffered_nand_latch.hpp:37
        I(cpphdl_n2234, Vss) <+ 8.0000000000000006e-15 * ddt(V(cpphdl_n2234, Vss)); // Bench initial voltage = 0.0 V.
        // device 1603, IC IC275, analog/basic/buffered_nand_latch.hpp:38
        I(cpphdl_n2250, Vss) <+ 1e-14 * ddt(V(cpphdl_n2250, Vss)); // Bench initial voltage = 0.0 V.
        // device 1604, IC IC281, analog/basic/cmos_logic.hpp:17
        I(cpphdl_n2905, Vss) <+ 5.0000000000000002e-14 * ddt(V(cpphdl_n2905, Vss)); // Bench initial voltage = 0.0 V.
        // device 1605, IC IC281, analog/basic/cmos_logic.hpp:18
        I(cpphdl_n2905, Vdd) <+ cpphdl_channel(V(cpphdl_n2244, Vdd), V(cpphdl_n2905, Vdd), 0.01, 0.69999999999999996, -1.0);
        // device 1606, IC IC281, analog/basic/cmos_logic.hpp:19
        I(cpphdl_n2905, Vdd) <+ cpphdl_channel(V(cpphdl_n2252, Vdd), V(cpphdl_n2905, Vdd), 0.01, 0.69999999999999996, -1.0);
        // device 1607, IC IC281, analog/basic/cmos_logic.hpp:20
        I(cpphdl_n2905, cpphdl_n2247) <+ cpphdl_channel(V(cpphdl_n2244, cpphdl_n2247), V(cpphdl_n2905, cpphdl_n2247), 0.01, 0.69999999999999996, 1.0);
        // device 1608, IC IC281, analog/basic/cmos_logic.hpp:21
        I(cpphdl_n2247, Vss) <+ cpphdl_channel(V(cpphdl_n2252, Vss), V(cpphdl_n2247, Vss), 0.01, 0.69999999999999996, 1.0);
        // device 1609, IC IC281, analog/basic/cmos_logic.hpp:23
        I(cpphdl_n2905, Vss) <+ V(cpphdl_n2905, Vss) / 1000000000.0;
        // device 1610, IC IC281, analog/basic/cmos_logic.hpp:24
        I(cpphdl_n2247, Vss) <+ V(cpphdl_n2247, Vss) / 1000000000.0;
        // device 1611, IC IC282, analog/basic/cmos_logic.hpp:17
        I(cpphdl_n2252, Vss) <+ 5.0000000000000002e-14 * ddt(V(cpphdl_n2252, Vss)); // Bench initial voltage = 0.0 V.
        // device 1612, IC IC282, analog/basic/cmos_logic.hpp:18
        I(cpphdl_n2252, Vdd) <+ cpphdl_channel(V(cpphdl_n2250, Vdd), V(cpphdl_n2252, Vdd), 0.01, 0.69999999999999996, -1.0);
        // device 1613, IC IC282, analog/basic/cmos_logic.hpp:19
        I(cpphdl_n2252, Vdd) <+ cpphdl_channel(V(cpphdl_n2905, Vdd), V(cpphdl_n2252, Vdd), 0.01, 0.69999999999999996, -1.0);
        // device 1614, IC IC282, analog/basic/cmos_logic.hpp:20
        I(cpphdl_n2252, cpphdl_n2253) <+ cpphdl_channel(V(cpphdl_n2250, cpphdl_n2253), V(cpphdl_n2252, cpphdl_n2253), 0.01, 0.69999999999999996, 1.0);
        // device 1615, IC IC282, analog/basic/cmos_logic.hpp:21
        I(cpphdl_n2253, Vss) <+ cpphdl_channel(V(cpphdl_n2905, Vss), V(cpphdl_n2253, Vss), 0.01, 0.69999999999999996, 1.0);
        // device 1616, IC IC282, analog/basic/cmos_logic.hpp:23
        I(cpphdl_n2252, Vss) <+ V(cpphdl_n2252, Vss) / 1000000000.0;
        // device 1617, IC IC282, analog/basic/cmos_logic.hpp:24
        I(cpphdl_n2253, Vss) <+ V(cpphdl_n2253, Vss) / 1000000000.0;
        // device 1618, IC IC280, analog/basic/nand_latch.hpp:36
        I(cpphdl_n2244, Vss) <+ 2.9999999999999998e-15 * ddt(V(cpphdl_n2244, Vss)); // Bench initial voltage = 0.0 V.
        // device 1619, IC IC280, analog/basic/nand_latch.hpp:37
        I(cpphdl_n2250, Vss) <+ 2.9999999999999998e-15 * ddt(V(cpphdl_n2250, Vss)); // Bench initial voltage = 0.0 V.
        // device 1620, IC IC283, analog/basic/inverter.hpp:11
        I(cpphdl_n2258, Vdd) <+ cpphdl_channel(V(CLEAR, Vdd), V(cpphdl_n2258, Vdd), 0.01, 0.69999999999999996, -1.0);
        // device 1621, IC IC283, analog/basic/inverter.hpp:12
        I(cpphdl_n2258, Vss) <+ cpphdl_channel(V(CLEAR, Vss), V(cpphdl_n2258, Vss), 0.01, 0.69999999999999996, 1.0);
        // device 1622, IC IC280, analog/basic/nand_latch.hpp:58
        I(cpphdl_n2258, Vss) <+ 2.9999999999999998e-15 * ddt(V(cpphdl_n2258, Vss)); // Bench initial voltage = 0.0 V.
        // device 1623, IC IC280, analog/basic/nand_latch.hpp:59
        I(cpphdl_n2905, Vss) <+ cpphdl_channel(V(CLEAR, Vss), V(cpphdl_n2905, Vss), 0.050000000000000003, 0.69999999999999996, 1.0);
        // device 1624, IC IC280, analog/basic/nand_latch.hpp:60
        I(cpphdl_n2252, Vdd) <+ cpphdl_channel(V(cpphdl_n2258, Vdd), V(cpphdl_n2252, Vdd), 0.050000000000000003, 0.69999999999999996, -1.0);
        // device 1625, IC IC286, analog/basic/inverter.hpp:11
        I(cpphdl_n2282, Vdd) <+ cpphdl_channel(V(TRACK12, Vdd), V(cpphdl_n2282, Vdd), 0.0040000000000000001, 0.69999999999999996, -1.0);
        // device 1626, IC IC286, analog/basic/inverter.hpp:12
        I(cpphdl_n2282, Vss) <+ cpphdl_channel(V(TRACK12, Vss), V(cpphdl_n2282, Vss), 0.0040000000000000001, 0.69999999999999996, 1.0);
        // device 1627, IC IC285, analog/basic/mos_track_hold.hpp:31
        I(cpphdl_n2282, Vss) <+ 2e-14 * ddt(V(cpphdl_n2282, Vss)); // Bench initial voltage = 3.2999999999999998 V.
        // device 1628, IC IC285, analog/basic/mos_track_hold.hpp:32
        I(cpphdl_n2705, cpphdl_n2336) <+ cpphdl_channel(V(TRACK12, cpphdl_n2336), V(cpphdl_n2705, cpphdl_n2336), 0.080000000000000002, 0.69999999999999996, 1.0);
        // device 1629, IC IC285, analog/basic/mos_track_hold.hpp:33
        I(cpphdl_n2336, cpphdl_n2705) <+ cpphdl_channel(V(cpphdl_n2282, cpphdl_n2705), V(cpphdl_n2336, cpphdl_n2705), 0.040000000000000001, 0.69999999999999996, -1.0);
        // device 1630, IC IC285, analog/basic/mos_track_hold.hpp:37
        I(cpphdl_n2336, cpphdl_n2336) <+ cpphdl_channel(V(cpphdl_n2282, cpphdl_n2336), V(cpphdl_n2336, cpphdl_n2336), 0.040000000000000001, 0.69999999999999996, 1.0);
        // device 1631, IC IC285, analog/basic/mos_track_hold.hpp:38
        I(cpphdl_n2336, cpphdl_n2336) <+ cpphdl_channel(V(TRACK12, cpphdl_n2336), V(cpphdl_n2336, cpphdl_n2336), 0.02, 0.69999999999999996, -1.0);
        // device 1632, IC IC285, analog/basic/mos_track_hold.hpp:39
        I(cpphdl_n2336, Vss) <+ 2e-12 * ddt(V(cpphdl_n2336, Vss)); // Bench initial voltage = 1.6499999999999999 V.
        // device 1633, IC IC285, analog/basic/mos_track_hold.hpp:41
        I(Vss, cpphdl_n2336) <+ V(Vss, cpphdl_n2336) / 1000000000.0;
        // device 1634, IC IC285, analog/basic/mos_track_hold.hpp:42
        I(TRACK12, cpphdl_n2336) <+ 8.0000000000000006e-15 * ddt(V(TRACK12, cpphdl_n2336)); // Bench initial voltage = -1.6499999999999999 V.
        // device 1635, IC IC285, analog/basic/mos_track_hold.hpp:43
        I(cpphdl_n2282, cpphdl_n2336) <+ 8.0000000000000006e-15 * ddt(V(cpphdl_n2282, cpphdl_n2336)); // Bench initial voltage = 1.6499999999999999 V.
        // device 1636, IC IC285, analog/basic/mos_track_hold.hpp:44
        I(cpphdl_n2705, cpphdl_n2336) <+ 4.0000000000000003e-15 * ddt(V(cpphdl_n2705, cpphdl_n2336)); // Bench initial voltage = 0.0 V.
        // device 1637, IC IC288, analog/basic/inverter.hpp:11
        I(cpphdl_n2297, Vdd) <+ cpphdl_channel(V(BIT_N12_0, Vdd), V(cpphdl_n2297, Vdd), 0.080000000000000002, 0.69999999999999996, -1.0);
        // device 1638, IC IC288, analog/basic/inverter.hpp:12
        I(cpphdl_n2297, Vss) <+ cpphdl_channel(V(BIT_N12_0, Vss), V(cpphdl_n2297, Vss), 0.080000000000000002, 0.69999999999999996, 1.0);
        // device 1639, IC IC287, analog/basic/mos_r2r_dac.hpp:27
        I(cpphdl_n2297, Vss) <+ 2.9999999999999998e-15 * ddt(V(cpphdl_n2297, Vss)); // Bench initial voltage = 0.0 V.
        // device 1640, IC IC287, analog/basic/mos_r2r_dac.hpp:28
        I(cpphdl_n2297, cpphdl_n2326) <+ V(cpphdl_n2297, cpphdl_n2326) / 2000.0;
        // device 1641, IC IC287, analog/basic/mos_r2r_dac.hpp:29
        I(cpphdl_n2326, Vss) <+ 2.9999999999999998e-15 * ddt(V(cpphdl_n2326, Vss)); // Bench initial voltage = 0.0 V.
        // device 1642, IC IC289, analog/basic/inverter.hpp:11
        I(cpphdl_n2301, Vdd) <+ cpphdl_channel(V(BIT_N12_1, Vdd), V(cpphdl_n2301, Vdd), 0.080000000000000002, 0.69999999999999996, -1.0);
        // device 1643, IC IC289, analog/basic/inverter.hpp:12
        I(cpphdl_n2301, Vss) <+ cpphdl_channel(V(BIT_N12_1, Vss), V(cpphdl_n2301, Vss), 0.080000000000000002, 0.69999999999999996, 1.0);
        // device 1644, IC IC287, analog/basic/mos_r2r_dac.hpp:27
        I(cpphdl_n2301, Vss) <+ 2.9999999999999998e-15 * ddt(V(cpphdl_n2301, Vss)); // Bench initial voltage = 0.0 V.
        // device 1645, IC IC287, analog/basic/mos_r2r_dac.hpp:28
        I(cpphdl_n2301, cpphdl_n2327) <+ V(cpphdl_n2301, cpphdl_n2327) / 2000.0;
        // device 1646, IC IC287, analog/basic/mos_r2r_dac.hpp:29
        I(cpphdl_n2327, Vss) <+ 2.9999999999999998e-15 * ddt(V(cpphdl_n2327, Vss)); // Bench initial voltage = 0.0 V.
        // device 1647, IC IC287, analog/basic/mos_r2r_dac.hpp:31
        I(cpphdl_n2326, cpphdl_n2327) <+ V(cpphdl_n2326, cpphdl_n2327) / 1000.0;
        // device 1648, IC IC290, analog/basic/inverter.hpp:11
        I(cpphdl_n2305, Vdd) <+ cpphdl_channel(V(BIT_N12_2, Vdd), V(cpphdl_n2305, Vdd), 0.080000000000000002, 0.69999999999999996, -1.0);
        // device 1649, IC IC290, analog/basic/inverter.hpp:12
        I(cpphdl_n2305, Vss) <+ cpphdl_channel(V(BIT_N12_2, Vss), V(cpphdl_n2305, Vss), 0.080000000000000002, 0.69999999999999996, 1.0);
        // device 1650, IC IC287, analog/basic/mos_r2r_dac.hpp:27
        I(cpphdl_n2305, Vss) <+ 2.9999999999999998e-15 * ddt(V(cpphdl_n2305, Vss)); // Bench initial voltage = 0.0 V.
        // device 1651, IC IC287, analog/basic/mos_r2r_dac.hpp:28
        I(cpphdl_n2305, cpphdl_n2328) <+ V(cpphdl_n2305, cpphdl_n2328) / 2000.0;
        // device 1652, IC IC287, analog/basic/mos_r2r_dac.hpp:29
        I(cpphdl_n2328, Vss) <+ 2.9999999999999998e-15 * ddt(V(cpphdl_n2328, Vss)); // Bench initial voltage = 0.0 V.
        // device 1653, IC IC287, analog/basic/mos_r2r_dac.hpp:31
        I(cpphdl_n2327, cpphdl_n2328) <+ V(cpphdl_n2327, cpphdl_n2328) / 1000.0;
        // device 1654, IC IC291, analog/basic/inverter.hpp:11
        I(cpphdl_n2309, Vdd) <+ cpphdl_channel(V(BIT_N12_3, Vdd), V(cpphdl_n2309, Vdd), 0.080000000000000002, 0.69999999999999996, -1.0);
        // device 1655, IC IC291, analog/basic/inverter.hpp:12
        I(cpphdl_n2309, Vss) <+ cpphdl_channel(V(BIT_N12_3, Vss), V(cpphdl_n2309, Vss), 0.080000000000000002, 0.69999999999999996, 1.0);
        // device 1656, IC IC287, analog/basic/mos_r2r_dac.hpp:27
        I(cpphdl_n2309, Vss) <+ 2.9999999999999998e-15 * ddt(V(cpphdl_n2309, Vss)); // Bench initial voltage = 0.0 V.
        // device 1657, IC IC287, analog/basic/mos_r2r_dac.hpp:28
        I(cpphdl_n2309, cpphdl_n2329) <+ V(cpphdl_n2309, cpphdl_n2329) / 2000.0;
        // device 1658, IC IC287, analog/basic/mos_r2r_dac.hpp:29
        I(cpphdl_n2329, Vss) <+ 2.9999999999999998e-15 * ddt(V(cpphdl_n2329, Vss)); // Bench initial voltage = 0.0 V.
        // device 1659, IC IC287, analog/basic/mos_r2r_dac.hpp:31
        I(cpphdl_n2328, cpphdl_n2329) <+ V(cpphdl_n2328, cpphdl_n2329) / 1000.0;
        // device 1660, IC IC292, analog/basic/inverter.hpp:11
        I(cpphdl_n2313, Vdd) <+ cpphdl_channel(V(BIT_N12_4, Vdd), V(cpphdl_n2313, Vdd), 0.080000000000000002, 0.69999999999999996, -1.0);
        // device 1661, IC IC292, analog/basic/inverter.hpp:12
        I(cpphdl_n2313, Vss) <+ cpphdl_channel(V(BIT_N12_4, Vss), V(cpphdl_n2313, Vss), 0.080000000000000002, 0.69999999999999996, 1.0);
        // device 1662, IC IC287, analog/basic/mos_r2r_dac.hpp:27
        I(cpphdl_n2313, Vss) <+ 2.9999999999999998e-15 * ddt(V(cpphdl_n2313, Vss)); // Bench initial voltage = 0.0 V.
        // device 1663, IC IC287, analog/basic/mos_r2r_dac.hpp:28
        I(cpphdl_n2313, cpphdl_n2330) <+ V(cpphdl_n2313, cpphdl_n2330) / 2000.0;
        // device 1664, IC IC287, analog/basic/mos_r2r_dac.hpp:29
        I(cpphdl_n2330, Vss) <+ 2.9999999999999998e-15 * ddt(V(cpphdl_n2330, Vss)); // Bench initial voltage = 0.0 V.
        // device 1665, IC IC287, analog/basic/mos_r2r_dac.hpp:31
        I(cpphdl_n2329, cpphdl_n2330) <+ V(cpphdl_n2329, cpphdl_n2330) / 1000.0;
        // device 1666, IC IC293, analog/basic/inverter.hpp:11
        I(cpphdl_n2317, Vdd) <+ cpphdl_channel(V(BIT_N12_5, Vdd), V(cpphdl_n2317, Vdd), 0.080000000000000002, 0.69999999999999996, -1.0);
        // device 1667, IC IC293, analog/basic/inverter.hpp:12
        I(cpphdl_n2317, Vss) <+ cpphdl_channel(V(BIT_N12_5, Vss), V(cpphdl_n2317, Vss), 0.080000000000000002, 0.69999999999999996, 1.0);
        // device 1668, IC IC287, analog/basic/mos_r2r_dac.hpp:27
        I(cpphdl_n2317, Vss) <+ 2.9999999999999998e-15 * ddt(V(cpphdl_n2317, Vss)); // Bench initial voltage = 0.0 V.
        // device 1669, IC IC287, analog/basic/mos_r2r_dac.hpp:28
        I(cpphdl_n2317, cpphdl_n2331) <+ V(cpphdl_n2317, cpphdl_n2331) / 2000.0;
        // device 1670, IC IC287, analog/basic/mos_r2r_dac.hpp:29
        I(cpphdl_n2331, Vss) <+ 2.9999999999999998e-15 * ddt(V(cpphdl_n2331, Vss)); // Bench initial voltage = 0.0 V.
        // device 1671, IC IC287, analog/basic/mos_r2r_dac.hpp:31
        I(cpphdl_n2330, cpphdl_n2331) <+ V(cpphdl_n2330, cpphdl_n2331) / 1000.0;
        // device 1672, IC IC294, analog/basic/inverter.hpp:11
        I(cpphdl_n2321, Vdd) <+ cpphdl_channel(V(BIT_N12_6, Vdd), V(cpphdl_n2321, Vdd), 0.080000000000000002, 0.69999999999999996, -1.0);
        // device 1673, IC IC294, analog/basic/inverter.hpp:12
        I(cpphdl_n2321, Vss) <+ cpphdl_channel(V(BIT_N12_6, Vss), V(cpphdl_n2321, Vss), 0.080000000000000002, 0.69999999999999996, 1.0);
        // device 1674, IC IC287, analog/basic/mos_r2r_dac.hpp:27
        I(cpphdl_n2321, Vss) <+ 2.9999999999999998e-15 * ddt(V(cpphdl_n2321, Vss)); // Bench initial voltage = 0.0 V.
        // device 1675, IC IC287, analog/basic/mos_r2r_dac.hpp:28
        I(cpphdl_n2321, cpphdl_n2332) <+ V(cpphdl_n2321, cpphdl_n2332) / 2000.0;
        // device 1676, IC IC287, analog/basic/mos_r2r_dac.hpp:29
        I(cpphdl_n2332, Vss) <+ 2.9999999999999998e-15 * ddt(V(cpphdl_n2332, Vss)); // Bench initial voltage = 0.0 V.
        // device 1677, IC IC287, analog/basic/mos_r2r_dac.hpp:31
        I(cpphdl_n2331, cpphdl_n2332) <+ V(cpphdl_n2331, cpphdl_n2332) / 1000.0;
        // device 1678, IC IC295, analog/basic/inverter.hpp:11
        I(cpphdl_n2325, Vdd) <+ cpphdl_channel(V(BIT_N12_7, Vdd), V(cpphdl_n2325, Vdd), 0.080000000000000002, 0.69999999999999996, -1.0);
        // device 1679, IC IC295, analog/basic/inverter.hpp:12
        I(cpphdl_n2325, Vss) <+ cpphdl_channel(V(BIT_N12_7, Vss), V(cpphdl_n2325, Vss), 0.080000000000000002, 0.69999999999999996, 1.0);
        // device 1680, IC IC287, analog/basic/mos_r2r_dac.hpp:27
        I(cpphdl_n2325, Vss) <+ 2.9999999999999998e-15 * ddt(V(cpphdl_n2325, Vss)); // Bench initial voltage = 0.0 V.
        // device 1681, IC IC287, analog/basic/mos_r2r_dac.hpp:28
        I(cpphdl_n2325, cpphdl_n2337) <+ V(cpphdl_n2325, cpphdl_n2337) / 2000.0;
        // device 1682, IC IC287, analog/basic/mos_r2r_dac.hpp:29
        I(cpphdl_n2337, Vss) <+ 2.9999999999999998e-15 * ddt(V(cpphdl_n2337, Vss)); // Bench initial voltage = 0.0 V.
        // device 1683, IC IC287, analog/basic/mos_r2r_dac.hpp:31
        I(cpphdl_n2332, cpphdl_n2337) <+ V(cpphdl_n2332, cpphdl_n2337) / 1000.0;
        // device 1684, IC IC287, analog/basic/mos_r2r_dac.hpp:33
        I(Vss, cpphdl_n2326) <+ V(Vss, cpphdl_n2326) / 2000.0;
        // device 1685, IC IC296, analog/basic/nmos_resistor_amplifier.hpp:23
        I(Vdd, cpphdl_n2346) <+ V(Vdd, cpphdl_n2346) / 1000.0;
        // device 1686, IC IC296, analog/basic/nmos_resistor_amplifier.hpp:24
        I(Vdd, cpphdl_n2345) <+ V(Vdd, cpphdl_n2345) / 1000.0;
        // device 1687, IC IC296, analog/basic/nmos_resistor_amplifier.hpp:25
        I(cpphdl_n2346, cpphdl_n2340) <+ cpphdl_channel(V(cpphdl_n2336, cpphdl_n2340), V(cpphdl_n2346, cpphdl_n2340), 0.014999999999999999, 0.69999999999999996, 1.0);
        // device 1688, IC IC296, analog/basic/nmos_resistor_amplifier.hpp:26
        I(cpphdl_n2345, cpphdl_n2341) <+ cpphdl_channel(V(cpphdl_n2337, cpphdl_n2341), V(cpphdl_n2345, cpphdl_n2341), 0.014999999999999999, 0.69999999999999996, 1.0);
        // device 1689, IC IC296, analog/basic/nmos_resistor_amplifier.hpp:27
        I(cpphdl_n2342, cpphdl_n2340) <+ V(cpphdl_n2342, cpphdl_n2340) / 50.0;
        // device 1690, IC IC296, analog/basic/nmos_resistor_amplifier.hpp:28
        I(cpphdl_n2342, cpphdl_n2341) <+ V(cpphdl_n2342, cpphdl_n2341) / 50.0;
        // device 1691, IC IC296, analog/basic/nmos_resistor_amplifier.hpp:29
        I(Vss, cpphdl_n2342) <+ V(Vss, cpphdl_n2342) / 150.0;
        // device 1692, IC IC296, analog/basic/nmos_resistor_amplifier.hpp:30
        I(cpphdl_n2346, Vdd) <+ 2.9999999999999998e-13 * ddt(V(cpphdl_n2346, Vdd)); // Bench initial voltage = 0.0 V.
        // device 1693, IC IC296, analog/basic/nmos_resistor_amplifier.hpp:31
        I(cpphdl_n2345, Vdd) <+ 2.9999999999999998e-13 * ddt(V(cpphdl_n2345, Vdd)); // Bench initial voltage = 0.0 V.
        // device 1694, IC IC296, analog/basic/nmos_resistor_amplifier.hpp:32
        I(cpphdl_n2342, Vss) <+ 4e-14 * ddt(V(cpphdl_n2342, Vss)); // Bench initial voltage = 0.0 V.
        // device 1695, IC IC296, analog/basic/nmos_resistor_amplifier.hpp:34
        I(cpphdl_n2336, cpphdl_n2340) <+ 2e-14 * ddt(V(cpphdl_n2336, cpphdl_n2340)); // Bench initial voltage = 1.6499999999999999 V.
        // device 1696, IC IC296, analog/basic/nmos_resistor_amplifier.hpp:35
        I(cpphdl_n2337, cpphdl_n2341) <+ 2e-14 * ddt(V(cpphdl_n2337, cpphdl_n2341)); // Bench initial voltage = 0.0 V.
        // device 1697, IC IC296, analog/basic/nmos_resistor_amplifier.hpp:36
        I(cpphdl_n2336, cpphdl_n2346) <+ 2.9999999999999998e-15 * ddt(V(cpphdl_n2336, cpphdl_n2346)); // Bench initial voltage = -1.6499999999999999 V.
        // device 1698, IC IC296, analog/basic/nmos_resistor_amplifier.hpp:37
        I(cpphdl_n2337, cpphdl_n2345) <+ 2.9999999999999998e-15 * ddt(V(cpphdl_n2337, cpphdl_n2345)); // Bench initial voltage = -3.2999999999999998 V.
        // device 1699, IC IC297, analog/basic/strongarm_comparator.hpp:28
        I(cpphdl_n2350, cpphdl_n2352) <+ cpphdl_channel(V(cpphdl_n2345, cpphdl_n2352), V(cpphdl_n2350, cpphdl_n2352), 0.0080000000000000002, 0.69999999999999996, 1.0);
        // device 1700, IC IC297, analog/basic/strongarm_comparator.hpp:29
        I(cpphdl_n2351, cpphdl_n2352) <+ cpphdl_channel(V(cpphdl_n2346, cpphdl_n2352), V(cpphdl_n2351, cpphdl_n2352), 0.0080000000000000002, 0.69999999999999996, 1.0);
        // device 1701, IC IC297, analog/basic/strongarm_comparator.hpp:30
        I(cpphdl_n2352, Vss) <+ cpphdl_channel(V(EVALUATE, Vss), V(cpphdl_n2352, Vss), 0.0080000000000000002, 0.69999999999999996, 1.0);
        // device 1702, IC IC297, analog/basic/strongarm_comparator.hpp:33
        I(cpphdl_n2365, cpphdl_n2350) <+ cpphdl_channel(V(cpphdl_n2369, cpphdl_n2350), V(cpphdl_n2365, cpphdl_n2350), 0.0040000000000000001, 0.69999999999999996, 1.0);
        // device 1703, IC IC297, analog/basic/strongarm_comparator.hpp:34
        I(cpphdl_n2369, cpphdl_n2351) <+ cpphdl_channel(V(cpphdl_n2365, cpphdl_n2351), V(cpphdl_n2369, cpphdl_n2351), 0.0040000000000000001, 0.69999999999999996, 1.0);
        // device 1704, IC IC297, analog/basic/strongarm_comparator.hpp:35
        I(cpphdl_n2369, Vdd) <+ cpphdl_channel(V(cpphdl_n2365, Vdd), V(cpphdl_n2369, Vdd), 0.002, 0.69999999999999996, -1.0);
        // device 1705, IC IC297, analog/basic/strongarm_comparator.hpp:36
        I(cpphdl_n2365, Vdd) <+ cpphdl_channel(V(cpphdl_n2369, Vdd), V(cpphdl_n2365, Vdd), 0.002, 0.69999999999999996, -1.0);
        // device 1706, IC IC297, analog/basic/strongarm_comparator.hpp:38
        I(cpphdl_n2350, Vdd) <+ cpphdl_channel(V(EVALUATE, Vdd), V(cpphdl_n2350, Vdd), 0.002, 0.69999999999999996, -1.0);
        // device 1707, IC IC297, analog/basic/strongarm_comparator.hpp:39
        I(cpphdl_n2351, Vdd) <+ cpphdl_channel(V(EVALUATE, Vdd), V(cpphdl_n2351, Vdd), 0.002, 0.69999999999999996, -1.0);
        // device 1708, IC IC297, analog/basic/strongarm_comparator.hpp:40
        I(cpphdl_n2369, Vdd) <+ cpphdl_channel(V(EVALUATE, Vdd), V(cpphdl_n2369, Vdd), 0.002, 0.69999999999999996, -1.0);
        // device 1709, IC IC297, analog/basic/strongarm_comparator.hpp:41
        I(cpphdl_n2365, Vdd) <+ cpphdl_channel(V(EVALUATE, Vdd), V(cpphdl_n2365, Vdd), 0.002, 0.69999999999999996, -1.0);
        // device 1710, IC IC297, analog/basic/strongarm_comparator.hpp:42
        I(cpphdl_n2350, Vss) <+ 2.9999999999999998e-14 * ddt(V(cpphdl_n2350, Vss)); // Bench initial voltage = 0.0 V.
        // device 1711, IC IC297, analog/basic/strongarm_comparator.hpp:43
        I(cpphdl_n2351, Vss) <+ 2.9999999999999998e-14 * ddt(V(cpphdl_n2351, Vss)); // Bench initial voltage = 0.0 V.
        // device 1712, IC IC297, analog/basic/strongarm_comparator.hpp:44
        I(cpphdl_n2352, Vss) <+ 2.9999999999999998e-14 * ddt(V(cpphdl_n2352, Vss)); // Bench initial voltage = 0.0 V.
        // device 1713, IC IC297, analog/basic/strongarm_comparator.hpp:45
        I(cpphdl_n2369, Vss) <+ 5.0000000000000002e-14 * ddt(V(cpphdl_n2369, Vss)); // Bench initial voltage = 0.0 V.
        // device 1714, IC IC297, analog/basic/strongarm_comparator.hpp:46
        I(cpphdl_n2365, Vss) <+ 5.0000000000000002e-14 * ddt(V(cpphdl_n2365, Vss)); // Bench initial voltage = 0.0 V.
        // device 1715, IC IC297, analog/basic/strongarm_comparator.hpp:47
        I(cpphdl_n2345, cpphdl_n2352) <+ 2e-14 * ddt(V(cpphdl_n2345, cpphdl_n2352)); // Bench initial voltage = 3.2999999999999998 V.
        // device 1716, IC IC297, analog/basic/strongarm_comparator.hpp:48
        I(cpphdl_n2346, cpphdl_n2352) <+ 2e-14 * ddt(V(cpphdl_n2346, cpphdl_n2352)); // Bench initial voltage = 3.2999999999999998 V.
        // device 1717, IC IC297, analog/basic/strongarm_comparator.hpp:49
        I(cpphdl_n2345, cpphdl_n2350) <+ 2.9999999999999998e-15 * ddt(V(cpphdl_n2345, cpphdl_n2350)); // Bench initial voltage = 3.2999999999999998 V.
        // device 1718, IC IC297, analog/basic/strongarm_comparator.hpp:50
        I(cpphdl_n2346, cpphdl_n2351) <+ 2.9999999999999998e-15 * ddt(V(cpphdl_n2346, cpphdl_n2351)); // Bench initial voltage = 3.2999999999999998 V.
        // device 1719, IC IC299, analog/basic/inverter.hpp:11
        I(cpphdl_n2373, Vdd) <+ cpphdl_channel(V(cpphdl_n2365, Vdd), V(cpphdl_n2373, Vdd), 0.001, 0.69999999999999996, -1.0);
        // device 1720, IC IC299, analog/basic/inverter.hpp:12
        I(cpphdl_n2373, Vss) <+ cpphdl_channel(V(cpphdl_n2365, Vss), V(cpphdl_n2373, Vss), 0.001, 0.69999999999999996, 1.0);
        // device 1721, IC IC301, analog/basic/inverter.hpp:11
        I(cpphdl_n2387, Vdd) <+ cpphdl_channel(V(cpphdl_n2373, Vdd), V(cpphdl_n2387, Vdd), 0.0040000000000000001, 0.69999999999999996, -1.0);
        // device 1722, IC IC301, analog/basic/inverter.hpp:12
        I(cpphdl_n2387, Vss) <+ cpphdl_channel(V(cpphdl_n2373, Vss), V(cpphdl_n2387, Vss), 0.0040000000000000001, 0.69999999999999996, 1.0);
        // device 1723, IC IC298, analog/basic/buffered_nand_latch.hpp:34
        I(cpphdl_n2365, Vss) <+ 2.0000000000000002e-15 * ddt(V(cpphdl_n2365, Vss)); // Bench initial voltage = 0.0 V.
        // device 1724, IC IC298, analog/basic/buffered_nand_latch.hpp:35
        I(cpphdl_n2365, cpphdl_n2373) <+ 1.0000000000000001e-15 * ddt(V(cpphdl_n2365, cpphdl_n2373)); // Bench initial voltage = 0.0 V.
        // device 1725, IC IC298, analog/basic/buffered_nand_latch.hpp:36
        I(cpphdl_n2373, Vss) <+ 5e-15 * ddt(V(cpphdl_n2373, Vss)); // Bench initial voltage = 0.0 V.
        // device 1726, IC IC298, analog/basic/buffered_nand_latch.hpp:37
        I(cpphdl_n2373, Vss) <+ 8.0000000000000006e-15 * ddt(V(cpphdl_n2373, Vss)); // Bench initial voltage = 0.0 V.
        // device 1727, IC IC298, analog/basic/buffered_nand_latch.hpp:38
        I(cpphdl_n2387, Vss) <+ 1e-14 * ddt(V(cpphdl_n2387, Vss)); // Bench initial voltage = 0.0 V.
        // device 1728, IC IC300, analog/basic/inverter.hpp:11
        I(cpphdl_n2377, Vdd) <+ cpphdl_channel(V(cpphdl_n2369, Vdd), V(cpphdl_n2377, Vdd), 0.001, 0.69999999999999996, -1.0);
        // device 1729, IC IC300, analog/basic/inverter.hpp:12
        I(cpphdl_n2377, Vss) <+ cpphdl_channel(V(cpphdl_n2369, Vss), V(cpphdl_n2377, Vss), 0.001, 0.69999999999999996, 1.0);
        // device 1730, IC IC302, analog/basic/inverter.hpp:11
        I(cpphdl_n2393, Vdd) <+ cpphdl_channel(V(cpphdl_n2377, Vdd), V(cpphdl_n2393, Vdd), 0.0040000000000000001, 0.69999999999999996, -1.0);
        // device 1731, IC IC302, analog/basic/inverter.hpp:12
        I(cpphdl_n2393, Vss) <+ cpphdl_channel(V(cpphdl_n2377, Vss), V(cpphdl_n2393, Vss), 0.0040000000000000001, 0.69999999999999996, 1.0);
        // device 1732, IC IC298, analog/basic/buffered_nand_latch.hpp:34
        I(cpphdl_n2369, Vss) <+ 2.0000000000000002e-15 * ddt(V(cpphdl_n2369, Vss)); // Bench initial voltage = 0.0 V.
        // device 1733, IC IC298, analog/basic/buffered_nand_latch.hpp:35
        I(cpphdl_n2369, cpphdl_n2377) <+ 1.0000000000000001e-15 * ddt(V(cpphdl_n2369, cpphdl_n2377)); // Bench initial voltage = 0.0 V.
        // device 1734, IC IC298, analog/basic/buffered_nand_latch.hpp:36
        I(cpphdl_n2377, Vss) <+ 5e-15 * ddt(V(cpphdl_n2377, Vss)); // Bench initial voltage = 0.0 V.
        // device 1735, IC IC298, analog/basic/buffered_nand_latch.hpp:37
        I(cpphdl_n2377, Vss) <+ 8.0000000000000006e-15 * ddt(V(cpphdl_n2377, Vss)); // Bench initial voltage = 0.0 V.
        // device 1736, IC IC298, analog/basic/buffered_nand_latch.hpp:38
        I(cpphdl_n2393, Vss) <+ 1e-14 * ddt(V(cpphdl_n2393, Vss)); // Bench initial voltage = 0.0 V.
        // device 1737, IC IC304, analog/basic/cmos_logic.hpp:17
        I(cpphdl_n2910, Vss) <+ 5.0000000000000002e-14 * ddt(V(cpphdl_n2910, Vss)); // Bench initial voltage = 0.0 V.
        // device 1738, IC IC304, analog/basic/cmos_logic.hpp:18
        I(cpphdl_n2910, Vdd) <+ cpphdl_channel(V(cpphdl_n2387, Vdd), V(cpphdl_n2910, Vdd), 0.01, 0.69999999999999996, -1.0);
        // device 1739, IC IC304, analog/basic/cmos_logic.hpp:19
        I(cpphdl_n2910, Vdd) <+ cpphdl_channel(V(cpphdl_n2395, Vdd), V(cpphdl_n2910, Vdd), 0.01, 0.69999999999999996, -1.0);
        // device 1740, IC IC304, analog/basic/cmos_logic.hpp:20
        I(cpphdl_n2910, cpphdl_n2390) <+ cpphdl_channel(V(cpphdl_n2387, cpphdl_n2390), V(cpphdl_n2910, cpphdl_n2390), 0.01, 0.69999999999999996, 1.0);
        // device 1741, IC IC304, analog/basic/cmos_logic.hpp:21
        I(cpphdl_n2390, Vss) <+ cpphdl_channel(V(cpphdl_n2395, Vss), V(cpphdl_n2390, Vss), 0.01, 0.69999999999999996, 1.0);
        // device 1742, IC IC304, analog/basic/cmos_logic.hpp:23
        I(cpphdl_n2910, Vss) <+ V(cpphdl_n2910, Vss) / 1000000000.0;
        // device 1743, IC IC304, analog/basic/cmos_logic.hpp:24
        I(cpphdl_n2390, Vss) <+ V(cpphdl_n2390, Vss) / 1000000000.0;
        // device 1744, IC IC305, analog/basic/cmos_logic.hpp:17
        I(cpphdl_n2395, Vss) <+ 5.0000000000000002e-14 * ddt(V(cpphdl_n2395, Vss)); // Bench initial voltage = 0.0 V.
        // device 1745, IC IC305, analog/basic/cmos_logic.hpp:18
        I(cpphdl_n2395, Vdd) <+ cpphdl_channel(V(cpphdl_n2393, Vdd), V(cpphdl_n2395, Vdd), 0.01, 0.69999999999999996, -1.0);
        // device 1746, IC IC305, analog/basic/cmos_logic.hpp:19
        I(cpphdl_n2395, Vdd) <+ cpphdl_channel(V(cpphdl_n2910, Vdd), V(cpphdl_n2395, Vdd), 0.01, 0.69999999999999996, -1.0);
        // device 1747, IC IC305, analog/basic/cmos_logic.hpp:20
        I(cpphdl_n2395, cpphdl_n2396) <+ cpphdl_channel(V(cpphdl_n2393, cpphdl_n2396), V(cpphdl_n2395, cpphdl_n2396), 0.01, 0.69999999999999996, 1.0);
        // device 1748, IC IC305, analog/basic/cmos_logic.hpp:21
        I(cpphdl_n2396, Vss) <+ cpphdl_channel(V(cpphdl_n2910, Vss), V(cpphdl_n2396, Vss), 0.01, 0.69999999999999996, 1.0);
        // device 1749, IC IC305, analog/basic/cmos_logic.hpp:23
        I(cpphdl_n2395, Vss) <+ V(cpphdl_n2395, Vss) / 1000000000.0;
        // device 1750, IC IC305, analog/basic/cmos_logic.hpp:24
        I(cpphdl_n2396, Vss) <+ V(cpphdl_n2396, Vss) / 1000000000.0;
        // device 1751, IC IC303, analog/basic/nand_latch.hpp:36
        I(cpphdl_n2387, Vss) <+ 2.9999999999999998e-15 * ddt(V(cpphdl_n2387, Vss)); // Bench initial voltage = 0.0 V.
        // device 1752, IC IC303, analog/basic/nand_latch.hpp:37
        I(cpphdl_n2393, Vss) <+ 2.9999999999999998e-15 * ddt(V(cpphdl_n2393, Vss)); // Bench initial voltage = 0.0 V.
        // device 1753, IC IC306, analog/basic/inverter.hpp:11
        I(cpphdl_n2401, Vdd) <+ cpphdl_channel(V(CLEAR, Vdd), V(cpphdl_n2401, Vdd), 0.01, 0.69999999999999996, -1.0);
        // device 1754, IC IC306, analog/basic/inverter.hpp:12
        I(cpphdl_n2401, Vss) <+ cpphdl_channel(V(CLEAR, Vss), V(cpphdl_n2401, Vss), 0.01, 0.69999999999999996, 1.0);
        // device 1755, IC IC303, analog/basic/nand_latch.hpp:58
        I(cpphdl_n2401, Vss) <+ 2.9999999999999998e-15 * ddt(V(cpphdl_n2401, Vss)); // Bench initial voltage = 0.0 V.
        // device 1756, IC IC303, analog/basic/nand_latch.hpp:59
        I(cpphdl_n2910, Vss) <+ cpphdl_channel(V(CLEAR, Vss), V(cpphdl_n2910, Vss), 0.050000000000000003, 0.69999999999999996, 1.0);
        // device 1757, IC IC303, analog/basic/nand_latch.hpp:60
        I(cpphdl_n2395, Vdd) <+ cpphdl_channel(V(cpphdl_n2401, Vdd), V(cpphdl_n2395, Vdd), 0.050000000000000003, 0.69999999999999996, -1.0);
        // device 1758, IC IC309, analog/basic/inverter.hpp:11
        I(cpphdl_n2425, Vdd) <+ cpphdl_channel(V(TRACK13, Vdd), V(cpphdl_n2425, Vdd), 0.0040000000000000001, 0.69999999999999996, -1.0);
        // device 1759, IC IC309, analog/basic/inverter.hpp:12
        I(cpphdl_n2425, Vss) <+ cpphdl_channel(V(TRACK13, Vss), V(cpphdl_n2425, Vss), 0.0040000000000000001, 0.69999999999999996, 1.0);
        // device 1760, IC IC308, analog/basic/mos_track_hold.hpp:31
        I(cpphdl_n2425, Vss) <+ 2e-14 * ddt(V(cpphdl_n2425, Vss)); // Bench initial voltage = 3.2999999999999998 V.
        // device 1761, IC IC308, analog/basic/mos_track_hold.hpp:32
        I(cpphdl_n2705, cpphdl_n2479) <+ cpphdl_channel(V(TRACK13, cpphdl_n2479), V(cpphdl_n2705, cpphdl_n2479), 0.080000000000000002, 0.69999999999999996, 1.0);
        // device 1762, IC IC308, analog/basic/mos_track_hold.hpp:33
        I(cpphdl_n2479, cpphdl_n2705) <+ cpphdl_channel(V(cpphdl_n2425, cpphdl_n2705), V(cpphdl_n2479, cpphdl_n2705), 0.040000000000000001, 0.69999999999999996, -1.0);
        // device 1763, IC IC308, analog/basic/mos_track_hold.hpp:37
        I(cpphdl_n2479, cpphdl_n2479) <+ cpphdl_channel(V(cpphdl_n2425, cpphdl_n2479), V(cpphdl_n2479, cpphdl_n2479), 0.040000000000000001, 0.69999999999999996, 1.0);
        // device 1764, IC IC308, analog/basic/mos_track_hold.hpp:38
        I(cpphdl_n2479, cpphdl_n2479) <+ cpphdl_channel(V(TRACK13, cpphdl_n2479), V(cpphdl_n2479, cpphdl_n2479), 0.02, 0.69999999999999996, -1.0);
        // device 1765, IC IC308, analog/basic/mos_track_hold.hpp:39
        I(cpphdl_n2479, Vss) <+ 2e-12 * ddt(V(cpphdl_n2479, Vss)); // Bench initial voltage = 1.6499999999999999 V.
        // device 1766, IC IC308, analog/basic/mos_track_hold.hpp:41
        I(Vss, cpphdl_n2479) <+ V(Vss, cpphdl_n2479) / 1000000000.0;
        // device 1767, IC IC308, analog/basic/mos_track_hold.hpp:42
        I(TRACK13, cpphdl_n2479) <+ 8.0000000000000006e-15 * ddt(V(TRACK13, cpphdl_n2479)); // Bench initial voltage = -1.6499999999999999 V.
        // device 1768, IC IC308, analog/basic/mos_track_hold.hpp:43
        I(cpphdl_n2425, cpphdl_n2479) <+ 8.0000000000000006e-15 * ddt(V(cpphdl_n2425, cpphdl_n2479)); // Bench initial voltage = 1.6499999999999999 V.
        // device 1769, IC IC308, analog/basic/mos_track_hold.hpp:44
        I(cpphdl_n2705, cpphdl_n2479) <+ 4.0000000000000003e-15 * ddt(V(cpphdl_n2705, cpphdl_n2479)); // Bench initial voltage = 0.0 V.
        // device 1770, IC IC311, analog/basic/inverter.hpp:11
        I(cpphdl_n2440, Vdd) <+ cpphdl_channel(V(BIT_N13_0, Vdd), V(cpphdl_n2440, Vdd), 0.080000000000000002, 0.69999999999999996, -1.0);
        // device 1771, IC IC311, analog/basic/inverter.hpp:12
        I(cpphdl_n2440, Vss) <+ cpphdl_channel(V(BIT_N13_0, Vss), V(cpphdl_n2440, Vss), 0.080000000000000002, 0.69999999999999996, 1.0);
        // device 1772, IC IC310, analog/basic/mos_r2r_dac.hpp:27
        I(cpphdl_n2440, Vss) <+ 2.9999999999999998e-15 * ddt(V(cpphdl_n2440, Vss)); // Bench initial voltage = 0.0 V.
        // device 1773, IC IC310, analog/basic/mos_r2r_dac.hpp:28
        I(cpphdl_n2440, cpphdl_n2469) <+ V(cpphdl_n2440, cpphdl_n2469) / 2000.0;
        // device 1774, IC IC310, analog/basic/mos_r2r_dac.hpp:29
        I(cpphdl_n2469, Vss) <+ 2.9999999999999998e-15 * ddt(V(cpphdl_n2469, Vss)); // Bench initial voltage = 0.0 V.
        // device 1775, IC IC312, analog/basic/inverter.hpp:11
        I(cpphdl_n2444, Vdd) <+ cpphdl_channel(V(BIT_N13_1, Vdd), V(cpphdl_n2444, Vdd), 0.080000000000000002, 0.69999999999999996, -1.0);
        // device 1776, IC IC312, analog/basic/inverter.hpp:12
        I(cpphdl_n2444, Vss) <+ cpphdl_channel(V(BIT_N13_1, Vss), V(cpphdl_n2444, Vss), 0.080000000000000002, 0.69999999999999996, 1.0);
        // device 1777, IC IC310, analog/basic/mos_r2r_dac.hpp:27
        I(cpphdl_n2444, Vss) <+ 2.9999999999999998e-15 * ddt(V(cpphdl_n2444, Vss)); // Bench initial voltage = 0.0 V.
        // device 1778, IC IC310, analog/basic/mos_r2r_dac.hpp:28
        I(cpphdl_n2444, cpphdl_n2470) <+ V(cpphdl_n2444, cpphdl_n2470) / 2000.0;
        // device 1779, IC IC310, analog/basic/mos_r2r_dac.hpp:29
        I(cpphdl_n2470, Vss) <+ 2.9999999999999998e-15 * ddt(V(cpphdl_n2470, Vss)); // Bench initial voltage = 0.0 V.
        // device 1780, IC IC310, analog/basic/mos_r2r_dac.hpp:31
        I(cpphdl_n2469, cpphdl_n2470) <+ V(cpphdl_n2469, cpphdl_n2470) / 1000.0;
        // device 1781, IC IC313, analog/basic/inverter.hpp:11
        I(cpphdl_n2448, Vdd) <+ cpphdl_channel(V(BIT_N13_2, Vdd), V(cpphdl_n2448, Vdd), 0.080000000000000002, 0.69999999999999996, -1.0);
        // device 1782, IC IC313, analog/basic/inverter.hpp:12
        I(cpphdl_n2448, Vss) <+ cpphdl_channel(V(BIT_N13_2, Vss), V(cpphdl_n2448, Vss), 0.080000000000000002, 0.69999999999999996, 1.0);
        // device 1783, IC IC310, analog/basic/mos_r2r_dac.hpp:27
        I(cpphdl_n2448, Vss) <+ 2.9999999999999998e-15 * ddt(V(cpphdl_n2448, Vss)); // Bench initial voltage = 0.0 V.
        // device 1784, IC IC310, analog/basic/mos_r2r_dac.hpp:28
        I(cpphdl_n2448, cpphdl_n2471) <+ V(cpphdl_n2448, cpphdl_n2471) / 2000.0;
        // device 1785, IC IC310, analog/basic/mos_r2r_dac.hpp:29
        I(cpphdl_n2471, Vss) <+ 2.9999999999999998e-15 * ddt(V(cpphdl_n2471, Vss)); // Bench initial voltage = 0.0 V.
        // device 1786, IC IC310, analog/basic/mos_r2r_dac.hpp:31
        I(cpphdl_n2470, cpphdl_n2471) <+ V(cpphdl_n2470, cpphdl_n2471) / 1000.0;
        // device 1787, IC IC314, analog/basic/inverter.hpp:11
        I(cpphdl_n2452, Vdd) <+ cpphdl_channel(V(BIT_N13_3, Vdd), V(cpphdl_n2452, Vdd), 0.080000000000000002, 0.69999999999999996, -1.0);
        // device 1788, IC IC314, analog/basic/inverter.hpp:12
        I(cpphdl_n2452, Vss) <+ cpphdl_channel(V(BIT_N13_3, Vss), V(cpphdl_n2452, Vss), 0.080000000000000002, 0.69999999999999996, 1.0);
        // device 1789, IC IC310, analog/basic/mos_r2r_dac.hpp:27
        I(cpphdl_n2452, Vss) <+ 2.9999999999999998e-15 * ddt(V(cpphdl_n2452, Vss)); // Bench initial voltage = 0.0 V.
        // device 1790, IC IC310, analog/basic/mos_r2r_dac.hpp:28
        I(cpphdl_n2452, cpphdl_n2472) <+ V(cpphdl_n2452, cpphdl_n2472) / 2000.0;
        // device 1791, IC IC310, analog/basic/mos_r2r_dac.hpp:29
        I(cpphdl_n2472, Vss) <+ 2.9999999999999998e-15 * ddt(V(cpphdl_n2472, Vss)); // Bench initial voltage = 0.0 V.
        // device 1792, IC IC310, analog/basic/mos_r2r_dac.hpp:31
        I(cpphdl_n2471, cpphdl_n2472) <+ V(cpphdl_n2471, cpphdl_n2472) / 1000.0;
        // device 1793, IC IC315, analog/basic/inverter.hpp:11
        I(cpphdl_n2456, Vdd) <+ cpphdl_channel(V(BIT_N13_4, Vdd), V(cpphdl_n2456, Vdd), 0.080000000000000002, 0.69999999999999996, -1.0);
        // device 1794, IC IC315, analog/basic/inverter.hpp:12
        I(cpphdl_n2456, Vss) <+ cpphdl_channel(V(BIT_N13_4, Vss), V(cpphdl_n2456, Vss), 0.080000000000000002, 0.69999999999999996, 1.0);
        // device 1795, IC IC310, analog/basic/mos_r2r_dac.hpp:27
        I(cpphdl_n2456, Vss) <+ 2.9999999999999998e-15 * ddt(V(cpphdl_n2456, Vss)); // Bench initial voltage = 0.0 V.
        // device 1796, IC IC310, analog/basic/mos_r2r_dac.hpp:28
        I(cpphdl_n2456, cpphdl_n2473) <+ V(cpphdl_n2456, cpphdl_n2473) / 2000.0;
        // device 1797, IC IC310, analog/basic/mos_r2r_dac.hpp:29
        I(cpphdl_n2473, Vss) <+ 2.9999999999999998e-15 * ddt(V(cpphdl_n2473, Vss)); // Bench initial voltage = 0.0 V.
        // device 1798, IC IC310, analog/basic/mos_r2r_dac.hpp:31
        I(cpphdl_n2472, cpphdl_n2473) <+ V(cpphdl_n2472, cpphdl_n2473) / 1000.0;
        // device 1799, IC IC316, analog/basic/inverter.hpp:11
        I(cpphdl_n2460, Vdd) <+ cpphdl_channel(V(BIT_N13_5, Vdd), V(cpphdl_n2460, Vdd), 0.080000000000000002, 0.69999999999999996, -1.0);
        // device 1800, IC IC316, analog/basic/inverter.hpp:12
        I(cpphdl_n2460, Vss) <+ cpphdl_channel(V(BIT_N13_5, Vss), V(cpphdl_n2460, Vss), 0.080000000000000002, 0.69999999999999996, 1.0);
        // device 1801, IC IC310, analog/basic/mos_r2r_dac.hpp:27
        I(cpphdl_n2460, Vss) <+ 2.9999999999999998e-15 * ddt(V(cpphdl_n2460, Vss)); // Bench initial voltage = 0.0 V.
        // device 1802, IC IC310, analog/basic/mos_r2r_dac.hpp:28
        I(cpphdl_n2460, cpphdl_n2474) <+ V(cpphdl_n2460, cpphdl_n2474) / 2000.0;
        // device 1803, IC IC310, analog/basic/mos_r2r_dac.hpp:29
        I(cpphdl_n2474, Vss) <+ 2.9999999999999998e-15 * ddt(V(cpphdl_n2474, Vss)); // Bench initial voltage = 0.0 V.
        // device 1804, IC IC310, analog/basic/mos_r2r_dac.hpp:31
        I(cpphdl_n2473, cpphdl_n2474) <+ V(cpphdl_n2473, cpphdl_n2474) / 1000.0;
        // device 1805, IC IC317, analog/basic/inverter.hpp:11
        I(cpphdl_n2464, Vdd) <+ cpphdl_channel(V(BIT_N13_6, Vdd), V(cpphdl_n2464, Vdd), 0.080000000000000002, 0.69999999999999996, -1.0);
        // device 1806, IC IC317, analog/basic/inverter.hpp:12
        I(cpphdl_n2464, Vss) <+ cpphdl_channel(V(BIT_N13_6, Vss), V(cpphdl_n2464, Vss), 0.080000000000000002, 0.69999999999999996, 1.0);
        // device 1807, IC IC310, analog/basic/mos_r2r_dac.hpp:27
        I(cpphdl_n2464, Vss) <+ 2.9999999999999998e-15 * ddt(V(cpphdl_n2464, Vss)); // Bench initial voltage = 0.0 V.
        // device 1808, IC IC310, analog/basic/mos_r2r_dac.hpp:28
        I(cpphdl_n2464, cpphdl_n2475) <+ V(cpphdl_n2464, cpphdl_n2475) / 2000.0;
        // device 1809, IC IC310, analog/basic/mos_r2r_dac.hpp:29
        I(cpphdl_n2475, Vss) <+ 2.9999999999999998e-15 * ddt(V(cpphdl_n2475, Vss)); // Bench initial voltage = 0.0 V.
        // device 1810, IC IC310, analog/basic/mos_r2r_dac.hpp:31
        I(cpphdl_n2474, cpphdl_n2475) <+ V(cpphdl_n2474, cpphdl_n2475) / 1000.0;
        // device 1811, IC IC318, analog/basic/inverter.hpp:11
        I(cpphdl_n2468, Vdd) <+ cpphdl_channel(V(BIT_N13_7, Vdd), V(cpphdl_n2468, Vdd), 0.080000000000000002, 0.69999999999999996, -1.0);
        // device 1812, IC IC318, analog/basic/inverter.hpp:12
        I(cpphdl_n2468, Vss) <+ cpphdl_channel(V(BIT_N13_7, Vss), V(cpphdl_n2468, Vss), 0.080000000000000002, 0.69999999999999996, 1.0);
        // device 1813, IC IC310, analog/basic/mos_r2r_dac.hpp:27
        I(cpphdl_n2468, Vss) <+ 2.9999999999999998e-15 * ddt(V(cpphdl_n2468, Vss)); // Bench initial voltage = 0.0 V.
        // device 1814, IC IC310, analog/basic/mos_r2r_dac.hpp:28
        I(cpphdl_n2468, cpphdl_n2480) <+ V(cpphdl_n2468, cpphdl_n2480) / 2000.0;
        // device 1815, IC IC310, analog/basic/mos_r2r_dac.hpp:29
        I(cpphdl_n2480, Vss) <+ 2.9999999999999998e-15 * ddt(V(cpphdl_n2480, Vss)); // Bench initial voltage = 0.0 V.
        // device 1816, IC IC310, analog/basic/mos_r2r_dac.hpp:31
        I(cpphdl_n2475, cpphdl_n2480) <+ V(cpphdl_n2475, cpphdl_n2480) / 1000.0;
        // device 1817, IC IC310, analog/basic/mos_r2r_dac.hpp:33
        I(Vss, cpphdl_n2469) <+ V(Vss, cpphdl_n2469) / 2000.0;
        // device 1818, IC IC319, analog/basic/nmos_resistor_amplifier.hpp:23
        I(Vdd, cpphdl_n2489) <+ V(Vdd, cpphdl_n2489) / 1000.0;
        // device 1819, IC IC319, analog/basic/nmos_resistor_amplifier.hpp:24
        I(Vdd, cpphdl_n2488) <+ V(Vdd, cpphdl_n2488) / 1000.0;
        // device 1820, IC IC319, analog/basic/nmos_resistor_amplifier.hpp:25
        I(cpphdl_n2489, cpphdl_n2483) <+ cpphdl_channel(V(cpphdl_n2479, cpphdl_n2483), V(cpphdl_n2489, cpphdl_n2483), 0.014999999999999999, 0.69999999999999996, 1.0);
        // device 1821, IC IC319, analog/basic/nmos_resistor_amplifier.hpp:26
        I(cpphdl_n2488, cpphdl_n2484) <+ cpphdl_channel(V(cpphdl_n2480, cpphdl_n2484), V(cpphdl_n2488, cpphdl_n2484), 0.014999999999999999, 0.69999999999999996, 1.0);
        // device 1822, IC IC319, analog/basic/nmos_resistor_amplifier.hpp:27
        I(cpphdl_n2485, cpphdl_n2483) <+ V(cpphdl_n2485, cpphdl_n2483) / 50.0;
        // device 1823, IC IC319, analog/basic/nmos_resistor_amplifier.hpp:28
        I(cpphdl_n2485, cpphdl_n2484) <+ V(cpphdl_n2485, cpphdl_n2484) / 50.0;
        // device 1824, IC IC319, analog/basic/nmos_resistor_amplifier.hpp:29
        I(Vss, cpphdl_n2485) <+ V(Vss, cpphdl_n2485) / 150.0;
        // device 1825, IC IC319, analog/basic/nmos_resistor_amplifier.hpp:30
        I(cpphdl_n2489, Vdd) <+ 2.9999999999999998e-13 * ddt(V(cpphdl_n2489, Vdd)); // Bench initial voltage = 0.0 V.
        // device 1826, IC IC319, analog/basic/nmos_resistor_amplifier.hpp:31
        I(cpphdl_n2488, Vdd) <+ 2.9999999999999998e-13 * ddt(V(cpphdl_n2488, Vdd)); // Bench initial voltage = 0.0 V.
        // device 1827, IC IC319, analog/basic/nmos_resistor_amplifier.hpp:32
        I(cpphdl_n2485, Vss) <+ 4e-14 * ddt(V(cpphdl_n2485, Vss)); // Bench initial voltage = 0.0 V.
        // device 1828, IC IC319, analog/basic/nmos_resistor_amplifier.hpp:34
        I(cpphdl_n2479, cpphdl_n2483) <+ 2e-14 * ddt(V(cpphdl_n2479, cpphdl_n2483)); // Bench initial voltage = 1.6499999999999999 V.
        // device 1829, IC IC319, analog/basic/nmos_resistor_amplifier.hpp:35
        I(cpphdl_n2480, cpphdl_n2484) <+ 2e-14 * ddt(V(cpphdl_n2480, cpphdl_n2484)); // Bench initial voltage = 0.0 V.
        // device 1830, IC IC319, analog/basic/nmos_resistor_amplifier.hpp:36
        I(cpphdl_n2479, cpphdl_n2489) <+ 2.9999999999999998e-15 * ddt(V(cpphdl_n2479, cpphdl_n2489)); // Bench initial voltage = -1.6499999999999999 V.
        // device 1831, IC IC319, analog/basic/nmos_resistor_amplifier.hpp:37
        I(cpphdl_n2480, cpphdl_n2488) <+ 2.9999999999999998e-15 * ddt(V(cpphdl_n2480, cpphdl_n2488)); // Bench initial voltage = -3.2999999999999998 V.
        // device 1832, IC IC320, analog/basic/strongarm_comparator.hpp:28
        I(cpphdl_n2493, cpphdl_n2495) <+ cpphdl_channel(V(cpphdl_n2488, cpphdl_n2495), V(cpphdl_n2493, cpphdl_n2495), 0.0080000000000000002, 0.69999999999999996, 1.0);
        // device 1833, IC IC320, analog/basic/strongarm_comparator.hpp:29
        I(cpphdl_n2494, cpphdl_n2495) <+ cpphdl_channel(V(cpphdl_n2489, cpphdl_n2495), V(cpphdl_n2494, cpphdl_n2495), 0.0080000000000000002, 0.69999999999999996, 1.0);
        // device 1834, IC IC320, analog/basic/strongarm_comparator.hpp:30
        I(cpphdl_n2495, Vss) <+ cpphdl_channel(V(EVALUATE, Vss), V(cpphdl_n2495, Vss), 0.0080000000000000002, 0.69999999999999996, 1.0);
        // device 1835, IC IC320, analog/basic/strongarm_comparator.hpp:33
        I(cpphdl_n2508, cpphdl_n2493) <+ cpphdl_channel(V(cpphdl_n2512, cpphdl_n2493), V(cpphdl_n2508, cpphdl_n2493), 0.0040000000000000001, 0.69999999999999996, 1.0);
        // device 1836, IC IC320, analog/basic/strongarm_comparator.hpp:34
        I(cpphdl_n2512, cpphdl_n2494) <+ cpphdl_channel(V(cpphdl_n2508, cpphdl_n2494), V(cpphdl_n2512, cpphdl_n2494), 0.0040000000000000001, 0.69999999999999996, 1.0);
        // device 1837, IC IC320, analog/basic/strongarm_comparator.hpp:35
        I(cpphdl_n2512, Vdd) <+ cpphdl_channel(V(cpphdl_n2508, Vdd), V(cpphdl_n2512, Vdd), 0.002, 0.69999999999999996, -1.0);
        // device 1838, IC IC320, analog/basic/strongarm_comparator.hpp:36
        I(cpphdl_n2508, Vdd) <+ cpphdl_channel(V(cpphdl_n2512, Vdd), V(cpphdl_n2508, Vdd), 0.002, 0.69999999999999996, -1.0);
        // device 1839, IC IC320, analog/basic/strongarm_comparator.hpp:38
        I(cpphdl_n2493, Vdd) <+ cpphdl_channel(V(EVALUATE, Vdd), V(cpphdl_n2493, Vdd), 0.002, 0.69999999999999996, -1.0);
        // device 1840, IC IC320, analog/basic/strongarm_comparator.hpp:39
        I(cpphdl_n2494, Vdd) <+ cpphdl_channel(V(EVALUATE, Vdd), V(cpphdl_n2494, Vdd), 0.002, 0.69999999999999996, -1.0);
        // device 1841, IC IC320, analog/basic/strongarm_comparator.hpp:40
        I(cpphdl_n2512, Vdd) <+ cpphdl_channel(V(EVALUATE, Vdd), V(cpphdl_n2512, Vdd), 0.002, 0.69999999999999996, -1.0);
        // device 1842, IC IC320, analog/basic/strongarm_comparator.hpp:41
        I(cpphdl_n2508, Vdd) <+ cpphdl_channel(V(EVALUATE, Vdd), V(cpphdl_n2508, Vdd), 0.002, 0.69999999999999996, -1.0);
        // device 1843, IC IC320, analog/basic/strongarm_comparator.hpp:42
        I(cpphdl_n2493, Vss) <+ 2.9999999999999998e-14 * ddt(V(cpphdl_n2493, Vss)); // Bench initial voltage = 0.0 V.
        // device 1844, IC IC320, analog/basic/strongarm_comparator.hpp:43
        I(cpphdl_n2494, Vss) <+ 2.9999999999999998e-14 * ddt(V(cpphdl_n2494, Vss)); // Bench initial voltage = 0.0 V.
        // device 1845, IC IC320, analog/basic/strongarm_comparator.hpp:44
        I(cpphdl_n2495, Vss) <+ 2.9999999999999998e-14 * ddt(V(cpphdl_n2495, Vss)); // Bench initial voltage = 0.0 V.
        // device 1846, IC IC320, analog/basic/strongarm_comparator.hpp:45
        I(cpphdl_n2512, Vss) <+ 5.0000000000000002e-14 * ddt(V(cpphdl_n2512, Vss)); // Bench initial voltage = 0.0 V.
        // device 1847, IC IC320, analog/basic/strongarm_comparator.hpp:46
        I(cpphdl_n2508, Vss) <+ 5.0000000000000002e-14 * ddt(V(cpphdl_n2508, Vss)); // Bench initial voltage = 0.0 V.
        // device 1848, IC IC320, analog/basic/strongarm_comparator.hpp:47
        I(cpphdl_n2488, cpphdl_n2495) <+ 2e-14 * ddt(V(cpphdl_n2488, cpphdl_n2495)); // Bench initial voltage = 3.2999999999999998 V.
        // device 1849, IC IC320, analog/basic/strongarm_comparator.hpp:48
        I(cpphdl_n2489, cpphdl_n2495) <+ 2e-14 * ddt(V(cpphdl_n2489, cpphdl_n2495)); // Bench initial voltage = 3.2999999999999998 V.
        // device 1850, IC IC320, analog/basic/strongarm_comparator.hpp:49
        I(cpphdl_n2488, cpphdl_n2493) <+ 2.9999999999999998e-15 * ddt(V(cpphdl_n2488, cpphdl_n2493)); // Bench initial voltage = 3.2999999999999998 V.
        // device 1851, IC IC320, analog/basic/strongarm_comparator.hpp:50
        I(cpphdl_n2489, cpphdl_n2494) <+ 2.9999999999999998e-15 * ddt(V(cpphdl_n2489, cpphdl_n2494)); // Bench initial voltage = 3.2999999999999998 V.
        // device 1852, IC IC322, analog/basic/inverter.hpp:11
        I(cpphdl_n2516, Vdd) <+ cpphdl_channel(V(cpphdl_n2508, Vdd), V(cpphdl_n2516, Vdd), 0.001, 0.69999999999999996, -1.0);
        // device 1853, IC IC322, analog/basic/inverter.hpp:12
        I(cpphdl_n2516, Vss) <+ cpphdl_channel(V(cpphdl_n2508, Vss), V(cpphdl_n2516, Vss), 0.001, 0.69999999999999996, 1.0);
        // device 1854, IC IC324, analog/basic/inverter.hpp:11
        I(cpphdl_n2530, Vdd) <+ cpphdl_channel(V(cpphdl_n2516, Vdd), V(cpphdl_n2530, Vdd), 0.0040000000000000001, 0.69999999999999996, -1.0);
        // device 1855, IC IC324, analog/basic/inverter.hpp:12
        I(cpphdl_n2530, Vss) <+ cpphdl_channel(V(cpphdl_n2516, Vss), V(cpphdl_n2530, Vss), 0.0040000000000000001, 0.69999999999999996, 1.0);
        // device 1856, IC IC321, analog/basic/buffered_nand_latch.hpp:34
        I(cpphdl_n2508, Vss) <+ 2.0000000000000002e-15 * ddt(V(cpphdl_n2508, Vss)); // Bench initial voltage = 0.0 V.
        // device 1857, IC IC321, analog/basic/buffered_nand_latch.hpp:35
        I(cpphdl_n2508, cpphdl_n2516) <+ 1.0000000000000001e-15 * ddt(V(cpphdl_n2508, cpphdl_n2516)); // Bench initial voltage = 0.0 V.
        // device 1858, IC IC321, analog/basic/buffered_nand_latch.hpp:36
        I(cpphdl_n2516, Vss) <+ 5e-15 * ddt(V(cpphdl_n2516, Vss)); // Bench initial voltage = 0.0 V.
        // device 1859, IC IC321, analog/basic/buffered_nand_latch.hpp:37
        I(cpphdl_n2516, Vss) <+ 8.0000000000000006e-15 * ddt(V(cpphdl_n2516, Vss)); // Bench initial voltage = 0.0 V.
        // device 1860, IC IC321, analog/basic/buffered_nand_latch.hpp:38
        I(cpphdl_n2530, Vss) <+ 1e-14 * ddt(V(cpphdl_n2530, Vss)); // Bench initial voltage = 0.0 V.
        // device 1861, IC IC323, analog/basic/inverter.hpp:11
        I(cpphdl_n2520, Vdd) <+ cpphdl_channel(V(cpphdl_n2512, Vdd), V(cpphdl_n2520, Vdd), 0.001, 0.69999999999999996, -1.0);
        // device 1862, IC IC323, analog/basic/inverter.hpp:12
        I(cpphdl_n2520, Vss) <+ cpphdl_channel(V(cpphdl_n2512, Vss), V(cpphdl_n2520, Vss), 0.001, 0.69999999999999996, 1.0);
        // device 1863, IC IC325, analog/basic/inverter.hpp:11
        I(cpphdl_n2536, Vdd) <+ cpphdl_channel(V(cpphdl_n2520, Vdd), V(cpphdl_n2536, Vdd), 0.0040000000000000001, 0.69999999999999996, -1.0);
        // device 1864, IC IC325, analog/basic/inverter.hpp:12
        I(cpphdl_n2536, Vss) <+ cpphdl_channel(V(cpphdl_n2520, Vss), V(cpphdl_n2536, Vss), 0.0040000000000000001, 0.69999999999999996, 1.0);
        // device 1865, IC IC321, analog/basic/buffered_nand_latch.hpp:34
        I(cpphdl_n2512, Vss) <+ 2.0000000000000002e-15 * ddt(V(cpphdl_n2512, Vss)); // Bench initial voltage = 0.0 V.
        // device 1866, IC IC321, analog/basic/buffered_nand_latch.hpp:35
        I(cpphdl_n2512, cpphdl_n2520) <+ 1.0000000000000001e-15 * ddt(V(cpphdl_n2512, cpphdl_n2520)); // Bench initial voltage = 0.0 V.
        // device 1867, IC IC321, analog/basic/buffered_nand_latch.hpp:36
        I(cpphdl_n2520, Vss) <+ 5e-15 * ddt(V(cpphdl_n2520, Vss)); // Bench initial voltage = 0.0 V.
        // device 1868, IC IC321, analog/basic/buffered_nand_latch.hpp:37
        I(cpphdl_n2520, Vss) <+ 8.0000000000000006e-15 * ddt(V(cpphdl_n2520, Vss)); // Bench initial voltage = 0.0 V.
        // device 1869, IC IC321, analog/basic/buffered_nand_latch.hpp:38
        I(cpphdl_n2536, Vss) <+ 1e-14 * ddt(V(cpphdl_n2536, Vss)); // Bench initial voltage = 0.0 V.
        // device 1870, IC IC327, analog/basic/cmos_logic.hpp:17
        I(cpphdl_n2915, Vss) <+ 5.0000000000000002e-14 * ddt(V(cpphdl_n2915, Vss)); // Bench initial voltage = 0.0 V.
        // device 1871, IC IC327, analog/basic/cmos_logic.hpp:18
        I(cpphdl_n2915, Vdd) <+ cpphdl_channel(V(cpphdl_n2530, Vdd), V(cpphdl_n2915, Vdd), 0.01, 0.69999999999999996, -1.0);
        // device 1872, IC IC327, analog/basic/cmos_logic.hpp:19
        I(cpphdl_n2915, Vdd) <+ cpphdl_channel(V(cpphdl_n2538, Vdd), V(cpphdl_n2915, Vdd), 0.01, 0.69999999999999996, -1.0);
        // device 1873, IC IC327, analog/basic/cmos_logic.hpp:20
        I(cpphdl_n2915, cpphdl_n2533) <+ cpphdl_channel(V(cpphdl_n2530, cpphdl_n2533), V(cpphdl_n2915, cpphdl_n2533), 0.01, 0.69999999999999996, 1.0);
        // device 1874, IC IC327, analog/basic/cmos_logic.hpp:21
        I(cpphdl_n2533, Vss) <+ cpphdl_channel(V(cpphdl_n2538, Vss), V(cpphdl_n2533, Vss), 0.01, 0.69999999999999996, 1.0);
        // device 1875, IC IC327, analog/basic/cmos_logic.hpp:23
        I(cpphdl_n2915, Vss) <+ V(cpphdl_n2915, Vss) / 1000000000.0;
        // device 1876, IC IC327, analog/basic/cmos_logic.hpp:24
        I(cpphdl_n2533, Vss) <+ V(cpphdl_n2533, Vss) / 1000000000.0;
        // device 1877, IC IC328, analog/basic/cmos_logic.hpp:17
        I(cpphdl_n2538, Vss) <+ 5.0000000000000002e-14 * ddt(V(cpphdl_n2538, Vss)); // Bench initial voltage = 0.0 V.
        // device 1878, IC IC328, analog/basic/cmos_logic.hpp:18
        I(cpphdl_n2538, Vdd) <+ cpphdl_channel(V(cpphdl_n2536, Vdd), V(cpphdl_n2538, Vdd), 0.01, 0.69999999999999996, -1.0);
        // device 1879, IC IC328, analog/basic/cmos_logic.hpp:19
        I(cpphdl_n2538, Vdd) <+ cpphdl_channel(V(cpphdl_n2915, Vdd), V(cpphdl_n2538, Vdd), 0.01, 0.69999999999999996, -1.0);
        // device 1880, IC IC328, analog/basic/cmos_logic.hpp:20
        I(cpphdl_n2538, cpphdl_n2539) <+ cpphdl_channel(V(cpphdl_n2536, cpphdl_n2539), V(cpphdl_n2538, cpphdl_n2539), 0.01, 0.69999999999999996, 1.0);
        // device 1881, IC IC328, analog/basic/cmos_logic.hpp:21
        I(cpphdl_n2539, Vss) <+ cpphdl_channel(V(cpphdl_n2915, Vss), V(cpphdl_n2539, Vss), 0.01, 0.69999999999999996, 1.0);
        // device 1882, IC IC328, analog/basic/cmos_logic.hpp:23
        I(cpphdl_n2538, Vss) <+ V(cpphdl_n2538, Vss) / 1000000000.0;
        // device 1883, IC IC328, analog/basic/cmos_logic.hpp:24
        I(cpphdl_n2539, Vss) <+ V(cpphdl_n2539, Vss) / 1000000000.0;
        // device 1884, IC IC326, analog/basic/nand_latch.hpp:36
        I(cpphdl_n2530, Vss) <+ 2.9999999999999998e-15 * ddt(V(cpphdl_n2530, Vss)); // Bench initial voltage = 0.0 V.
        // device 1885, IC IC326, analog/basic/nand_latch.hpp:37
        I(cpphdl_n2536, Vss) <+ 2.9999999999999998e-15 * ddt(V(cpphdl_n2536, Vss)); // Bench initial voltage = 0.0 V.
        // device 1886, IC IC329, analog/basic/inverter.hpp:11
        I(cpphdl_n2544, Vdd) <+ cpphdl_channel(V(CLEAR, Vdd), V(cpphdl_n2544, Vdd), 0.01, 0.69999999999999996, -1.0);
        // device 1887, IC IC329, analog/basic/inverter.hpp:12
        I(cpphdl_n2544, Vss) <+ cpphdl_channel(V(CLEAR, Vss), V(cpphdl_n2544, Vss), 0.01, 0.69999999999999996, 1.0);
        // device 1888, IC IC326, analog/basic/nand_latch.hpp:58
        I(cpphdl_n2544, Vss) <+ 2.9999999999999998e-15 * ddt(V(cpphdl_n2544, Vss)); // Bench initial voltage = 0.0 V.
        // device 1889, IC IC326, analog/basic/nand_latch.hpp:59
        I(cpphdl_n2915, Vss) <+ cpphdl_channel(V(CLEAR, Vss), V(cpphdl_n2915, Vss), 0.050000000000000003, 0.69999999999999996, 1.0);
        // device 1890, IC IC326, analog/basic/nand_latch.hpp:60
        I(cpphdl_n2538, Vdd) <+ cpphdl_channel(V(cpphdl_n2544, Vdd), V(cpphdl_n2538, Vdd), 0.050000000000000003, 0.69999999999999996, -1.0);
        // device 1891, IC IC332, analog/basic/inverter.hpp:11
        I(cpphdl_n2568, Vdd) <+ cpphdl_channel(V(TRACK14, Vdd), V(cpphdl_n2568, Vdd), 0.0040000000000000001, 0.69999999999999996, -1.0);
        // device 1892, IC IC332, analog/basic/inverter.hpp:12
        I(cpphdl_n2568, Vss) <+ cpphdl_channel(V(TRACK14, Vss), V(cpphdl_n2568, Vss), 0.0040000000000000001, 0.69999999999999996, 1.0);
        // device 1893, IC IC331, analog/basic/mos_track_hold.hpp:31
        I(cpphdl_n2568, Vss) <+ 2e-14 * ddt(V(cpphdl_n2568, Vss)); // Bench initial voltage = 3.2999999999999998 V.
        // device 1894, IC IC331, analog/basic/mos_track_hold.hpp:32
        I(cpphdl_n2705, cpphdl_n2622) <+ cpphdl_channel(V(TRACK14, cpphdl_n2622), V(cpphdl_n2705, cpphdl_n2622), 0.080000000000000002, 0.69999999999999996, 1.0);
        // device 1895, IC IC331, analog/basic/mos_track_hold.hpp:33
        I(cpphdl_n2622, cpphdl_n2705) <+ cpphdl_channel(V(cpphdl_n2568, cpphdl_n2705), V(cpphdl_n2622, cpphdl_n2705), 0.040000000000000001, 0.69999999999999996, -1.0);
        // device 1896, IC IC331, analog/basic/mos_track_hold.hpp:37
        I(cpphdl_n2622, cpphdl_n2622) <+ cpphdl_channel(V(cpphdl_n2568, cpphdl_n2622), V(cpphdl_n2622, cpphdl_n2622), 0.040000000000000001, 0.69999999999999996, 1.0);
        // device 1897, IC IC331, analog/basic/mos_track_hold.hpp:38
        I(cpphdl_n2622, cpphdl_n2622) <+ cpphdl_channel(V(TRACK14, cpphdl_n2622), V(cpphdl_n2622, cpphdl_n2622), 0.02, 0.69999999999999996, -1.0);
        // device 1898, IC IC331, analog/basic/mos_track_hold.hpp:39
        I(cpphdl_n2622, Vss) <+ 2e-12 * ddt(V(cpphdl_n2622, Vss)); // Bench initial voltage = 1.6499999999999999 V.
        // device 1899, IC IC331, analog/basic/mos_track_hold.hpp:41
        I(Vss, cpphdl_n2622) <+ V(Vss, cpphdl_n2622) / 1000000000.0;
        // device 1900, IC IC331, analog/basic/mos_track_hold.hpp:42
        I(TRACK14, cpphdl_n2622) <+ 8.0000000000000006e-15 * ddt(V(TRACK14, cpphdl_n2622)); // Bench initial voltage = -1.6499999999999999 V.
        // device 1901, IC IC331, analog/basic/mos_track_hold.hpp:43
        I(cpphdl_n2568, cpphdl_n2622) <+ 8.0000000000000006e-15 * ddt(V(cpphdl_n2568, cpphdl_n2622)); // Bench initial voltage = 1.6499999999999999 V.
        // device 1902, IC IC331, analog/basic/mos_track_hold.hpp:44
        I(cpphdl_n2705, cpphdl_n2622) <+ 4.0000000000000003e-15 * ddt(V(cpphdl_n2705, cpphdl_n2622)); // Bench initial voltage = 0.0 V.
        // device 1903, IC IC334, analog/basic/inverter.hpp:11
        I(cpphdl_n2583, Vdd) <+ cpphdl_channel(V(BIT_N14_0, Vdd), V(cpphdl_n2583, Vdd), 0.080000000000000002, 0.69999999999999996, -1.0);
        // device 1904, IC IC334, analog/basic/inverter.hpp:12
        I(cpphdl_n2583, Vss) <+ cpphdl_channel(V(BIT_N14_0, Vss), V(cpphdl_n2583, Vss), 0.080000000000000002, 0.69999999999999996, 1.0);
        // device 1905, IC IC333, analog/basic/mos_r2r_dac.hpp:27
        I(cpphdl_n2583, Vss) <+ 2.9999999999999998e-15 * ddt(V(cpphdl_n2583, Vss)); // Bench initial voltage = 0.0 V.
        // device 1906, IC IC333, analog/basic/mos_r2r_dac.hpp:28
        I(cpphdl_n2583, cpphdl_n2612) <+ V(cpphdl_n2583, cpphdl_n2612) / 2000.0;
        // device 1907, IC IC333, analog/basic/mos_r2r_dac.hpp:29
        I(cpphdl_n2612, Vss) <+ 2.9999999999999998e-15 * ddt(V(cpphdl_n2612, Vss)); // Bench initial voltage = 0.0 V.
        // device 1908, IC IC335, analog/basic/inverter.hpp:11
        I(cpphdl_n2587, Vdd) <+ cpphdl_channel(V(BIT_N14_1, Vdd), V(cpphdl_n2587, Vdd), 0.080000000000000002, 0.69999999999999996, -1.0);
        // device 1909, IC IC335, analog/basic/inverter.hpp:12
        I(cpphdl_n2587, Vss) <+ cpphdl_channel(V(BIT_N14_1, Vss), V(cpphdl_n2587, Vss), 0.080000000000000002, 0.69999999999999996, 1.0);
        // device 1910, IC IC333, analog/basic/mos_r2r_dac.hpp:27
        I(cpphdl_n2587, Vss) <+ 2.9999999999999998e-15 * ddt(V(cpphdl_n2587, Vss)); // Bench initial voltage = 0.0 V.
        // device 1911, IC IC333, analog/basic/mos_r2r_dac.hpp:28
        I(cpphdl_n2587, cpphdl_n2613) <+ V(cpphdl_n2587, cpphdl_n2613) / 2000.0;
        // device 1912, IC IC333, analog/basic/mos_r2r_dac.hpp:29
        I(cpphdl_n2613, Vss) <+ 2.9999999999999998e-15 * ddt(V(cpphdl_n2613, Vss)); // Bench initial voltage = 0.0 V.
        // device 1913, IC IC333, analog/basic/mos_r2r_dac.hpp:31
        I(cpphdl_n2612, cpphdl_n2613) <+ V(cpphdl_n2612, cpphdl_n2613) / 1000.0;
        // device 1914, IC IC336, analog/basic/inverter.hpp:11
        I(cpphdl_n2591, Vdd) <+ cpphdl_channel(V(BIT_N14_2, Vdd), V(cpphdl_n2591, Vdd), 0.080000000000000002, 0.69999999999999996, -1.0);
        // device 1915, IC IC336, analog/basic/inverter.hpp:12
        I(cpphdl_n2591, Vss) <+ cpphdl_channel(V(BIT_N14_2, Vss), V(cpphdl_n2591, Vss), 0.080000000000000002, 0.69999999999999996, 1.0);
        // device 1916, IC IC333, analog/basic/mos_r2r_dac.hpp:27
        I(cpphdl_n2591, Vss) <+ 2.9999999999999998e-15 * ddt(V(cpphdl_n2591, Vss)); // Bench initial voltage = 0.0 V.
        // device 1917, IC IC333, analog/basic/mos_r2r_dac.hpp:28
        I(cpphdl_n2591, cpphdl_n2614) <+ V(cpphdl_n2591, cpphdl_n2614) / 2000.0;
        // device 1918, IC IC333, analog/basic/mos_r2r_dac.hpp:29
        I(cpphdl_n2614, Vss) <+ 2.9999999999999998e-15 * ddt(V(cpphdl_n2614, Vss)); // Bench initial voltage = 0.0 V.
        // device 1919, IC IC333, analog/basic/mos_r2r_dac.hpp:31
        I(cpphdl_n2613, cpphdl_n2614) <+ V(cpphdl_n2613, cpphdl_n2614) / 1000.0;
        // device 1920, IC IC337, analog/basic/inverter.hpp:11
        I(cpphdl_n2595, Vdd) <+ cpphdl_channel(V(BIT_N14_3, Vdd), V(cpphdl_n2595, Vdd), 0.080000000000000002, 0.69999999999999996, -1.0);
        // device 1921, IC IC337, analog/basic/inverter.hpp:12
        I(cpphdl_n2595, Vss) <+ cpphdl_channel(V(BIT_N14_3, Vss), V(cpphdl_n2595, Vss), 0.080000000000000002, 0.69999999999999996, 1.0);
        // device 1922, IC IC333, analog/basic/mos_r2r_dac.hpp:27
        I(cpphdl_n2595, Vss) <+ 2.9999999999999998e-15 * ddt(V(cpphdl_n2595, Vss)); // Bench initial voltage = 0.0 V.
        // device 1923, IC IC333, analog/basic/mos_r2r_dac.hpp:28
        I(cpphdl_n2595, cpphdl_n2615) <+ V(cpphdl_n2595, cpphdl_n2615) / 2000.0;
        // device 1924, IC IC333, analog/basic/mos_r2r_dac.hpp:29
        I(cpphdl_n2615, Vss) <+ 2.9999999999999998e-15 * ddt(V(cpphdl_n2615, Vss)); // Bench initial voltage = 0.0 V.
        // device 1925, IC IC333, analog/basic/mos_r2r_dac.hpp:31
        I(cpphdl_n2614, cpphdl_n2615) <+ V(cpphdl_n2614, cpphdl_n2615) / 1000.0;
        // device 1926, IC IC338, analog/basic/inverter.hpp:11
        I(cpphdl_n2599, Vdd) <+ cpphdl_channel(V(BIT_N14_4, Vdd), V(cpphdl_n2599, Vdd), 0.080000000000000002, 0.69999999999999996, -1.0);
        // device 1927, IC IC338, analog/basic/inverter.hpp:12
        I(cpphdl_n2599, Vss) <+ cpphdl_channel(V(BIT_N14_4, Vss), V(cpphdl_n2599, Vss), 0.080000000000000002, 0.69999999999999996, 1.0);
        // device 1928, IC IC333, analog/basic/mos_r2r_dac.hpp:27
        I(cpphdl_n2599, Vss) <+ 2.9999999999999998e-15 * ddt(V(cpphdl_n2599, Vss)); // Bench initial voltage = 0.0 V.
        // device 1929, IC IC333, analog/basic/mos_r2r_dac.hpp:28
        I(cpphdl_n2599, cpphdl_n2616) <+ V(cpphdl_n2599, cpphdl_n2616) / 2000.0;
        // device 1930, IC IC333, analog/basic/mos_r2r_dac.hpp:29
        I(cpphdl_n2616, Vss) <+ 2.9999999999999998e-15 * ddt(V(cpphdl_n2616, Vss)); // Bench initial voltage = 0.0 V.
        // device 1931, IC IC333, analog/basic/mos_r2r_dac.hpp:31
        I(cpphdl_n2615, cpphdl_n2616) <+ V(cpphdl_n2615, cpphdl_n2616) / 1000.0;
        // device 1932, IC IC339, analog/basic/inverter.hpp:11
        I(cpphdl_n2603, Vdd) <+ cpphdl_channel(V(BIT_N14_5, Vdd), V(cpphdl_n2603, Vdd), 0.080000000000000002, 0.69999999999999996, -1.0);
        // device 1933, IC IC339, analog/basic/inverter.hpp:12
        I(cpphdl_n2603, Vss) <+ cpphdl_channel(V(BIT_N14_5, Vss), V(cpphdl_n2603, Vss), 0.080000000000000002, 0.69999999999999996, 1.0);
        // device 1934, IC IC333, analog/basic/mos_r2r_dac.hpp:27
        I(cpphdl_n2603, Vss) <+ 2.9999999999999998e-15 * ddt(V(cpphdl_n2603, Vss)); // Bench initial voltage = 0.0 V.
        // device 1935, IC IC333, analog/basic/mos_r2r_dac.hpp:28
        I(cpphdl_n2603, cpphdl_n2617) <+ V(cpphdl_n2603, cpphdl_n2617) / 2000.0;
        // device 1936, IC IC333, analog/basic/mos_r2r_dac.hpp:29
        I(cpphdl_n2617, Vss) <+ 2.9999999999999998e-15 * ddt(V(cpphdl_n2617, Vss)); // Bench initial voltage = 0.0 V.
        // device 1937, IC IC333, analog/basic/mos_r2r_dac.hpp:31
        I(cpphdl_n2616, cpphdl_n2617) <+ V(cpphdl_n2616, cpphdl_n2617) / 1000.0;
        // device 1938, IC IC340, analog/basic/inverter.hpp:11
        I(cpphdl_n2607, Vdd) <+ cpphdl_channel(V(BIT_N14_6, Vdd), V(cpphdl_n2607, Vdd), 0.080000000000000002, 0.69999999999999996, -1.0);
        // device 1939, IC IC340, analog/basic/inverter.hpp:12
        I(cpphdl_n2607, Vss) <+ cpphdl_channel(V(BIT_N14_6, Vss), V(cpphdl_n2607, Vss), 0.080000000000000002, 0.69999999999999996, 1.0);
        // device 1940, IC IC333, analog/basic/mos_r2r_dac.hpp:27
        I(cpphdl_n2607, Vss) <+ 2.9999999999999998e-15 * ddt(V(cpphdl_n2607, Vss)); // Bench initial voltage = 0.0 V.
        // device 1941, IC IC333, analog/basic/mos_r2r_dac.hpp:28
        I(cpphdl_n2607, cpphdl_n2618) <+ V(cpphdl_n2607, cpphdl_n2618) / 2000.0;
        // device 1942, IC IC333, analog/basic/mos_r2r_dac.hpp:29
        I(cpphdl_n2618, Vss) <+ 2.9999999999999998e-15 * ddt(V(cpphdl_n2618, Vss)); // Bench initial voltage = 0.0 V.
        // device 1943, IC IC333, analog/basic/mos_r2r_dac.hpp:31
        I(cpphdl_n2617, cpphdl_n2618) <+ V(cpphdl_n2617, cpphdl_n2618) / 1000.0;
        // device 1944, IC IC341, analog/basic/inverter.hpp:11
        I(cpphdl_n2611, Vdd) <+ cpphdl_channel(V(BIT_N14_7, Vdd), V(cpphdl_n2611, Vdd), 0.080000000000000002, 0.69999999999999996, -1.0);
        // device 1945, IC IC341, analog/basic/inverter.hpp:12
        I(cpphdl_n2611, Vss) <+ cpphdl_channel(V(BIT_N14_7, Vss), V(cpphdl_n2611, Vss), 0.080000000000000002, 0.69999999999999996, 1.0);
        // device 1946, IC IC333, analog/basic/mos_r2r_dac.hpp:27
        I(cpphdl_n2611, Vss) <+ 2.9999999999999998e-15 * ddt(V(cpphdl_n2611, Vss)); // Bench initial voltage = 0.0 V.
        // device 1947, IC IC333, analog/basic/mos_r2r_dac.hpp:28
        I(cpphdl_n2611, cpphdl_n2623) <+ V(cpphdl_n2611, cpphdl_n2623) / 2000.0;
        // device 1948, IC IC333, analog/basic/mos_r2r_dac.hpp:29
        I(cpphdl_n2623, Vss) <+ 2.9999999999999998e-15 * ddt(V(cpphdl_n2623, Vss)); // Bench initial voltage = 0.0 V.
        // device 1949, IC IC333, analog/basic/mos_r2r_dac.hpp:31
        I(cpphdl_n2618, cpphdl_n2623) <+ V(cpphdl_n2618, cpphdl_n2623) / 1000.0;
        // device 1950, IC IC333, analog/basic/mos_r2r_dac.hpp:33
        I(Vss, cpphdl_n2612) <+ V(Vss, cpphdl_n2612) / 2000.0;
        // device 1951, IC IC342, analog/basic/nmos_resistor_amplifier.hpp:23
        I(Vdd, cpphdl_n2632) <+ V(Vdd, cpphdl_n2632) / 1000.0;
        // device 1952, IC IC342, analog/basic/nmos_resistor_amplifier.hpp:24
        I(Vdd, cpphdl_n2631) <+ V(Vdd, cpphdl_n2631) / 1000.0;
        // device 1953, IC IC342, analog/basic/nmos_resistor_amplifier.hpp:25
        I(cpphdl_n2632, cpphdl_n2626) <+ cpphdl_channel(V(cpphdl_n2622, cpphdl_n2626), V(cpphdl_n2632, cpphdl_n2626), 0.014999999999999999, 0.69999999999999996, 1.0);
        // device 1954, IC IC342, analog/basic/nmos_resistor_amplifier.hpp:26
        I(cpphdl_n2631, cpphdl_n2627) <+ cpphdl_channel(V(cpphdl_n2623, cpphdl_n2627), V(cpphdl_n2631, cpphdl_n2627), 0.014999999999999999, 0.69999999999999996, 1.0);
        // device 1955, IC IC342, analog/basic/nmos_resistor_amplifier.hpp:27
        I(cpphdl_n2628, cpphdl_n2626) <+ V(cpphdl_n2628, cpphdl_n2626) / 50.0;
        // device 1956, IC IC342, analog/basic/nmos_resistor_amplifier.hpp:28
        I(cpphdl_n2628, cpphdl_n2627) <+ V(cpphdl_n2628, cpphdl_n2627) / 50.0;
        // device 1957, IC IC342, analog/basic/nmos_resistor_amplifier.hpp:29
        I(Vss, cpphdl_n2628) <+ V(Vss, cpphdl_n2628) / 150.0;
        // device 1958, IC IC342, analog/basic/nmos_resistor_amplifier.hpp:30
        I(cpphdl_n2632, Vdd) <+ 2.9999999999999998e-13 * ddt(V(cpphdl_n2632, Vdd)); // Bench initial voltage = 0.0 V.
        // device 1959, IC IC342, analog/basic/nmos_resistor_amplifier.hpp:31
        I(cpphdl_n2631, Vdd) <+ 2.9999999999999998e-13 * ddt(V(cpphdl_n2631, Vdd)); // Bench initial voltage = 0.0 V.
        // device 1960, IC IC342, analog/basic/nmos_resistor_amplifier.hpp:32
        I(cpphdl_n2628, Vss) <+ 4e-14 * ddt(V(cpphdl_n2628, Vss)); // Bench initial voltage = 0.0 V.
        // device 1961, IC IC342, analog/basic/nmos_resistor_amplifier.hpp:34
        I(cpphdl_n2622, cpphdl_n2626) <+ 2e-14 * ddt(V(cpphdl_n2622, cpphdl_n2626)); // Bench initial voltage = 1.6499999999999999 V.
        // device 1962, IC IC342, analog/basic/nmos_resistor_amplifier.hpp:35
        I(cpphdl_n2623, cpphdl_n2627) <+ 2e-14 * ddt(V(cpphdl_n2623, cpphdl_n2627)); // Bench initial voltage = 0.0 V.
        // device 1963, IC IC342, analog/basic/nmos_resistor_amplifier.hpp:36
        I(cpphdl_n2622, cpphdl_n2632) <+ 2.9999999999999998e-15 * ddt(V(cpphdl_n2622, cpphdl_n2632)); // Bench initial voltage = -1.6499999999999999 V.
        // device 1964, IC IC342, analog/basic/nmos_resistor_amplifier.hpp:37
        I(cpphdl_n2623, cpphdl_n2631) <+ 2.9999999999999998e-15 * ddt(V(cpphdl_n2623, cpphdl_n2631)); // Bench initial voltage = -3.2999999999999998 V.
        // device 1965, IC IC343, analog/basic/strongarm_comparator.hpp:28
        I(cpphdl_n2636, cpphdl_n2638) <+ cpphdl_channel(V(cpphdl_n2631, cpphdl_n2638), V(cpphdl_n2636, cpphdl_n2638), 0.0080000000000000002, 0.69999999999999996, 1.0);
        // device 1966, IC IC343, analog/basic/strongarm_comparator.hpp:29
        I(cpphdl_n2637, cpphdl_n2638) <+ cpphdl_channel(V(cpphdl_n2632, cpphdl_n2638), V(cpphdl_n2637, cpphdl_n2638), 0.0080000000000000002, 0.69999999999999996, 1.0);
        // device 1967, IC IC343, analog/basic/strongarm_comparator.hpp:30
        I(cpphdl_n2638, Vss) <+ cpphdl_channel(V(EVALUATE, Vss), V(cpphdl_n2638, Vss), 0.0080000000000000002, 0.69999999999999996, 1.0);
        // device 1968, IC IC343, analog/basic/strongarm_comparator.hpp:33
        I(cpphdl_n2651, cpphdl_n2636) <+ cpphdl_channel(V(cpphdl_n2655, cpphdl_n2636), V(cpphdl_n2651, cpphdl_n2636), 0.0040000000000000001, 0.69999999999999996, 1.0);
        // device 1969, IC IC343, analog/basic/strongarm_comparator.hpp:34
        I(cpphdl_n2655, cpphdl_n2637) <+ cpphdl_channel(V(cpphdl_n2651, cpphdl_n2637), V(cpphdl_n2655, cpphdl_n2637), 0.0040000000000000001, 0.69999999999999996, 1.0);
        // device 1970, IC IC343, analog/basic/strongarm_comparator.hpp:35
        I(cpphdl_n2655, Vdd) <+ cpphdl_channel(V(cpphdl_n2651, Vdd), V(cpphdl_n2655, Vdd), 0.002, 0.69999999999999996, -1.0);
        // device 1971, IC IC343, analog/basic/strongarm_comparator.hpp:36
        I(cpphdl_n2651, Vdd) <+ cpphdl_channel(V(cpphdl_n2655, Vdd), V(cpphdl_n2651, Vdd), 0.002, 0.69999999999999996, -1.0);
        // device 1972, IC IC343, analog/basic/strongarm_comparator.hpp:38
        I(cpphdl_n2636, Vdd) <+ cpphdl_channel(V(EVALUATE, Vdd), V(cpphdl_n2636, Vdd), 0.002, 0.69999999999999996, -1.0);
        // device 1973, IC IC343, analog/basic/strongarm_comparator.hpp:39
        I(cpphdl_n2637, Vdd) <+ cpphdl_channel(V(EVALUATE, Vdd), V(cpphdl_n2637, Vdd), 0.002, 0.69999999999999996, -1.0);
        // device 1974, IC IC343, analog/basic/strongarm_comparator.hpp:40
        I(cpphdl_n2655, Vdd) <+ cpphdl_channel(V(EVALUATE, Vdd), V(cpphdl_n2655, Vdd), 0.002, 0.69999999999999996, -1.0);
        // device 1975, IC IC343, analog/basic/strongarm_comparator.hpp:41
        I(cpphdl_n2651, Vdd) <+ cpphdl_channel(V(EVALUATE, Vdd), V(cpphdl_n2651, Vdd), 0.002, 0.69999999999999996, -1.0);
        // device 1976, IC IC343, analog/basic/strongarm_comparator.hpp:42
        I(cpphdl_n2636, Vss) <+ 2.9999999999999998e-14 * ddt(V(cpphdl_n2636, Vss)); // Bench initial voltage = 0.0 V.
        // device 1977, IC IC343, analog/basic/strongarm_comparator.hpp:43
        I(cpphdl_n2637, Vss) <+ 2.9999999999999998e-14 * ddt(V(cpphdl_n2637, Vss)); // Bench initial voltage = 0.0 V.
        // device 1978, IC IC343, analog/basic/strongarm_comparator.hpp:44
        I(cpphdl_n2638, Vss) <+ 2.9999999999999998e-14 * ddt(V(cpphdl_n2638, Vss)); // Bench initial voltage = 0.0 V.
        // device 1979, IC IC343, analog/basic/strongarm_comparator.hpp:45
        I(cpphdl_n2655, Vss) <+ 5.0000000000000002e-14 * ddt(V(cpphdl_n2655, Vss)); // Bench initial voltage = 0.0 V.
        // device 1980, IC IC343, analog/basic/strongarm_comparator.hpp:46
        I(cpphdl_n2651, Vss) <+ 5.0000000000000002e-14 * ddt(V(cpphdl_n2651, Vss)); // Bench initial voltage = 0.0 V.
        // device 1981, IC IC343, analog/basic/strongarm_comparator.hpp:47
        I(cpphdl_n2631, cpphdl_n2638) <+ 2e-14 * ddt(V(cpphdl_n2631, cpphdl_n2638)); // Bench initial voltage = 3.2999999999999998 V.
        // device 1982, IC IC343, analog/basic/strongarm_comparator.hpp:48
        I(cpphdl_n2632, cpphdl_n2638) <+ 2e-14 * ddt(V(cpphdl_n2632, cpphdl_n2638)); // Bench initial voltage = 3.2999999999999998 V.
        // device 1983, IC IC343, analog/basic/strongarm_comparator.hpp:49
        I(cpphdl_n2631, cpphdl_n2636) <+ 2.9999999999999998e-15 * ddt(V(cpphdl_n2631, cpphdl_n2636)); // Bench initial voltage = 3.2999999999999998 V.
        // device 1984, IC IC343, analog/basic/strongarm_comparator.hpp:50
        I(cpphdl_n2632, cpphdl_n2637) <+ 2.9999999999999998e-15 * ddt(V(cpphdl_n2632, cpphdl_n2637)); // Bench initial voltage = 3.2999999999999998 V.
        // device 1985, IC IC345, analog/basic/inverter.hpp:11
        I(cpphdl_n2659, Vdd) <+ cpphdl_channel(V(cpphdl_n2651, Vdd), V(cpphdl_n2659, Vdd), 0.001, 0.69999999999999996, -1.0);
        // device 1986, IC IC345, analog/basic/inverter.hpp:12
        I(cpphdl_n2659, Vss) <+ cpphdl_channel(V(cpphdl_n2651, Vss), V(cpphdl_n2659, Vss), 0.001, 0.69999999999999996, 1.0);
        // device 1987, IC IC347, analog/basic/inverter.hpp:11
        I(cpphdl_n2673, Vdd) <+ cpphdl_channel(V(cpphdl_n2659, Vdd), V(cpphdl_n2673, Vdd), 0.0040000000000000001, 0.69999999999999996, -1.0);
        // device 1988, IC IC347, analog/basic/inverter.hpp:12
        I(cpphdl_n2673, Vss) <+ cpphdl_channel(V(cpphdl_n2659, Vss), V(cpphdl_n2673, Vss), 0.0040000000000000001, 0.69999999999999996, 1.0);
        // device 1989, IC IC344, analog/basic/buffered_nand_latch.hpp:34
        I(cpphdl_n2651, Vss) <+ 2.0000000000000002e-15 * ddt(V(cpphdl_n2651, Vss)); // Bench initial voltage = 0.0 V.
        // device 1990, IC IC344, analog/basic/buffered_nand_latch.hpp:35
        I(cpphdl_n2651, cpphdl_n2659) <+ 1.0000000000000001e-15 * ddt(V(cpphdl_n2651, cpphdl_n2659)); // Bench initial voltage = 0.0 V.
        // device 1991, IC IC344, analog/basic/buffered_nand_latch.hpp:36
        I(cpphdl_n2659, Vss) <+ 5e-15 * ddt(V(cpphdl_n2659, Vss)); // Bench initial voltage = 0.0 V.
        // device 1992, IC IC344, analog/basic/buffered_nand_latch.hpp:37
        I(cpphdl_n2659, Vss) <+ 8.0000000000000006e-15 * ddt(V(cpphdl_n2659, Vss)); // Bench initial voltage = 0.0 V.
        // device 1993, IC IC344, analog/basic/buffered_nand_latch.hpp:38
        I(cpphdl_n2673, Vss) <+ 1e-14 * ddt(V(cpphdl_n2673, Vss)); // Bench initial voltage = 0.0 V.
        // device 1994, IC IC346, analog/basic/inverter.hpp:11
        I(cpphdl_n2663, Vdd) <+ cpphdl_channel(V(cpphdl_n2655, Vdd), V(cpphdl_n2663, Vdd), 0.001, 0.69999999999999996, -1.0);
        // device 1995, IC IC346, analog/basic/inverter.hpp:12
        I(cpphdl_n2663, Vss) <+ cpphdl_channel(V(cpphdl_n2655, Vss), V(cpphdl_n2663, Vss), 0.001, 0.69999999999999996, 1.0);
        // device 1996, IC IC348, analog/basic/inverter.hpp:11
        I(cpphdl_n2679, Vdd) <+ cpphdl_channel(V(cpphdl_n2663, Vdd), V(cpphdl_n2679, Vdd), 0.0040000000000000001, 0.69999999999999996, -1.0);
        // device 1997, IC IC348, analog/basic/inverter.hpp:12
        I(cpphdl_n2679, Vss) <+ cpphdl_channel(V(cpphdl_n2663, Vss), V(cpphdl_n2679, Vss), 0.0040000000000000001, 0.69999999999999996, 1.0);
        // device 1998, IC IC344, analog/basic/buffered_nand_latch.hpp:34
        I(cpphdl_n2655, Vss) <+ 2.0000000000000002e-15 * ddt(V(cpphdl_n2655, Vss)); // Bench initial voltage = 0.0 V.
        // device 1999, IC IC344, analog/basic/buffered_nand_latch.hpp:35
        I(cpphdl_n2655, cpphdl_n2663) <+ 1.0000000000000001e-15 * ddt(V(cpphdl_n2655, cpphdl_n2663)); // Bench initial voltage = 0.0 V.
        // device 2000, IC IC344, analog/basic/buffered_nand_latch.hpp:36
        I(cpphdl_n2663, Vss) <+ 5e-15 * ddt(V(cpphdl_n2663, Vss)); // Bench initial voltage = 0.0 V.
        // device 2001, IC IC344, analog/basic/buffered_nand_latch.hpp:37
        I(cpphdl_n2663, Vss) <+ 8.0000000000000006e-15 * ddt(V(cpphdl_n2663, Vss)); // Bench initial voltage = 0.0 V.
        // device 2002, IC IC344, analog/basic/buffered_nand_latch.hpp:38
        I(cpphdl_n2679, Vss) <+ 1e-14 * ddt(V(cpphdl_n2679, Vss)); // Bench initial voltage = 0.0 V.
        // device 2003, IC IC350, analog/basic/cmos_logic.hpp:17
        I(cpphdl_n2920, Vss) <+ 5.0000000000000002e-14 * ddt(V(cpphdl_n2920, Vss)); // Bench initial voltage = 0.0 V.
        // device 2004, IC IC350, analog/basic/cmos_logic.hpp:18
        I(cpphdl_n2920, Vdd) <+ cpphdl_channel(V(cpphdl_n2673, Vdd), V(cpphdl_n2920, Vdd), 0.01, 0.69999999999999996, -1.0);
        // device 2005, IC IC350, analog/basic/cmos_logic.hpp:19
        I(cpphdl_n2920, Vdd) <+ cpphdl_channel(V(cpphdl_n2681, Vdd), V(cpphdl_n2920, Vdd), 0.01, 0.69999999999999996, -1.0);
        // device 2006, IC IC350, analog/basic/cmos_logic.hpp:20
        I(cpphdl_n2920, cpphdl_n2676) <+ cpphdl_channel(V(cpphdl_n2673, cpphdl_n2676), V(cpphdl_n2920, cpphdl_n2676), 0.01, 0.69999999999999996, 1.0);
        // device 2007, IC IC350, analog/basic/cmos_logic.hpp:21
        I(cpphdl_n2676, Vss) <+ cpphdl_channel(V(cpphdl_n2681, Vss), V(cpphdl_n2676, Vss), 0.01, 0.69999999999999996, 1.0);
        // device 2008, IC IC350, analog/basic/cmos_logic.hpp:23
        I(cpphdl_n2920, Vss) <+ V(cpphdl_n2920, Vss) / 1000000000.0;
        // device 2009, IC IC350, analog/basic/cmos_logic.hpp:24
        I(cpphdl_n2676, Vss) <+ V(cpphdl_n2676, Vss) / 1000000000.0;
        // device 2010, IC IC351, analog/basic/cmos_logic.hpp:17
        I(cpphdl_n2681, Vss) <+ 5.0000000000000002e-14 * ddt(V(cpphdl_n2681, Vss)); // Bench initial voltage = 0.0 V.
        // device 2011, IC IC351, analog/basic/cmos_logic.hpp:18
        I(cpphdl_n2681, Vdd) <+ cpphdl_channel(V(cpphdl_n2679, Vdd), V(cpphdl_n2681, Vdd), 0.01, 0.69999999999999996, -1.0);
        // device 2012, IC IC351, analog/basic/cmos_logic.hpp:19
        I(cpphdl_n2681, Vdd) <+ cpphdl_channel(V(cpphdl_n2920, Vdd), V(cpphdl_n2681, Vdd), 0.01, 0.69999999999999996, -1.0);
        // device 2013, IC IC351, analog/basic/cmos_logic.hpp:20
        I(cpphdl_n2681, cpphdl_n2682) <+ cpphdl_channel(V(cpphdl_n2679, cpphdl_n2682), V(cpphdl_n2681, cpphdl_n2682), 0.01, 0.69999999999999996, 1.0);
        // device 2014, IC IC351, analog/basic/cmos_logic.hpp:21
        I(cpphdl_n2682, Vss) <+ cpphdl_channel(V(cpphdl_n2920, Vss), V(cpphdl_n2682, Vss), 0.01, 0.69999999999999996, 1.0);
        // device 2015, IC IC351, analog/basic/cmos_logic.hpp:23
        I(cpphdl_n2681, Vss) <+ V(cpphdl_n2681, Vss) / 1000000000.0;
        // device 2016, IC IC351, analog/basic/cmos_logic.hpp:24
        I(cpphdl_n2682, Vss) <+ V(cpphdl_n2682, Vss) / 1000000000.0;
        // device 2017, IC IC349, analog/basic/nand_latch.hpp:36
        I(cpphdl_n2673, Vss) <+ 2.9999999999999998e-15 * ddt(V(cpphdl_n2673, Vss)); // Bench initial voltage = 0.0 V.
        // device 2018, IC IC349, analog/basic/nand_latch.hpp:37
        I(cpphdl_n2679, Vss) <+ 2.9999999999999998e-15 * ddt(V(cpphdl_n2679, Vss)); // Bench initial voltage = 0.0 V.
        // device 2019, IC IC352, analog/basic/inverter.hpp:11
        I(cpphdl_n2687, Vdd) <+ cpphdl_channel(V(CLEAR, Vdd), V(cpphdl_n2687, Vdd), 0.01, 0.69999999999999996, -1.0);
        // device 2020, IC IC352, analog/basic/inverter.hpp:12
        I(cpphdl_n2687, Vss) <+ cpphdl_channel(V(CLEAR, Vss), V(cpphdl_n2687, Vss), 0.01, 0.69999999999999996, 1.0);
        // device 2021, IC IC349, analog/basic/nand_latch.hpp:58
        I(cpphdl_n2687, Vss) <+ 2.9999999999999998e-15 * ddt(V(cpphdl_n2687, Vss)); // Bench initial voltage = 0.0 V.
        // device 2022, IC IC349, analog/basic/nand_latch.hpp:59
        I(cpphdl_n2920, Vss) <+ cpphdl_channel(V(CLEAR, Vss), V(cpphdl_n2920, Vss), 0.050000000000000003, 0.69999999999999996, 1.0);
        // device 2023, IC IC349, analog/basic/nand_latch.hpp:60
        I(cpphdl_n2681, Vdd) <+ cpphdl_channel(V(cpphdl_n2687, Vdd), V(cpphdl_n2681, Vdd), 0.050000000000000003, 0.69999999999999996, -1.0);
        // device 2024, IC IC355, analog/basic/inverter.hpp:11
        I(cpphdl_n2711, Vdd) <+ cpphdl_channel(V(TRACK15, Vdd), V(cpphdl_n2711, Vdd), 0.0040000000000000001, 0.69999999999999996, -1.0);
        // device 2025, IC IC355, analog/basic/inverter.hpp:12
        I(cpphdl_n2711, Vss) <+ cpphdl_channel(V(TRACK15, Vss), V(cpphdl_n2711, Vss), 0.0040000000000000001, 0.69999999999999996, 1.0);
        // device 2026, IC IC354, analog/basic/mos_track_hold.hpp:31
        I(cpphdl_n2711, Vss) <+ 2e-14 * ddt(V(cpphdl_n2711, Vss)); // Bench initial voltage = 3.2999999999999998 V.
        // device 2027, IC IC354, analog/basic/mos_track_hold.hpp:32
        I(cpphdl_n2705, cpphdl_n2765) <+ cpphdl_channel(V(TRACK15, cpphdl_n2765), V(cpphdl_n2705, cpphdl_n2765), 0.080000000000000002, 0.69999999999999996, 1.0);
        // device 2028, IC IC354, analog/basic/mos_track_hold.hpp:33
        I(cpphdl_n2765, cpphdl_n2705) <+ cpphdl_channel(V(cpphdl_n2711, cpphdl_n2705), V(cpphdl_n2765, cpphdl_n2705), 0.040000000000000001, 0.69999999999999996, -1.0);
        // device 2029, IC IC354, analog/basic/mos_track_hold.hpp:37
        I(cpphdl_n2765, cpphdl_n2765) <+ cpphdl_channel(V(cpphdl_n2711, cpphdl_n2765), V(cpphdl_n2765, cpphdl_n2765), 0.040000000000000001, 0.69999999999999996, 1.0);
        // device 2030, IC IC354, analog/basic/mos_track_hold.hpp:38
        I(cpphdl_n2765, cpphdl_n2765) <+ cpphdl_channel(V(TRACK15, cpphdl_n2765), V(cpphdl_n2765, cpphdl_n2765), 0.02, 0.69999999999999996, -1.0);
        // device 2031, IC IC354, analog/basic/mos_track_hold.hpp:39
        I(cpphdl_n2765, Vss) <+ 2e-12 * ddt(V(cpphdl_n2765, Vss)); // Bench initial voltage = 1.6499999999999999 V.
        // device 2032, IC IC354, analog/basic/mos_track_hold.hpp:41
        I(Vss, cpphdl_n2765) <+ V(Vss, cpphdl_n2765) / 1000000000.0;
        // device 2033, IC IC354, analog/basic/mos_track_hold.hpp:42
        I(TRACK15, cpphdl_n2765) <+ 8.0000000000000006e-15 * ddt(V(TRACK15, cpphdl_n2765)); // Bench initial voltage = -1.6499999999999999 V.
        // device 2034, IC IC354, analog/basic/mos_track_hold.hpp:43
        I(cpphdl_n2711, cpphdl_n2765) <+ 8.0000000000000006e-15 * ddt(V(cpphdl_n2711, cpphdl_n2765)); // Bench initial voltage = 1.6499999999999999 V.
        // device 2035, IC IC354, analog/basic/mos_track_hold.hpp:44
        I(cpphdl_n2705, cpphdl_n2765) <+ 4.0000000000000003e-15 * ddt(V(cpphdl_n2705, cpphdl_n2765)); // Bench initial voltage = 0.0 V.
        // device 2036, IC IC357, analog/basic/inverter.hpp:11
        I(cpphdl_n2726, Vdd) <+ cpphdl_channel(V(BIT_N15_0, Vdd), V(cpphdl_n2726, Vdd), 0.080000000000000002, 0.69999999999999996, -1.0);
        // device 2037, IC IC357, analog/basic/inverter.hpp:12
        I(cpphdl_n2726, Vss) <+ cpphdl_channel(V(BIT_N15_0, Vss), V(cpphdl_n2726, Vss), 0.080000000000000002, 0.69999999999999996, 1.0);
        // device 2038, IC IC356, analog/basic/mos_r2r_dac.hpp:27
        I(cpphdl_n2726, Vss) <+ 2.9999999999999998e-15 * ddt(V(cpphdl_n2726, Vss)); // Bench initial voltage = 0.0 V.
        // device 2039, IC IC356, analog/basic/mos_r2r_dac.hpp:28
        I(cpphdl_n2726, cpphdl_n2755) <+ V(cpphdl_n2726, cpphdl_n2755) / 2000.0;
        // device 2040, IC IC356, analog/basic/mos_r2r_dac.hpp:29
        I(cpphdl_n2755, Vss) <+ 2.9999999999999998e-15 * ddt(V(cpphdl_n2755, Vss)); // Bench initial voltage = 0.0 V.
        // device 2041, IC IC358, analog/basic/inverter.hpp:11
        I(cpphdl_n2730, Vdd) <+ cpphdl_channel(V(BIT_N15_1, Vdd), V(cpphdl_n2730, Vdd), 0.080000000000000002, 0.69999999999999996, -1.0);
        // device 2042, IC IC358, analog/basic/inverter.hpp:12
        I(cpphdl_n2730, Vss) <+ cpphdl_channel(V(BIT_N15_1, Vss), V(cpphdl_n2730, Vss), 0.080000000000000002, 0.69999999999999996, 1.0);
        // device 2043, IC IC356, analog/basic/mos_r2r_dac.hpp:27
        I(cpphdl_n2730, Vss) <+ 2.9999999999999998e-15 * ddt(V(cpphdl_n2730, Vss)); // Bench initial voltage = 0.0 V.
        // device 2044, IC IC356, analog/basic/mos_r2r_dac.hpp:28
        I(cpphdl_n2730, cpphdl_n2756) <+ V(cpphdl_n2730, cpphdl_n2756) / 2000.0;
        // device 2045, IC IC356, analog/basic/mos_r2r_dac.hpp:29
        I(cpphdl_n2756, Vss) <+ 2.9999999999999998e-15 * ddt(V(cpphdl_n2756, Vss)); // Bench initial voltage = 0.0 V.
        // device 2046, IC IC356, analog/basic/mos_r2r_dac.hpp:31
        I(cpphdl_n2755, cpphdl_n2756) <+ V(cpphdl_n2755, cpphdl_n2756) / 1000.0;
        // device 2047, IC IC359, analog/basic/inverter.hpp:11
        I(cpphdl_n2734, Vdd) <+ cpphdl_channel(V(BIT_N15_2, Vdd), V(cpphdl_n2734, Vdd), 0.080000000000000002, 0.69999999999999996, -1.0);
        // device 2048, IC IC359, analog/basic/inverter.hpp:12
        I(cpphdl_n2734, Vss) <+ cpphdl_channel(V(BIT_N15_2, Vss), V(cpphdl_n2734, Vss), 0.080000000000000002, 0.69999999999999996, 1.0);
        // device 2049, IC IC356, analog/basic/mos_r2r_dac.hpp:27
        I(cpphdl_n2734, Vss) <+ 2.9999999999999998e-15 * ddt(V(cpphdl_n2734, Vss)); // Bench initial voltage = 0.0 V.
        // device 2050, IC IC356, analog/basic/mos_r2r_dac.hpp:28
        I(cpphdl_n2734, cpphdl_n2757) <+ V(cpphdl_n2734, cpphdl_n2757) / 2000.0;
        // device 2051, IC IC356, analog/basic/mos_r2r_dac.hpp:29
        I(cpphdl_n2757, Vss) <+ 2.9999999999999998e-15 * ddt(V(cpphdl_n2757, Vss)); // Bench initial voltage = 0.0 V.
        // device 2052, IC IC356, analog/basic/mos_r2r_dac.hpp:31
        I(cpphdl_n2756, cpphdl_n2757) <+ V(cpphdl_n2756, cpphdl_n2757) / 1000.0;
        // device 2053, IC IC360, analog/basic/inverter.hpp:11
        I(cpphdl_n2738, Vdd) <+ cpphdl_channel(V(BIT_N15_3, Vdd), V(cpphdl_n2738, Vdd), 0.080000000000000002, 0.69999999999999996, -1.0);
        // device 2054, IC IC360, analog/basic/inverter.hpp:12
        I(cpphdl_n2738, Vss) <+ cpphdl_channel(V(BIT_N15_3, Vss), V(cpphdl_n2738, Vss), 0.080000000000000002, 0.69999999999999996, 1.0);
        // device 2055, IC IC356, analog/basic/mos_r2r_dac.hpp:27
        I(cpphdl_n2738, Vss) <+ 2.9999999999999998e-15 * ddt(V(cpphdl_n2738, Vss)); // Bench initial voltage = 0.0 V.
        // device 2056, IC IC356, analog/basic/mos_r2r_dac.hpp:28
        I(cpphdl_n2738, cpphdl_n2758) <+ V(cpphdl_n2738, cpphdl_n2758) / 2000.0;
        // device 2057, IC IC356, analog/basic/mos_r2r_dac.hpp:29
        I(cpphdl_n2758, Vss) <+ 2.9999999999999998e-15 * ddt(V(cpphdl_n2758, Vss)); // Bench initial voltage = 0.0 V.
        // device 2058, IC IC356, analog/basic/mos_r2r_dac.hpp:31
        I(cpphdl_n2757, cpphdl_n2758) <+ V(cpphdl_n2757, cpphdl_n2758) / 1000.0;
        // device 2059, IC IC361, analog/basic/inverter.hpp:11
        I(cpphdl_n2742, Vdd) <+ cpphdl_channel(V(BIT_N15_4, Vdd), V(cpphdl_n2742, Vdd), 0.080000000000000002, 0.69999999999999996, -1.0);
        // device 2060, IC IC361, analog/basic/inverter.hpp:12
        I(cpphdl_n2742, Vss) <+ cpphdl_channel(V(BIT_N15_4, Vss), V(cpphdl_n2742, Vss), 0.080000000000000002, 0.69999999999999996, 1.0);
        // device 2061, IC IC356, analog/basic/mos_r2r_dac.hpp:27
        I(cpphdl_n2742, Vss) <+ 2.9999999999999998e-15 * ddt(V(cpphdl_n2742, Vss)); // Bench initial voltage = 0.0 V.
        // device 2062, IC IC356, analog/basic/mos_r2r_dac.hpp:28
        I(cpphdl_n2742, cpphdl_n2759) <+ V(cpphdl_n2742, cpphdl_n2759) / 2000.0;
        // device 2063, IC IC356, analog/basic/mos_r2r_dac.hpp:29
        I(cpphdl_n2759, Vss) <+ 2.9999999999999998e-15 * ddt(V(cpphdl_n2759, Vss)); // Bench initial voltage = 0.0 V.
        // device 2064, IC IC356, analog/basic/mos_r2r_dac.hpp:31
        I(cpphdl_n2758, cpphdl_n2759) <+ V(cpphdl_n2758, cpphdl_n2759) / 1000.0;
        // device 2065, IC IC362, analog/basic/inverter.hpp:11
        I(cpphdl_n2746, Vdd) <+ cpphdl_channel(V(BIT_N15_5, Vdd), V(cpphdl_n2746, Vdd), 0.080000000000000002, 0.69999999999999996, -1.0);
        // device 2066, IC IC362, analog/basic/inverter.hpp:12
        I(cpphdl_n2746, Vss) <+ cpphdl_channel(V(BIT_N15_5, Vss), V(cpphdl_n2746, Vss), 0.080000000000000002, 0.69999999999999996, 1.0);
        // device 2067, IC IC356, analog/basic/mos_r2r_dac.hpp:27
        I(cpphdl_n2746, Vss) <+ 2.9999999999999998e-15 * ddt(V(cpphdl_n2746, Vss)); // Bench initial voltage = 0.0 V.
        // device 2068, IC IC356, analog/basic/mos_r2r_dac.hpp:28
        I(cpphdl_n2746, cpphdl_n2760) <+ V(cpphdl_n2746, cpphdl_n2760) / 2000.0;
        // device 2069, IC IC356, analog/basic/mos_r2r_dac.hpp:29
        I(cpphdl_n2760, Vss) <+ 2.9999999999999998e-15 * ddt(V(cpphdl_n2760, Vss)); // Bench initial voltage = 0.0 V.
        // device 2070, IC IC356, analog/basic/mos_r2r_dac.hpp:31
        I(cpphdl_n2759, cpphdl_n2760) <+ V(cpphdl_n2759, cpphdl_n2760) / 1000.0;
        // device 2071, IC IC363, analog/basic/inverter.hpp:11
        I(cpphdl_n2750, Vdd) <+ cpphdl_channel(V(BIT_N15_6, Vdd), V(cpphdl_n2750, Vdd), 0.080000000000000002, 0.69999999999999996, -1.0);
        // device 2072, IC IC363, analog/basic/inverter.hpp:12
        I(cpphdl_n2750, Vss) <+ cpphdl_channel(V(BIT_N15_6, Vss), V(cpphdl_n2750, Vss), 0.080000000000000002, 0.69999999999999996, 1.0);
        // device 2073, IC IC356, analog/basic/mos_r2r_dac.hpp:27
        I(cpphdl_n2750, Vss) <+ 2.9999999999999998e-15 * ddt(V(cpphdl_n2750, Vss)); // Bench initial voltage = 0.0 V.
        // device 2074, IC IC356, analog/basic/mos_r2r_dac.hpp:28
        I(cpphdl_n2750, cpphdl_n2761) <+ V(cpphdl_n2750, cpphdl_n2761) / 2000.0;
        // device 2075, IC IC356, analog/basic/mos_r2r_dac.hpp:29
        I(cpphdl_n2761, Vss) <+ 2.9999999999999998e-15 * ddt(V(cpphdl_n2761, Vss)); // Bench initial voltage = 0.0 V.
        // device 2076, IC IC356, analog/basic/mos_r2r_dac.hpp:31
        I(cpphdl_n2760, cpphdl_n2761) <+ V(cpphdl_n2760, cpphdl_n2761) / 1000.0;
        // device 2077, IC IC364, analog/basic/inverter.hpp:11
        I(cpphdl_n2754, Vdd) <+ cpphdl_channel(V(BIT_N15_7, Vdd), V(cpphdl_n2754, Vdd), 0.080000000000000002, 0.69999999999999996, -1.0);
        // device 2078, IC IC364, analog/basic/inverter.hpp:12
        I(cpphdl_n2754, Vss) <+ cpphdl_channel(V(BIT_N15_7, Vss), V(cpphdl_n2754, Vss), 0.080000000000000002, 0.69999999999999996, 1.0);
        // device 2079, IC IC356, analog/basic/mos_r2r_dac.hpp:27
        I(cpphdl_n2754, Vss) <+ 2.9999999999999998e-15 * ddt(V(cpphdl_n2754, Vss)); // Bench initial voltage = 0.0 V.
        // device 2080, IC IC356, analog/basic/mos_r2r_dac.hpp:28
        I(cpphdl_n2754, cpphdl_n2766) <+ V(cpphdl_n2754, cpphdl_n2766) / 2000.0;
        // device 2081, IC IC356, analog/basic/mos_r2r_dac.hpp:29
        I(cpphdl_n2766, Vss) <+ 2.9999999999999998e-15 * ddt(V(cpphdl_n2766, Vss)); // Bench initial voltage = 0.0 V.
        // device 2082, IC IC356, analog/basic/mos_r2r_dac.hpp:31
        I(cpphdl_n2761, cpphdl_n2766) <+ V(cpphdl_n2761, cpphdl_n2766) / 1000.0;
        // device 2083, IC IC356, analog/basic/mos_r2r_dac.hpp:33
        I(Vss, cpphdl_n2755) <+ V(Vss, cpphdl_n2755) / 2000.0;
        // device 2084, IC IC365, analog/basic/nmos_resistor_amplifier.hpp:23
        I(Vdd, cpphdl_n2775) <+ V(Vdd, cpphdl_n2775) / 1000.0;
        // device 2085, IC IC365, analog/basic/nmos_resistor_amplifier.hpp:24
        I(Vdd, cpphdl_n2774) <+ V(Vdd, cpphdl_n2774) / 1000.0;
        // device 2086, IC IC365, analog/basic/nmos_resistor_amplifier.hpp:25
        I(cpphdl_n2775, cpphdl_n2769) <+ cpphdl_channel(V(cpphdl_n2765, cpphdl_n2769), V(cpphdl_n2775, cpphdl_n2769), 0.014999999999999999, 0.69999999999999996, 1.0);
        // device 2087, IC IC365, analog/basic/nmos_resistor_amplifier.hpp:26
        I(cpphdl_n2774, cpphdl_n2770) <+ cpphdl_channel(V(cpphdl_n2766, cpphdl_n2770), V(cpphdl_n2774, cpphdl_n2770), 0.014999999999999999, 0.69999999999999996, 1.0);
        // device 2088, IC IC365, analog/basic/nmos_resistor_amplifier.hpp:27
        I(cpphdl_n2771, cpphdl_n2769) <+ V(cpphdl_n2771, cpphdl_n2769) / 50.0;
        // device 2089, IC IC365, analog/basic/nmos_resistor_amplifier.hpp:28
        I(cpphdl_n2771, cpphdl_n2770) <+ V(cpphdl_n2771, cpphdl_n2770) / 50.0;
        // device 2090, IC IC365, analog/basic/nmos_resistor_amplifier.hpp:29
        I(Vss, cpphdl_n2771) <+ V(Vss, cpphdl_n2771) / 150.0;
        // device 2091, IC IC365, analog/basic/nmos_resistor_amplifier.hpp:30
        I(cpphdl_n2775, Vdd) <+ 2.9999999999999998e-13 * ddt(V(cpphdl_n2775, Vdd)); // Bench initial voltage = 0.0 V.
        // device 2092, IC IC365, analog/basic/nmos_resistor_amplifier.hpp:31
        I(cpphdl_n2774, Vdd) <+ 2.9999999999999998e-13 * ddt(V(cpphdl_n2774, Vdd)); // Bench initial voltage = 0.0 V.
        // device 2093, IC IC365, analog/basic/nmos_resistor_amplifier.hpp:32
        I(cpphdl_n2771, Vss) <+ 4e-14 * ddt(V(cpphdl_n2771, Vss)); // Bench initial voltage = 0.0 V.
        // device 2094, IC IC365, analog/basic/nmos_resistor_amplifier.hpp:34
        I(cpphdl_n2765, cpphdl_n2769) <+ 2e-14 * ddt(V(cpphdl_n2765, cpphdl_n2769)); // Bench initial voltage = 1.6499999999999999 V.
        // device 2095, IC IC365, analog/basic/nmos_resistor_amplifier.hpp:35
        I(cpphdl_n2766, cpphdl_n2770) <+ 2e-14 * ddt(V(cpphdl_n2766, cpphdl_n2770)); // Bench initial voltage = 0.0 V.
        // device 2096, IC IC365, analog/basic/nmos_resistor_amplifier.hpp:36
        I(cpphdl_n2765, cpphdl_n2775) <+ 2.9999999999999998e-15 * ddt(V(cpphdl_n2765, cpphdl_n2775)); // Bench initial voltage = -1.6499999999999999 V.
        // device 2097, IC IC365, analog/basic/nmos_resistor_amplifier.hpp:37
        I(cpphdl_n2766, cpphdl_n2774) <+ 2.9999999999999998e-15 * ddt(V(cpphdl_n2766, cpphdl_n2774)); // Bench initial voltage = -3.2999999999999998 V.
        // device 2098, IC IC366, analog/basic/strongarm_comparator.hpp:28
        I(cpphdl_n2779, cpphdl_n2781) <+ cpphdl_channel(V(cpphdl_n2774, cpphdl_n2781), V(cpphdl_n2779, cpphdl_n2781), 0.0080000000000000002, 0.69999999999999996, 1.0);
        // device 2099, IC IC366, analog/basic/strongarm_comparator.hpp:29
        I(cpphdl_n2780, cpphdl_n2781) <+ cpphdl_channel(V(cpphdl_n2775, cpphdl_n2781), V(cpphdl_n2780, cpphdl_n2781), 0.0080000000000000002, 0.69999999999999996, 1.0);
        // device 2100, IC IC366, analog/basic/strongarm_comparator.hpp:30
        I(cpphdl_n2781, Vss) <+ cpphdl_channel(V(EVALUATE, Vss), V(cpphdl_n2781, Vss), 0.0080000000000000002, 0.69999999999999996, 1.0);
        // device 2101, IC IC366, analog/basic/strongarm_comparator.hpp:33
        I(cpphdl_n2794, cpphdl_n2779) <+ cpphdl_channel(V(cpphdl_n2798, cpphdl_n2779), V(cpphdl_n2794, cpphdl_n2779), 0.0040000000000000001, 0.69999999999999996, 1.0);
        // device 2102, IC IC366, analog/basic/strongarm_comparator.hpp:34
        I(cpphdl_n2798, cpphdl_n2780) <+ cpphdl_channel(V(cpphdl_n2794, cpphdl_n2780), V(cpphdl_n2798, cpphdl_n2780), 0.0040000000000000001, 0.69999999999999996, 1.0);
        // device 2103, IC IC366, analog/basic/strongarm_comparator.hpp:35
        I(cpphdl_n2798, Vdd) <+ cpphdl_channel(V(cpphdl_n2794, Vdd), V(cpphdl_n2798, Vdd), 0.002, 0.69999999999999996, -1.0);
        // device 2104, IC IC366, analog/basic/strongarm_comparator.hpp:36
        I(cpphdl_n2794, Vdd) <+ cpphdl_channel(V(cpphdl_n2798, Vdd), V(cpphdl_n2794, Vdd), 0.002, 0.69999999999999996, -1.0);
        // device 2105, IC IC366, analog/basic/strongarm_comparator.hpp:38
        I(cpphdl_n2779, Vdd) <+ cpphdl_channel(V(EVALUATE, Vdd), V(cpphdl_n2779, Vdd), 0.002, 0.69999999999999996, -1.0);
        // device 2106, IC IC366, analog/basic/strongarm_comparator.hpp:39
        I(cpphdl_n2780, Vdd) <+ cpphdl_channel(V(EVALUATE, Vdd), V(cpphdl_n2780, Vdd), 0.002, 0.69999999999999996, -1.0);
        // device 2107, IC IC366, analog/basic/strongarm_comparator.hpp:40
        I(cpphdl_n2798, Vdd) <+ cpphdl_channel(V(EVALUATE, Vdd), V(cpphdl_n2798, Vdd), 0.002, 0.69999999999999996, -1.0);
        // device 2108, IC IC366, analog/basic/strongarm_comparator.hpp:41
        I(cpphdl_n2794, Vdd) <+ cpphdl_channel(V(EVALUATE, Vdd), V(cpphdl_n2794, Vdd), 0.002, 0.69999999999999996, -1.0);
        // device 2109, IC IC366, analog/basic/strongarm_comparator.hpp:42
        I(cpphdl_n2779, Vss) <+ 2.9999999999999998e-14 * ddt(V(cpphdl_n2779, Vss)); // Bench initial voltage = 0.0 V.
        // device 2110, IC IC366, analog/basic/strongarm_comparator.hpp:43
        I(cpphdl_n2780, Vss) <+ 2.9999999999999998e-14 * ddt(V(cpphdl_n2780, Vss)); // Bench initial voltage = 0.0 V.
        // device 2111, IC IC366, analog/basic/strongarm_comparator.hpp:44
        I(cpphdl_n2781, Vss) <+ 2.9999999999999998e-14 * ddt(V(cpphdl_n2781, Vss)); // Bench initial voltage = 0.0 V.
        // device 2112, IC IC366, analog/basic/strongarm_comparator.hpp:45
        I(cpphdl_n2798, Vss) <+ 5.0000000000000002e-14 * ddt(V(cpphdl_n2798, Vss)); // Bench initial voltage = 0.0 V.
        // device 2113, IC IC366, analog/basic/strongarm_comparator.hpp:46
        I(cpphdl_n2794, Vss) <+ 5.0000000000000002e-14 * ddt(V(cpphdl_n2794, Vss)); // Bench initial voltage = 0.0 V.
        // device 2114, IC IC366, analog/basic/strongarm_comparator.hpp:47
        I(cpphdl_n2774, cpphdl_n2781) <+ 2e-14 * ddt(V(cpphdl_n2774, cpphdl_n2781)); // Bench initial voltage = 3.2999999999999998 V.
        // device 2115, IC IC366, analog/basic/strongarm_comparator.hpp:48
        I(cpphdl_n2775, cpphdl_n2781) <+ 2e-14 * ddt(V(cpphdl_n2775, cpphdl_n2781)); // Bench initial voltage = 3.2999999999999998 V.
        // device 2116, IC IC366, analog/basic/strongarm_comparator.hpp:49
        I(cpphdl_n2774, cpphdl_n2779) <+ 2.9999999999999998e-15 * ddt(V(cpphdl_n2774, cpphdl_n2779)); // Bench initial voltage = 3.2999999999999998 V.
        // device 2117, IC IC366, analog/basic/strongarm_comparator.hpp:50
        I(cpphdl_n2775, cpphdl_n2780) <+ 2.9999999999999998e-15 * ddt(V(cpphdl_n2775, cpphdl_n2780)); // Bench initial voltage = 3.2999999999999998 V.
        // device 2118, IC IC368, analog/basic/inverter.hpp:11
        I(cpphdl_n2802, Vdd) <+ cpphdl_channel(V(cpphdl_n2794, Vdd), V(cpphdl_n2802, Vdd), 0.001, 0.69999999999999996, -1.0);
        // device 2119, IC IC368, analog/basic/inverter.hpp:12
        I(cpphdl_n2802, Vss) <+ cpphdl_channel(V(cpphdl_n2794, Vss), V(cpphdl_n2802, Vss), 0.001, 0.69999999999999996, 1.0);
        // device 2120, IC IC370, analog/basic/inverter.hpp:11
        I(cpphdl_n2816, Vdd) <+ cpphdl_channel(V(cpphdl_n2802, Vdd), V(cpphdl_n2816, Vdd), 0.0040000000000000001, 0.69999999999999996, -1.0);
        // device 2121, IC IC370, analog/basic/inverter.hpp:12
        I(cpphdl_n2816, Vss) <+ cpphdl_channel(V(cpphdl_n2802, Vss), V(cpphdl_n2816, Vss), 0.0040000000000000001, 0.69999999999999996, 1.0);
        // device 2122, IC IC367, analog/basic/buffered_nand_latch.hpp:34
        I(cpphdl_n2794, Vss) <+ 2.0000000000000002e-15 * ddt(V(cpphdl_n2794, Vss)); // Bench initial voltage = 0.0 V.
        // device 2123, IC IC367, analog/basic/buffered_nand_latch.hpp:35
        I(cpphdl_n2794, cpphdl_n2802) <+ 1.0000000000000001e-15 * ddt(V(cpphdl_n2794, cpphdl_n2802)); // Bench initial voltage = 0.0 V.
        // device 2124, IC IC367, analog/basic/buffered_nand_latch.hpp:36
        I(cpphdl_n2802, Vss) <+ 5e-15 * ddt(V(cpphdl_n2802, Vss)); // Bench initial voltage = 0.0 V.
        // device 2125, IC IC367, analog/basic/buffered_nand_latch.hpp:37
        I(cpphdl_n2802, Vss) <+ 8.0000000000000006e-15 * ddt(V(cpphdl_n2802, Vss)); // Bench initial voltage = 0.0 V.
        // device 2126, IC IC367, analog/basic/buffered_nand_latch.hpp:38
        I(cpphdl_n2816, Vss) <+ 1e-14 * ddt(V(cpphdl_n2816, Vss)); // Bench initial voltage = 0.0 V.
        // device 2127, IC IC369, analog/basic/inverter.hpp:11
        I(cpphdl_n2806, Vdd) <+ cpphdl_channel(V(cpphdl_n2798, Vdd), V(cpphdl_n2806, Vdd), 0.001, 0.69999999999999996, -1.0);
        // device 2128, IC IC369, analog/basic/inverter.hpp:12
        I(cpphdl_n2806, Vss) <+ cpphdl_channel(V(cpphdl_n2798, Vss), V(cpphdl_n2806, Vss), 0.001, 0.69999999999999996, 1.0);
        // device 2129, IC IC371, analog/basic/inverter.hpp:11
        I(cpphdl_n2822, Vdd) <+ cpphdl_channel(V(cpphdl_n2806, Vdd), V(cpphdl_n2822, Vdd), 0.0040000000000000001, 0.69999999999999996, -1.0);
        // device 2130, IC IC371, analog/basic/inverter.hpp:12
        I(cpphdl_n2822, Vss) <+ cpphdl_channel(V(cpphdl_n2806, Vss), V(cpphdl_n2822, Vss), 0.0040000000000000001, 0.69999999999999996, 1.0);
        // device 2131, IC IC367, analog/basic/buffered_nand_latch.hpp:34
        I(cpphdl_n2798, Vss) <+ 2.0000000000000002e-15 * ddt(V(cpphdl_n2798, Vss)); // Bench initial voltage = 0.0 V.
        // device 2132, IC IC367, analog/basic/buffered_nand_latch.hpp:35
        I(cpphdl_n2798, cpphdl_n2806) <+ 1.0000000000000001e-15 * ddt(V(cpphdl_n2798, cpphdl_n2806)); // Bench initial voltage = 0.0 V.
        // device 2133, IC IC367, analog/basic/buffered_nand_latch.hpp:36
        I(cpphdl_n2806, Vss) <+ 5e-15 * ddt(V(cpphdl_n2806, Vss)); // Bench initial voltage = 0.0 V.
        // device 2134, IC IC367, analog/basic/buffered_nand_latch.hpp:37
        I(cpphdl_n2806, Vss) <+ 8.0000000000000006e-15 * ddt(V(cpphdl_n2806, Vss)); // Bench initial voltage = 0.0 V.
        // device 2135, IC IC367, analog/basic/buffered_nand_latch.hpp:38
        I(cpphdl_n2822, Vss) <+ 1e-14 * ddt(V(cpphdl_n2822, Vss)); // Bench initial voltage = 0.0 V.
        // device 2136, IC IC373, analog/basic/cmos_logic.hpp:17
        I(cpphdl_n2925, Vss) <+ 5.0000000000000002e-14 * ddt(V(cpphdl_n2925, Vss)); // Bench initial voltage = 0.0 V.
        // device 2137, IC IC373, analog/basic/cmos_logic.hpp:18
        I(cpphdl_n2925, Vdd) <+ cpphdl_channel(V(cpphdl_n2816, Vdd), V(cpphdl_n2925, Vdd), 0.01, 0.69999999999999996, -1.0);
        // device 2138, IC IC373, analog/basic/cmos_logic.hpp:19
        I(cpphdl_n2925, Vdd) <+ cpphdl_channel(V(cpphdl_n2824, Vdd), V(cpphdl_n2925, Vdd), 0.01, 0.69999999999999996, -1.0);
        // device 2139, IC IC373, analog/basic/cmos_logic.hpp:20
        I(cpphdl_n2925, cpphdl_n2819) <+ cpphdl_channel(V(cpphdl_n2816, cpphdl_n2819), V(cpphdl_n2925, cpphdl_n2819), 0.01, 0.69999999999999996, 1.0);
        // device 2140, IC IC373, analog/basic/cmos_logic.hpp:21
        I(cpphdl_n2819, Vss) <+ cpphdl_channel(V(cpphdl_n2824, Vss), V(cpphdl_n2819, Vss), 0.01, 0.69999999999999996, 1.0);
        // device 2141, IC IC373, analog/basic/cmos_logic.hpp:23
        I(cpphdl_n2925, Vss) <+ V(cpphdl_n2925, Vss) / 1000000000.0;
        // device 2142, IC IC373, analog/basic/cmos_logic.hpp:24
        I(cpphdl_n2819, Vss) <+ V(cpphdl_n2819, Vss) / 1000000000.0;
        // device 2143, IC IC374, analog/basic/cmos_logic.hpp:17
        I(cpphdl_n2824, Vss) <+ 5.0000000000000002e-14 * ddt(V(cpphdl_n2824, Vss)); // Bench initial voltage = 0.0 V.
        // device 2144, IC IC374, analog/basic/cmos_logic.hpp:18
        I(cpphdl_n2824, Vdd) <+ cpphdl_channel(V(cpphdl_n2822, Vdd), V(cpphdl_n2824, Vdd), 0.01, 0.69999999999999996, -1.0);
        // device 2145, IC IC374, analog/basic/cmos_logic.hpp:19
        I(cpphdl_n2824, Vdd) <+ cpphdl_channel(V(cpphdl_n2925, Vdd), V(cpphdl_n2824, Vdd), 0.01, 0.69999999999999996, -1.0);
        // device 2146, IC IC374, analog/basic/cmos_logic.hpp:20
        I(cpphdl_n2824, cpphdl_n2825) <+ cpphdl_channel(V(cpphdl_n2822, cpphdl_n2825), V(cpphdl_n2824, cpphdl_n2825), 0.01, 0.69999999999999996, 1.0);
        // device 2147, IC IC374, analog/basic/cmos_logic.hpp:21
        I(cpphdl_n2825, Vss) <+ cpphdl_channel(V(cpphdl_n2925, Vss), V(cpphdl_n2825, Vss), 0.01, 0.69999999999999996, 1.0);
        // device 2148, IC IC374, analog/basic/cmos_logic.hpp:23
        I(cpphdl_n2824, Vss) <+ V(cpphdl_n2824, Vss) / 1000000000.0;
        // device 2149, IC IC374, analog/basic/cmos_logic.hpp:24
        I(cpphdl_n2825, Vss) <+ V(cpphdl_n2825, Vss) / 1000000000.0;
        // device 2150, IC IC372, analog/basic/nand_latch.hpp:36
        I(cpphdl_n2816, Vss) <+ 2.9999999999999998e-15 * ddt(V(cpphdl_n2816, Vss)); // Bench initial voltage = 0.0 V.
        // device 2151, IC IC372, analog/basic/nand_latch.hpp:37
        I(cpphdl_n2822, Vss) <+ 2.9999999999999998e-15 * ddt(V(cpphdl_n2822, Vss)); // Bench initial voltage = 0.0 V.
        // device 2152, IC IC375, analog/basic/inverter.hpp:11
        I(cpphdl_n2830, Vdd) <+ cpphdl_channel(V(CLEAR, Vdd), V(cpphdl_n2830, Vdd), 0.01, 0.69999999999999996, -1.0);
        // device 2153, IC IC375, analog/basic/inverter.hpp:12
        I(cpphdl_n2830, Vss) <+ cpphdl_channel(V(CLEAR, Vss), V(cpphdl_n2830, Vss), 0.01, 0.69999999999999996, 1.0);
        // device 2154, IC IC372, analog/basic/nand_latch.hpp:58
        I(cpphdl_n2830, Vss) <+ 2.9999999999999998e-15 * ddt(V(cpphdl_n2830, Vss)); // Bench initial voltage = 0.0 V.
        // device 2155, IC IC372, analog/basic/nand_latch.hpp:59
        I(cpphdl_n2925, Vss) <+ cpphdl_channel(V(CLEAR, Vss), V(cpphdl_n2925, Vss), 0.050000000000000003, 0.69999999999999996, 1.0);
        // device 2156, IC IC372, analog/basic/nand_latch.hpp:60
        I(cpphdl_n2824, Vdd) <+ cpphdl_channel(V(cpphdl_n2830, Vdd), V(cpphdl_n2824, Vdd), 0.050000000000000003, 0.69999999999999996, -1.0);
        // device 2157, IC IC376, analog/basic/level_down.hpp:23
        I(cpphdl_n2852, Vlogic) <+ cpphdl_channel(V(Vss, Vlogic), V(cpphdl_n2852, Vlogic), 0.00050000000000000001, 0.34999999999999998, -1.0);
        // device 2158, IC IC376, analog/basic/level_down.hpp:24
        I(cpphdl_n2852, Vss) <+ cpphdl_channel(V(cpphdl_n2850, Vss), V(cpphdl_n2852, Vss), 0.0040000000000000001, 0.69999999999999996, 1.0);
        // device 2159, IC IC376, analog/basic/level_down.hpp:25
        I(CORE_DECISION0, Vlogic) <+ cpphdl_channel(V(cpphdl_n2852, Vlogic), V(CORE_DECISION0, Vlogic), 0.0050000000000000001, 0.34999999999999998, -1.0);
        // device 2160, IC IC376, analog/basic/level_down.hpp:26
        I(CORE_DECISION0, Vss) <+ cpphdl_channel(V(cpphdl_n2852, Vss), V(CORE_DECISION0, Vss), 0.01, 0.34999999999999998, 1.0);
        // device 2161, IC IC376, analog/basic/level_down.hpp:27
        I(cpphdl_n2850, Vss) <+ 5e-15 * ddt(V(cpphdl_n2850, Vss)); // Bench initial voltage = 0.0 V.
        // device 2162, IC IC376, analog/basic/level_down.hpp:28
        I(cpphdl_n2850, Vlogic) <+ 5e-15 * ddt(V(cpphdl_n2850, Vlogic)); // Bench initial voltage = 0.0 V.
        // device 2163, IC IC376, analog/basic/level_down.hpp:29
        I(cpphdl_n2850, cpphdl_n2852) <+ 2.0000000000000002e-15 * ddt(V(cpphdl_n2850, cpphdl_n2852)); // Bench initial voltage = 0.0 V.
        // device 2164, IC IC376, analog/basic/level_down.hpp:30
        I(cpphdl_n2852, Vss) <+ 8e-14 * ddt(V(cpphdl_n2852, Vss)); // Bench initial voltage = 0.0 V.
        // device 2165, IC IC376, analog/basic/level_down.hpp:31
        I(cpphdl_n2852, Vlogic) <+ 5e-15 * ddt(V(cpphdl_n2852, Vlogic)); // Bench initial voltage = 0.0 V.
        // device 2166, IC IC376, analog/basic/level_down.hpp:32
        I(cpphdl_n2852, CORE_DECISION0) <+ 2.0000000000000002e-15 * ddt(V(cpphdl_n2852, CORE_DECISION0)); // Bench initial voltage = 0.0 V.
        // device 2167, IC IC376, analog/basic/level_down.hpp:33
        I(CORE_DECISION0, Vss) <+ 1e-14 * ddt(V(CORE_DECISION0, Vss)); // Bench initial voltage = 0.0 V.
        // device 2168, IC IC377, analog/basic/level_down.hpp:23
        I(cpphdl_n2857, Vlogic) <+ cpphdl_channel(V(Vss, Vlogic), V(cpphdl_n2857, Vlogic), 0.00050000000000000001, 0.34999999999999998, -1.0);
        // device 2169, IC IC377, analog/basic/level_down.hpp:24
        I(cpphdl_n2857, Vss) <+ cpphdl_channel(V(cpphdl_n2855, Vss), V(cpphdl_n2857, Vss), 0.0040000000000000001, 0.69999999999999996, 1.0);
        // device 2170, IC IC377, analog/basic/level_down.hpp:25
        I(CORE_DECISION1, Vlogic) <+ cpphdl_channel(V(cpphdl_n2857, Vlogic), V(CORE_DECISION1, Vlogic), 0.0050000000000000001, 0.34999999999999998, -1.0);
        // device 2171, IC IC377, analog/basic/level_down.hpp:26
        I(CORE_DECISION1, Vss) <+ cpphdl_channel(V(cpphdl_n2857, Vss), V(CORE_DECISION1, Vss), 0.01, 0.34999999999999998, 1.0);
        // device 2172, IC IC377, analog/basic/level_down.hpp:27
        I(cpphdl_n2855, Vss) <+ 5e-15 * ddt(V(cpphdl_n2855, Vss)); // Bench initial voltage = 0.0 V.
        // device 2173, IC IC377, analog/basic/level_down.hpp:28
        I(cpphdl_n2855, Vlogic) <+ 5e-15 * ddt(V(cpphdl_n2855, Vlogic)); // Bench initial voltage = 0.0 V.
        // device 2174, IC IC377, analog/basic/level_down.hpp:29
        I(cpphdl_n2855, cpphdl_n2857) <+ 2.0000000000000002e-15 * ddt(V(cpphdl_n2855, cpphdl_n2857)); // Bench initial voltage = 0.0 V.
        // device 2175, IC IC377, analog/basic/level_down.hpp:30
        I(cpphdl_n2857, Vss) <+ 8e-14 * ddt(V(cpphdl_n2857, Vss)); // Bench initial voltage = 0.0 V.
        // device 2176, IC IC377, analog/basic/level_down.hpp:31
        I(cpphdl_n2857, Vlogic) <+ 5e-15 * ddt(V(cpphdl_n2857, Vlogic)); // Bench initial voltage = 0.0 V.
        // device 2177, IC IC377, analog/basic/level_down.hpp:32
        I(cpphdl_n2857, CORE_DECISION1) <+ 2.0000000000000002e-15 * ddt(V(cpphdl_n2857, CORE_DECISION1)); // Bench initial voltage = 0.0 V.
        // device 2178, IC IC377, analog/basic/level_down.hpp:33
        I(CORE_DECISION1, Vss) <+ 1e-14 * ddt(V(CORE_DECISION1, Vss)); // Bench initial voltage = 0.0 V.
        // device 2179, IC IC378, analog/basic/level_down.hpp:23
        I(cpphdl_n2862, Vlogic) <+ cpphdl_channel(V(Vss, Vlogic), V(cpphdl_n2862, Vlogic), 0.00050000000000000001, 0.34999999999999998, -1.0);
        // device 2180, IC IC378, analog/basic/level_down.hpp:24
        I(cpphdl_n2862, Vss) <+ cpphdl_channel(V(cpphdl_n2860, Vss), V(cpphdl_n2862, Vss), 0.0040000000000000001, 0.69999999999999996, 1.0);
        // device 2181, IC IC378, analog/basic/level_down.hpp:25
        I(CORE_DECISION2, Vlogic) <+ cpphdl_channel(V(cpphdl_n2862, Vlogic), V(CORE_DECISION2, Vlogic), 0.0050000000000000001, 0.34999999999999998, -1.0);
        // device 2182, IC IC378, analog/basic/level_down.hpp:26
        I(CORE_DECISION2, Vss) <+ cpphdl_channel(V(cpphdl_n2862, Vss), V(CORE_DECISION2, Vss), 0.01, 0.34999999999999998, 1.0);
        // device 2183, IC IC378, analog/basic/level_down.hpp:27
        I(cpphdl_n2860, Vss) <+ 5e-15 * ddt(V(cpphdl_n2860, Vss)); // Bench initial voltage = 0.0 V.
        // device 2184, IC IC378, analog/basic/level_down.hpp:28
        I(cpphdl_n2860, Vlogic) <+ 5e-15 * ddt(V(cpphdl_n2860, Vlogic)); // Bench initial voltage = 0.0 V.
        // device 2185, IC IC378, analog/basic/level_down.hpp:29
        I(cpphdl_n2860, cpphdl_n2862) <+ 2.0000000000000002e-15 * ddt(V(cpphdl_n2860, cpphdl_n2862)); // Bench initial voltage = 0.0 V.
        // device 2186, IC IC378, analog/basic/level_down.hpp:30
        I(cpphdl_n2862, Vss) <+ 8e-14 * ddt(V(cpphdl_n2862, Vss)); // Bench initial voltage = 0.0 V.
        // device 2187, IC IC378, analog/basic/level_down.hpp:31
        I(cpphdl_n2862, Vlogic) <+ 5e-15 * ddt(V(cpphdl_n2862, Vlogic)); // Bench initial voltage = 0.0 V.
        // device 2188, IC IC378, analog/basic/level_down.hpp:32
        I(cpphdl_n2862, CORE_DECISION2) <+ 2.0000000000000002e-15 * ddt(V(cpphdl_n2862, CORE_DECISION2)); // Bench initial voltage = 0.0 V.
        // device 2189, IC IC378, analog/basic/level_down.hpp:33
        I(CORE_DECISION2, Vss) <+ 1e-14 * ddt(V(CORE_DECISION2, Vss)); // Bench initial voltage = 0.0 V.
        // device 2190, IC IC379, analog/basic/level_down.hpp:23
        I(cpphdl_n2867, Vlogic) <+ cpphdl_channel(V(Vss, Vlogic), V(cpphdl_n2867, Vlogic), 0.00050000000000000001, 0.34999999999999998, -1.0);
        // device 2191, IC IC379, analog/basic/level_down.hpp:24
        I(cpphdl_n2867, Vss) <+ cpphdl_channel(V(cpphdl_n2865, Vss), V(cpphdl_n2867, Vss), 0.0040000000000000001, 0.69999999999999996, 1.0);
        // device 2192, IC IC379, analog/basic/level_down.hpp:25
        I(CORE_DECISION3, Vlogic) <+ cpphdl_channel(V(cpphdl_n2867, Vlogic), V(CORE_DECISION3, Vlogic), 0.0050000000000000001, 0.34999999999999998, -1.0);
        // device 2193, IC IC379, analog/basic/level_down.hpp:26
        I(CORE_DECISION3, Vss) <+ cpphdl_channel(V(cpphdl_n2867, Vss), V(CORE_DECISION3, Vss), 0.01, 0.34999999999999998, 1.0);
        // device 2194, IC IC379, analog/basic/level_down.hpp:27
        I(cpphdl_n2865, Vss) <+ 5e-15 * ddt(V(cpphdl_n2865, Vss)); // Bench initial voltage = 0.0 V.
        // device 2195, IC IC379, analog/basic/level_down.hpp:28
        I(cpphdl_n2865, Vlogic) <+ 5e-15 * ddt(V(cpphdl_n2865, Vlogic)); // Bench initial voltage = 0.0 V.
        // device 2196, IC IC379, analog/basic/level_down.hpp:29
        I(cpphdl_n2865, cpphdl_n2867) <+ 2.0000000000000002e-15 * ddt(V(cpphdl_n2865, cpphdl_n2867)); // Bench initial voltage = 0.0 V.
        // device 2197, IC IC379, analog/basic/level_down.hpp:30
        I(cpphdl_n2867, Vss) <+ 8e-14 * ddt(V(cpphdl_n2867, Vss)); // Bench initial voltage = 0.0 V.
        // device 2198, IC IC379, analog/basic/level_down.hpp:31
        I(cpphdl_n2867, Vlogic) <+ 5e-15 * ddt(V(cpphdl_n2867, Vlogic)); // Bench initial voltage = 0.0 V.
        // device 2199, IC IC379, analog/basic/level_down.hpp:32
        I(cpphdl_n2867, CORE_DECISION3) <+ 2.0000000000000002e-15 * ddt(V(cpphdl_n2867, CORE_DECISION3)); // Bench initial voltage = 0.0 V.
        // device 2200, IC IC379, analog/basic/level_down.hpp:33
        I(CORE_DECISION3, Vss) <+ 1e-14 * ddt(V(CORE_DECISION3, Vss)); // Bench initial voltage = 0.0 V.
        // device 2201, IC IC380, analog/basic/level_down.hpp:23
        I(cpphdl_n2872, Vlogic) <+ cpphdl_channel(V(Vss, Vlogic), V(cpphdl_n2872, Vlogic), 0.00050000000000000001, 0.34999999999999998, -1.0);
        // device 2202, IC IC380, analog/basic/level_down.hpp:24
        I(cpphdl_n2872, Vss) <+ cpphdl_channel(V(cpphdl_n2870, Vss), V(cpphdl_n2872, Vss), 0.0040000000000000001, 0.69999999999999996, 1.0);
        // device 2203, IC IC380, analog/basic/level_down.hpp:25
        I(CORE_DECISION4, Vlogic) <+ cpphdl_channel(V(cpphdl_n2872, Vlogic), V(CORE_DECISION4, Vlogic), 0.0050000000000000001, 0.34999999999999998, -1.0);
        // device 2204, IC IC380, analog/basic/level_down.hpp:26
        I(CORE_DECISION4, Vss) <+ cpphdl_channel(V(cpphdl_n2872, Vss), V(CORE_DECISION4, Vss), 0.01, 0.34999999999999998, 1.0);
        // device 2205, IC IC380, analog/basic/level_down.hpp:27
        I(cpphdl_n2870, Vss) <+ 5e-15 * ddt(V(cpphdl_n2870, Vss)); // Bench initial voltage = 0.0 V.
        // device 2206, IC IC380, analog/basic/level_down.hpp:28
        I(cpphdl_n2870, Vlogic) <+ 5e-15 * ddt(V(cpphdl_n2870, Vlogic)); // Bench initial voltage = 0.0 V.
        // device 2207, IC IC380, analog/basic/level_down.hpp:29
        I(cpphdl_n2870, cpphdl_n2872) <+ 2.0000000000000002e-15 * ddt(V(cpphdl_n2870, cpphdl_n2872)); // Bench initial voltage = 0.0 V.
        // device 2208, IC IC380, analog/basic/level_down.hpp:30
        I(cpphdl_n2872, Vss) <+ 8e-14 * ddt(V(cpphdl_n2872, Vss)); // Bench initial voltage = 0.0 V.
        // device 2209, IC IC380, analog/basic/level_down.hpp:31
        I(cpphdl_n2872, Vlogic) <+ 5e-15 * ddt(V(cpphdl_n2872, Vlogic)); // Bench initial voltage = 0.0 V.
        // device 2210, IC IC380, analog/basic/level_down.hpp:32
        I(cpphdl_n2872, CORE_DECISION4) <+ 2.0000000000000002e-15 * ddt(V(cpphdl_n2872, CORE_DECISION4)); // Bench initial voltage = 0.0 V.
        // device 2211, IC IC380, analog/basic/level_down.hpp:33
        I(CORE_DECISION4, Vss) <+ 1e-14 * ddt(V(CORE_DECISION4, Vss)); // Bench initial voltage = 0.0 V.
        // device 2212, IC IC381, analog/basic/level_down.hpp:23
        I(cpphdl_n2877, Vlogic) <+ cpphdl_channel(V(Vss, Vlogic), V(cpphdl_n2877, Vlogic), 0.00050000000000000001, 0.34999999999999998, -1.0);
        // device 2213, IC IC381, analog/basic/level_down.hpp:24
        I(cpphdl_n2877, Vss) <+ cpphdl_channel(V(cpphdl_n2875, Vss), V(cpphdl_n2877, Vss), 0.0040000000000000001, 0.69999999999999996, 1.0);
        // device 2214, IC IC381, analog/basic/level_down.hpp:25
        I(CORE_DECISION5, Vlogic) <+ cpphdl_channel(V(cpphdl_n2877, Vlogic), V(CORE_DECISION5, Vlogic), 0.0050000000000000001, 0.34999999999999998, -1.0);
        // device 2215, IC IC381, analog/basic/level_down.hpp:26
        I(CORE_DECISION5, Vss) <+ cpphdl_channel(V(cpphdl_n2877, Vss), V(CORE_DECISION5, Vss), 0.01, 0.34999999999999998, 1.0);
        // device 2216, IC IC381, analog/basic/level_down.hpp:27
        I(cpphdl_n2875, Vss) <+ 5e-15 * ddt(V(cpphdl_n2875, Vss)); // Bench initial voltage = 0.0 V.
        // device 2217, IC IC381, analog/basic/level_down.hpp:28
        I(cpphdl_n2875, Vlogic) <+ 5e-15 * ddt(V(cpphdl_n2875, Vlogic)); // Bench initial voltage = 0.0 V.
        // device 2218, IC IC381, analog/basic/level_down.hpp:29
        I(cpphdl_n2875, cpphdl_n2877) <+ 2.0000000000000002e-15 * ddt(V(cpphdl_n2875, cpphdl_n2877)); // Bench initial voltage = 0.0 V.
        // device 2219, IC IC381, analog/basic/level_down.hpp:30
        I(cpphdl_n2877, Vss) <+ 8e-14 * ddt(V(cpphdl_n2877, Vss)); // Bench initial voltage = 0.0 V.
        // device 2220, IC IC381, analog/basic/level_down.hpp:31
        I(cpphdl_n2877, Vlogic) <+ 5e-15 * ddt(V(cpphdl_n2877, Vlogic)); // Bench initial voltage = 0.0 V.
        // device 2221, IC IC381, analog/basic/level_down.hpp:32
        I(cpphdl_n2877, CORE_DECISION5) <+ 2.0000000000000002e-15 * ddt(V(cpphdl_n2877, CORE_DECISION5)); // Bench initial voltage = 0.0 V.
        // device 2222, IC IC381, analog/basic/level_down.hpp:33
        I(CORE_DECISION5, Vss) <+ 1e-14 * ddt(V(CORE_DECISION5, Vss)); // Bench initial voltage = 0.0 V.
        // device 2223, IC IC382, analog/basic/level_down.hpp:23
        I(cpphdl_n2882, Vlogic) <+ cpphdl_channel(V(Vss, Vlogic), V(cpphdl_n2882, Vlogic), 0.00050000000000000001, 0.34999999999999998, -1.0);
        // device 2224, IC IC382, analog/basic/level_down.hpp:24
        I(cpphdl_n2882, Vss) <+ cpphdl_channel(V(cpphdl_n2880, Vss), V(cpphdl_n2882, Vss), 0.0040000000000000001, 0.69999999999999996, 1.0);
        // device 2225, IC IC382, analog/basic/level_down.hpp:25
        I(CORE_DECISION6, Vlogic) <+ cpphdl_channel(V(cpphdl_n2882, Vlogic), V(CORE_DECISION6, Vlogic), 0.0050000000000000001, 0.34999999999999998, -1.0);
        // device 2226, IC IC382, analog/basic/level_down.hpp:26
        I(CORE_DECISION6, Vss) <+ cpphdl_channel(V(cpphdl_n2882, Vss), V(CORE_DECISION6, Vss), 0.01, 0.34999999999999998, 1.0);
        // device 2227, IC IC382, analog/basic/level_down.hpp:27
        I(cpphdl_n2880, Vss) <+ 5e-15 * ddt(V(cpphdl_n2880, Vss)); // Bench initial voltage = 0.0 V.
        // device 2228, IC IC382, analog/basic/level_down.hpp:28
        I(cpphdl_n2880, Vlogic) <+ 5e-15 * ddt(V(cpphdl_n2880, Vlogic)); // Bench initial voltage = 0.0 V.
        // device 2229, IC IC382, analog/basic/level_down.hpp:29
        I(cpphdl_n2880, cpphdl_n2882) <+ 2.0000000000000002e-15 * ddt(V(cpphdl_n2880, cpphdl_n2882)); // Bench initial voltage = 0.0 V.
        // device 2230, IC IC382, analog/basic/level_down.hpp:30
        I(cpphdl_n2882, Vss) <+ 8e-14 * ddt(V(cpphdl_n2882, Vss)); // Bench initial voltage = 0.0 V.
        // device 2231, IC IC382, analog/basic/level_down.hpp:31
        I(cpphdl_n2882, Vlogic) <+ 5e-15 * ddt(V(cpphdl_n2882, Vlogic)); // Bench initial voltage = 0.0 V.
        // device 2232, IC IC382, analog/basic/level_down.hpp:32
        I(cpphdl_n2882, CORE_DECISION6) <+ 2.0000000000000002e-15 * ddt(V(cpphdl_n2882, CORE_DECISION6)); // Bench initial voltage = 0.0 V.
        // device 2233, IC IC382, analog/basic/level_down.hpp:33
        I(CORE_DECISION6, Vss) <+ 1e-14 * ddt(V(CORE_DECISION6, Vss)); // Bench initial voltage = 0.0 V.
        // device 2234, IC IC383, analog/basic/level_down.hpp:23
        I(cpphdl_n2887, Vlogic) <+ cpphdl_channel(V(Vss, Vlogic), V(cpphdl_n2887, Vlogic), 0.00050000000000000001, 0.34999999999999998, -1.0);
        // device 2235, IC IC383, analog/basic/level_down.hpp:24
        I(cpphdl_n2887, Vss) <+ cpphdl_channel(V(cpphdl_n2885, Vss), V(cpphdl_n2887, Vss), 0.0040000000000000001, 0.69999999999999996, 1.0);
        // device 2236, IC IC383, analog/basic/level_down.hpp:25
        I(CORE_DECISION7, Vlogic) <+ cpphdl_channel(V(cpphdl_n2887, Vlogic), V(CORE_DECISION7, Vlogic), 0.0050000000000000001, 0.34999999999999998, -1.0);
        // device 2237, IC IC383, analog/basic/level_down.hpp:26
        I(CORE_DECISION7, Vss) <+ cpphdl_channel(V(cpphdl_n2887, Vss), V(CORE_DECISION7, Vss), 0.01, 0.34999999999999998, 1.0);
        // device 2238, IC IC383, analog/basic/level_down.hpp:27
        I(cpphdl_n2885, Vss) <+ 5e-15 * ddt(V(cpphdl_n2885, Vss)); // Bench initial voltage = 0.0 V.
        // device 2239, IC IC383, analog/basic/level_down.hpp:28
        I(cpphdl_n2885, Vlogic) <+ 5e-15 * ddt(V(cpphdl_n2885, Vlogic)); // Bench initial voltage = 0.0 V.
        // device 2240, IC IC383, analog/basic/level_down.hpp:29
        I(cpphdl_n2885, cpphdl_n2887) <+ 2.0000000000000002e-15 * ddt(V(cpphdl_n2885, cpphdl_n2887)); // Bench initial voltage = 0.0 V.
        // device 2241, IC IC383, analog/basic/level_down.hpp:30
        I(cpphdl_n2887, Vss) <+ 8e-14 * ddt(V(cpphdl_n2887, Vss)); // Bench initial voltage = 0.0 V.
        // device 2242, IC IC383, analog/basic/level_down.hpp:31
        I(cpphdl_n2887, Vlogic) <+ 5e-15 * ddt(V(cpphdl_n2887, Vlogic)); // Bench initial voltage = 0.0 V.
        // device 2243, IC IC383, analog/basic/level_down.hpp:32
        I(cpphdl_n2887, CORE_DECISION7) <+ 2.0000000000000002e-15 * ddt(V(cpphdl_n2887, CORE_DECISION7)); // Bench initial voltage = 0.0 V.
        // device 2244, IC IC383, analog/basic/level_down.hpp:33
        I(CORE_DECISION7, Vss) <+ 1e-14 * ddt(V(CORE_DECISION7, Vss)); // Bench initial voltage = 0.0 V.
        // device 2245, IC IC384, analog/basic/level_down.hpp:23
        I(cpphdl_n2892, Vlogic) <+ cpphdl_channel(V(Vss, Vlogic), V(cpphdl_n2892, Vlogic), 0.00050000000000000001, 0.34999999999999998, -1.0);
        // device 2246, IC IC384, analog/basic/level_down.hpp:24
        I(cpphdl_n2892, Vss) <+ cpphdl_channel(V(cpphdl_n2890, Vss), V(cpphdl_n2892, Vss), 0.0040000000000000001, 0.69999999999999996, 1.0);
        // device 2247, IC IC384, analog/basic/level_down.hpp:25
        I(CORE_DECISION8, Vlogic) <+ cpphdl_channel(V(cpphdl_n2892, Vlogic), V(CORE_DECISION8, Vlogic), 0.0050000000000000001, 0.34999999999999998, -1.0);
        // device 2248, IC IC384, analog/basic/level_down.hpp:26
        I(CORE_DECISION8, Vss) <+ cpphdl_channel(V(cpphdl_n2892, Vss), V(CORE_DECISION8, Vss), 0.01, 0.34999999999999998, 1.0);
        // device 2249, IC IC384, analog/basic/level_down.hpp:27
        I(cpphdl_n2890, Vss) <+ 5e-15 * ddt(V(cpphdl_n2890, Vss)); // Bench initial voltage = 0.0 V.
        // device 2250, IC IC384, analog/basic/level_down.hpp:28
        I(cpphdl_n2890, Vlogic) <+ 5e-15 * ddt(V(cpphdl_n2890, Vlogic)); // Bench initial voltage = 0.0 V.
        // device 2251, IC IC384, analog/basic/level_down.hpp:29
        I(cpphdl_n2890, cpphdl_n2892) <+ 2.0000000000000002e-15 * ddt(V(cpphdl_n2890, cpphdl_n2892)); // Bench initial voltage = 0.0 V.
        // device 2252, IC IC384, analog/basic/level_down.hpp:30
        I(cpphdl_n2892, Vss) <+ 8e-14 * ddt(V(cpphdl_n2892, Vss)); // Bench initial voltage = 0.0 V.
        // device 2253, IC IC384, analog/basic/level_down.hpp:31
        I(cpphdl_n2892, Vlogic) <+ 5e-15 * ddt(V(cpphdl_n2892, Vlogic)); // Bench initial voltage = 0.0 V.
        // device 2254, IC IC384, analog/basic/level_down.hpp:32
        I(cpphdl_n2892, CORE_DECISION8) <+ 2.0000000000000002e-15 * ddt(V(cpphdl_n2892, CORE_DECISION8)); // Bench initial voltage = 0.0 V.
        // device 2255, IC IC384, analog/basic/level_down.hpp:33
        I(CORE_DECISION8, Vss) <+ 1e-14 * ddt(V(CORE_DECISION8, Vss)); // Bench initial voltage = 0.0 V.
        // device 2256, IC IC385, analog/basic/level_down.hpp:23
        I(cpphdl_n2897, Vlogic) <+ cpphdl_channel(V(Vss, Vlogic), V(cpphdl_n2897, Vlogic), 0.00050000000000000001, 0.34999999999999998, -1.0);
        // device 2257, IC IC385, analog/basic/level_down.hpp:24
        I(cpphdl_n2897, Vss) <+ cpphdl_channel(V(cpphdl_n2895, Vss), V(cpphdl_n2897, Vss), 0.0040000000000000001, 0.69999999999999996, 1.0);
        // device 2258, IC IC385, analog/basic/level_down.hpp:25
        I(CORE_DECISION9, Vlogic) <+ cpphdl_channel(V(cpphdl_n2897, Vlogic), V(CORE_DECISION9, Vlogic), 0.0050000000000000001, 0.34999999999999998, -1.0);
        // device 2259, IC IC385, analog/basic/level_down.hpp:26
        I(CORE_DECISION9, Vss) <+ cpphdl_channel(V(cpphdl_n2897, Vss), V(CORE_DECISION9, Vss), 0.01, 0.34999999999999998, 1.0);
        // device 2260, IC IC385, analog/basic/level_down.hpp:27
        I(cpphdl_n2895, Vss) <+ 5e-15 * ddt(V(cpphdl_n2895, Vss)); // Bench initial voltage = 0.0 V.
        // device 2261, IC IC385, analog/basic/level_down.hpp:28
        I(cpphdl_n2895, Vlogic) <+ 5e-15 * ddt(V(cpphdl_n2895, Vlogic)); // Bench initial voltage = 0.0 V.
        // device 2262, IC IC385, analog/basic/level_down.hpp:29
        I(cpphdl_n2895, cpphdl_n2897) <+ 2.0000000000000002e-15 * ddt(V(cpphdl_n2895, cpphdl_n2897)); // Bench initial voltage = 0.0 V.
        // device 2263, IC IC385, analog/basic/level_down.hpp:30
        I(cpphdl_n2897, Vss) <+ 8e-14 * ddt(V(cpphdl_n2897, Vss)); // Bench initial voltage = 0.0 V.
        // device 2264, IC IC385, analog/basic/level_down.hpp:31
        I(cpphdl_n2897, Vlogic) <+ 5e-15 * ddt(V(cpphdl_n2897, Vlogic)); // Bench initial voltage = 0.0 V.
        // device 2265, IC IC385, analog/basic/level_down.hpp:32
        I(cpphdl_n2897, CORE_DECISION9) <+ 2.0000000000000002e-15 * ddt(V(cpphdl_n2897, CORE_DECISION9)); // Bench initial voltage = 0.0 V.
        // device 2266, IC IC385, analog/basic/level_down.hpp:33
        I(CORE_DECISION9, Vss) <+ 1e-14 * ddt(V(CORE_DECISION9, Vss)); // Bench initial voltage = 0.0 V.
        // device 2267, IC IC386, analog/basic/level_down.hpp:23
        I(cpphdl_n2902, Vlogic) <+ cpphdl_channel(V(Vss, Vlogic), V(cpphdl_n2902, Vlogic), 0.00050000000000000001, 0.34999999999999998, -1.0);
        // device 2268, IC IC386, analog/basic/level_down.hpp:24
        I(cpphdl_n2902, Vss) <+ cpphdl_channel(V(cpphdl_n2900, Vss), V(cpphdl_n2902, Vss), 0.0040000000000000001, 0.69999999999999996, 1.0);
        // device 2269, IC IC386, analog/basic/level_down.hpp:25
        I(CORE_DECISION10, Vlogic) <+ cpphdl_channel(V(cpphdl_n2902, Vlogic), V(CORE_DECISION10, Vlogic), 0.0050000000000000001, 0.34999999999999998, -1.0);
        // device 2270, IC IC386, analog/basic/level_down.hpp:26
        I(CORE_DECISION10, Vss) <+ cpphdl_channel(V(cpphdl_n2902, Vss), V(CORE_DECISION10, Vss), 0.01, 0.34999999999999998, 1.0);
        // device 2271, IC IC386, analog/basic/level_down.hpp:27
        I(cpphdl_n2900, Vss) <+ 5e-15 * ddt(V(cpphdl_n2900, Vss)); // Bench initial voltage = 0.0 V.
        // device 2272, IC IC386, analog/basic/level_down.hpp:28
        I(cpphdl_n2900, Vlogic) <+ 5e-15 * ddt(V(cpphdl_n2900, Vlogic)); // Bench initial voltage = 0.0 V.
        // device 2273, IC IC386, analog/basic/level_down.hpp:29
        I(cpphdl_n2900, cpphdl_n2902) <+ 2.0000000000000002e-15 * ddt(V(cpphdl_n2900, cpphdl_n2902)); // Bench initial voltage = 0.0 V.
        // device 2274, IC IC386, analog/basic/level_down.hpp:30
        I(cpphdl_n2902, Vss) <+ 8e-14 * ddt(V(cpphdl_n2902, Vss)); // Bench initial voltage = 0.0 V.
        // device 2275, IC IC386, analog/basic/level_down.hpp:31
        I(cpphdl_n2902, Vlogic) <+ 5e-15 * ddt(V(cpphdl_n2902, Vlogic)); // Bench initial voltage = 0.0 V.
        // device 2276, IC IC386, analog/basic/level_down.hpp:32
        I(cpphdl_n2902, CORE_DECISION10) <+ 2.0000000000000002e-15 * ddt(V(cpphdl_n2902, CORE_DECISION10)); // Bench initial voltage = 0.0 V.
        // device 2277, IC IC386, analog/basic/level_down.hpp:33
        I(CORE_DECISION10, Vss) <+ 1e-14 * ddt(V(CORE_DECISION10, Vss)); // Bench initial voltage = 0.0 V.
        // device 2278, IC IC387, analog/basic/level_down.hpp:23
        I(cpphdl_n2907, Vlogic) <+ cpphdl_channel(V(Vss, Vlogic), V(cpphdl_n2907, Vlogic), 0.00050000000000000001, 0.34999999999999998, -1.0);
        // device 2279, IC IC387, analog/basic/level_down.hpp:24
        I(cpphdl_n2907, Vss) <+ cpphdl_channel(V(cpphdl_n2905, Vss), V(cpphdl_n2907, Vss), 0.0040000000000000001, 0.69999999999999996, 1.0);
        // device 2280, IC IC387, analog/basic/level_down.hpp:25
        I(CORE_DECISION11, Vlogic) <+ cpphdl_channel(V(cpphdl_n2907, Vlogic), V(CORE_DECISION11, Vlogic), 0.0050000000000000001, 0.34999999999999998, -1.0);
        // device 2281, IC IC387, analog/basic/level_down.hpp:26
        I(CORE_DECISION11, Vss) <+ cpphdl_channel(V(cpphdl_n2907, Vss), V(CORE_DECISION11, Vss), 0.01, 0.34999999999999998, 1.0);
        // device 2282, IC IC387, analog/basic/level_down.hpp:27
        I(cpphdl_n2905, Vss) <+ 5e-15 * ddt(V(cpphdl_n2905, Vss)); // Bench initial voltage = 0.0 V.
        // device 2283, IC IC387, analog/basic/level_down.hpp:28
        I(cpphdl_n2905, Vlogic) <+ 5e-15 * ddt(V(cpphdl_n2905, Vlogic)); // Bench initial voltage = 0.0 V.
        // device 2284, IC IC387, analog/basic/level_down.hpp:29
        I(cpphdl_n2905, cpphdl_n2907) <+ 2.0000000000000002e-15 * ddt(V(cpphdl_n2905, cpphdl_n2907)); // Bench initial voltage = 0.0 V.
        // device 2285, IC IC387, analog/basic/level_down.hpp:30
        I(cpphdl_n2907, Vss) <+ 8e-14 * ddt(V(cpphdl_n2907, Vss)); // Bench initial voltage = 0.0 V.
        // device 2286, IC IC387, analog/basic/level_down.hpp:31
        I(cpphdl_n2907, Vlogic) <+ 5e-15 * ddt(V(cpphdl_n2907, Vlogic)); // Bench initial voltage = 0.0 V.
        // device 2287, IC IC387, analog/basic/level_down.hpp:32
        I(cpphdl_n2907, CORE_DECISION11) <+ 2.0000000000000002e-15 * ddt(V(cpphdl_n2907, CORE_DECISION11)); // Bench initial voltage = 0.0 V.
        // device 2288, IC IC387, analog/basic/level_down.hpp:33
        I(CORE_DECISION11, Vss) <+ 1e-14 * ddt(V(CORE_DECISION11, Vss)); // Bench initial voltage = 0.0 V.
        // device 2289, IC IC388, analog/basic/level_down.hpp:23
        I(cpphdl_n2912, Vlogic) <+ cpphdl_channel(V(Vss, Vlogic), V(cpphdl_n2912, Vlogic), 0.00050000000000000001, 0.34999999999999998, -1.0);
        // device 2290, IC IC388, analog/basic/level_down.hpp:24
        I(cpphdl_n2912, Vss) <+ cpphdl_channel(V(cpphdl_n2910, Vss), V(cpphdl_n2912, Vss), 0.0040000000000000001, 0.69999999999999996, 1.0);
        // device 2291, IC IC388, analog/basic/level_down.hpp:25
        I(CORE_DECISION12, Vlogic) <+ cpphdl_channel(V(cpphdl_n2912, Vlogic), V(CORE_DECISION12, Vlogic), 0.0050000000000000001, 0.34999999999999998, -1.0);
        // device 2292, IC IC388, analog/basic/level_down.hpp:26
        I(CORE_DECISION12, Vss) <+ cpphdl_channel(V(cpphdl_n2912, Vss), V(CORE_DECISION12, Vss), 0.01, 0.34999999999999998, 1.0);
        // device 2293, IC IC388, analog/basic/level_down.hpp:27
        I(cpphdl_n2910, Vss) <+ 5e-15 * ddt(V(cpphdl_n2910, Vss)); // Bench initial voltage = 0.0 V.
        // device 2294, IC IC388, analog/basic/level_down.hpp:28
        I(cpphdl_n2910, Vlogic) <+ 5e-15 * ddt(V(cpphdl_n2910, Vlogic)); // Bench initial voltage = 0.0 V.
        // device 2295, IC IC388, analog/basic/level_down.hpp:29
        I(cpphdl_n2910, cpphdl_n2912) <+ 2.0000000000000002e-15 * ddt(V(cpphdl_n2910, cpphdl_n2912)); // Bench initial voltage = 0.0 V.
        // device 2296, IC IC388, analog/basic/level_down.hpp:30
        I(cpphdl_n2912, Vss) <+ 8e-14 * ddt(V(cpphdl_n2912, Vss)); // Bench initial voltage = 0.0 V.
        // device 2297, IC IC388, analog/basic/level_down.hpp:31
        I(cpphdl_n2912, Vlogic) <+ 5e-15 * ddt(V(cpphdl_n2912, Vlogic)); // Bench initial voltage = 0.0 V.
        // device 2298, IC IC388, analog/basic/level_down.hpp:32
        I(cpphdl_n2912, CORE_DECISION12) <+ 2.0000000000000002e-15 * ddt(V(cpphdl_n2912, CORE_DECISION12)); // Bench initial voltage = 0.0 V.
        // device 2299, IC IC388, analog/basic/level_down.hpp:33
        I(CORE_DECISION12, Vss) <+ 1e-14 * ddt(V(CORE_DECISION12, Vss)); // Bench initial voltage = 0.0 V.
        // device 2300, IC IC389, analog/basic/level_down.hpp:23
        I(cpphdl_n2917, Vlogic) <+ cpphdl_channel(V(Vss, Vlogic), V(cpphdl_n2917, Vlogic), 0.00050000000000000001, 0.34999999999999998, -1.0);
        // device 2301, IC IC389, analog/basic/level_down.hpp:24
        I(cpphdl_n2917, Vss) <+ cpphdl_channel(V(cpphdl_n2915, Vss), V(cpphdl_n2917, Vss), 0.0040000000000000001, 0.69999999999999996, 1.0);
        // device 2302, IC IC389, analog/basic/level_down.hpp:25
        I(CORE_DECISION13, Vlogic) <+ cpphdl_channel(V(cpphdl_n2917, Vlogic), V(CORE_DECISION13, Vlogic), 0.0050000000000000001, 0.34999999999999998, -1.0);
        // device 2303, IC IC389, analog/basic/level_down.hpp:26
        I(CORE_DECISION13, Vss) <+ cpphdl_channel(V(cpphdl_n2917, Vss), V(CORE_DECISION13, Vss), 0.01, 0.34999999999999998, 1.0);
        // device 2304, IC IC389, analog/basic/level_down.hpp:27
        I(cpphdl_n2915, Vss) <+ 5e-15 * ddt(V(cpphdl_n2915, Vss)); // Bench initial voltage = 0.0 V.
        // device 2305, IC IC389, analog/basic/level_down.hpp:28
        I(cpphdl_n2915, Vlogic) <+ 5e-15 * ddt(V(cpphdl_n2915, Vlogic)); // Bench initial voltage = 0.0 V.
        // device 2306, IC IC389, analog/basic/level_down.hpp:29
        I(cpphdl_n2915, cpphdl_n2917) <+ 2.0000000000000002e-15 * ddt(V(cpphdl_n2915, cpphdl_n2917)); // Bench initial voltage = 0.0 V.
        // device 2307, IC IC389, analog/basic/level_down.hpp:30
        I(cpphdl_n2917, Vss) <+ 8e-14 * ddt(V(cpphdl_n2917, Vss)); // Bench initial voltage = 0.0 V.
        // device 2308, IC IC389, analog/basic/level_down.hpp:31
        I(cpphdl_n2917, Vlogic) <+ 5e-15 * ddt(V(cpphdl_n2917, Vlogic)); // Bench initial voltage = 0.0 V.
        // device 2309, IC IC389, analog/basic/level_down.hpp:32
        I(cpphdl_n2917, CORE_DECISION13) <+ 2.0000000000000002e-15 * ddt(V(cpphdl_n2917, CORE_DECISION13)); // Bench initial voltage = 0.0 V.
        // device 2310, IC IC389, analog/basic/level_down.hpp:33
        I(CORE_DECISION13, Vss) <+ 1e-14 * ddt(V(CORE_DECISION13, Vss)); // Bench initial voltage = 0.0 V.
        // device 2311, IC IC390, analog/basic/level_down.hpp:23
        I(cpphdl_n2922, Vlogic) <+ cpphdl_channel(V(Vss, Vlogic), V(cpphdl_n2922, Vlogic), 0.00050000000000000001, 0.34999999999999998, -1.0);
        // device 2312, IC IC390, analog/basic/level_down.hpp:24
        I(cpphdl_n2922, Vss) <+ cpphdl_channel(V(cpphdl_n2920, Vss), V(cpphdl_n2922, Vss), 0.0040000000000000001, 0.69999999999999996, 1.0);
        // device 2313, IC IC390, analog/basic/level_down.hpp:25
        I(CORE_DECISION14, Vlogic) <+ cpphdl_channel(V(cpphdl_n2922, Vlogic), V(CORE_DECISION14, Vlogic), 0.0050000000000000001, 0.34999999999999998, -1.0);
        // device 2314, IC IC390, analog/basic/level_down.hpp:26
        I(CORE_DECISION14, Vss) <+ cpphdl_channel(V(cpphdl_n2922, Vss), V(CORE_DECISION14, Vss), 0.01, 0.34999999999999998, 1.0);
        // device 2315, IC IC390, analog/basic/level_down.hpp:27
        I(cpphdl_n2920, Vss) <+ 5e-15 * ddt(V(cpphdl_n2920, Vss)); // Bench initial voltage = 0.0 V.
        // device 2316, IC IC390, analog/basic/level_down.hpp:28
        I(cpphdl_n2920, Vlogic) <+ 5e-15 * ddt(V(cpphdl_n2920, Vlogic)); // Bench initial voltage = 0.0 V.
        // device 2317, IC IC390, analog/basic/level_down.hpp:29
        I(cpphdl_n2920, cpphdl_n2922) <+ 2.0000000000000002e-15 * ddt(V(cpphdl_n2920, cpphdl_n2922)); // Bench initial voltage = 0.0 V.
        // device 2318, IC IC390, analog/basic/level_down.hpp:30
        I(cpphdl_n2922, Vss) <+ 8e-14 * ddt(V(cpphdl_n2922, Vss)); // Bench initial voltage = 0.0 V.
        // device 2319, IC IC390, analog/basic/level_down.hpp:31
        I(cpphdl_n2922, Vlogic) <+ 5e-15 * ddt(V(cpphdl_n2922, Vlogic)); // Bench initial voltage = 0.0 V.
        // device 2320, IC IC390, analog/basic/level_down.hpp:32
        I(cpphdl_n2922, CORE_DECISION14) <+ 2.0000000000000002e-15 * ddt(V(cpphdl_n2922, CORE_DECISION14)); // Bench initial voltage = 0.0 V.
        // device 2321, IC IC390, analog/basic/level_down.hpp:33
        I(CORE_DECISION14, Vss) <+ 1e-14 * ddt(V(CORE_DECISION14, Vss)); // Bench initial voltage = 0.0 V.
        // device 2322, IC IC391, analog/basic/level_down.hpp:23
        I(cpphdl_n2927, Vlogic) <+ cpphdl_channel(V(Vss, Vlogic), V(cpphdl_n2927, Vlogic), 0.00050000000000000001, 0.34999999999999998, -1.0);
        // device 2323, IC IC391, analog/basic/level_down.hpp:24
        I(cpphdl_n2927, Vss) <+ cpphdl_channel(V(cpphdl_n2925, Vss), V(cpphdl_n2927, Vss), 0.0040000000000000001, 0.69999999999999996, 1.0);
        // device 2324, IC IC391, analog/basic/level_down.hpp:25
        I(CORE_DECISION15, Vlogic) <+ cpphdl_channel(V(cpphdl_n2927, Vlogic), V(CORE_DECISION15, Vlogic), 0.0050000000000000001, 0.34999999999999998, -1.0);
        // device 2325, IC IC391, analog/basic/level_down.hpp:26
        I(CORE_DECISION15, Vss) <+ cpphdl_channel(V(cpphdl_n2927, Vss), V(CORE_DECISION15, Vss), 0.01, 0.34999999999999998, 1.0);
        // device 2326, IC IC391, analog/basic/level_down.hpp:27
        I(cpphdl_n2925, Vss) <+ 5e-15 * ddt(V(cpphdl_n2925, Vss)); // Bench initial voltage = 0.0 V.
        // device 2327, IC IC391, analog/basic/level_down.hpp:28
        I(cpphdl_n2925, Vlogic) <+ 5e-15 * ddt(V(cpphdl_n2925, Vlogic)); // Bench initial voltage = 0.0 V.
        // device 2328, IC IC391, analog/basic/level_down.hpp:29
        I(cpphdl_n2925, cpphdl_n2927) <+ 2.0000000000000002e-15 * ddt(V(cpphdl_n2925, cpphdl_n2927)); // Bench initial voltage = 0.0 V.
        // device 2329, IC IC391, analog/basic/level_down.hpp:30
        I(cpphdl_n2927, Vss) <+ 8e-14 * ddt(V(cpphdl_n2927, Vss)); // Bench initial voltage = 0.0 V.
        // device 2330, IC IC391, analog/basic/level_down.hpp:31
        I(cpphdl_n2927, Vlogic) <+ 5e-15 * ddt(V(cpphdl_n2927, Vlogic)); // Bench initial voltage = 0.0 V.
        // device 2331, IC IC391, analog/basic/level_down.hpp:32
        I(cpphdl_n2927, CORE_DECISION15) <+ 2.0000000000000002e-15 * ddt(V(cpphdl_n2927, CORE_DECISION15)); // Bench initial voltage = 0.0 V.
        // device 2332, IC IC391, analog/basic/level_down.hpp:33
        I(CORE_DECISION15, Vss) <+ 1e-14 * ddt(V(CORE_DECISION15, Vss)); // Bench initial voltage = 0.0 V.
    end
endmodule
