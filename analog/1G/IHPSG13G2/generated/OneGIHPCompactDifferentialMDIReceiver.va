// SIMULATION APPROXIMATION: controlled conductances are not physical MOS devices.
// Generated from elaborated C++HDL IC purposes; all contributions coexist.
// Capacitor initialization belongs to the host analysis; declared initial voltages appear below.
`include "disciplines.vams"

module OneGIHPCompactDifferentialMDIReceiver(Vdd, Vss, Vlogic, VREF, EVALUATE, CLEAR, P, N, SELECT_N0, SELECT_N1, SELECT_N2, SELECT_N3, SELECT_N4, TRACK0, CORE_DECISION0, BIT_N0_0, BIT_N0_1, BIT_N0_2, BIT_N0_3, BIT_N0_4, BIT_N0_5, BIT_N0_6, BIT_N0_7, TRACK1, CORE_DECISION1, BIT_N1_0, BIT_N1_1, BIT_N1_2, BIT_N1_3, BIT_N1_4, BIT_N1_5, BIT_N1_6, BIT_N1_7, TRACK2, CORE_DECISION2, BIT_N2_0, BIT_N2_1, BIT_N2_2, BIT_N2_3, BIT_N2_4, BIT_N2_5, BIT_N2_6, BIT_N2_7, TRACK3, CORE_DECISION3, BIT_N3_0, BIT_N3_1, BIT_N3_2, BIT_N3_3, BIT_N3_4, BIT_N3_5, BIT_N3_6, BIT_N3_7, TRACK4, CORE_DECISION4, BIT_N4_0, BIT_N4_1, BIT_N4_2, BIT_N4_3, BIT_N4_4, BIT_N4_5, BIT_N4_6, BIT_N4_7, TRACK5, CORE_DECISION5, BIT_N5_0, BIT_N5_1, BIT_N5_2, BIT_N5_3, BIT_N5_4, BIT_N5_5, BIT_N5_6, BIT_N5_7, TRACK6, CORE_DECISION6, BIT_N6_0, BIT_N6_1, BIT_N6_2, BIT_N6_3, BIT_N6_4, BIT_N6_5, BIT_N6_6, BIT_N6_7, TRACK7, CORE_DECISION7, BIT_N7_0, BIT_N7_1, BIT_N7_2, BIT_N7_3, BIT_N7_4, BIT_N7_5, BIT_N7_6, BIT_N7_7, TRACK8, CORE_DECISION8, BIT_N8_0, BIT_N8_1, BIT_N8_2, BIT_N8_3, BIT_N8_4, BIT_N8_5, BIT_N8_6, BIT_N8_7, TRACK9, CORE_DECISION9, BIT_N9_0, BIT_N9_1, BIT_N9_2, BIT_N9_3, BIT_N9_4, BIT_N9_5, BIT_N9_6, BIT_N9_7, TRACK10, CORE_DECISION10, BIT_N10_0, BIT_N10_1, BIT_N10_2, BIT_N10_3, BIT_N10_4, BIT_N10_5, BIT_N10_6, BIT_N10_7, TRACK11, CORE_DECISION11, BIT_N11_0, BIT_N11_1, BIT_N11_2, BIT_N11_3, BIT_N11_4, BIT_N11_5, BIT_N11_6, BIT_N11_7, TRACK12, CORE_DECISION12, BIT_N12_0, BIT_N12_1, BIT_N12_2, BIT_N12_3, BIT_N12_4, BIT_N12_5, BIT_N12_6, BIT_N12_7);
    inout Vdd, Vss, Vlogic, VREF, EVALUATE, CLEAR, P, N, SELECT_N0, SELECT_N1, SELECT_N2, SELECT_N3, SELECT_N4, TRACK0, CORE_DECISION0, BIT_N0_0, BIT_N0_1, BIT_N0_2, BIT_N0_3, BIT_N0_4, BIT_N0_5, BIT_N0_6, BIT_N0_7, TRACK1, CORE_DECISION1, BIT_N1_0, BIT_N1_1, BIT_N1_2, BIT_N1_3, BIT_N1_4, BIT_N1_5, BIT_N1_6, BIT_N1_7, TRACK2, CORE_DECISION2, BIT_N2_0, BIT_N2_1, BIT_N2_2, BIT_N2_3, BIT_N2_4, BIT_N2_5, BIT_N2_6, BIT_N2_7, TRACK3, CORE_DECISION3, BIT_N3_0, BIT_N3_1, BIT_N3_2, BIT_N3_3, BIT_N3_4, BIT_N3_5, BIT_N3_6, BIT_N3_7, TRACK4, CORE_DECISION4, BIT_N4_0, BIT_N4_1, BIT_N4_2, BIT_N4_3, BIT_N4_4, BIT_N4_5, BIT_N4_6, BIT_N4_7, TRACK5, CORE_DECISION5, BIT_N5_0, BIT_N5_1, BIT_N5_2, BIT_N5_3, BIT_N5_4, BIT_N5_5, BIT_N5_6, BIT_N5_7, TRACK6, CORE_DECISION6, BIT_N6_0, BIT_N6_1, BIT_N6_2, BIT_N6_3, BIT_N6_4, BIT_N6_5, BIT_N6_6, BIT_N6_7, TRACK7, CORE_DECISION7, BIT_N7_0, BIT_N7_1, BIT_N7_2, BIT_N7_3, BIT_N7_4, BIT_N7_5, BIT_N7_6, BIT_N7_7, TRACK8, CORE_DECISION8, BIT_N8_0, BIT_N8_1, BIT_N8_2, BIT_N8_3, BIT_N8_4, BIT_N8_5, BIT_N8_6, BIT_N8_7, TRACK9, CORE_DECISION9, BIT_N9_0, BIT_N9_1, BIT_N9_2, BIT_N9_3, BIT_N9_4, BIT_N9_5, BIT_N9_6, BIT_N9_7, TRACK10, CORE_DECISION10, BIT_N10_0, BIT_N10_1, BIT_N10_2, BIT_N10_3, BIT_N10_4, BIT_N10_5, BIT_N10_6, BIT_N10_7, TRACK11, CORE_DECISION11, BIT_N11_0, BIT_N11_1, BIT_N11_2, BIT_N11_3, BIT_N11_4, BIT_N11_5, BIT_N11_6, BIT_N11_7, TRACK12, CORE_DECISION12, BIT_N12_0, BIT_N12_1, BIT_N12_2, BIT_N12_3, BIT_N12_4, BIT_N12_5, BIT_N12_6, BIT_N12_7;
    electrical Vdd, Vss, Vlogic, VREF, EVALUATE, CLEAR, P, N, SELECT_N0, SELECT_N1, SELECT_N2, SELECT_N3, SELECT_N4, TRACK0, CORE_DECISION0, BIT_N0_0, BIT_N0_1, BIT_N0_2, BIT_N0_3, BIT_N0_4, BIT_N0_5, BIT_N0_6, BIT_N0_7, TRACK1, CORE_DECISION1, BIT_N1_0, BIT_N1_1, BIT_N1_2, BIT_N1_3, BIT_N1_4, BIT_N1_5, BIT_N1_6, BIT_N1_7, TRACK2, CORE_DECISION2, BIT_N2_0, BIT_N2_1, BIT_N2_2, BIT_N2_3, BIT_N2_4, BIT_N2_5, BIT_N2_6, BIT_N2_7, TRACK3, CORE_DECISION3, BIT_N3_0, BIT_N3_1, BIT_N3_2, BIT_N3_3, BIT_N3_4, BIT_N3_5, BIT_N3_6, BIT_N3_7, TRACK4, CORE_DECISION4, BIT_N4_0, BIT_N4_1, BIT_N4_2, BIT_N4_3, BIT_N4_4, BIT_N4_5, BIT_N4_6, BIT_N4_7, TRACK5, CORE_DECISION5, BIT_N5_0, BIT_N5_1, BIT_N5_2, BIT_N5_3, BIT_N5_4, BIT_N5_5, BIT_N5_6, BIT_N5_7, TRACK6, CORE_DECISION6, BIT_N6_0, BIT_N6_1, BIT_N6_2, BIT_N6_3, BIT_N6_4, BIT_N6_5, BIT_N6_6, BIT_N6_7, TRACK7, CORE_DECISION7, BIT_N7_0, BIT_N7_1, BIT_N7_2, BIT_N7_3, BIT_N7_4, BIT_N7_5, BIT_N7_6, BIT_N7_7, TRACK8, CORE_DECISION8, BIT_N8_0, BIT_N8_1, BIT_N8_2, BIT_N8_3, BIT_N8_4, BIT_N8_5, BIT_N8_6, BIT_N8_7, TRACK9, CORE_DECISION9, BIT_N9_0, BIT_N9_1, BIT_N9_2, BIT_N9_3, BIT_N9_4, BIT_N9_5, BIT_N9_6, BIT_N9_7, TRACK10, CORE_DECISION10, BIT_N10_0, BIT_N10_1, BIT_N10_2, BIT_N10_3, BIT_N10_4, BIT_N10_5, BIT_N10_6, BIT_N10_7, TRACK11, CORE_DECISION11, BIT_N11_0, BIT_N11_1, BIT_N11_2, BIT_N11_3, BIT_N11_4, BIT_N11_5, BIT_N11_6, BIT_N11_7, TRACK12, CORE_DECISION12, BIT_N12_0, BIT_N12_1, BIT_N12_2, BIT_N12_3, BIT_N12_4, BIT_N12_5, BIT_N12_6, BIT_N12_7;
    electrical cpphdl_n150;
    electrical cpphdl_n307;
    electrical cpphdl_n308;
    electrical cpphdl_n311;
    electrical cpphdl_n312;
    electrical cpphdl_n313;
    electrical cpphdl_n316;
    electrical cpphdl_n317;
    electrical cpphdl_n320;
    electrical cpphdl_n321;
    electrical cpphdl_n337;
    electrical cpphdl_n338;
    electrical cpphdl_n339;
    electrical cpphdl_n340;
    electrical cpphdl_n341;
    electrical cpphdl_n342;
    electrical cpphdl_n343;
    electrical cpphdl_n344;
    electrical cpphdl_n345;
    electrical cpphdl_n346;
    electrical cpphdl_n347;
    electrical cpphdl_n348;
    electrical cpphdl_n349;
    electrical cpphdl_n350;
    electrical cpphdl_n351;
    electrical cpphdl_n352;
    electrical cpphdl_n356;
    electrical cpphdl_n360;
    electrical cpphdl_n364;
    electrical cpphdl_n368;
    electrical cpphdl_n372;
    electrical cpphdl_n373;
    electrical cpphdl_n374;
    electrical cpphdl_n375;
    electrical cpphdl_n376;
    electrical cpphdl_n379;
    electrical cpphdl_n380;
    electrical cpphdl_n382;
    electrical cpphdl_n383;
    electrical cpphdl_n384;
    electrical cpphdl_n385;
    electrical cpphdl_n386;
    electrical cpphdl_n387;
    electrical cpphdl_n388;
    electrical cpphdl_n389;
    electrical cpphdl_n390;
    electrical cpphdl_n393;
    electrical cpphdl_n576;
    electrical cpphdl_n591;
    electrical cpphdl_n595;
    electrical cpphdl_n599;
    electrical cpphdl_n603;
    electrical cpphdl_n607;
    electrical cpphdl_n611;
    electrical cpphdl_n615;
    electrical cpphdl_n619;
    electrical cpphdl_n620;
    electrical cpphdl_n621;
    electrical cpphdl_n622;
    electrical cpphdl_n623;
    electrical cpphdl_n624;
    electrical cpphdl_n625;
    electrical cpphdl_n626;
    electrical cpphdl_n630;
    electrical cpphdl_n631;
    electrical cpphdl_n634;
    electrical cpphdl_n635;
    electrical cpphdl_n636;
    electrical cpphdl_n639;
    electrical cpphdl_n640;
    electrical cpphdl_n644;
    electrical cpphdl_n645;
    electrical cpphdl_n646;
    electrical cpphdl_n659;
    electrical cpphdl_n663;
    electrical cpphdl_n667;
    electrical cpphdl_n671;
    electrical cpphdl_n681;
    electrical cpphdl_n684;
    electrical cpphdl_n687;
    electrical cpphdl_n689;
    electrical cpphdl_n690;
    electrical cpphdl_n695;
    electrical cpphdl_n719;
    electrical cpphdl_n734;
    electrical cpphdl_n738;
    electrical cpphdl_n742;
    electrical cpphdl_n746;
    electrical cpphdl_n750;
    electrical cpphdl_n754;
    electrical cpphdl_n758;
    electrical cpphdl_n762;
    electrical cpphdl_n763;
    electrical cpphdl_n764;
    electrical cpphdl_n765;
    electrical cpphdl_n766;
    electrical cpphdl_n767;
    electrical cpphdl_n768;
    electrical cpphdl_n769;
    electrical cpphdl_n773;
    electrical cpphdl_n774;
    electrical cpphdl_n777;
    electrical cpphdl_n778;
    electrical cpphdl_n779;
    electrical cpphdl_n782;
    electrical cpphdl_n783;
    electrical cpphdl_n787;
    electrical cpphdl_n788;
    electrical cpphdl_n789;
    electrical cpphdl_n802;
    electrical cpphdl_n806;
    electrical cpphdl_n810;
    electrical cpphdl_n814;
    electrical cpphdl_n824;
    electrical cpphdl_n827;
    electrical cpphdl_n830;
    electrical cpphdl_n832;
    electrical cpphdl_n833;
    electrical cpphdl_n838;
    electrical cpphdl_n862;
    electrical cpphdl_n877;
    electrical cpphdl_n881;
    electrical cpphdl_n885;
    electrical cpphdl_n889;
    electrical cpphdl_n893;
    electrical cpphdl_n897;
    electrical cpphdl_n901;
    electrical cpphdl_n905;
    electrical cpphdl_n906;
    electrical cpphdl_n907;
    electrical cpphdl_n908;
    electrical cpphdl_n909;
    electrical cpphdl_n910;
    electrical cpphdl_n911;
    electrical cpphdl_n912;
    electrical cpphdl_n916;
    electrical cpphdl_n917;
    electrical cpphdl_n920;
    electrical cpphdl_n921;
    electrical cpphdl_n922;
    electrical cpphdl_n925;
    electrical cpphdl_n926;
    electrical cpphdl_n930;
    electrical cpphdl_n931;
    electrical cpphdl_n932;
    electrical cpphdl_n945;
    electrical cpphdl_n949;
    electrical cpphdl_n953;
    electrical cpphdl_n957;
    electrical cpphdl_n967;
    electrical cpphdl_n970;
    electrical cpphdl_n973;
    electrical cpphdl_n975;
    electrical cpphdl_n976;
    electrical cpphdl_n981;
    electrical cpphdl_n1005;
    electrical cpphdl_n1020;
    electrical cpphdl_n1024;
    electrical cpphdl_n1028;
    electrical cpphdl_n1032;
    electrical cpphdl_n1036;
    electrical cpphdl_n1040;
    electrical cpphdl_n1044;
    electrical cpphdl_n1048;
    electrical cpphdl_n1049;
    electrical cpphdl_n1050;
    electrical cpphdl_n1051;
    electrical cpphdl_n1052;
    electrical cpphdl_n1053;
    electrical cpphdl_n1054;
    electrical cpphdl_n1055;
    electrical cpphdl_n1059;
    electrical cpphdl_n1060;
    electrical cpphdl_n1063;
    electrical cpphdl_n1064;
    electrical cpphdl_n1065;
    electrical cpphdl_n1068;
    electrical cpphdl_n1069;
    electrical cpphdl_n1073;
    electrical cpphdl_n1074;
    electrical cpphdl_n1075;
    electrical cpphdl_n1088;
    electrical cpphdl_n1092;
    electrical cpphdl_n1096;
    electrical cpphdl_n1100;
    electrical cpphdl_n1110;
    electrical cpphdl_n1113;
    electrical cpphdl_n1116;
    electrical cpphdl_n1118;
    electrical cpphdl_n1119;
    electrical cpphdl_n1124;
    electrical cpphdl_n1148;
    electrical cpphdl_n1163;
    electrical cpphdl_n1167;
    electrical cpphdl_n1171;
    electrical cpphdl_n1175;
    electrical cpphdl_n1179;
    electrical cpphdl_n1183;
    electrical cpphdl_n1187;
    electrical cpphdl_n1191;
    electrical cpphdl_n1192;
    electrical cpphdl_n1193;
    electrical cpphdl_n1194;
    electrical cpphdl_n1195;
    electrical cpphdl_n1196;
    electrical cpphdl_n1197;
    electrical cpphdl_n1198;
    electrical cpphdl_n1202;
    electrical cpphdl_n1203;
    electrical cpphdl_n1206;
    electrical cpphdl_n1207;
    electrical cpphdl_n1208;
    electrical cpphdl_n1211;
    electrical cpphdl_n1212;
    electrical cpphdl_n1216;
    electrical cpphdl_n1217;
    electrical cpphdl_n1218;
    electrical cpphdl_n1231;
    electrical cpphdl_n1235;
    electrical cpphdl_n1239;
    electrical cpphdl_n1243;
    electrical cpphdl_n1253;
    electrical cpphdl_n1256;
    electrical cpphdl_n1259;
    electrical cpphdl_n1261;
    electrical cpphdl_n1262;
    electrical cpphdl_n1267;
    electrical cpphdl_n1291;
    electrical cpphdl_n1306;
    electrical cpphdl_n1310;
    electrical cpphdl_n1314;
    electrical cpphdl_n1318;
    electrical cpphdl_n1322;
    electrical cpphdl_n1326;
    electrical cpphdl_n1330;
    electrical cpphdl_n1334;
    electrical cpphdl_n1335;
    electrical cpphdl_n1336;
    electrical cpphdl_n1337;
    electrical cpphdl_n1338;
    electrical cpphdl_n1339;
    electrical cpphdl_n1340;
    electrical cpphdl_n1341;
    electrical cpphdl_n1345;
    electrical cpphdl_n1346;
    electrical cpphdl_n1349;
    electrical cpphdl_n1350;
    electrical cpphdl_n1351;
    electrical cpphdl_n1354;
    electrical cpphdl_n1355;
    electrical cpphdl_n1359;
    electrical cpphdl_n1360;
    electrical cpphdl_n1361;
    electrical cpphdl_n1374;
    electrical cpphdl_n1378;
    electrical cpphdl_n1382;
    electrical cpphdl_n1386;
    electrical cpphdl_n1396;
    electrical cpphdl_n1399;
    electrical cpphdl_n1402;
    electrical cpphdl_n1404;
    electrical cpphdl_n1405;
    electrical cpphdl_n1410;
    electrical cpphdl_n1434;
    electrical cpphdl_n1449;
    electrical cpphdl_n1453;
    electrical cpphdl_n1457;
    electrical cpphdl_n1461;
    electrical cpphdl_n1465;
    electrical cpphdl_n1469;
    electrical cpphdl_n1473;
    electrical cpphdl_n1477;
    electrical cpphdl_n1478;
    electrical cpphdl_n1479;
    electrical cpphdl_n1480;
    electrical cpphdl_n1481;
    electrical cpphdl_n1482;
    electrical cpphdl_n1483;
    electrical cpphdl_n1484;
    electrical cpphdl_n1488;
    electrical cpphdl_n1489;
    electrical cpphdl_n1492;
    electrical cpphdl_n1493;
    electrical cpphdl_n1494;
    electrical cpphdl_n1497;
    electrical cpphdl_n1498;
    electrical cpphdl_n1502;
    electrical cpphdl_n1503;
    electrical cpphdl_n1504;
    electrical cpphdl_n1517;
    electrical cpphdl_n1521;
    electrical cpphdl_n1525;
    electrical cpphdl_n1529;
    electrical cpphdl_n1539;
    electrical cpphdl_n1542;
    electrical cpphdl_n1545;
    electrical cpphdl_n1547;
    electrical cpphdl_n1548;
    electrical cpphdl_n1553;
    electrical cpphdl_n1577;
    electrical cpphdl_n1592;
    electrical cpphdl_n1596;
    electrical cpphdl_n1600;
    electrical cpphdl_n1604;
    electrical cpphdl_n1608;
    electrical cpphdl_n1612;
    electrical cpphdl_n1616;
    electrical cpphdl_n1620;
    electrical cpphdl_n1621;
    electrical cpphdl_n1622;
    electrical cpphdl_n1623;
    electrical cpphdl_n1624;
    electrical cpphdl_n1625;
    electrical cpphdl_n1626;
    electrical cpphdl_n1627;
    electrical cpphdl_n1631;
    electrical cpphdl_n1632;
    electrical cpphdl_n1635;
    electrical cpphdl_n1636;
    electrical cpphdl_n1637;
    electrical cpphdl_n1640;
    electrical cpphdl_n1641;
    electrical cpphdl_n1645;
    electrical cpphdl_n1646;
    electrical cpphdl_n1647;
    electrical cpphdl_n1660;
    electrical cpphdl_n1664;
    electrical cpphdl_n1668;
    electrical cpphdl_n1672;
    electrical cpphdl_n1682;
    electrical cpphdl_n1685;
    electrical cpphdl_n1688;
    electrical cpphdl_n1690;
    electrical cpphdl_n1691;
    electrical cpphdl_n1696;
    electrical cpphdl_n1720;
    electrical cpphdl_n1735;
    electrical cpphdl_n1739;
    electrical cpphdl_n1743;
    electrical cpphdl_n1747;
    electrical cpphdl_n1751;
    electrical cpphdl_n1755;
    electrical cpphdl_n1759;
    electrical cpphdl_n1763;
    electrical cpphdl_n1764;
    electrical cpphdl_n1765;
    electrical cpphdl_n1766;
    electrical cpphdl_n1767;
    electrical cpphdl_n1768;
    electrical cpphdl_n1769;
    electrical cpphdl_n1770;
    electrical cpphdl_n1774;
    electrical cpphdl_n1775;
    electrical cpphdl_n1778;
    electrical cpphdl_n1779;
    electrical cpphdl_n1780;
    electrical cpphdl_n1783;
    electrical cpphdl_n1784;
    electrical cpphdl_n1788;
    electrical cpphdl_n1789;
    electrical cpphdl_n1790;
    electrical cpphdl_n1803;
    electrical cpphdl_n1807;
    electrical cpphdl_n1811;
    electrical cpphdl_n1815;
    electrical cpphdl_n1825;
    electrical cpphdl_n1828;
    electrical cpphdl_n1831;
    electrical cpphdl_n1833;
    electrical cpphdl_n1834;
    electrical cpphdl_n1839;
    electrical cpphdl_n1863;
    electrical cpphdl_n1878;
    electrical cpphdl_n1882;
    electrical cpphdl_n1886;
    electrical cpphdl_n1890;
    electrical cpphdl_n1894;
    electrical cpphdl_n1898;
    electrical cpphdl_n1902;
    electrical cpphdl_n1906;
    electrical cpphdl_n1907;
    electrical cpphdl_n1908;
    electrical cpphdl_n1909;
    electrical cpphdl_n1910;
    electrical cpphdl_n1911;
    electrical cpphdl_n1912;
    electrical cpphdl_n1913;
    electrical cpphdl_n1917;
    electrical cpphdl_n1918;
    electrical cpphdl_n1921;
    electrical cpphdl_n1922;
    electrical cpphdl_n1923;
    electrical cpphdl_n1926;
    electrical cpphdl_n1927;
    electrical cpphdl_n1931;
    electrical cpphdl_n1932;
    electrical cpphdl_n1933;
    electrical cpphdl_n1946;
    electrical cpphdl_n1950;
    electrical cpphdl_n1954;
    electrical cpphdl_n1958;
    electrical cpphdl_n1968;
    electrical cpphdl_n1971;
    electrical cpphdl_n1974;
    electrical cpphdl_n1976;
    electrical cpphdl_n1977;
    electrical cpphdl_n1982;
    electrical cpphdl_n2006;
    electrical cpphdl_n2021;
    electrical cpphdl_n2025;
    electrical cpphdl_n2029;
    electrical cpphdl_n2033;
    electrical cpphdl_n2037;
    electrical cpphdl_n2041;
    electrical cpphdl_n2045;
    electrical cpphdl_n2049;
    electrical cpphdl_n2050;
    electrical cpphdl_n2051;
    electrical cpphdl_n2052;
    electrical cpphdl_n2053;
    electrical cpphdl_n2054;
    electrical cpphdl_n2055;
    electrical cpphdl_n2056;
    electrical cpphdl_n2060;
    electrical cpphdl_n2061;
    electrical cpphdl_n2064;
    electrical cpphdl_n2065;
    electrical cpphdl_n2066;
    electrical cpphdl_n2069;
    electrical cpphdl_n2070;
    electrical cpphdl_n2074;
    electrical cpphdl_n2075;
    electrical cpphdl_n2076;
    electrical cpphdl_n2089;
    electrical cpphdl_n2093;
    electrical cpphdl_n2097;
    electrical cpphdl_n2101;
    electrical cpphdl_n2111;
    electrical cpphdl_n2114;
    electrical cpphdl_n2117;
    electrical cpphdl_n2119;
    electrical cpphdl_n2120;
    electrical cpphdl_n2125;
    electrical cpphdl_n2149;
    electrical cpphdl_n2164;
    electrical cpphdl_n2168;
    electrical cpphdl_n2172;
    electrical cpphdl_n2176;
    electrical cpphdl_n2180;
    electrical cpphdl_n2184;
    electrical cpphdl_n2188;
    electrical cpphdl_n2192;
    electrical cpphdl_n2193;
    electrical cpphdl_n2194;
    electrical cpphdl_n2195;
    electrical cpphdl_n2196;
    electrical cpphdl_n2197;
    electrical cpphdl_n2198;
    electrical cpphdl_n2199;
    electrical cpphdl_n2203;
    electrical cpphdl_n2204;
    electrical cpphdl_n2207;
    electrical cpphdl_n2208;
    electrical cpphdl_n2209;
    electrical cpphdl_n2212;
    electrical cpphdl_n2213;
    electrical cpphdl_n2217;
    electrical cpphdl_n2218;
    electrical cpphdl_n2219;
    electrical cpphdl_n2232;
    electrical cpphdl_n2236;
    electrical cpphdl_n2240;
    electrical cpphdl_n2244;
    electrical cpphdl_n2254;
    electrical cpphdl_n2257;
    electrical cpphdl_n2260;
    electrical cpphdl_n2262;
    electrical cpphdl_n2263;
    electrical cpphdl_n2268;
    electrical cpphdl_n2286;
    electrical cpphdl_n2292;
    electrical cpphdl_n2307;
    electrical cpphdl_n2311;
    electrical cpphdl_n2315;
    electrical cpphdl_n2319;
    electrical cpphdl_n2323;
    electrical cpphdl_n2327;
    electrical cpphdl_n2331;
    electrical cpphdl_n2335;
    electrical cpphdl_n2336;
    electrical cpphdl_n2337;
    electrical cpphdl_n2338;
    electrical cpphdl_n2339;
    electrical cpphdl_n2340;
    electrical cpphdl_n2341;
    electrical cpphdl_n2342;
    electrical cpphdl_n2346;
    electrical cpphdl_n2347;
    electrical cpphdl_n2350;
    electrical cpphdl_n2351;
    electrical cpphdl_n2352;
    electrical cpphdl_n2355;
    electrical cpphdl_n2356;
    electrical cpphdl_n2360;
    electrical cpphdl_n2361;
    electrical cpphdl_n2362;
    electrical cpphdl_n2375;
    electrical cpphdl_n2379;
    electrical cpphdl_n2383;
    electrical cpphdl_n2387;
    electrical cpphdl_n2397;
    electrical cpphdl_n2400;
    electrical cpphdl_n2403;
    electrical cpphdl_n2405;
    electrical cpphdl_n2406;
    electrical cpphdl_n2411;
    electrical cpphdl_n2428;
    electrical cpphdl_n2430;
    electrical cpphdl_n2433;
    electrical cpphdl_n2435;
    electrical cpphdl_n2438;
    electrical cpphdl_n2440;
    electrical cpphdl_n2443;
    electrical cpphdl_n2445;
    electrical cpphdl_n2448;
    electrical cpphdl_n2450;
    electrical cpphdl_n2453;
    electrical cpphdl_n2455;
    electrical cpphdl_n2458;
    electrical cpphdl_n2460;
    electrical cpphdl_n2463;
    electrical cpphdl_n2465;
    electrical cpphdl_n2468;
    electrical cpphdl_n2470;
    electrical cpphdl_n2473;
    electrical cpphdl_n2475;
    electrical cpphdl_n2478;
    electrical cpphdl_n2480;
    electrical cpphdl_n2483;
    electrical cpphdl_n2485;
    electrical cpphdl_n2488;
    electrical cpphdl_n2490;

    // Square-law channel, including reverse conduction. This is not a BSIM model.
    analog function real cpphdl_channel;
        input vgs, vds, beta, threshold, polarity;
        real vgs, vds, beta, threshold, polarity;
        real gate, drain, direction, overdrive, current;
        begin
            gate = polarity * vgs;
            drain = polarity * vds;
            direction = 1.0;
            if (drain < 0.0) begin
                gate = gate - drain;
                drain = -drain;
                direction = -1.0;
            end
            overdrive = gate - threshold;
            current = 0.0;
            if (overdrive > 0.0) begin
                if (drain < overdrive)
                    current = beta * (overdrive * drain - drain * drain / 2.0);
                else
                    current = beta * overdrive * overdrive / 2.0;
            end
            cpphdl_channel = polarity * direction * current;
        end
    endfunction

    analog begin
        // device 0, IC IC1, analog/1G/mdi_input_network.hpp:20
        I(P, cpphdl_n307) <+ V(P, cpphdl_n307) / 2000.0;
        // device 1, IC IC1, analog/1G/mdi_input_network.hpp:21
        I(N, cpphdl_n308) <+ V(N, cpphdl_n308) / 2000.0;
        // device 2, IC IC1, analog/1G/mdi_input_network.hpp:22
        I(Vdd, cpphdl_n150) <+ V(Vdd, cpphdl_n150) / 1000.0;
        // device 3, IC IC1, analog/1G/mdi_input_network.hpp:23
        I(cpphdl_n150, Vss) <+ V(cpphdl_n150, Vss) / 1000.0;
        // device 4, IC IC1, analog/1G/mdi_input_network.hpp:24
        I(cpphdl_n150, cpphdl_n307) <+ V(cpphdl_n150, cpphdl_n307) / 330.0;
        // device 5, IC IC1, analog/1G/mdi_input_network.hpp:25
        I(cpphdl_n150, cpphdl_n308) <+ V(cpphdl_n150, cpphdl_n308) / 330.0;
        // device 6, IC IC1, analog/1G/mdi_input_network.hpp:26
        I(cpphdl_n150, Vss) <+ 2e-12 * ddt(V(cpphdl_n150, Vss)); // Bench initial voltage = 0.0 V.
        // device 7, IC IC3, analog/1G/IHPSG13G2/differential_receive_frontend.hpp:24
        I(cpphdl_n307, cpphdl_n308) <+ V(cpphdl_n307, cpphdl_n308) / 100.0;
        // device 8, IC IC4, analog/basic/nmos_resistor_amplifier.hpp:23
        I(Vdd, cpphdl_n320) <+ V(Vdd, cpphdl_n320) / 500.0;
        // device 9, IC IC4, analog/basic/nmos_resistor_amplifier.hpp:24
        I(Vdd, cpphdl_n316) <+ V(Vdd, cpphdl_n316) / 500.0;
        // device 10, IC IC4, analog/basic/nmos_resistor_amplifier.hpp:25
        I(cpphdl_n320, cpphdl_n311) <+ cpphdl_channel(V(cpphdl_n307, cpphdl_n311), V(cpphdl_n320, cpphdl_n311), 0.014999999999999999, 0.69999999999999996, 1.0);
        // device 11, IC IC4, analog/basic/nmos_resistor_amplifier.hpp:26
        I(cpphdl_n316, cpphdl_n312) <+ cpphdl_channel(V(cpphdl_n308, cpphdl_n312), V(cpphdl_n316, cpphdl_n312), 0.014999999999999999, 0.69999999999999996, 1.0);
        // device 12, IC IC4, analog/basic/nmos_resistor_amplifier.hpp:27
        I(cpphdl_n313, cpphdl_n311) <+ V(cpphdl_n313, cpphdl_n311) / 50.0;
        // device 13, IC IC4, analog/basic/nmos_resistor_amplifier.hpp:28
        I(cpphdl_n313, cpphdl_n312) <+ V(cpphdl_n313, cpphdl_n312) / 50.0;
        // device 14, IC IC4, analog/basic/nmos_resistor_amplifier.hpp:29
        I(Vss, cpphdl_n313) <+ V(Vss, cpphdl_n313) / 150.0;
        // device 15, IC IC4, analog/basic/nmos_resistor_amplifier.hpp:30
        I(cpphdl_n320, Vdd) <+ 1e-13 * ddt(V(cpphdl_n320, Vdd)); // Bench initial voltage = 0.0 V.
        // device 16, IC IC4, analog/basic/nmos_resistor_amplifier.hpp:31
        I(cpphdl_n316, Vdd) <+ 1e-13 * ddt(V(cpphdl_n316, Vdd)); // Bench initial voltage = 0.0 V.
        // device 17, IC IC4, analog/basic/nmos_resistor_amplifier.hpp:32
        I(cpphdl_n313, Vss) <+ 4e-14 * ddt(V(cpphdl_n313, Vss)); // Bench initial voltage = 0.0 V.
        // device 18, IC IC4, analog/basic/nmos_resistor_amplifier.hpp:34
        I(cpphdl_n307, cpphdl_n311) <+ 1.4999999999999999e-13 * ddt(V(cpphdl_n307, cpphdl_n311)); // Bench initial voltage = 0.0 V.
        // device 19, IC IC4, analog/basic/nmos_resistor_amplifier.hpp:35
        I(cpphdl_n308, cpphdl_n312) <+ 1.4999999999999999e-13 * ddt(V(cpphdl_n308, cpphdl_n312)); // Bench initial voltage = 0.0 V.
        // device 20, IC IC4, analog/basic/nmos_resistor_amplifier.hpp:36
        I(cpphdl_n307, cpphdl_n320) <+ 2e-14 * ddt(V(cpphdl_n307, cpphdl_n320)); // Bench initial voltage = 0.0 V.
        // device 21, IC IC4, analog/basic/nmos_resistor_amplifier.hpp:37
        I(cpphdl_n308, cpphdl_n316) <+ 2e-14 * ddt(V(cpphdl_n308, cpphdl_n316)); // Bench initial voltage = 0.0 V.
        // device 22, IC IC5, analog/basic/nmos_source_follower.hpp:19
        I(Vdd, cpphdl_n317) <+ cpphdl_channel(V(cpphdl_n316, cpphdl_n317), V(Vdd, cpphdl_n317), 0.10000000000000001, 0.69999999999999996, 1.0);
        // device 23, IC IC5, analog/basic/nmos_source_follower.hpp:20
        I(Vss, cpphdl_n317) <+ V(Vss, cpphdl_n317) / 250.0;
        // device 24, IC IC5, analog/basic/nmos_source_follower.hpp:23
        I(cpphdl_n316, cpphdl_n317) <+ 4e-14 * ddt(V(cpphdl_n316, cpphdl_n317)); // Bench initial voltage = 0.0 V.
        // device 25, IC IC5, analog/basic/nmos_source_follower.hpp:24
        I(cpphdl_n316, Vdd) <+ 1e-14 * ddt(V(cpphdl_n316, Vdd)); // Bench initial voltage = 0.0 V.
        // device 26, IC IC5, analog/basic/nmos_source_follower.hpp:25
        I(cpphdl_n317, Vss) <+ 4e-14 * ddt(V(cpphdl_n317, Vss)); // Bench initial voltage = 0.0 V.
        // device 27, IC IC6, analog/basic/nmos_source_follower.hpp:19
        I(Vdd, cpphdl_n321) <+ cpphdl_channel(V(cpphdl_n320, cpphdl_n321), V(Vdd, cpphdl_n321), 0.10000000000000001, 0.69999999999999996, 1.0);
        // device 28, IC IC6, analog/basic/nmos_source_follower.hpp:20
        I(Vss, cpphdl_n321) <+ V(Vss, cpphdl_n321) / 250.0;
        // device 29, IC IC6, analog/basic/nmos_source_follower.hpp:23
        I(cpphdl_n320, cpphdl_n321) <+ 4e-14 * ddt(V(cpphdl_n320, cpphdl_n321)); // Bench initial voltage = 0.0 V.
        // device 30, IC IC6, analog/basic/nmos_source_follower.hpp:24
        I(cpphdl_n320, Vdd) <+ 1e-14 * ddt(V(cpphdl_n320, Vdd)); // Bench initial voltage = 0.0 V.
        // device 31, IC IC6, analog/basic/nmos_source_follower.hpp:25
        I(cpphdl_n321, Vss) <+ 4e-14 * ddt(V(cpphdl_n321, Vss)); // Bench initial voltage = 0.0 V.
        // device 32, IC IC8, analog/basic/inverter.hpp:11
        I(cpphdl_n356, Vdd) <+ cpphdl_channel(V(SELECT_N0, Vdd), V(cpphdl_n356, Vdd), 0.0030000000000000001, 0.69999999999999996, -1.0);
        // device 33, IC IC8, analog/basic/inverter.hpp:12
        I(cpphdl_n356, Vss) <+ cpphdl_channel(V(SELECT_N0, Vss), V(cpphdl_n356, Vss), 0.0030000000000000001, 0.69999999999999996, 1.0);
        // device 34, IC IC7, analog/1G/IHPSG13G2/differential_receive_gain.hpp:41
        I(cpphdl_n356, Vss) <+ 2e-14 * ddt(V(cpphdl_n356, Vss)); // Bench initial voltage = 0.0 V.
        // device 35, IC IC9, analog/basic/inverter.hpp:11
        I(cpphdl_n360, Vdd) <+ cpphdl_channel(V(SELECT_N1, Vdd), V(cpphdl_n360, Vdd), 0.0030000000000000001, 0.69999999999999996, -1.0);
        // device 36, IC IC9, analog/basic/inverter.hpp:12
        I(cpphdl_n360, Vss) <+ cpphdl_channel(V(SELECT_N1, Vss), V(cpphdl_n360, Vss), 0.0030000000000000001, 0.69999999999999996, 1.0);
        // device 37, IC IC7, analog/1G/IHPSG13G2/differential_receive_gain.hpp:41
        I(cpphdl_n360, Vss) <+ 2e-14 * ddt(V(cpphdl_n360, Vss)); // Bench initial voltage = 0.0 V.
        // device 38, IC IC10, analog/basic/inverter.hpp:11
        I(cpphdl_n364, Vdd) <+ cpphdl_channel(V(SELECT_N2, Vdd), V(cpphdl_n364, Vdd), 0.0030000000000000001, 0.69999999999999996, -1.0);
        // device 39, IC IC10, analog/basic/inverter.hpp:12
        I(cpphdl_n364, Vss) <+ cpphdl_channel(V(SELECT_N2, Vss), V(cpphdl_n364, Vss), 0.0030000000000000001, 0.69999999999999996, 1.0);
        // device 40, IC IC7, analog/1G/IHPSG13G2/differential_receive_gain.hpp:41
        I(cpphdl_n364, Vss) <+ 2e-14 * ddt(V(cpphdl_n364, Vss)); // Bench initial voltage = 0.0 V.
        // device 41, IC IC11, analog/basic/inverter.hpp:11
        I(cpphdl_n368, Vdd) <+ cpphdl_channel(V(SELECT_N3, Vdd), V(cpphdl_n368, Vdd), 0.0030000000000000001, 0.69999999999999996, -1.0);
        // device 42, IC IC11, analog/basic/inverter.hpp:12
        I(cpphdl_n368, Vss) <+ cpphdl_channel(V(SELECT_N3, Vss), V(cpphdl_n368, Vss), 0.0030000000000000001, 0.69999999999999996, 1.0);
        // device 43, IC IC7, analog/1G/IHPSG13G2/differential_receive_gain.hpp:41
        I(cpphdl_n368, Vss) <+ 2e-14 * ddt(V(cpphdl_n368, Vss)); // Bench initial voltage = 0.0 V.
        // device 44, IC IC12, analog/basic/inverter.hpp:11
        I(cpphdl_n372, Vdd) <+ cpphdl_channel(V(SELECT_N4, Vdd), V(cpphdl_n372, Vdd), 0.0030000000000000001, 0.69999999999999996, -1.0);
        // device 45, IC IC12, analog/basic/inverter.hpp:12
        I(cpphdl_n372, Vss) <+ cpphdl_channel(V(SELECT_N4, Vss), V(cpphdl_n372, Vss), 0.0030000000000000001, 0.69999999999999996, 1.0);
        // device 46, IC IC7, analog/1G/IHPSG13G2/differential_receive_gain.hpp:41
        I(cpphdl_n372, Vss) <+ 2e-14 * ddt(V(cpphdl_n372, Vss)); // Bench initial voltage = 0.0 V.
        // device 47, IC IC7, analog/1G/IHPSG13G2/differential_receive_gain.hpp:43
        I(VREF, cpphdl_n345) <+ V(VREF, cpphdl_n345) / 100.0;
        // device 48, IC IC7, analog/1G/IHPSG13G2/differential_receive_gain.hpp:45
        I(cpphdl_n345, cpphdl_n346) <+ V(cpphdl_n345, cpphdl_n346) / 100.0;
        // device 49, IC IC7, analog/1G/IHPSG13G2/differential_receive_gain.hpp:45
        I(cpphdl_n346, cpphdl_n347) <+ V(cpphdl_n346, cpphdl_n347) / 100.0;
        // device 50, IC IC7, analog/1G/IHPSG13G2/differential_receive_gain.hpp:45
        I(cpphdl_n347, cpphdl_n348) <+ V(cpphdl_n347, cpphdl_n348) / 100.0;
        // device 51, IC IC7, analog/1G/IHPSG13G2/differential_receive_gain.hpp:45
        I(cpphdl_n348, cpphdl_n349) <+ V(cpphdl_n348, cpphdl_n349) / 100.0;
        // device 52, IC IC7, analog/1G/IHPSG13G2/differential_receive_gain.hpp:45
        I(cpphdl_n349, cpphdl_n350) <+ V(cpphdl_n349, cpphdl_n350) / 100.0;
        // device 53, IC IC7, analog/1G/IHPSG13G2/differential_receive_gain.hpp:45
        I(cpphdl_n350, cpphdl_n351) <+ V(cpphdl_n350, cpphdl_n351) / 100.0;
        // device 54, IC IC7, analog/1G/IHPSG13G2/differential_receive_gain.hpp:45
        I(cpphdl_n351, cpphdl_n352) <+ V(cpphdl_n351, cpphdl_n352) / 100.0;
        // device 55, IC IC7, analog/1G/IHPSG13G2/differential_receive_gain.hpp:46
        I(cpphdl_n352, cpphdl_n317) <+ V(cpphdl_n352, cpphdl_n317) / 100.0;
        // device 56, IC IC7, analog/1G/IHPSG13G2/differential_receive_gain.hpp:48
        I(cpphdl_n348, cpphdl_n379) <+ cpphdl_channel(V(cpphdl_n356, cpphdl_n379), V(cpphdl_n348, cpphdl_n379), 0.029999999999999999, 0.69999999999999996, 1.0);
        // device 57, IC IC7, analog/1G/IHPSG13G2/differential_receive_gain.hpp:48
        I(cpphdl_n349, cpphdl_n379) <+ cpphdl_channel(V(cpphdl_n360, cpphdl_n379), V(cpphdl_n349, cpphdl_n379), 0.029999999999999999, 0.69999999999999996, 1.0);
        // device 58, IC IC7, analog/1G/IHPSG13G2/differential_receive_gain.hpp:48
        I(cpphdl_n350, cpphdl_n379) <+ cpphdl_channel(V(cpphdl_n364, cpphdl_n379), V(cpphdl_n350, cpphdl_n379), 0.029999999999999999, 0.69999999999999996, 1.0);
        // device 59, IC IC7, analog/1G/IHPSG13G2/differential_receive_gain.hpp:48
        I(cpphdl_n351, cpphdl_n379) <+ cpphdl_channel(V(cpphdl_n368, cpphdl_n379), V(cpphdl_n351, cpphdl_n379), 0.029999999999999999, 0.69999999999999996, 1.0);
        // device 60, IC IC7, analog/1G/IHPSG13G2/differential_receive_gain.hpp:48
        I(cpphdl_n352, cpphdl_n379) <+ cpphdl_channel(V(cpphdl_n372, cpphdl_n379), V(cpphdl_n352, cpphdl_n379), 0.029999999999999999, 0.69999999999999996, 1.0);
        // device 61, IC IC7, analog/1G/IHPSG13G2/differential_receive_gain.hpp:49
        I(cpphdl_n321, cpphdl_n379) <+ V(cpphdl_n321, cpphdl_n379) / 100000.0;
        // device 62, IC IC7, analog/1G/IHPSG13G2/differential_receive_gain.hpp:50
        I(cpphdl_n379, Vss) <+ 5.0000000000000002e-14 * ddt(V(cpphdl_n379, Vss)); // Bench initial voltage = 0.0 V.
        // device 63, IC IC15, analog/basic/resistor_divider.hpp:15
        I(Vdd, cpphdl_n382) <+ V(Vdd, cpphdl_n382) / 15000.0;
        // device 64, IC IC15, analog/basic/resistor_divider.hpp:16
        I(cpphdl_n382, Vss) <+ V(cpphdl_n382, Vss) / 18000.0;
        // device 65, IC IC16, analog/basic/resistor_divider.hpp:15
        I(Vdd, cpphdl_n383) <+ V(Vdd, cpphdl_n383) / 23000.0;
        // device 66, IC IC16, analog/basic/resistor_divider.hpp:16
        I(cpphdl_n383, Vss) <+ V(cpphdl_n383, Vss) / 43000.0;
        // device 67, IC IC7, analog/1G/IHPSG13G2/differential_receive_gain.hpp:61
        I(cpphdl_n382, Vss) <+ 9.9999999999999994e-12 * ddt(V(cpphdl_n382, Vss)); // Bench initial voltage = 0.0 V.
        // device 68, IC IC7, analog/1G/IHPSG13G2/differential_receive_gain.hpp:62
        I(cpphdl_n383, Vss) <+ 9.9999999999999994e-12 * ddt(V(cpphdl_n383, Vss)); // Bench initial voltage = 0.0 V.
        // device 69, IC IC7, analog/1G/IHPSG13G2/differential_receive_gain.hpp:63
        I(Vdd, cpphdl_n384) <+ V(Vdd, cpphdl_n384) / 2500.0;
        // device 70, IC IC7, analog/1G/IHPSG13G2/differential_receive_gain.hpp:64
        I(cpphdl_n384, Vss) <+ cpphdl_channel(V(cpphdl_n384, Vss), V(cpphdl_n384, Vss), 0.029999999999999999, 0.69999999999999996, 1.0);
        // device 71, IC IC7, analog/1G/IHPSG13G2/differential_receive_gain.hpp:65
        I(cpphdl_n384, Vss) <+ 9.9999999999999994e-12 * ddt(V(cpphdl_n384, Vss)); // Bench initial voltage = 0.0 V.
        // device 72, IC IC7, analog/1G/IHPSG13G2/differential_receive_gain.hpp:67
        I(cpphdl_n2286, cpphdl_n337) <+ V(cpphdl_n2286, cpphdl_n337) / 100.0;
        // device 73, IC IC7, analog/1G/IHPSG13G2/differential_receive_gain.hpp:69
        I(cpphdl_n337, cpphdl_n338) <+ V(cpphdl_n337, cpphdl_n338) / 100.0;
        // device 74, IC IC7, analog/1G/IHPSG13G2/differential_receive_gain.hpp:69
        I(cpphdl_n338, cpphdl_n339) <+ V(cpphdl_n338, cpphdl_n339) / 100.0;
        // device 75, IC IC7, analog/1G/IHPSG13G2/differential_receive_gain.hpp:69
        I(cpphdl_n339, cpphdl_n340) <+ V(cpphdl_n339, cpphdl_n340) / 100.0;
        // device 76, IC IC7, analog/1G/IHPSG13G2/differential_receive_gain.hpp:69
        I(cpphdl_n340, cpphdl_n341) <+ V(cpphdl_n340, cpphdl_n341) / 100.0;
        // device 77, IC IC7, analog/1G/IHPSG13G2/differential_receive_gain.hpp:69
        I(cpphdl_n341, cpphdl_n342) <+ V(cpphdl_n341, cpphdl_n342) / 100.0;
        // device 78, IC IC7, analog/1G/IHPSG13G2/differential_receive_gain.hpp:69
        I(cpphdl_n342, cpphdl_n343) <+ V(cpphdl_n342, cpphdl_n343) / 100.0;
        // device 79, IC IC7, analog/1G/IHPSG13G2/differential_receive_gain.hpp:69
        I(cpphdl_n343, cpphdl_n344) <+ V(cpphdl_n343, cpphdl_n344) / 100.0;
        // device 80, IC IC7, analog/1G/IHPSG13G2/differential_receive_gain.hpp:70
        I(cpphdl_n344, cpphdl_n321) <+ V(cpphdl_n344, cpphdl_n321) / 100.0;
        // device 81, IC IC7, analog/1G/IHPSG13G2/differential_receive_gain.hpp:73
        I(cpphdl_n340, cpphdl_n380) <+ cpphdl_channel(V(cpphdl_n356, cpphdl_n380), V(cpphdl_n340, cpphdl_n380), 0.029999999999999999, 0.69999999999999996, 1.0);
        // device 82, IC IC7, analog/1G/IHPSG13G2/differential_receive_gain.hpp:75
        I(cpphdl_n373, cpphdl_n393) <+ cpphdl_channel(V(SELECT_N0, cpphdl_n393), V(cpphdl_n373, cpphdl_n393), 0.02, 0.69999999999999996, -1.0);
        // device 83, IC IC7, analog/1G/IHPSG13G2/differential_receive_gain.hpp:76
        I(cpphdl_n373, Vss) <+ 9.9999999999999998e-13 * ddt(V(cpphdl_n373, Vss)); // Bench initial voltage = 0.0 V.
        // device 84, IC IC7, analog/1G/IHPSG13G2/differential_receive_gain.hpp:73
        I(cpphdl_n341, cpphdl_n380) <+ cpphdl_channel(V(cpphdl_n360, cpphdl_n380), V(cpphdl_n341, cpphdl_n380), 0.029999999999999999, 0.69999999999999996, 1.0);
        // device 85, IC IC7, analog/1G/IHPSG13G2/differential_receive_gain.hpp:75
        I(cpphdl_n374, cpphdl_n393) <+ cpphdl_channel(V(SELECT_N1, cpphdl_n393), V(cpphdl_n374, cpphdl_n393), 0.02, 0.69999999999999996, -1.0);
        // device 86, IC IC7, analog/1G/IHPSG13G2/differential_receive_gain.hpp:76
        I(cpphdl_n374, Vss) <+ 7.5000000000000004e-13 * ddt(V(cpphdl_n374, Vss)); // Bench initial voltage = 0.0 V.
        // device 87, IC IC7, analog/1G/IHPSG13G2/differential_receive_gain.hpp:73
        I(cpphdl_n342, cpphdl_n380) <+ cpphdl_channel(V(cpphdl_n364, cpphdl_n380), V(cpphdl_n342, cpphdl_n380), 0.029999999999999999, 0.69999999999999996, 1.0);
        // device 88, IC IC7, analog/1G/IHPSG13G2/differential_receive_gain.hpp:75
        I(cpphdl_n375, cpphdl_n393) <+ cpphdl_channel(V(SELECT_N2, cpphdl_n393), V(cpphdl_n375, cpphdl_n393), 0.02, 0.69999999999999996, -1.0);
        // device 89, IC IC7, analog/1G/IHPSG13G2/differential_receive_gain.hpp:76
        I(cpphdl_n375, Vss) <+ 4.9999999999999999e-13 * ddt(V(cpphdl_n375, Vss)); // Bench initial voltage = 0.0 V.
        // device 90, IC IC7, analog/1G/IHPSG13G2/differential_receive_gain.hpp:73
        I(cpphdl_n343, cpphdl_n380) <+ cpphdl_channel(V(cpphdl_n368, cpphdl_n380), V(cpphdl_n343, cpphdl_n380), 0.029999999999999999, 0.69999999999999996, 1.0);
        // device 91, IC IC7, analog/1G/IHPSG13G2/differential_receive_gain.hpp:75
        I(cpphdl_n376, cpphdl_n393) <+ cpphdl_channel(V(SELECT_N3, cpphdl_n393), V(cpphdl_n376, cpphdl_n393), 0.02, 0.69999999999999996, -1.0);
        // device 92, IC IC7, analog/1G/IHPSG13G2/differential_receive_gain.hpp:76
        I(cpphdl_n376, Vss) <+ 2.4999999999999999e-13 * ddt(V(cpphdl_n376, Vss)); // Bench initial voltage = 0.0 V.
        // device 93, IC IC7, analog/1G/IHPSG13G2/differential_receive_gain.hpp:73
        I(cpphdl_n344, cpphdl_n380) <+ cpphdl_channel(V(cpphdl_n372, cpphdl_n380), V(cpphdl_n344, cpphdl_n380), 0.029999999999999999, 0.69999999999999996, 1.0);
        // device 94, IC IC13, analog/basic/cascode_ota.hpp:29
        I(cpphdl_n385, cpphdl_n390) <+ cpphdl_channel(V(cpphdl_n379, cpphdl_n390), V(cpphdl_n385, cpphdl_n390), 0.029999999999999999, 0.69999999999999996, 1.0);
        // device 95, IC IC13, analog/basic/cascode_ota.hpp:30
        I(cpphdl_n386, cpphdl_n390) <+ cpphdl_channel(V(cpphdl_n380, cpphdl_n390), V(cpphdl_n386, cpphdl_n390), 0.029999999999999999, 0.69999999999999996, 1.0);
        // device 96, IC IC13, analog/basic/cascode_ota.hpp:31
        I(cpphdl_n387, cpphdl_n385) <+ cpphdl_channel(V(cpphdl_n382, cpphdl_n385), V(cpphdl_n387, cpphdl_n385), 0.059999999999999998, 0.69999999999999996, 1.0);
        // device 97, IC IC13, analog/basic/cascode_ota.hpp:32
        I(cpphdl_n393, cpphdl_n386) <+ cpphdl_channel(V(cpphdl_n382, cpphdl_n386), V(cpphdl_n393, cpphdl_n386), 0.059999999999999998, 0.69999999999999996, 1.0);
        // device 98, IC IC13, analog/basic/cascode_ota.hpp:33
        I(cpphdl_n388, Vdd) <+ cpphdl_channel(V(cpphdl_n387, Vdd), V(cpphdl_n388, Vdd), 0.029999999999999999, 0.69999999999999996, -1.0);
        // device 99, IC IC13, analog/basic/cascode_ota.hpp:34
        I(cpphdl_n389, Vdd) <+ cpphdl_channel(V(cpphdl_n387, Vdd), V(cpphdl_n389, Vdd), 0.029999999999999999, 0.69999999999999996, -1.0);
        // device 100, IC IC13, analog/basic/cascode_ota.hpp:35
        I(cpphdl_n387, cpphdl_n388) <+ cpphdl_channel(V(cpphdl_n383, cpphdl_n388), V(cpphdl_n387, cpphdl_n388), 0.059999999999999998, 0.69999999999999996, -1.0);
        // device 101, IC IC13, analog/basic/cascode_ota.hpp:36
        I(cpphdl_n393, cpphdl_n389) <+ cpphdl_channel(V(cpphdl_n383, cpphdl_n389), V(cpphdl_n393, cpphdl_n389), 0.059999999999999998, 0.69999999999999996, -1.0);
        // device 102, IC IC13, analog/basic/cascode_ota.hpp:37
        I(cpphdl_n390, Vss) <+ cpphdl_channel(V(cpphdl_n384, Vss), V(cpphdl_n390, Vss), 0.059999999999999998, 0.69999999999999996, 1.0);
        // device 103, IC IC13, analog/basic/cascode_ota.hpp:38
        I(cpphdl_n393, Vss) <+ 2.4999999999999999e-13 * ddt(V(cpphdl_n393, Vss)); // Bench initial voltage = 0.0 V.
        // device 104, IC IC13, analog/basic/cascode_ota.hpp:39
        I(cpphdl_n385, Vss) <+ 4e-14 * ddt(V(cpphdl_n385, Vss)); // Bench initial voltage = 0.0 V.
        // device 105, IC IC13, analog/basic/cascode_ota.hpp:40
        I(cpphdl_n386, Vss) <+ 4e-14 * ddt(V(cpphdl_n386, Vss)); // Bench initial voltage = 0.0 V.
        // device 106, IC IC13, analog/basic/cascode_ota.hpp:41
        I(cpphdl_n390, Vss) <+ 4e-14 * ddt(V(cpphdl_n390, Vss)); // Bench initial voltage = 0.0 V.
        // device 107, IC IC13, analog/basic/cascode_ota.hpp:42
        I(cpphdl_n388, Vdd) <+ 4e-14 * ddt(V(cpphdl_n388, Vdd)); // Bench initial voltage = 0.0 V.
        // device 108, IC IC13, analog/basic/cascode_ota.hpp:43
        I(cpphdl_n389, Vdd) <+ 4e-14 * ddt(V(cpphdl_n389, Vdd)); // Bench initial voltage = 0.0 V.
        // device 109, IC IC13, analog/basic/cascode_ota.hpp:44
        I(cpphdl_n387, Vss) <+ 4e-14 * ddt(V(cpphdl_n387, Vss)); // Bench initial voltage = 0.0 V.
        // device 110, IC IC13, analog/basic/cascode_ota.hpp:45
        I(cpphdl_n379, cpphdl_n390) <+ 4e-14 * ddt(V(cpphdl_n379, cpphdl_n390)); // Bench initial voltage = 0.0 V.
        // device 111, IC IC13, analog/basic/cascode_ota.hpp:46
        I(cpphdl_n380, cpphdl_n390) <+ 4e-14 * ddt(V(cpphdl_n380, cpphdl_n390)); // Bench initial voltage = 0.0 V.
        // device 112, IC IC13, analog/basic/cascode_ota.hpp:47
        I(cpphdl_n379, cpphdl_n385) <+ 1e-14 * ddt(V(cpphdl_n379, cpphdl_n385)); // Bench initial voltage = 0.0 V.
        // device 113, IC IC13, analog/basic/cascode_ota.hpp:48
        I(cpphdl_n380, cpphdl_n386) <+ 1e-14 * ddt(V(cpphdl_n380, cpphdl_n386)); // Bench initial voltage = 0.0 V.
        // device 114, IC IC14, analog/basic/nmos_source_follower.hpp:19
        I(Vdd, cpphdl_n2286) <+ cpphdl_channel(V(cpphdl_n393, cpphdl_n2286), V(Vdd, cpphdl_n2286), 0.20000000000000001, 0.69999999999999996, 1.0);
        // device 115, IC IC14, analog/basic/nmos_source_follower.hpp:20
        I(Vss, cpphdl_n2286) <+ V(Vss, cpphdl_n2286) / 500.0;
        // device 116, IC IC14, analog/basic/nmos_source_follower.hpp:23
        I(cpphdl_n393, cpphdl_n2286) <+ 8e-14 * ddt(V(cpphdl_n393, cpphdl_n2286)); // Bench initial voltage = 0.0 V.
        // device 117, IC IC14, analog/basic/nmos_source_follower.hpp:24
        I(cpphdl_n393, Vdd) <+ 2e-14 * ddt(V(cpphdl_n393, Vdd)); // Bench initial voltage = 0.0 V.
        // device 118, IC IC14, analog/basic/nmos_source_follower.hpp:25
        I(cpphdl_n2286, Vss) <+ 8e-14 * ddt(V(cpphdl_n2286, Vss)); // Bench initial voltage = 0.0 V.
        // device 119, IC IC3, analog/1G/IHPSG13G2/differential_receive_frontend.hpp:60
        I(cpphdl_n2286, Vss) <+ 3.0000000000000001e-12 * ddt(V(cpphdl_n2286, Vss)); // Bench initial voltage = 0.0 V.
        // device 120, IC IC20, analog/basic/inverter.hpp:11
        I(cpphdl_n576, Vdd) <+ cpphdl_channel(V(TRACK0, Vdd), V(cpphdl_n576, Vdd), 0.0040000000000000001, 0.69999999999999996, -1.0);
        // device 121, IC IC20, analog/basic/inverter.hpp:12
        I(cpphdl_n576, Vss) <+ cpphdl_channel(V(TRACK0, Vss), V(cpphdl_n576, Vss), 0.0040000000000000001, 0.69999999999999996, 1.0);
        // device 122, IC IC19, analog/basic/mos_track_hold.hpp:31
        I(cpphdl_n576, Vss) <+ 2e-14 * ddt(V(cpphdl_n576, Vss)); // Bench initial voltage = 0.0 V.
        // device 123, IC IC19, analog/basic/mos_track_hold.hpp:32
        I(cpphdl_n2286, cpphdl_n630) <+ cpphdl_channel(V(TRACK0, cpphdl_n630), V(cpphdl_n2286, cpphdl_n630), 0.029999999999999999, 0.69999999999999996, 1.0);
        // device 124, IC IC19, analog/basic/mos_track_hold.hpp:33
        I(cpphdl_n630, cpphdl_n2286) <+ cpphdl_channel(V(cpphdl_n576, cpphdl_n2286), V(cpphdl_n630, cpphdl_n2286), 0.014999999999999999, 0.69999999999999996, -1.0);
        // device 125, IC IC19, analog/basic/mos_track_hold.hpp:37
        I(cpphdl_n630, cpphdl_n630) <+ cpphdl_channel(V(cpphdl_n576, cpphdl_n630), V(cpphdl_n630, cpphdl_n630), 0.016, 0.69999999999999996, 1.0);
        // device 126, IC IC19, analog/basic/mos_track_hold.hpp:38
        I(cpphdl_n630, cpphdl_n630) <+ cpphdl_channel(V(TRACK0, cpphdl_n630), V(cpphdl_n630, cpphdl_n630), 0.0083999999999999995, 0.69999999999999996, -1.0);
        // device 127, IC IC19, analog/basic/mos_track_hold.hpp:39
        I(cpphdl_n630, Vss) <+ 1.5000000000000001e-12 * ddt(V(cpphdl_n630, Vss)); // Bench initial voltage = 0.0 V.
        // device 128, IC IC19, analog/basic/mos_track_hold.hpp:42
        I(TRACK0, cpphdl_n630) <+ 2.0000000000000002e-15 * ddt(V(TRACK0, cpphdl_n630)); // Bench initial voltage = -0.0 V.
        // device 129, IC IC19, analog/basic/mos_track_hold.hpp:43
        I(cpphdl_n576, cpphdl_n630) <+ 2.0000000000000002e-15 * ddt(V(cpphdl_n576, cpphdl_n630)); // Bench initial voltage = 0.0 V.
        // device 130, IC IC19, analog/basic/mos_track_hold.hpp:44
        I(cpphdl_n2286, cpphdl_n630) <+ 1.0000000000000001e-15 * ddt(V(cpphdl_n2286, cpphdl_n630)); // Bench initial voltage = 0.0 V.
        // device 131, IC IC22, analog/basic/inverter.hpp:11
        I(cpphdl_n591, Vdd) <+ cpphdl_channel(V(BIT_N0_0, Vdd), V(cpphdl_n591, Vdd), 0.080000000000000002, 0.69999999999999996, -1.0);
        // device 132, IC IC22, analog/basic/inverter.hpp:12
        I(cpphdl_n591, Vss) <+ cpphdl_channel(V(BIT_N0_0, Vss), V(cpphdl_n591, Vss), 0.080000000000000002, 0.69999999999999996, 1.0);
        // device 133, IC IC21, analog/basic/mos_r2r_dac.hpp:27
        I(cpphdl_n591, Vss) <+ 2.9999999999999998e-15 * ddt(V(cpphdl_n591, Vss)); // Bench initial voltage = 0.0 V.
        // device 134, IC IC21, analog/basic/mos_r2r_dac.hpp:28
        I(cpphdl_n591, cpphdl_n620) <+ V(cpphdl_n591, cpphdl_n620) / 2000.0;
        // device 135, IC IC21, analog/basic/mos_r2r_dac.hpp:29
        I(cpphdl_n620, Vss) <+ 2.9999999999999998e-15 * ddt(V(cpphdl_n620, Vss)); // Bench initial voltage = 0.0 V.
        // device 136, IC IC23, analog/basic/inverter.hpp:11
        I(cpphdl_n595, Vdd) <+ cpphdl_channel(V(BIT_N0_1, Vdd), V(cpphdl_n595, Vdd), 0.080000000000000002, 0.69999999999999996, -1.0);
        // device 137, IC IC23, analog/basic/inverter.hpp:12
        I(cpphdl_n595, Vss) <+ cpphdl_channel(V(BIT_N0_1, Vss), V(cpphdl_n595, Vss), 0.080000000000000002, 0.69999999999999996, 1.0);
        // device 138, IC IC21, analog/basic/mos_r2r_dac.hpp:27
        I(cpphdl_n595, Vss) <+ 2.9999999999999998e-15 * ddt(V(cpphdl_n595, Vss)); // Bench initial voltage = 0.0 V.
        // device 139, IC IC21, analog/basic/mos_r2r_dac.hpp:28
        I(cpphdl_n595, cpphdl_n621) <+ V(cpphdl_n595, cpphdl_n621) / 2000.0;
        // device 140, IC IC21, analog/basic/mos_r2r_dac.hpp:29
        I(cpphdl_n621, Vss) <+ 2.9999999999999998e-15 * ddt(V(cpphdl_n621, Vss)); // Bench initial voltage = 0.0 V.
        // device 141, IC IC21, analog/basic/mos_r2r_dac.hpp:31
        I(cpphdl_n620, cpphdl_n621) <+ V(cpphdl_n620, cpphdl_n621) / 1000.0;
        // device 142, IC IC24, analog/basic/inverter.hpp:11
        I(cpphdl_n599, Vdd) <+ cpphdl_channel(V(BIT_N0_2, Vdd), V(cpphdl_n599, Vdd), 0.080000000000000002, 0.69999999999999996, -1.0);
        // device 143, IC IC24, analog/basic/inverter.hpp:12
        I(cpphdl_n599, Vss) <+ cpphdl_channel(V(BIT_N0_2, Vss), V(cpphdl_n599, Vss), 0.080000000000000002, 0.69999999999999996, 1.0);
        // device 144, IC IC21, analog/basic/mos_r2r_dac.hpp:27
        I(cpphdl_n599, Vss) <+ 2.9999999999999998e-15 * ddt(V(cpphdl_n599, Vss)); // Bench initial voltage = 0.0 V.
        // device 145, IC IC21, analog/basic/mos_r2r_dac.hpp:28
        I(cpphdl_n599, cpphdl_n622) <+ V(cpphdl_n599, cpphdl_n622) / 2000.0;
        // device 146, IC IC21, analog/basic/mos_r2r_dac.hpp:29
        I(cpphdl_n622, Vss) <+ 2.9999999999999998e-15 * ddt(V(cpphdl_n622, Vss)); // Bench initial voltage = 0.0 V.
        // device 147, IC IC21, analog/basic/mos_r2r_dac.hpp:31
        I(cpphdl_n621, cpphdl_n622) <+ V(cpphdl_n621, cpphdl_n622) / 1000.0;
        // device 148, IC IC25, analog/basic/inverter.hpp:11
        I(cpphdl_n603, Vdd) <+ cpphdl_channel(V(BIT_N0_3, Vdd), V(cpphdl_n603, Vdd), 0.080000000000000002, 0.69999999999999996, -1.0);
        // device 149, IC IC25, analog/basic/inverter.hpp:12
        I(cpphdl_n603, Vss) <+ cpphdl_channel(V(BIT_N0_3, Vss), V(cpphdl_n603, Vss), 0.080000000000000002, 0.69999999999999996, 1.0);
        // device 150, IC IC21, analog/basic/mos_r2r_dac.hpp:27
        I(cpphdl_n603, Vss) <+ 2.9999999999999998e-15 * ddt(V(cpphdl_n603, Vss)); // Bench initial voltage = 0.0 V.
        // device 151, IC IC21, analog/basic/mos_r2r_dac.hpp:28
        I(cpphdl_n603, cpphdl_n623) <+ V(cpphdl_n603, cpphdl_n623) / 2000.0;
        // device 152, IC IC21, analog/basic/mos_r2r_dac.hpp:29
        I(cpphdl_n623, Vss) <+ 2.9999999999999998e-15 * ddt(V(cpphdl_n623, Vss)); // Bench initial voltage = 0.0 V.
        // device 153, IC IC21, analog/basic/mos_r2r_dac.hpp:31
        I(cpphdl_n622, cpphdl_n623) <+ V(cpphdl_n622, cpphdl_n623) / 1000.0;
        // device 154, IC IC26, analog/basic/inverter.hpp:11
        I(cpphdl_n607, Vdd) <+ cpphdl_channel(V(BIT_N0_4, Vdd), V(cpphdl_n607, Vdd), 0.080000000000000002, 0.69999999999999996, -1.0);
        // device 155, IC IC26, analog/basic/inverter.hpp:12
        I(cpphdl_n607, Vss) <+ cpphdl_channel(V(BIT_N0_4, Vss), V(cpphdl_n607, Vss), 0.080000000000000002, 0.69999999999999996, 1.0);
        // device 156, IC IC21, analog/basic/mos_r2r_dac.hpp:27
        I(cpphdl_n607, Vss) <+ 2.9999999999999998e-15 * ddt(V(cpphdl_n607, Vss)); // Bench initial voltage = 0.0 V.
        // device 157, IC IC21, analog/basic/mos_r2r_dac.hpp:28
        I(cpphdl_n607, cpphdl_n624) <+ V(cpphdl_n607, cpphdl_n624) / 2000.0;
        // device 158, IC IC21, analog/basic/mos_r2r_dac.hpp:29
        I(cpphdl_n624, Vss) <+ 2.9999999999999998e-15 * ddt(V(cpphdl_n624, Vss)); // Bench initial voltage = 0.0 V.
        // device 159, IC IC21, analog/basic/mos_r2r_dac.hpp:31
        I(cpphdl_n623, cpphdl_n624) <+ V(cpphdl_n623, cpphdl_n624) / 1000.0;
        // device 160, IC IC27, analog/basic/inverter.hpp:11
        I(cpphdl_n611, Vdd) <+ cpphdl_channel(V(BIT_N0_5, Vdd), V(cpphdl_n611, Vdd), 0.080000000000000002, 0.69999999999999996, -1.0);
        // device 161, IC IC27, analog/basic/inverter.hpp:12
        I(cpphdl_n611, Vss) <+ cpphdl_channel(V(BIT_N0_5, Vss), V(cpphdl_n611, Vss), 0.080000000000000002, 0.69999999999999996, 1.0);
        // device 162, IC IC21, analog/basic/mos_r2r_dac.hpp:27
        I(cpphdl_n611, Vss) <+ 2.9999999999999998e-15 * ddt(V(cpphdl_n611, Vss)); // Bench initial voltage = 0.0 V.
        // device 163, IC IC21, analog/basic/mos_r2r_dac.hpp:28
        I(cpphdl_n611, cpphdl_n625) <+ V(cpphdl_n611, cpphdl_n625) / 2000.0;
        // device 164, IC IC21, analog/basic/mos_r2r_dac.hpp:29
        I(cpphdl_n625, Vss) <+ 2.9999999999999998e-15 * ddt(V(cpphdl_n625, Vss)); // Bench initial voltage = 0.0 V.
        // device 165, IC IC21, analog/basic/mos_r2r_dac.hpp:31
        I(cpphdl_n624, cpphdl_n625) <+ V(cpphdl_n624, cpphdl_n625) / 1000.0;
        // device 166, IC IC28, analog/basic/inverter.hpp:11
        I(cpphdl_n615, Vdd) <+ cpphdl_channel(V(BIT_N0_6, Vdd), V(cpphdl_n615, Vdd), 0.080000000000000002, 0.69999999999999996, -1.0);
        // device 167, IC IC28, analog/basic/inverter.hpp:12
        I(cpphdl_n615, Vss) <+ cpphdl_channel(V(BIT_N0_6, Vss), V(cpphdl_n615, Vss), 0.080000000000000002, 0.69999999999999996, 1.0);
        // device 168, IC IC21, analog/basic/mos_r2r_dac.hpp:27
        I(cpphdl_n615, Vss) <+ 2.9999999999999998e-15 * ddt(V(cpphdl_n615, Vss)); // Bench initial voltage = 0.0 V.
        // device 169, IC IC21, analog/basic/mos_r2r_dac.hpp:28
        I(cpphdl_n615, cpphdl_n626) <+ V(cpphdl_n615, cpphdl_n626) / 2000.0;
        // device 170, IC IC21, analog/basic/mos_r2r_dac.hpp:29
        I(cpphdl_n626, Vss) <+ 2.9999999999999998e-15 * ddt(V(cpphdl_n626, Vss)); // Bench initial voltage = 0.0 V.
        // device 171, IC IC21, analog/basic/mos_r2r_dac.hpp:31
        I(cpphdl_n625, cpphdl_n626) <+ V(cpphdl_n625, cpphdl_n626) / 1000.0;
        // device 172, IC IC29, analog/basic/inverter.hpp:11
        I(cpphdl_n619, Vdd) <+ cpphdl_channel(V(BIT_N0_7, Vdd), V(cpphdl_n619, Vdd), 0.080000000000000002, 0.69999999999999996, -1.0);
        // device 173, IC IC29, analog/basic/inverter.hpp:12
        I(cpphdl_n619, Vss) <+ cpphdl_channel(V(BIT_N0_7, Vss), V(cpphdl_n619, Vss), 0.080000000000000002, 0.69999999999999996, 1.0);
        // device 174, IC IC21, analog/basic/mos_r2r_dac.hpp:27
        I(cpphdl_n619, Vss) <+ 2.9999999999999998e-15 * ddt(V(cpphdl_n619, Vss)); // Bench initial voltage = 0.0 V.
        // device 175, IC IC21, analog/basic/mos_r2r_dac.hpp:28
        I(cpphdl_n619, cpphdl_n631) <+ V(cpphdl_n619, cpphdl_n631) / 2000.0;
        // device 176, IC IC21, analog/basic/mos_r2r_dac.hpp:29
        I(cpphdl_n631, Vss) <+ 2.9999999999999998e-15 * ddt(V(cpphdl_n631, Vss)); // Bench initial voltage = 0.0 V.
        // device 177, IC IC21, analog/basic/mos_r2r_dac.hpp:31
        I(cpphdl_n626, cpphdl_n631) <+ V(cpphdl_n626, cpphdl_n631) / 1000.0;
        // device 178, IC IC21, analog/basic/mos_r2r_dac.hpp:33
        I(Vss, cpphdl_n620) <+ V(Vss, cpphdl_n620) / 2000.0;
        // device 179, IC IC30, analog/basic/nmos_resistor_amplifier.hpp:23
        I(Vdd, cpphdl_n640) <+ V(Vdd, cpphdl_n640) / 1000.0;
        // device 180, IC IC30, analog/basic/nmos_resistor_amplifier.hpp:24
        I(Vdd, cpphdl_n639) <+ V(Vdd, cpphdl_n639) / 1000.0;
        // device 181, IC IC30, analog/basic/nmos_resistor_amplifier.hpp:25
        I(cpphdl_n640, cpphdl_n634) <+ cpphdl_channel(V(cpphdl_n630, cpphdl_n634), V(cpphdl_n640, cpphdl_n634), 0.0074999999999999997, 0.69999999999999996, 1.0);
        // device 182, IC IC30, analog/basic/nmos_resistor_amplifier.hpp:26
        I(cpphdl_n639, cpphdl_n635) <+ cpphdl_channel(V(cpphdl_n631, cpphdl_n635), V(cpphdl_n639, cpphdl_n635), 0.0074999999999999997, 0.69999999999999996, 1.0);
        // device 183, IC IC30, analog/basic/nmos_resistor_amplifier.hpp:27
        I(cpphdl_n636, cpphdl_n634) <+ V(cpphdl_n636, cpphdl_n634) / 100.0;
        // device 184, IC IC30, analog/basic/nmos_resistor_amplifier.hpp:28
        I(cpphdl_n636, cpphdl_n635) <+ V(cpphdl_n636, cpphdl_n635) / 100.0;
        // device 185, IC IC30, analog/basic/nmos_resistor_amplifier.hpp:29
        I(Vss, cpphdl_n636) <+ V(Vss, cpphdl_n636) / 300.0;
        // device 186, IC IC30, analog/basic/nmos_resistor_amplifier.hpp:30
        I(cpphdl_n640, Vdd) <+ 2.9999999999999998e-13 * ddt(V(cpphdl_n640, Vdd)); // Bench initial voltage = 0.0 V.
        // device 187, IC IC30, analog/basic/nmos_resistor_amplifier.hpp:31
        I(cpphdl_n639, Vdd) <+ 2.9999999999999998e-13 * ddt(V(cpphdl_n639, Vdd)); // Bench initial voltage = 0.0 V.
        // device 188, IC IC30, analog/basic/nmos_resistor_amplifier.hpp:32
        I(cpphdl_n636, Vss) <+ 4e-14 * ddt(V(cpphdl_n636, Vss)); // Bench initial voltage = 0.0 V.
        // device 189, IC IC30, analog/basic/nmos_resistor_amplifier.hpp:34
        I(cpphdl_n630, cpphdl_n634) <+ 2e-14 * ddt(V(cpphdl_n630, cpphdl_n634)); // Bench initial voltage = 0.0 V.
        // device 190, IC IC30, analog/basic/nmos_resistor_amplifier.hpp:35
        I(cpphdl_n631, cpphdl_n635) <+ 2e-14 * ddt(V(cpphdl_n631, cpphdl_n635)); // Bench initial voltage = 0.0 V.
        // device 191, IC IC30, analog/basic/nmos_resistor_amplifier.hpp:36
        I(cpphdl_n630, cpphdl_n640) <+ 2.9999999999999998e-15 * ddt(V(cpphdl_n630, cpphdl_n640)); // Bench initial voltage = 0.0 V.
        // device 192, IC IC30, analog/basic/nmos_resistor_amplifier.hpp:37
        I(cpphdl_n631, cpphdl_n639) <+ 2.9999999999999998e-15 * ddt(V(cpphdl_n631, cpphdl_n639)); // Bench initial voltage = 0.0 V.
        // device 193, IC IC31, analog/basic/strongarm_comparator.hpp:28
        I(cpphdl_n644, cpphdl_n646) <+ cpphdl_channel(V(cpphdl_n639, cpphdl_n646), V(cpphdl_n644, cpphdl_n646), 0.0080000000000000002, 0.69999999999999996, 1.0);
        // device 194, IC IC31, analog/basic/strongarm_comparator.hpp:29
        I(cpphdl_n645, cpphdl_n646) <+ cpphdl_channel(V(cpphdl_n640, cpphdl_n646), V(cpphdl_n645, cpphdl_n646), 0.0080000000000000002, 0.69999999999999996, 1.0);
        // device 195, IC IC31, analog/basic/strongarm_comparator.hpp:30
        I(cpphdl_n646, Vss) <+ cpphdl_channel(V(EVALUATE, Vss), V(cpphdl_n646, Vss), 0.0080000000000000002, 0.69999999999999996, 1.0);
        // device 196, IC IC31, analog/basic/strongarm_comparator.hpp:33
        I(cpphdl_n659, cpphdl_n644) <+ cpphdl_channel(V(cpphdl_n663, cpphdl_n644), V(cpphdl_n659, cpphdl_n644), 0.0040000000000000001, 0.69999999999999996, 1.0);
        // device 197, IC IC31, analog/basic/strongarm_comparator.hpp:34
        I(cpphdl_n663, cpphdl_n645) <+ cpphdl_channel(V(cpphdl_n659, cpphdl_n645), V(cpphdl_n663, cpphdl_n645), 0.0040000000000000001, 0.69999999999999996, 1.0);
        // device 198, IC IC31, analog/basic/strongarm_comparator.hpp:35
        I(cpphdl_n663, Vdd) <+ cpphdl_channel(V(cpphdl_n659, Vdd), V(cpphdl_n663, Vdd), 0.002, 0.69999999999999996, -1.0);
        // device 199, IC IC31, analog/basic/strongarm_comparator.hpp:36
        I(cpphdl_n659, Vdd) <+ cpphdl_channel(V(cpphdl_n663, Vdd), V(cpphdl_n659, Vdd), 0.002, 0.69999999999999996, -1.0);
        // device 200, IC IC31, analog/basic/strongarm_comparator.hpp:38
        I(cpphdl_n644, Vdd) <+ cpphdl_channel(V(EVALUATE, Vdd), V(cpphdl_n644, Vdd), 0.002, 0.69999999999999996, -1.0);
        // device 201, IC IC31, analog/basic/strongarm_comparator.hpp:39
        I(cpphdl_n645, Vdd) <+ cpphdl_channel(V(EVALUATE, Vdd), V(cpphdl_n645, Vdd), 0.002, 0.69999999999999996, -1.0);
        // device 202, IC IC31, analog/basic/strongarm_comparator.hpp:40
        I(cpphdl_n663, Vdd) <+ cpphdl_channel(V(EVALUATE, Vdd), V(cpphdl_n663, Vdd), 0.002, 0.69999999999999996, -1.0);
        // device 203, IC IC31, analog/basic/strongarm_comparator.hpp:41
        I(cpphdl_n659, Vdd) <+ cpphdl_channel(V(EVALUATE, Vdd), V(cpphdl_n659, Vdd), 0.002, 0.69999999999999996, -1.0);
        // device 204, IC IC31, analog/basic/strongarm_comparator.hpp:42
        I(cpphdl_n644, Vss) <+ 2.9999999999999998e-14 * ddt(V(cpphdl_n644, Vss)); // Bench initial voltage = 0.0 V.
        // device 205, IC IC31, analog/basic/strongarm_comparator.hpp:43
        I(cpphdl_n645, Vss) <+ 2.9999999999999998e-14 * ddt(V(cpphdl_n645, Vss)); // Bench initial voltage = 0.0 V.
        // device 206, IC IC31, analog/basic/strongarm_comparator.hpp:44
        I(cpphdl_n646, Vss) <+ 2.9999999999999998e-14 * ddt(V(cpphdl_n646, Vss)); // Bench initial voltage = 0.0 V.
        // device 207, IC IC31, analog/basic/strongarm_comparator.hpp:45
        I(cpphdl_n663, Vss) <+ 5.0000000000000002e-14 * ddt(V(cpphdl_n663, Vss)); // Bench initial voltage = 0.0 V.
        // device 208, IC IC31, analog/basic/strongarm_comparator.hpp:46
        I(cpphdl_n659, Vss) <+ 5.0000000000000002e-14 * ddt(V(cpphdl_n659, Vss)); // Bench initial voltage = 0.0 V.
        // device 209, IC IC31, analog/basic/strongarm_comparator.hpp:47
        I(cpphdl_n639, cpphdl_n646) <+ 2e-14 * ddt(V(cpphdl_n639, cpphdl_n646)); // Bench initial voltage = 0.0 V.
        // device 210, IC IC31, analog/basic/strongarm_comparator.hpp:48
        I(cpphdl_n640, cpphdl_n646) <+ 2e-14 * ddt(V(cpphdl_n640, cpphdl_n646)); // Bench initial voltage = 0.0 V.
        // device 211, IC IC31, analog/basic/strongarm_comparator.hpp:49
        I(cpphdl_n639, cpphdl_n644) <+ 2.9999999999999998e-15 * ddt(V(cpphdl_n639, cpphdl_n644)); // Bench initial voltage = 0.0 V.
        // device 212, IC IC31, analog/basic/strongarm_comparator.hpp:50
        I(cpphdl_n640, cpphdl_n645) <+ 2.9999999999999998e-15 * ddt(V(cpphdl_n640, cpphdl_n645)); // Bench initial voltage = 0.0 V.
        // device 213, IC IC33, analog/basic/inverter.hpp:11
        I(cpphdl_n667, Vdd) <+ cpphdl_channel(V(cpphdl_n659, Vdd), V(cpphdl_n667, Vdd), 0.001, 0.69999999999999996, -1.0);
        // device 214, IC IC33, analog/basic/inverter.hpp:12
        I(cpphdl_n667, Vss) <+ cpphdl_channel(V(cpphdl_n659, Vss), V(cpphdl_n667, Vss), 0.001, 0.69999999999999996, 1.0);
        // device 215, IC IC35, analog/basic/inverter.hpp:11
        I(cpphdl_n681, Vdd) <+ cpphdl_channel(V(cpphdl_n667, Vdd), V(cpphdl_n681, Vdd), 0.0040000000000000001, 0.69999999999999996, -1.0);
        // device 216, IC IC35, analog/basic/inverter.hpp:12
        I(cpphdl_n681, Vss) <+ cpphdl_channel(V(cpphdl_n667, Vss), V(cpphdl_n681, Vss), 0.0040000000000000001, 0.69999999999999996, 1.0);
        // device 217, IC IC32, analog/basic/buffered_nand_latch.hpp:34
        I(cpphdl_n659, Vss) <+ 2.0000000000000002e-15 * ddt(V(cpphdl_n659, Vss)); // Bench initial voltage = 0.0 V.
        // device 218, IC IC32, analog/basic/buffered_nand_latch.hpp:35
        I(cpphdl_n659, cpphdl_n667) <+ 1.0000000000000001e-15 * ddt(V(cpphdl_n659, cpphdl_n667)); // Bench initial voltage = 0.0 V.
        // device 219, IC IC32, analog/basic/buffered_nand_latch.hpp:36
        I(cpphdl_n667, Vss) <+ 5e-15 * ddt(V(cpphdl_n667, Vss)); // Bench initial voltage = 0.0 V.
        // device 220, IC IC32, analog/basic/buffered_nand_latch.hpp:37
        I(cpphdl_n667, Vss) <+ 8.0000000000000006e-15 * ddt(V(cpphdl_n667, Vss)); // Bench initial voltage = 0.0 V.
        // device 221, IC IC32, analog/basic/buffered_nand_latch.hpp:38
        I(cpphdl_n681, Vss) <+ 1e-14 * ddt(V(cpphdl_n681, Vss)); // Bench initial voltage = 0.0 V.
        // device 222, IC IC34, analog/basic/inverter.hpp:11
        I(cpphdl_n671, Vdd) <+ cpphdl_channel(V(cpphdl_n663, Vdd), V(cpphdl_n671, Vdd), 0.001, 0.69999999999999996, -1.0);
        // device 223, IC IC34, analog/basic/inverter.hpp:12
        I(cpphdl_n671, Vss) <+ cpphdl_channel(V(cpphdl_n663, Vss), V(cpphdl_n671, Vss), 0.001, 0.69999999999999996, 1.0);
        // device 224, IC IC36, analog/basic/inverter.hpp:11
        I(cpphdl_n687, Vdd) <+ cpphdl_channel(V(cpphdl_n671, Vdd), V(cpphdl_n687, Vdd), 0.0040000000000000001, 0.69999999999999996, -1.0);
        // device 225, IC IC36, analog/basic/inverter.hpp:12
        I(cpphdl_n687, Vss) <+ cpphdl_channel(V(cpphdl_n671, Vss), V(cpphdl_n687, Vss), 0.0040000000000000001, 0.69999999999999996, 1.0);
        // device 226, IC IC32, analog/basic/buffered_nand_latch.hpp:34
        I(cpphdl_n663, Vss) <+ 2.0000000000000002e-15 * ddt(V(cpphdl_n663, Vss)); // Bench initial voltage = 0.0 V.
        // device 227, IC IC32, analog/basic/buffered_nand_latch.hpp:35
        I(cpphdl_n663, cpphdl_n671) <+ 1.0000000000000001e-15 * ddt(V(cpphdl_n663, cpphdl_n671)); // Bench initial voltage = 0.0 V.
        // device 228, IC IC32, analog/basic/buffered_nand_latch.hpp:36
        I(cpphdl_n671, Vss) <+ 5e-15 * ddt(V(cpphdl_n671, Vss)); // Bench initial voltage = 0.0 V.
        // device 229, IC IC32, analog/basic/buffered_nand_latch.hpp:37
        I(cpphdl_n671, Vss) <+ 8.0000000000000006e-15 * ddt(V(cpphdl_n671, Vss)); // Bench initial voltage = 0.0 V.
        // device 230, IC IC32, analog/basic/buffered_nand_latch.hpp:38
        I(cpphdl_n687, Vss) <+ 1e-14 * ddt(V(cpphdl_n687, Vss)); // Bench initial voltage = 0.0 V.
        // device 231, IC IC38, analog/basic/cmos_logic.hpp:17
        I(cpphdl_n2428, Vss) <+ 5.0000000000000002e-14 * ddt(V(cpphdl_n2428, Vss)); // Bench initial voltage = 0.0 V.
        // device 232, IC IC38, analog/basic/cmos_logic.hpp:18
        I(cpphdl_n2428, Vdd) <+ cpphdl_channel(V(cpphdl_n681, Vdd), V(cpphdl_n2428, Vdd), 0.01, 0.69999999999999996, -1.0);
        // device 233, IC IC38, analog/basic/cmos_logic.hpp:19
        I(cpphdl_n2428, Vdd) <+ cpphdl_channel(V(cpphdl_n689, Vdd), V(cpphdl_n2428, Vdd), 0.01, 0.69999999999999996, -1.0);
        // device 234, IC IC38, analog/basic/cmos_logic.hpp:20
        I(cpphdl_n2428, cpphdl_n684) <+ cpphdl_channel(V(cpphdl_n681, cpphdl_n684), V(cpphdl_n2428, cpphdl_n684), 0.01, 0.69999999999999996, 1.0);
        // device 235, IC IC38, analog/basic/cmos_logic.hpp:21
        I(cpphdl_n684, Vss) <+ cpphdl_channel(V(cpphdl_n689, Vss), V(cpphdl_n684, Vss), 0.01, 0.69999999999999996, 1.0);
        // device 236, IC IC38, analog/basic/cmos_logic.hpp:27
        I(cpphdl_n684, Vss) <+ 1e-14 * ddt(V(cpphdl_n684, Vss)); // Bench initial voltage = 0.0 V.
        // device 237, IC IC39, analog/basic/cmos_logic.hpp:17
        I(cpphdl_n689, Vss) <+ 5.0000000000000002e-14 * ddt(V(cpphdl_n689, Vss)); // Bench initial voltage = 0.0 V.
        // device 238, IC IC39, analog/basic/cmos_logic.hpp:18
        I(cpphdl_n689, Vdd) <+ cpphdl_channel(V(cpphdl_n687, Vdd), V(cpphdl_n689, Vdd), 0.01, 0.69999999999999996, -1.0);
        // device 239, IC IC39, analog/basic/cmos_logic.hpp:19
        I(cpphdl_n689, Vdd) <+ cpphdl_channel(V(cpphdl_n2428, Vdd), V(cpphdl_n689, Vdd), 0.01, 0.69999999999999996, -1.0);
        // device 240, IC IC39, analog/basic/cmos_logic.hpp:20
        I(cpphdl_n689, cpphdl_n690) <+ cpphdl_channel(V(cpphdl_n687, cpphdl_n690), V(cpphdl_n689, cpphdl_n690), 0.01, 0.69999999999999996, 1.0);
        // device 241, IC IC39, analog/basic/cmos_logic.hpp:21
        I(cpphdl_n690, Vss) <+ cpphdl_channel(V(cpphdl_n2428, Vss), V(cpphdl_n690, Vss), 0.01, 0.69999999999999996, 1.0);
        // device 242, IC IC39, analog/basic/cmos_logic.hpp:27
        I(cpphdl_n690, Vss) <+ 1e-14 * ddt(V(cpphdl_n690, Vss)); // Bench initial voltage = 0.0 V.
        // device 243, IC IC37, analog/basic/nand_latch.hpp:36
        I(cpphdl_n681, Vss) <+ 2.9999999999999998e-15 * ddt(V(cpphdl_n681, Vss)); // Bench initial voltage = 0.0 V.
        // device 244, IC IC37, analog/basic/nand_latch.hpp:37
        I(cpphdl_n687, Vss) <+ 2.9999999999999998e-15 * ddt(V(cpphdl_n687, Vss)); // Bench initial voltage = 0.0 V.
        // device 245, IC IC40, analog/basic/inverter.hpp:11
        I(cpphdl_n695, Vdd) <+ cpphdl_channel(V(CLEAR, Vdd), V(cpphdl_n695, Vdd), 0.01, 0.69999999999999996, -1.0);
        // device 246, IC IC40, analog/basic/inverter.hpp:12
        I(cpphdl_n695, Vss) <+ cpphdl_channel(V(CLEAR, Vss), V(cpphdl_n695, Vss), 0.01, 0.69999999999999996, 1.0);
        // device 247, IC IC37, analog/basic/nand_latch.hpp:58
        I(cpphdl_n695, Vss) <+ 2.9999999999999998e-15 * ddt(V(cpphdl_n695, Vss)); // Bench initial voltage = 0.0 V.
        // device 248, IC IC37, analog/basic/nand_latch.hpp:59
        I(cpphdl_n2428, Vss) <+ cpphdl_channel(V(CLEAR, Vss), V(cpphdl_n2428, Vss), 0.050000000000000003, 0.69999999999999996, 1.0);
        // device 249, IC IC37, analog/basic/nand_latch.hpp:60
        I(cpphdl_n689, Vdd) <+ cpphdl_channel(V(cpphdl_n695, Vdd), V(cpphdl_n689, Vdd), 0.050000000000000003, 0.69999999999999996, -1.0);
        // device 250, IC IC43, analog/basic/inverter.hpp:11
        I(cpphdl_n719, Vdd) <+ cpphdl_channel(V(TRACK1, Vdd), V(cpphdl_n719, Vdd), 0.0040000000000000001, 0.69999999999999996, -1.0);
        // device 251, IC IC43, analog/basic/inverter.hpp:12
        I(cpphdl_n719, Vss) <+ cpphdl_channel(V(TRACK1, Vss), V(cpphdl_n719, Vss), 0.0040000000000000001, 0.69999999999999996, 1.0);
        // device 252, IC IC42, analog/basic/mos_track_hold.hpp:31
        I(cpphdl_n719, Vss) <+ 2e-14 * ddt(V(cpphdl_n719, Vss)); // Bench initial voltage = 0.0 V.
        // device 253, IC IC42, analog/basic/mos_track_hold.hpp:32
        I(cpphdl_n2286, cpphdl_n773) <+ cpphdl_channel(V(TRACK1, cpphdl_n773), V(cpphdl_n2286, cpphdl_n773), 0.029999999999999999, 0.69999999999999996, 1.0);
        // device 254, IC IC42, analog/basic/mos_track_hold.hpp:33
        I(cpphdl_n773, cpphdl_n2286) <+ cpphdl_channel(V(cpphdl_n719, cpphdl_n2286), V(cpphdl_n773, cpphdl_n2286), 0.014999999999999999, 0.69999999999999996, -1.0);
        // device 255, IC IC42, analog/basic/mos_track_hold.hpp:37
        I(cpphdl_n773, cpphdl_n773) <+ cpphdl_channel(V(cpphdl_n719, cpphdl_n773), V(cpphdl_n773, cpphdl_n773), 0.016, 0.69999999999999996, 1.0);
        // device 256, IC IC42, analog/basic/mos_track_hold.hpp:38
        I(cpphdl_n773, cpphdl_n773) <+ cpphdl_channel(V(TRACK1, cpphdl_n773), V(cpphdl_n773, cpphdl_n773), 0.0083999999999999995, 0.69999999999999996, -1.0);
        // device 257, IC IC42, analog/basic/mos_track_hold.hpp:39
        I(cpphdl_n773, Vss) <+ 1.5000000000000001e-12 * ddt(V(cpphdl_n773, Vss)); // Bench initial voltage = 0.0 V.
        // device 258, IC IC42, analog/basic/mos_track_hold.hpp:42
        I(TRACK1, cpphdl_n773) <+ 2.0000000000000002e-15 * ddt(V(TRACK1, cpphdl_n773)); // Bench initial voltage = -0.0 V.
        // device 259, IC IC42, analog/basic/mos_track_hold.hpp:43
        I(cpphdl_n719, cpphdl_n773) <+ 2.0000000000000002e-15 * ddt(V(cpphdl_n719, cpphdl_n773)); // Bench initial voltage = 0.0 V.
        // device 260, IC IC42, analog/basic/mos_track_hold.hpp:44
        I(cpphdl_n2286, cpphdl_n773) <+ 1.0000000000000001e-15 * ddt(V(cpphdl_n2286, cpphdl_n773)); // Bench initial voltage = 0.0 V.
        // device 261, IC IC45, analog/basic/inverter.hpp:11
        I(cpphdl_n734, Vdd) <+ cpphdl_channel(V(BIT_N1_0, Vdd), V(cpphdl_n734, Vdd), 0.080000000000000002, 0.69999999999999996, -1.0);
        // device 262, IC IC45, analog/basic/inverter.hpp:12
        I(cpphdl_n734, Vss) <+ cpphdl_channel(V(BIT_N1_0, Vss), V(cpphdl_n734, Vss), 0.080000000000000002, 0.69999999999999996, 1.0);
        // device 263, IC IC44, analog/basic/mos_r2r_dac.hpp:27
        I(cpphdl_n734, Vss) <+ 2.9999999999999998e-15 * ddt(V(cpphdl_n734, Vss)); // Bench initial voltage = 0.0 V.
        // device 264, IC IC44, analog/basic/mos_r2r_dac.hpp:28
        I(cpphdl_n734, cpphdl_n763) <+ V(cpphdl_n734, cpphdl_n763) / 2000.0;
        // device 265, IC IC44, analog/basic/mos_r2r_dac.hpp:29
        I(cpphdl_n763, Vss) <+ 2.9999999999999998e-15 * ddt(V(cpphdl_n763, Vss)); // Bench initial voltage = 0.0 V.
        // device 266, IC IC46, analog/basic/inverter.hpp:11
        I(cpphdl_n738, Vdd) <+ cpphdl_channel(V(BIT_N1_1, Vdd), V(cpphdl_n738, Vdd), 0.080000000000000002, 0.69999999999999996, -1.0);
        // device 267, IC IC46, analog/basic/inverter.hpp:12
        I(cpphdl_n738, Vss) <+ cpphdl_channel(V(BIT_N1_1, Vss), V(cpphdl_n738, Vss), 0.080000000000000002, 0.69999999999999996, 1.0);
        // device 268, IC IC44, analog/basic/mos_r2r_dac.hpp:27
        I(cpphdl_n738, Vss) <+ 2.9999999999999998e-15 * ddt(V(cpphdl_n738, Vss)); // Bench initial voltage = 0.0 V.
        // device 269, IC IC44, analog/basic/mos_r2r_dac.hpp:28
        I(cpphdl_n738, cpphdl_n764) <+ V(cpphdl_n738, cpphdl_n764) / 2000.0;
        // device 270, IC IC44, analog/basic/mos_r2r_dac.hpp:29
        I(cpphdl_n764, Vss) <+ 2.9999999999999998e-15 * ddt(V(cpphdl_n764, Vss)); // Bench initial voltage = 0.0 V.
        // device 271, IC IC44, analog/basic/mos_r2r_dac.hpp:31
        I(cpphdl_n763, cpphdl_n764) <+ V(cpphdl_n763, cpphdl_n764) / 1000.0;
        // device 272, IC IC47, analog/basic/inverter.hpp:11
        I(cpphdl_n742, Vdd) <+ cpphdl_channel(V(BIT_N1_2, Vdd), V(cpphdl_n742, Vdd), 0.080000000000000002, 0.69999999999999996, -1.0);
        // device 273, IC IC47, analog/basic/inverter.hpp:12
        I(cpphdl_n742, Vss) <+ cpphdl_channel(V(BIT_N1_2, Vss), V(cpphdl_n742, Vss), 0.080000000000000002, 0.69999999999999996, 1.0);
        // device 274, IC IC44, analog/basic/mos_r2r_dac.hpp:27
        I(cpphdl_n742, Vss) <+ 2.9999999999999998e-15 * ddt(V(cpphdl_n742, Vss)); // Bench initial voltage = 0.0 V.
        // device 275, IC IC44, analog/basic/mos_r2r_dac.hpp:28
        I(cpphdl_n742, cpphdl_n765) <+ V(cpphdl_n742, cpphdl_n765) / 2000.0;
        // device 276, IC IC44, analog/basic/mos_r2r_dac.hpp:29
        I(cpphdl_n765, Vss) <+ 2.9999999999999998e-15 * ddt(V(cpphdl_n765, Vss)); // Bench initial voltage = 0.0 V.
        // device 277, IC IC44, analog/basic/mos_r2r_dac.hpp:31
        I(cpphdl_n764, cpphdl_n765) <+ V(cpphdl_n764, cpphdl_n765) / 1000.0;
        // device 278, IC IC48, analog/basic/inverter.hpp:11
        I(cpphdl_n746, Vdd) <+ cpphdl_channel(V(BIT_N1_3, Vdd), V(cpphdl_n746, Vdd), 0.080000000000000002, 0.69999999999999996, -1.0);
        // device 279, IC IC48, analog/basic/inverter.hpp:12
        I(cpphdl_n746, Vss) <+ cpphdl_channel(V(BIT_N1_3, Vss), V(cpphdl_n746, Vss), 0.080000000000000002, 0.69999999999999996, 1.0);
        // device 280, IC IC44, analog/basic/mos_r2r_dac.hpp:27
        I(cpphdl_n746, Vss) <+ 2.9999999999999998e-15 * ddt(V(cpphdl_n746, Vss)); // Bench initial voltage = 0.0 V.
        // device 281, IC IC44, analog/basic/mos_r2r_dac.hpp:28
        I(cpphdl_n746, cpphdl_n766) <+ V(cpphdl_n746, cpphdl_n766) / 2000.0;
        // device 282, IC IC44, analog/basic/mos_r2r_dac.hpp:29
        I(cpphdl_n766, Vss) <+ 2.9999999999999998e-15 * ddt(V(cpphdl_n766, Vss)); // Bench initial voltage = 0.0 V.
        // device 283, IC IC44, analog/basic/mos_r2r_dac.hpp:31
        I(cpphdl_n765, cpphdl_n766) <+ V(cpphdl_n765, cpphdl_n766) / 1000.0;
        // device 284, IC IC49, analog/basic/inverter.hpp:11
        I(cpphdl_n750, Vdd) <+ cpphdl_channel(V(BIT_N1_4, Vdd), V(cpphdl_n750, Vdd), 0.080000000000000002, 0.69999999999999996, -1.0);
        // device 285, IC IC49, analog/basic/inverter.hpp:12
        I(cpphdl_n750, Vss) <+ cpphdl_channel(V(BIT_N1_4, Vss), V(cpphdl_n750, Vss), 0.080000000000000002, 0.69999999999999996, 1.0);
        // device 286, IC IC44, analog/basic/mos_r2r_dac.hpp:27
        I(cpphdl_n750, Vss) <+ 2.9999999999999998e-15 * ddt(V(cpphdl_n750, Vss)); // Bench initial voltage = 0.0 V.
        // device 287, IC IC44, analog/basic/mos_r2r_dac.hpp:28
        I(cpphdl_n750, cpphdl_n767) <+ V(cpphdl_n750, cpphdl_n767) / 2000.0;
        // device 288, IC IC44, analog/basic/mos_r2r_dac.hpp:29
        I(cpphdl_n767, Vss) <+ 2.9999999999999998e-15 * ddt(V(cpphdl_n767, Vss)); // Bench initial voltage = 0.0 V.
        // device 289, IC IC44, analog/basic/mos_r2r_dac.hpp:31
        I(cpphdl_n766, cpphdl_n767) <+ V(cpphdl_n766, cpphdl_n767) / 1000.0;
        // device 290, IC IC50, analog/basic/inverter.hpp:11
        I(cpphdl_n754, Vdd) <+ cpphdl_channel(V(BIT_N1_5, Vdd), V(cpphdl_n754, Vdd), 0.080000000000000002, 0.69999999999999996, -1.0);
        // device 291, IC IC50, analog/basic/inverter.hpp:12
        I(cpphdl_n754, Vss) <+ cpphdl_channel(V(BIT_N1_5, Vss), V(cpphdl_n754, Vss), 0.080000000000000002, 0.69999999999999996, 1.0);
        // device 292, IC IC44, analog/basic/mos_r2r_dac.hpp:27
        I(cpphdl_n754, Vss) <+ 2.9999999999999998e-15 * ddt(V(cpphdl_n754, Vss)); // Bench initial voltage = 0.0 V.
        // device 293, IC IC44, analog/basic/mos_r2r_dac.hpp:28
        I(cpphdl_n754, cpphdl_n768) <+ V(cpphdl_n754, cpphdl_n768) / 2000.0;
        // device 294, IC IC44, analog/basic/mos_r2r_dac.hpp:29
        I(cpphdl_n768, Vss) <+ 2.9999999999999998e-15 * ddt(V(cpphdl_n768, Vss)); // Bench initial voltage = 0.0 V.
        // device 295, IC IC44, analog/basic/mos_r2r_dac.hpp:31
        I(cpphdl_n767, cpphdl_n768) <+ V(cpphdl_n767, cpphdl_n768) / 1000.0;
        // device 296, IC IC51, analog/basic/inverter.hpp:11
        I(cpphdl_n758, Vdd) <+ cpphdl_channel(V(BIT_N1_6, Vdd), V(cpphdl_n758, Vdd), 0.080000000000000002, 0.69999999999999996, -1.0);
        // device 297, IC IC51, analog/basic/inverter.hpp:12
        I(cpphdl_n758, Vss) <+ cpphdl_channel(V(BIT_N1_6, Vss), V(cpphdl_n758, Vss), 0.080000000000000002, 0.69999999999999996, 1.0);
        // device 298, IC IC44, analog/basic/mos_r2r_dac.hpp:27
        I(cpphdl_n758, Vss) <+ 2.9999999999999998e-15 * ddt(V(cpphdl_n758, Vss)); // Bench initial voltage = 0.0 V.
        // device 299, IC IC44, analog/basic/mos_r2r_dac.hpp:28
        I(cpphdl_n758, cpphdl_n769) <+ V(cpphdl_n758, cpphdl_n769) / 2000.0;
        // device 300, IC IC44, analog/basic/mos_r2r_dac.hpp:29
        I(cpphdl_n769, Vss) <+ 2.9999999999999998e-15 * ddt(V(cpphdl_n769, Vss)); // Bench initial voltage = 0.0 V.
        // device 301, IC IC44, analog/basic/mos_r2r_dac.hpp:31
        I(cpphdl_n768, cpphdl_n769) <+ V(cpphdl_n768, cpphdl_n769) / 1000.0;
        // device 302, IC IC52, analog/basic/inverter.hpp:11
        I(cpphdl_n762, Vdd) <+ cpphdl_channel(V(BIT_N1_7, Vdd), V(cpphdl_n762, Vdd), 0.080000000000000002, 0.69999999999999996, -1.0);
        // device 303, IC IC52, analog/basic/inverter.hpp:12
        I(cpphdl_n762, Vss) <+ cpphdl_channel(V(BIT_N1_7, Vss), V(cpphdl_n762, Vss), 0.080000000000000002, 0.69999999999999996, 1.0);
        // device 304, IC IC44, analog/basic/mos_r2r_dac.hpp:27
        I(cpphdl_n762, Vss) <+ 2.9999999999999998e-15 * ddt(V(cpphdl_n762, Vss)); // Bench initial voltage = 0.0 V.
        // device 305, IC IC44, analog/basic/mos_r2r_dac.hpp:28
        I(cpphdl_n762, cpphdl_n774) <+ V(cpphdl_n762, cpphdl_n774) / 2000.0;
        // device 306, IC IC44, analog/basic/mos_r2r_dac.hpp:29
        I(cpphdl_n774, Vss) <+ 2.9999999999999998e-15 * ddt(V(cpphdl_n774, Vss)); // Bench initial voltage = 0.0 V.
        // device 307, IC IC44, analog/basic/mos_r2r_dac.hpp:31
        I(cpphdl_n769, cpphdl_n774) <+ V(cpphdl_n769, cpphdl_n774) / 1000.0;
        // device 308, IC IC44, analog/basic/mos_r2r_dac.hpp:33
        I(Vss, cpphdl_n763) <+ V(Vss, cpphdl_n763) / 2000.0;
        // device 309, IC IC53, analog/basic/nmos_resistor_amplifier.hpp:23
        I(Vdd, cpphdl_n783) <+ V(Vdd, cpphdl_n783) / 1000.0;
        // device 310, IC IC53, analog/basic/nmos_resistor_amplifier.hpp:24
        I(Vdd, cpphdl_n782) <+ V(Vdd, cpphdl_n782) / 1000.0;
        // device 311, IC IC53, analog/basic/nmos_resistor_amplifier.hpp:25
        I(cpphdl_n783, cpphdl_n777) <+ cpphdl_channel(V(cpphdl_n773, cpphdl_n777), V(cpphdl_n783, cpphdl_n777), 0.0074999999999999997, 0.69999999999999996, 1.0);
        // device 312, IC IC53, analog/basic/nmos_resistor_amplifier.hpp:26
        I(cpphdl_n782, cpphdl_n778) <+ cpphdl_channel(V(cpphdl_n774, cpphdl_n778), V(cpphdl_n782, cpphdl_n778), 0.0074999999999999997, 0.69999999999999996, 1.0);
        // device 313, IC IC53, analog/basic/nmos_resistor_amplifier.hpp:27
        I(cpphdl_n779, cpphdl_n777) <+ V(cpphdl_n779, cpphdl_n777) / 100.0;
        // device 314, IC IC53, analog/basic/nmos_resistor_amplifier.hpp:28
        I(cpphdl_n779, cpphdl_n778) <+ V(cpphdl_n779, cpphdl_n778) / 100.0;
        // device 315, IC IC53, analog/basic/nmos_resistor_amplifier.hpp:29
        I(Vss, cpphdl_n779) <+ V(Vss, cpphdl_n779) / 300.0;
        // device 316, IC IC53, analog/basic/nmos_resistor_amplifier.hpp:30
        I(cpphdl_n783, Vdd) <+ 2.9999999999999998e-13 * ddt(V(cpphdl_n783, Vdd)); // Bench initial voltage = 0.0 V.
        // device 317, IC IC53, analog/basic/nmos_resistor_amplifier.hpp:31
        I(cpphdl_n782, Vdd) <+ 2.9999999999999998e-13 * ddt(V(cpphdl_n782, Vdd)); // Bench initial voltage = 0.0 V.
        // device 318, IC IC53, analog/basic/nmos_resistor_amplifier.hpp:32
        I(cpphdl_n779, Vss) <+ 4e-14 * ddt(V(cpphdl_n779, Vss)); // Bench initial voltage = 0.0 V.
        // device 319, IC IC53, analog/basic/nmos_resistor_amplifier.hpp:34
        I(cpphdl_n773, cpphdl_n777) <+ 2e-14 * ddt(V(cpphdl_n773, cpphdl_n777)); // Bench initial voltage = 0.0 V.
        // device 320, IC IC53, analog/basic/nmos_resistor_amplifier.hpp:35
        I(cpphdl_n774, cpphdl_n778) <+ 2e-14 * ddt(V(cpphdl_n774, cpphdl_n778)); // Bench initial voltage = 0.0 V.
        // device 321, IC IC53, analog/basic/nmos_resistor_amplifier.hpp:36
        I(cpphdl_n773, cpphdl_n783) <+ 2.9999999999999998e-15 * ddt(V(cpphdl_n773, cpphdl_n783)); // Bench initial voltage = 0.0 V.
        // device 322, IC IC53, analog/basic/nmos_resistor_amplifier.hpp:37
        I(cpphdl_n774, cpphdl_n782) <+ 2.9999999999999998e-15 * ddt(V(cpphdl_n774, cpphdl_n782)); // Bench initial voltage = 0.0 V.
        // device 323, IC IC54, analog/basic/strongarm_comparator.hpp:28
        I(cpphdl_n787, cpphdl_n789) <+ cpphdl_channel(V(cpphdl_n782, cpphdl_n789), V(cpphdl_n787, cpphdl_n789), 0.0080000000000000002, 0.69999999999999996, 1.0);
        // device 324, IC IC54, analog/basic/strongarm_comparator.hpp:29
        I(cpphdl_n788, cpphdl_n789) <+ cpphdl_channel(V(cpphdl_n783, cpphdl_n789), V(cpphdl_n788, cpphdl_n789), 0.0080000000000000002, 0.69999999999999996, 1.0);
        // device 325, IC IC54, analog/basic/strongarm_comparator.hpp:30
        I(cpphdl_n789, Vss) <+ cpphdl_channel(V(EVALUATE, Vss), V(cpphdl_n789, Vss), 0.0080000000000000002, 0.69999999999999996, 1.0);
        // device 326, IC IC54, analog/basic/strongarm_comparator.hpp:33
        I(cpphdl_n802, cpphdl_n787) <+ cpphdl_channel(V(cpphdl_n806, cpphdl_n787), V(cpphdl_n802, cpphdl_n787), 0.0040000000000000001, 0.69999999999999996, 1.0);
        // device 327, IC IC54, analog/basic/strongarm_comparator.hpp:34
        I(cpphdl_n806, cpphdl_n788) <+ cpphdl_channel(V(cpphdl_n802, cpphdl_n788), V(cpphdl_n806, cpphdl_n788), 0.0040000000000000001, 0.69999999999999996, 1.0);
        // device 328, IC IC54, analog/basic/strongarm_comparator.hpp:35
        I(cpphdl_n806, Vdd) <+ cpphdl_channel(V(cpphdl_n802, Vdd), V(cpphdl_n806, Vdd), 0.002, 0.69999999999999996, -1.0);
        // device 329, IC IC54, analog/basic/strongarm_comparator.hpp:36
        I(cpphdl_n802, Vdd) <+ cpphdl_channel(V(cpphdl_n806, Vdd), V(cpphdl_n802, Vdd), 0.002, 0.69999999999999996, -1.0);
        // device 330, IC IC54, analog/basic/strongarm_comparator.hpp:38
        I(cpphdl_n787, Vdd) <+ cpphdl_channel(V(EVALUATE, Vdd), V(cpphdl_n787, Vdd), 0.002, 0.69999999999999996, -1.0);
        // device 331, IC IC54, analog/basic/strongarm_comparator.hpp:39
        I(cpphdl_n788, Vdd) <+ cpphdl_channel(V(EVALUATE, Vdd), V(cpphdl_n788, Vdd), 0.002, 0.69999999999999996, -1.0);
        // device 332, IC IC54, analog/basic/strongarm_comparator.hpp:40
        I(cpphdl_n806, Vdd) <+ cpphdl_channel(V(EVALUATE, Vdd), V(cpphdl_n806, Vdd), 0.002, 0.69999999999999996, -1.0);
        // device 333, IC IC54, analog/basic/strongarm_comparator.hpp:41
        I(cpphdl_n802, Vdd) <+ cpphdl_channel(V(EVALUATE, Vdd), V(cpphdl_n802, Vdd), 0.002, 0.69999999999999996, -1.0);
        // device 334, IC IC54, analog/basic/strongarm_comparator.hpp:42
        I(cpphdl_n787, Vss) <+ 2.9999999999999998e-14 * ddt(V(cpphdl_n787, Vss)); // Bench initial voltage = 0.0 V.
        // device 335, IC IC54, analog/basic/strongarm_comparator.hpp:43
        I(cpphdl_n788, Vss) <+ 2.9999999999999998e-14 * ddt(V(cpphdl_n788, Vss)); // Bench initial voltage = 0.0 V.
        // device 336, IC IC54, analog/basic/strongarm_comparator.hpp:44
        I(cpphdl_n789, Vss) <+ 2.9999999999999998e-14 * ddt(V(cpphdl_n789, Vss)); // Bench initial voltage = 0.0 V.
        // device 337, IC IC54, analog/basic/strongarm_comparator.hpp:45
        I(cpphdl_n806, Vss) <+ 5.0000000000000002e-14 * ddt(V(cpphdl_n806, Vss)); // Bench initial voltage = 0.0 V.
        // device 338, IC IC54, analog/basic/strongarm_comparator.hpp:46
        I(cpphdl_n802, Vss) <+ 5.0000000000000002e-14 * ddt(V(cpphdl_n802, Vss)); // Bench initial voltage = 0.0 V.
        // device 339, IC IC54, analog/basic/strongarm_comparator.hpp:47
        I(cpphdl_n782, cpphdl_n789) <+ 2e-14 * ddt(V(cpphdl_n782, cpphdl_n789)); // Bench initial voltage = 0.0 V.
        // device 340, IC IC54, analog/basic/strongarm_comparator.hpp:48
        I(cpphdl_n783, cpphdl_n789) <+ 2e-14 * ddt(V(cpphdl_n783, cpphdl_n789)); // Bench initial voltage = 0.0 V.
        // device 341, IC IC54, analog/basic/strongarm_comparator.hpp:49
        I(cpphdl_n782, cpphdl_n787) <+ 2.9999999999999998e-15 * ddt(V(cpphdl_n782, cpphdl_n787)); // Bench initial voltage = 0.0 V.
        // device 342, IC IC54, analog/basic/strongarm_comparator.hpp:50
        I(cpphdl_n783, cpphdl_n788) <+ 2.9999999999999998e-15 * ddt(V(cpphdl_n783, cpphdl_n788)); // Bench initial voltage = 0.0 V.
        // device 343, IC IC56, analog/basic/inverter.hpp:11
        I(cpphdl_n810, Vdd) <+ cpphdl_channel(V(cpphdl_n802, Vdd), V(cpphdl_n810, Vdd), 0.001, 0.69999999999999996, -1.0);
        // device 344, IC IC56, analog/basic/inverter.hpp:12
        I(cpphdl_n810, Vss) <+ cpphdl_channel(V(cpphdl_n802, Vss), V(cpphdl_n810, Vss), 0.001, 0.69999999999999996, 1.0);
        // device 345, IC IC58, analog/basic/inverter.hpp:11
        I(cpphdl_n824, Vdd) <+ cpphdl_channel(V(cpphdl_n810, Vdd), V(cpphdl_n824, Vdd), 0.0040000000000000001, 0.69999999999999996, -1.0);
        // device 346, IC IC58, analog/basic/inverter.hpp:12
        I(cpphdl_n824, Vss) <+ cpphdl_channel(V(cpphdl_n810, Vss), V(cpphdl_n824, Vss), 0.0040000000000000001, 0.69999999999999996, 1.0);
        // device 347, IC IC55, analog/basic/buffered_nand_latch.hpp:34
        I(cpphdl_n802, Vss) <+ 2.0000000000000002e-15 * ddt(V(cpphdl_n802, Vss)); // Bench initial voltage = 0.0 V.
        // device 348, IC IC55, analog/basic/buffered_nand_latch.hpp:35
        I(cpphdl_n802, cpphdl_n810) <+ 1.0000000000000001e-15 * ddt(V(cpphdl_n802, cpphdl_n810)); // Bench initial voltage = 0.0 V.
        // device 349, IC IC55, analog/basic/buffered_nand_latch.hpp:36
        I(cpphdl_n810, Vss) <+ 5e-15 * ddt(V(cpphdl_n810, Vss)); // Bench initial voltage = 0.0 V.
        // device 350, IC IC55, analog/basic/buffered_nand_latch.hpp:37
        I(cpphdl_n810, Vss) <+ 8.0000000000000006e-15 * ddt(V(cpphdl_n810, Vss)); // Bench initial voltage = 0.0 V.
        // device 351, IC IC55, analog/basic/buffered_nand_latch.hpp:38
        I(cpphdl_n824, Vss) <+ 1e-14 * ddt(V(cpphdl_n824, Vss)); // Bench initial voltage = 0.0 V.
        // device 352, IC IC57, analog/basic/inverter.hpp:11
        I(cpphdl_n814, Vdd) <+ cpphdl_channel(V(cpphdl_n806, Vdd), V(cpphdl_n814, Vdd), 0.001, 0.69999999999999996, -1.0);
        // device 353, IC IC57, analog/basic/inverter.hpp:12
        I(cpphdl_n814, Vss) <+ cpphdl_channel(V(cpphdl_n806, Vss), V(cpphdl_n814, Vss), 0.001, 0.69999999999999996, 1.0);
        // device 354, IC IC59, analog/basic/inverter.hpp:11
        I(cpphdl_n830, Vdd) <+ cpphdl_channel(V(cpphdl_n814, Vdd), V(cpphdl_n830, Vdd), 0.0040000000000000001, 0.69999999999999996, -1.0);
        // device 355, IC IC59, analog/basic/inverter.hpp:12
        I(cpphdl_n830, Vss) <+ cpphdl_channel(V(cpphdl_n814, Vss), V(cpphdl_n830, Vss), 0.0040000000000000001, 0.69999999999999996, 1.0);
        // device 356, IC IC55, analog/basic/buffered_nand_latch.hpp:34
        I(cpphdl_n806, Vss) <+ 2.0000000000000002e-15 * ddt(V(cpphdl_n806, Vss)); // Bench initial voltage = 0.0 V.
        // device 357, IC IC55, analog/basic/buffered_nand_latch.hpp:35
        I(cpphdl_n806, cpphdl_n814) <+ 1.0000000000000001e-15 * ddt(V(cpphdl_n806, cpphdl_n814)); // Bench initial voltage = 0.0 V.
        // device 358, IC IC55, analog/basic/buffered_nand_latch.hpp:36
        I(cpphdl_n814, Vss) <+ 5e-15 * ddt(V(cpphdl_n814, Vss)); // Bench initial voltage = 0.0 V.
        // device 359, IC IC55, analog/basic/buffered_nand_latch.hpp:37
        I(cpphdl_n814, Vss) <+ 8.0000000000000006e-15 * ddt(V(cpphdl_n814, Vss)); // Bench initial voltage = 0.0 V.
        // device 360, IC IC55, analog/basic/buffered_nand_latch.hpp:38
        I(cpphdl_n830, Vss) <+ 1e-14 * ddt(V(cpphdl_n830, Vss)); // Bench initial voltage = 0.0 V.
        // device 361, IC IC61, analog/basic/cmos_logic.hpp:17
        I(cpphdl_n2433, Vss) <+ 5.0000000000000002e-14 * ddt(V(cpphdl_n2433, Vss)); // Bench initial voltage = 0.0 V.
        // device 362, IC IC61, analog/basic/cmos_logic.hpp:18
        I(cpphdl_n2433, Vdd) <+ cpphdl_channel(V(cpphdl_n824, Vdd), V(cpphdl_n2433, Vdd), 0.01, 0.69999999999999996, -1.0);
        // device 363, IC IC61, analog/basic/cmos_logic.hpp:19
        I(cpphdl_n2433, Vdd) <+ cpphdl_channel(V(cpphdl_n832, Vdd), V(cpphdl_n2433, Vdd), 0.01, 0.69999999999999996, -1.0);
        // device 364, IC IC61, analog/basic/cmos_logic.hpp:20
        I(cpphdl_n2433, cpphdl_n827) <+ cpphdl_channel(V(cpphdl_n824, cpphdl_n827), V(cpphdl_n2433, cpphdl_n827), 0.01, 0.69999999999999996, 1.0);
        // device 365, IC IC61, analog/basic/cmos_logic.hpp:21
        I(cpphdl_n827, Vss) <+ cpphdl_channel(V(cpphdl_n832, Vss), V(cpphdl_n827, Vss), 0.01, 0.69999999999999996, 1.0);
        // device 366, IC IC61, analog/basic/cmos_logic.hpp:27
        I(cpphdl_n827, Vss) <+ 1e-14 * ddt(V(cpphdl_n827, Vss)); // Bench initial voltage = 0.0 V.
        // device 367, IC IC62, analog/basic/cmos_logic.hpp:17
        I(cpphdl_n832, Vss) <+ 5.0000000000000002e-14 * ddt(V(cpphdl_n832, Vss)); // Bench initial voltage = 0.0 V.
        // device 368, IC IC62, analog/basic/cmos_logic.hpp:18
        I(cpphdl_n832, Vdd) <+ cpphdl_channel(V(cpphdl_n830, Vdd), V(cpphdl_n832, Vdd), 0.01, 0.69999999999999996, -1.0);
        // device 369, IC IC62, analog/basic/cmos_logic.hpp:19
        I(cpphdl_n832, Vdd) <+ cpphdl_channel(V(cpphdl_n2433, Vdd), V(cpphdl_n832, Vdd), 0.01, 0.69999999999999996, -1.0);
        // device 370, IC IC62, analog/basic/cmos_logic.hpp:20
        I(cpphdl_n832, cpphdl_n833) <+ cpphdl_channel(V(cpphdl_n830, cpphdl_n833), V(cpphdl_n832, cpphdl_n833), 0.01, 0.69999999999999996, 1.0);
        // device 371, IC IC62, analog/basic/cmos_logic.hpp:21
        I(cpphdl_n833, Vss) <+ cpphdl_channel(V(cpphdl_n2433, Vss), V(cpphdl_n833, Vss), 0.01, 0.69999999999999996, 1.0);
        // device 372, IC IC62, analog/basic/cmos_logic.hpp:27
        I(cpphdl_n833, Vss) <+ 1e-14 * ddt(V(cpphdl_n833, Vss)); // Bench initial voltage = 0.0 V.
        // device 373, IC IC60, analog/basic/nand_latch.hpp:36
        I(cpphdl_n824, Vss) <+ 2.9999999999999998e-15 * ddt(V(cpphdl_n824, Vss)); // Bench initial voltage = 0.0 V.
        // device 374, IC IC60, analog/basic/nand_latch.hpp:37
        I(cpphdl_n830, Vss) <+ 2.9999999999999998e-15 * ddt(V(cpphdl_n830, Vss)); // Bench initial voltage = 0.0 V.
        // device 375, IC IC63, analog/basic/inverter.hpp:11
        I(cpphdl_n838, Vdd) <+ cpphdl_channel(V(CLEAR, Vdd), V(cpphdl_n838, Vdd), 0.01, 0.69999999999999996, -1.0);
        // device 376, IC IC63, analog/basic/inverter.hpp:12
        I(cpphdl_n838, Vss) <+ cpphdl_channel(V(CLEAR, Vss), V(cpphdl_n838, Vss), 0.01, 0.69999999999999996, 1.0);
        // device 377, IC IC60, analog/basic/nand_latch.hpp:58
        I(cpphdl_n838, Vss) <+ 2.9999999999999998e-15 * ddt(V(cpphdl_n838, Vss)); // Bench initial voltage = 0.0 V.
        // device 378, IC IC60, analog/basic/nand_latch.hpp:59
        I(cpphdl_n2433, Vss) <+ cpphdl_channel(V(CLEAR, Vss), V(cpphdl_n2433, Vss), 0.050000000000000003, 0.69999999999999996, 1.0);
        // device 379, IC IC60, analog/basic/nand_latch.hpp:60
        I(cpphdl_n832, Vdd) <+ cpphdl_channel(V(cpphdl_n838, Vdd), V(cpphdl_n832, Vdd), 0.050000000000000003, 0.69999999999999996, -1.0);
        // device 380, IC IC66, analog/basic/inverter.hpp:11
        I(cpphdl_n862, Vdd) <+ cpphdl_channel(V(TRACK2, Vdd), V(cpphdl_n862, Vdd), 0.0040000000000000001, 0.69999999999999996, -1.0);
        // device 381, IC IC66, analog/basic/inverter.hpp:12
        I(cpphdl_n862, Vss) <+ cpphdl_channel(V(TRACK2, Vss), V(cpphdl_n862, Vss), 0.0040000000000000001, 0.69999999999999996, 1.0);
        // device 382, IC IC65, analog/basic/mos_track_hold.hpp:31
        I(cpphdl_n862, Vss) <+ 2e-14 * ddt(V(cpphdl_n862, Vss)); // Bench initial voltage = 0.0 V.
        // device 383, IC IC65, analog/basic/mos_track_hold.hpp:32
        I(cpphdl_n2286, cpphdl_n916) <+ cpphdl_channel(V(TRACK2, cpphdl_n916), V(cpphdl_n2286, cpphdl_n916), 0.029999999999999999, 0.69999999999999996, 1.0);
        // device 384, IC IC65, analog/basic/mos_track_hold.hpp:33
        I(cpphdl_n916, cpphdl_n2286) <+ cpphdl_channel(V(cpphdl_n862, cpphdl_n2286), V(cpphdl_n916, cpphdl_n2286), 0.014999999999999999, 0.69999999999999996, -1.0);
        // device 385, IC IC65, analog/basic/mos_track_hold.hpp:37
        I(cpphdl_n916, cpphdl_n916) <+ cpphdl_channel(V(cpphdl_n862, cpphdl_n916), V(cpphdl_n916, cpphdl_n916), 0.016, 0.69999999999999996, 1.0);
        // device 386, IC IC65, analog/basic/mos_track_hold.hpp:38
        I(cpphdl_n916, cpphdl_n916) <+ cpphdl_channel(V(TRACK2, cpphdl_n916), V(cpphdl_n916, cpphdl_n916), 0.0083999999999999995, 0.69999999999999996, -1.0);
        // device 387, IC IC65, analog/basic/mos_track_hold.hpp:39
        I(cpphdl_n916, Vss) <+ 1.5000000000000001e-12 * ddt(V(cpphdl_n916, Vss)); // Bench initial voltage = 0.0 V.
        // device 388, IC IC65, analog/basic/mos_track_hold.hpp:42
        I(TRACK2, cpphdl_n916) <+ 2.0000000000000002e-15 * ddt(V(TRACK2, cpphdl_n916)); // Bench initial voltage = -0.0 V.
        // device 389, IC IC65, analog/basic/mos_track_hold.hpp:43
        I(cpphdl_n862, cpphdl_n916) <+ 2.0000000000000002e-15 * ddt(V(cpphdl_n862, cpphdl_n916)); // Bench initial voltage = 0.0 V.
        // device 390, IC IC65, analog/basic/mos_track_hold.hpp:44
        I(cpphdl_n2286, cpphdl_n916) <+ 1.0000000000000001e-15 * ddt(V(cpphdl_n2286, cpphdl_n916)); // Bench initial voltage = 0.0 V.
        // device 391, IC IC68, analog/basic/inverter.hpp:11
        I(cpphdl_n877, Vdd) <+ cpphdl_channel(V(BIT_N2_0, Vdd), V(cpphdl_n877, Vdd), 0.080000000000000002, 0.69999999999999996, -1.0);
        // device 392, IC IC68, analog/basic/inverter.hpp:12
        I(cpphdl_n877, Vss) <+ cpphdl_channel(V(BIT_N2_0, Vss), V(cpphdl_n877, Vss), 0.080000000000000002, 0.69999999999999996, 1.0);
        // device 393, IC IC67, analog/basic/mos_r2r_dac.hpp:27
        I(cpphdl_n877, Vss) <+ 2.9999999999999998e-15 * ddt(V(cpphdl_n877, Vss)); // Bench initial voltage = 0.0 V.
        // device 394, IC IC67, analog/basic/mos_r2r_dac.hpp:28
        I(cpphdl_n877, cpphdl_n906) <+ V(cpphdl_n877, cpphdl_n906) / 2000.0;
        // device 395, IC IC67, analog/basic/mos_r2r_dac.hpp:29
        I(cpphdl_n906, Vss) <+ 2.9999999999999998e-15 * ddt(V(cpphdl_n906, Vss)); // Bench initial voltage = 0.0 V.
        // device 396, IC IC69, analog/basic/inverter.hpp:11
        I(cpphdl_n881, Vdd) <+ cpphdl_channel(V(BIT_N2_1, Vdd), V(cpphdl_n881, Vdd), 0.080000000000000002, 0.69999999999999996, -1.0);
        // device 397, IC IC69, analog/basic/inverter.hpp:12
        I(cpphdl_n881, Vss) <+ cpphdl_channel(V(BIT_N2_1, Vss), V(cpphdl_n881, Vss), 0.080000000000000002, 0.69999999999999996, 1.0);
        // device 398, IC IC67, analog/basic/mos_r2r_dac.hpp:27
        I(cpphdl_n881, Vss) <+ 2.9999999999999998e-15 * ddt(V(cpphdl_n881, Vss)); // Bench initial voltage = 0.0 V.
        // device 399, IC IC67, analog/basic/mos_r2r_dac.hpp:28
        I(cpphdl_n881, cpphdl_n907) <+ V(cpphdl_n881, cpphdl_n907) / 2000.0;
        // device 400, IC IC67, analog/basic/mos_r2r_dac.hpp:29
        I(cpphdl_n907, Vss) <+ 2.9999999999999998e-15 * ddt(V(cpphdl_n907, Vss)); // Bench initial voltage = 0.0 V.
        // device 401, IC IC67, analog/basic/mos_r2r_dac.hpp:31
        I(cpphdl_n906, cpphdl_n907) <+ V(cpphdl_n906, cpphdl_n907) / 1000.0;
        // device 402, IC IC70, analog/basic/inverter.hpp:11
        I(cpphdl_n885, Vdd) <+ cpphdl_channel(V(BIT_N2_2, Vdd), V(cpphdl_n885, Vdd), 0.080000000000000002, 0.69999999999999996, -1.0);
        // device 403, IC IC70, analog/basic/inverter.hpp:12
        I(cpphdl_n885, Vss) <+ cpphdl_channel(V(BIT_N2_2, Vss), V(cpphdl_n885, Vss), 0.080000000000000002, 0.69999999999999996, 1.0);
        // device 404, IC IC67, analog/basic/mos_r2r_dac.hpp:27
        I(cpphdl_n885, Vss) <+ 2.9999999999999998e-15 * ddt(V(cpphdl_n885, Vss)); // Bench initial voltage = 0.0 V.
        // device 405, IC IC67, analog/basic/mos_r2r_dac.hpp:28
        I(cpphdl_n885, cpphdl_n908) <+ V(cpphdl_n885, cpphdl_n908) / 2000.0;
        // device 406, IC IC67, analog/basic/mos_r2r_dac.hpp:29
        I(cpphdl_n908, Vss) <+ 2.9999999999999998e-15 * ddt(V(cpphdl_n908, Vss)); // Bench initial voltage = 0.0 V.
        // device 407, IC IC67, analog/basic/mos_r2r_dac.hpp:31
        I(cpphdl_n907, cpphdl_n908) <+ V(cpphdl_n907, cpphdl_n908) / 1000.0;
        // device 408, IC IC71, analog/basic/inverter.hpp:11
        I(cpphdl_n889, Vdd) <+ cpphdl_channel(V(BIT_N2_3, Vdd), V(cpphdl_n889, Vdd), 0.080000000000000002, 0.69999999999999996, -1.0);
        // device 409, IC IC71, analog/basic/inverter.hpp:12
        I(cpphdl_n889, Vss) <+ cpphdl_channel(V(BIT_N2_3, Vss), V(cpphdl_n889, Vss), 0.080000000000000002, 0.69999999999999996, 1.0);
        // device 410, IC IC67, analog/basic/mos_r2r_dac.hpp:27
        I(cpphdl_n889, Vss) <+ 2.9999999999999998e-15 * ddt(V(cpphdl_n889, Vss)); // Bench initial voltage = 0.0 V.
        // device 411, IC IC67, analog/basic/mos_r2r_dac.hpp:28
        I(cpphdl_n889, cpphdl_n909) <+ V(cpphdl_n889, cpphdl_n909) / 2000.0;
        // device 412, IC IC67, analog/basic/mos_r2r_dac.hpp:29
        I(cpphdl_n909, Vss) <+ 2.9999999999999998e-15 * ddt(V(cpphdl_n909, Vss)); // Bench initial voltage = 0.0 V.
        // device 413, IC IC67, analog/basic/mos_r2r_dac.hpp:31
        I(cpphdl_n908, cpphdl_n909) <+ V(cpphdl_n908, cpphdl_n909) / 1000.0;
        // device 414, IC IC72, analog/basic/inverter.hpp:11
        I(cpphdl_n893, Vdd) <+ cpphdl_channel(V(BIT_N2_4, Vdd), V(cpphdl_n893, Vdd), 0.080000000000000002, 0.69999999999999996, -1.0);
        // device 415, IC IC72, analog/basic/inverter.hpp:12
        I(cpphdl_n893, Vss) <+ cpphdl_channel(V(BIT_N2_4, Vss), V(cpphdl_n893, Vss), 0.080000000000000002, 0.69999999999999996, 1.0);
        // device 416, IC IC67, analog/basic/mos_r2r_dac.hpp:27
        I(cpphdl_n893, Vss) <+ 2.9999999999999998e-15 * ddt(V(cpphdl_n893, Vss)); // Bench initial voltage = 0.0 V.
        // device 417, IC IC67, analog/basic/mos_r2r_dac.hpp:28
        I(cpphdl_n893, cpphdl_n910) <+ V(cpphdl_n893, cpphdl_n910) / 2000.0;
        // device 418, IC IC67, analog/basic/mos_r2r_dac.hpp:29
        I(cpphdl_n910, Vss) <+ 2.9999999999999998e-15 * ddt(V(cpphdl_n910, Vss)); // Bench initial voltage = 0.0 V.
        // device 419, IC IC67, analog/basic/mos_r2r_dac.hpp:31
        I(cpphdl_n909, cpphdl_n910) <+ V(cpphdl_n909, cpphdl_n910) / 1000.0;
        // device 420, IC IC73, analog/basic/inverter.hpp:11
        I(cpphdl_n897, Vdd) <+ cpphdl_channel(V(BIT_N2_5, Vdd), V(cpphdl_n897, Vdd), 0.080000000000000002, 0.69999999999999996, -1.0);
        // device 421, IC IC73, analog/basic/inverter.hpp:12
        I(cpphdl_n897, Vss) <+ cpphdl_channel(V(BIT_N2_5, Vss), V(cpphdl_n897, Vss), 0.080000000000000002, 0.69999999999999996, 1.0);
        // device 422, IC IC67, analog/basic/mos_r2r_dac.hpp:27
        I(cpphdl_n897, Vss) <+ 2.9999999999999998e-15 * ddt(V(cpphdl_n897, Vss)); // Bench initial voltage = 0.0 V.
        // device 423, IC IC67, analog/basic/mos_r2r_dac.hpp:28
        I(cpphdl_n897, cpphdl_n911) <+ V(cpphdl_n897, cpphdl_n911) / 2000.0;
        // device 424, IC IC67, analog/basic/mos_r2r_dac.hpp:29
        I(cpphdl_n911, Vss) <+ 2.9999999999999998e-15 * ddt(V(cpphdl_n911, Vss)); // Bench initial voltage = 0.0 V.
        // device 425, IC IC67, analog/basic/mos_r2r_dac.hpp:31
        I(cpphdl_n910, cpphdl_n911) <+ V(cpphdl_n910, cpphdl_n911) / 1000.0;
        // device 426, IC IC74, analog/basic/inverter.hpp:11
        I(cpphdl_n901, Vdd) <+ cpphdl_channel(V(BIT_N2_6, Vdd), V(cpphdl_n901, Vdd), 0.080000000000000002, 0.69999999999999996, -1.0);
        // device 427, IC IC74, analog/basic/inverter.hpp:12
        I(cpphdl_n901, Vss) <+ cpphdl_channel(V(BIT_N2_6, Vss), V(cpphdl_n901, Vss), 0.080000000000000002, 0.69999999999999996, 1.0);
        // device 428, IC IC67, analog/basic/mos_r2r_dac.hpp:27
        I(cpphdl_n901, Vss) <+ 2.9999999999999998e-15 * ddt(V(cpphdl_n901, Vss)); // Bench initial voltage = 0.0 V.
        // device 429, IC IC67, analog/basic/mos_r2r_dac.hpp:28
        I(cpphdl_n901, cpphdl_n912) <+ V(cpphdl_n901, cpphdl_n912) / 2000.0;
        // device 430, IC IC67, analog/basic/mos_r2r_dac.hpp:29
        I(cpphdl_n912, Vss) <+ 2.9999999999999998e-15 * ddt(V(cpphdl_n912, Vss)); // Bench initial voltage = 0.0 V.
        // device 431, IC IC67, analog/basic/mos_r2r_dac.hpp:31
        I(cpphdl_n911, cpphdl_n912) <+ V(cpphdl_n911, cpphdl_n912) / 1000.0;
        // device 432, IC IC75, analog/basic/inverter.hpp:11
        I(cpphdl_n905, Vdd) <+ cpphdl_channel(V(BIT_N2_7, Vdd), V(cpphdl_n905, Vdd), 0.080000000000000002, 0.69999999999999996, -1.0);
        // device 433, IC IC75, analog/basic/inverter.hpp:12
        I(cpphdl_n905, Vss) <+ cpphdl_channel(V(BIT_N2_7, Vss), V(cpphdl_n905, Vss), 0.080000000000000002, 0.69999999999999996, 1.0);
        // device 434, IC IC67, analog/basic/mos_r2r_dac.hpp:27
        I(cpphdl_n905, Vss) <+ 2.9999999999999998e-15 * ddt(V(cpphdl_n905, Vss)); // Bench initial voltage = 0.0 V.
        // device 435, IC IC67, analog/basic/mos_r2r_dac.hpp:28
        I(cpphdl_n905, cpphdl_n917) <+ V(cpphdl_n905, cpphdl_n917) / 2000.0;
        // device 436, IC IC67, analog/basic/mos_r2r_dac.hpp:29
        I(cpphdl_n917, Vss) <+ 2.9999999999999998e-15 * ddt(V(cpphdl_n917, Vss)); // Bench initial voltage = 0.0 V.
        // device 437, IC IC67, analog/basic/mos_r2r_dac.hpp:31
        I(cpphdl_n912, cpphdl_n917) <+ V(cpphdl_n912, cpphdl_n917) / 1000.0;
        // device 438, IC IC67, analog/basic/mos_r2r_dac.hpp:33
        I(Vss, cpphdl_n906) <+ V(Vss, cpphdl_n906) / 2000.0;
        // device 439, IC IC76, analog/basic/nmos_resistor_amplifier.hpp:23
        I(Vdd, cpphdl_n926) <+ V(Vdd, cpphdl_n926) / 1000.0;
        // device 440, IC IC76, analog/basic/nmos_resistor_amplifier.hpp:24
        I(Vdd, cpphdl_n925) <+ V(Vdd, cpphdl_n925) / 1000.0;
        // device 441, IC IC76, analog/basic/nmos_resistor_amplifier.hpp:25
        I(cpphdl_n926, cpphdl_n920) <+ cpphdl_channel(V(cpphdl_n916, cpphdl_n920), V(cpphdl_n926, cpphdl_n920), 0.0074999999999999997, 0.69999999999999996, 1.0);
        // device 442, IC IC76, analog/basic/nmos_resistor_amplifier.hpp:26
        I(cpphdl_n925, cpphdl_n921) <+ cpphdl_channel(V(cpphdl_n917, cpphdl_n921), V(cpphdl_n925, cpphdl_n921), 0.0074999999999999997, 0.69999999999999996, 1.0);
        // device 443, IC IC76, analog/basic/nmos_resistor_amplifier.hpp:27
        I(cpphdl_n922, cpphdl_n920) <+ V(cpphdl_n922, cpphdl_n920) / 100.0;
        // device 444, IC IC76, analog/basic/nmos_resistor_amplifier.hpp:28
        I(cpphdl_n922, cpphdl_n921) <+ V(cpphdl_n922, cpphdl_n921) / 100.0;
        // device 445, IC IC76, analog/basic/nmos_resistor_amplifier.hpp:29
        I(Vss, cpphdl_n922) <+ V(Vss, cpphdl_n922) / 300.0;
        // device 446, IC IC76, analog/basic/nmos_resistor_amplifier.hpp:30
        I(cpphdl_n926, Vdd) <+ 2.9999999999999998e-13 * ddt(V(cpphdl_n926, Vdd)); // Bench initial voltage = 0.0 V.
        // device 447, IC IC76, analog/basic/nmos_resistor_amplifier.hpp:31
        I(cpphdl_n925, Vdd) <+ 2.9999999999999998e-13 * ddt(V(cpphdl_n925, Vdd)); // Bench initial voltage = 0.0 V.
        // device 448, IC IC76, analog/basic/nmos_resistor_amplifier.hpp:32
        I(cpphdl_n922, Vss) <+ 4e-14 * ddt(V(cpphdl_n922, Vss)); // Bench initial voltage = 0.0 V.
        // device 449, IC IC76, analog/basic/nmos_resistor_amplifier.hpp:34
        I(cpphdl_n916, cpphdl_n920) <+ 2e-14 * ddt(V(cpphdl_n916, cpphdl_n920)); // Bench initial voltage = 0.0 V.
        // device 450, IC IC76, analog/basic/nmos_resistor_amplifier.hpp:35
        I(cpphdl_n917, cpphdl_n921) <+ 2e-14 * ddt(V(cpphdl_n917, cpphdl_n921)); // Bench initial voltage = 0.0 V.
        // device 451, IC IC76, analog/basic/nmos_resistor_amplifier.hpp:36
        I(cpphdl_n916, cpphdl_n926) <+ 2.9999999999999998e-15 * ddt(V(cpphdl_n916, cpphdl_n926)); // Bench initial voltage = 0.0 V.
        // device 452, IC IC76, analog/basic/nmos_resistor_amplifier.hpp:37
        I(cpphdl_n917, cpphdl_n925) <+ 2.9999999999999998e-15 * ddt(V(cpphdl_n917, cpphdl_n925)); // Bench initial voltage = 0.0 V.
        // device 453, IC IC77, analog/basic/strongarm_comparator.hpp:28
        I(cpphdl_n930, cpphdl_n932) <+ cpphdl_channel(V(cpphdl_n925, cpphdl_n932), V(cpphdl_n930, cpphdl_n932), 0.0080000000000000002, 0.69999999999999996, 1.0);
        // device 454, IC IC77, analog/basic/strongarm_comparator.hpp:29
        I(cpphdl_n931, cpphdl_n932) <+ cpphdl_channel(V(cpphdl_n926, cpphdl_n932), V(cpphdl_n931, cpphdl_n932), 0.0080000000000000002, 0.69999999999999996, 1.0);
        // device 455, IC IC77, analog/basic/strongarm_comparator.hpp:30
        I(cpphdl_n932, Vss) <+ cpphdl_channel(V(EVALUATE, Vss), V(cpphdl_n932, Vss), 0.0080000000000000002, 0.69999999999999996, 1.0);
        // device 456, IC IC77, analog/basic/strongarm_comparator.hpp:33
        I(cpphdl_n945, cpphdl_n930) <+ cpphdl_channel(V(cpphdl_n949, cpphdl_n930), V(cpphdl_n945, cpphdl_n930), 0.0040000000000000001, 0.69999999999999996, 1.0);
        // device 457, IC IC77, analog/basic/strongarm_comparator.hpp:34
        I(cpphdl_n949, cpphdl_n931) <+ cpphdl_channel(V(cpphdl_n945, cpphdl_n931), V(cpphdl_n949, cpphdl_n931), 0.0040000000000000001, 0.69999999999999996, 1.0);
        // device 458, IC IC77, analog/basic/strongarm_comparator.hpp:35
        I(cpphdl_n949, Vdd) <+ cpphdl_channel(V(cpphdl_n945, Vdd), V(cpphdl_n949, Vdd), 0.002, 0.69999999999999996, -1.0);
        // device 459, IC IC77, analog/basic/strongarm_comparator.hpp:36
        I(cpphdl_n945, Vdd) <+ cpphdl_channel(V(cpphdl_n949, Vdd), V(cpphdl_n945, Vdd), 0.002, 0.69999999999999996, -1.0);
        // device 460, IC IC77, analog/basic/strongarm_comparator.hpp:38
        I(cpphdl_n930, Vdd) <+ cpphdl_channel(V(EVALUATE, Vdd), V(cpphdl_n930, Vdd), 0.002, 0.69999999999999996, -1.0);
        // device 461, IC IC77, analog/basic/strongarm_comparator.hpp:39
        I(cpphdl_n931, Vdd) <+ cpphdl_channel(V(EVALUATE, Vdd), V(cpphdl_n931, Vdd), 0.002, 0.69999999999999996, -1.0);
        // device 462, IC IC77, analog/basic/strongarm_comparator.hpp:40
        I(cpphdl_n949, Vdd) <+ cpphdl_channel(V(EVALUATE, Vdd), V(cpphdl_n949, Vdd), 0.002, 0.69999999999999996, -1.0);
        // device 463, IC IC77, analog/basic/strongarm_comparator.hpp:41
        I(cpphdl_n945, Vdd) <+ cpphdl_channel(V(EVALUATE, Vdd), V(cpphdl_n945, Vdd), 0.002, 0.69999999999999996, -1.0);
        // device 464, IC IC77, analog/basic/strongarm_comparator.hpp:42
        I(cpphdl_n930, Vss) <+ 2.9999999999999998e-14 * ddt(V(cpphdl_n930, Vss)); // Bench initial voltage = 0.0 V.
        // device 465, IC IC77, analog/basic/strongarm_comparator.hpp:43
        I(cpphdl_n931, Vss) <+ 2.9999999999999998e-14 * ddt(V(cpphdl_n931, Vss)); // Bench initial voltage = 0.0 V.
        // device 466, IC IC77, analog/basic/strongarm_comparator.hpp:44
        I(cpphdl_n932, Vss) <+ 2.9999999999999998e-14 * ddt(V(cpphdl_n932, Vss)); // Bench initial voltage = 0.0 V.
        // device 467, IC IC77, analog/basic/strongarm_comparator.hpp:45
        I(cpphdl_n949, Vss) <+ 5.0000000000000002e-14 * ddt(V(cpphdl_n949, Vss)); // Bench initial voltage = 0.0 V.
        // device 468, IC IC77, analog/basic/strongarm_comparator.hpp:46
        I(cpphdl_n945, Vss) <+ 5.0000000000000002e-14 * ddt(V(cpphdl_n945, Vss)); // Bench initial voltage = 0.0 V.
        // device 469, IC IC77, analog/basic/strongarm_comparator.hpp:47
        I(cpphdl_n925, cpphdl_n932) <+ 2e-14 * ddt(V(cpphdl_n925, cpphdl_n932)); // Bench initial voltage = 0.0 V.
        // device 470, IC IC77, analog/basic/strongarm_comparator.hpp:48
        I(cpphdl_n926, cpphdl_n932) <+ 2e-14 * ddt(V(cpphdl_n926, cpphdl_n932)); // Bench initial voltage = 0.0 V.
        // device 471, IC IC77, analog/basic/strongarm_comparator.hpp:49
        I(cpphdl_n925, cpphdl_n930) <+ 2.9999999999999998e-15 * ddt(V(cpphdl_n925, cpphdl_n930)); // Bench initial voltage = 0.0 V.
        // device 472, IC IC77, analog/basic/strongarm_comparator.hpp:50
        I(cpphdl_n926, cpphdl_n931) <+ 2.9999999999999998e-15 * ddt(V(cpphdl_n926, cpphdl_n931)); // Bench initial voltage = 0.0 V.
        // device 473, IC IC79, analog/basic/inverter.hpp:11
        I(cpphdl_n953, Vdd) <+ cpphdl_channel(V(cpphdl_n945, Vdd), V(cpphdl_n953, Vdd), 0.001, 0.69999999999999996, -1.0);
        // device 474, IC IC79, analog/basic/inverter.hpp:12
        I(cpphdl_n953, Vss) <+ cpphdl_channel(V(cpphdl_n945, Vss), V(cpphdl_n953, Vss), 0.001, 0.69999999999999996, 1.0);
        // device 475, IC IC81, analog/basic/inverter.hpp:11
        I(cpphdl_n967, Vdd) <+ cpphdl_channel(V(cpphdl_n953, Vdd), V(cpphdl_n967, Vdd), 0.0040000000000000001, 0.69999999999999996, -1.0);
        // device 476, IC IC81, analog/basic/inverter.hpp:12
        I(cpphdl_n967, Vss) <+ cpphdl_channel(V(cpphdl_n953, Vss), V(cpphdl_n967, Vss), 0.0040000000000000001, 0.69999999999999996, 1.0);
        // device 477, IC IC78, analog/basic/buffered_nand_latch.hpp:34
        I(cpphdl_n945, Vss) <+ 2.0000000000000002e-15 * ddt(V(cpphdl_n945, Vss)); // Bench initial voltage = 0.0 V.
        // device 478, IC IC78, analog/basic/buffered_nand_latch.hpp:35
        I(cpphdl_n945, cpphdl_n953) <+ 1.0000000000000001e-15 * ddt(V(cpphdl_n945, cpphdl_n953)); // Bench initial voltage = 0.0 V.
        // device 479, IC IC78, analog/basic/buffered_nand_latch.hpp:36
        I(cpphdl_n953, Vss) <+ 5e-15 * ddt(V(cpphdl_n953, Vss)); // Bench initial voltage = 0.0 V.
        // device 480, IC IC78, analog/basic/buffered_nand_latch.hpp:37
        I(cpphdl_n953, Vss) <+ 8.0000000000000006e-15 * ddt(V(cpphdl_n953, Vss)); // Bench initial voltage = 0.0 V.
        // device 481, IC IC78, analog/basic/buffered_nand_latch.hpp:38
        I(cpphdl_n967, Vss) <+ 1e-14 * ddt(V(cpphdl_n967, Vss)); // Bench initial voltage = 0.0 V.
        // device 482, IC IC80, analog/basic/inverter.hpp:11
        I(cpphdl_n957, Vdd) <+ cpphdl_channel(V(cpphdl_n949, Vdd), V(cpphdl_n957, Vdd), 0.001, 0.69999999999999996, -1.0);
        // device 483, IC IC80, analog/basic/inverter.hpp:12
        I(cpphdl_n957, Vss) <+ cpphdl_channel(V(cpphdl_n949, Vss), V(cpphdl_n957, Vss), 0.001, 0.69999999999999996, 1.0);
        // device 484, IC IC82, analog/basic/inverter.hpp:11
        I(cpphdl_n973, Vdd) <+ cpphdl_channel(V(cpphdl_n957, Vdd), V(cpphdl_n973, Vdd), 0.0040000000000000001, 0.69999999999999996, -1.0);
        // device 485, IC IC82, analog/basic/inverter.hpp:12
        I(cpphdl_n973, Vss) <+ cpphdl_channel(V(cpphdl_n957, Vss), V(cpphdl_n973, Vss), 0.0040000000000000001, 0.69999999999999996, 1.0);
        // device 486, IC IC78, analog/basic/buffered_nand_latch.hpp:34
        I(cpphdl_n949, Vss) <+ 2.0000000000000002e-15 * ddt(V(cpphdl_n949, Vss)); // Bench initial voltage = 0.0 V.
        // device 487, IC IC78, analog/basic/buffered_nand_latch.hpp:35
        I(cpphdl_n949, cpphdl_n957) <+ 1.0000000000000001e-15 * ddt(V(cpphdl_n949, cpphdl_n957)); // Bench initial voltage = 0.0 V.
        // device 488, IC IC78, analog/basic/buffered_nand_latch.hpp:36
        I(cpphdl_n957, Vss) <+ 5e-15 * ddt(V(cpphdl_n957, Vss)); // Bench initial voltage = 0.0 V.
        // device 489, IC IC78, analog/basic/buffered_nand_latch.hpp:37
        I(cpphdl_n957, Vss) <+ 8.0000000000000006e-15 * ddt(V(cpphdl_n957, Vss)); // Bench initial voltage = 0.0 V.
        // device 490, IC IC78, analog/basic/buffered_nand_latch.hpp:38
        I(cpphdl_n973, Vss) <+ 1e-14 * ddt(V(cpphdl_n973, Vss)); // Bench initial voltage = 0.0 V.
        // device 491, IC IC84, analog/basic/cmos_logic.hpp:17
        I(cpphdl_n2438, Vss) <+ 5.0000000000000002e-14 * ddt(V(cpphdl_n2438, Vss)); // Bench initial voltage = 0.0 V.
        // device 492, IC IC84, analog/basic/cmos_logic.hpp:18
        I(cpphdl_n2438, Vdd) <+ cpphdl_channel(V(cpphdl_n967, Vdd), V(cpphdl_n2438, Vdd), 0.01, 0.69999999999999996, -1.0);
        // device 493, IC IC84, analog/basic/cmos_logic.hpp:19
        I(cpphdl_n2438, Vdd) <+ cpphdl_channel(V(cpphdl_n975, Vdd), V(cpphdl_n2438, Vdd), 0.01, 0.69999999999999996, -1.0);
        // device 494, IC IC84, analog/basic/cmos_logic.hpp:20
        I(cpphdl_n2438, cpphdl_n970) <+ cpphdl_channel(V(cpphdl_n967, cpphdl_n970), V(cpphdl_n2438, cpphdl_n970), 0.01, 0.69999999999999996, 1.0);
        // device 495, IC IC84, analog/basic/cmos_logic.hpp:21
        I(cpphdl_n970, Vss) <+ cpphdl_channel(V(cpphdl_n975, Vss), V(cpphdl_n970, Vss), 0.01, 0.69999999999999996, 1.0);
        // device 496, IC IC84, analog/basic/cmos_logic.hpp:27
        I(cpphdl_n970, Vss) <+ 1e-14 * ddt(V(cpphdl_n970, Vss)); // Bench initial voltage = 0.0 V.
        // device 497, IC IC85, analog/basic/cmos_logic.hpp:17
        I(cpphdl_n975, Vss) <+ 5.0000000000000002e-14 * ddt(V(cpphdl_n975, Vss)); // Bench initial voltage = 0.0 V.
        // device 498, IC IC85, analog/basic/cmos_logic.hpp:18
        I(cpphdl_n975, Vdd) <+ cpphdl_channel(V(cpphdl_n973, Vdd), V(cpphdl_n975, Vdd), 0.01, 0.69999999999999996, -1.0);
        // device 499, IC IC85, analog/basic/cmos_logic.hpp:19
        I(cpphdl_n975, Vdd) <+ cpphdl_channel(V(cpphdl_n2438, Vdd), V(cpphdl_n975, Vdd), 0.01, 0.69999999999999996, -1.0);
        // device 500, IC IC85, analog/basic/cmos_logic.hpp:20
        I(cpphdl_n975, cpphdl_n976) <+ cpphdl_channel(V(cpphdl_n973, cpphdl_n976), V(cpphdl_n975, cpphdl_n976), 0.01, 0.69999999999999996, 1.0);
        // device 501, IC IC85, analog/basic/cmos_logic.hpp:21
        I(cpphdl_n976, Vss) <+ cpphdl_channel(V(cpphdl_n2438, Vss), V(cpphdl_n976, Vss), 0.01, 0.69999999999999996, 1.0);
        // device 502, IC IC85, analog/basic/cmos_logic.hpp:27
        I(cpphdl_n976, Vss) <+ 1e-14 * ddt(V(cpphdl_n976, Vss)); // Bench initial voltage = 0.0 V.
        // device 503, IC IC83, analog/basic/nand_latch.hpp:36
        I(cpphdl_n967, Vss) <+ 2.9999999999999998e-15 * ddt(V(cpphdl_n967, Vss)); // Bench initial voltage = 0.0 V.
        // device 504, IC IC83, analog/basic/nand_latch.hpp:37
        I(cpphdl_n973, Vss) <+ 2.9999999999999998e-15 * ddt(V(cpphdl_n973, Vss)); // Bench initial voltage = 0.0 V.
        // device 505, IC IC86, analog/basic/inverter.hpp:11
        I(cpphdl_n981, Vdd) <+ cpphdl_channel(V(CLEAR, Vdd), V(cpphdl_n981, Vdd), 0.01, 0.69999999999999996, -1.0);
        // device 506, IC IC86, analog/basic/inverter.hpp:12
        I(cpphdl_n981, Vss) <+ cpphdl_channel(V(CLEAR, Vss), V(cpphdl_n981, Vss), 0.01, 0.69999999999999996, 1.0);
        // device 507, IC IC83, analog/basic/nand_latch.hpp:58
        I(cpphdl_n981, Vss) <+ 2.9999999999999998e-15 * ddt(V(cpphdl_n981, Vss)); // Bench initial voltage = 0.0 V.
        // device 508, IC IC83, analog/basic/nand_latch.hpp:59
        I(cpphdl_n2438, Vss) <+ cpphdl_channel(V(CLEAR, Vss), V(cpphdl_n2438, Vss), 0.050000000000000003, 0.69999999999999996, 1.0);
        // device 509, IC IC83, analog/basic/nand_latch.hpp:60
        I(cpphdl_n975, Vdd) <+ cpphdl_channel(V(cpphdl_n981, Vdd), V(cpphdl_n975, Vdd), 0.050000000000000003, 0.69999999999999996, -1.0);
        // device 510, IC IC89, analog/basic/inverter.hpp:11
        I(cpphdl_n1005, Vdd) <+ cpphdl_channel(V(TRACK3, Vdd), V(cpphdl_n1005, Vdd), 0.0040000000000000001, 0.69999999999999996, -1.0);
        // device 511, IC IC89, analog/basic/inverter.hpp:12
        I(cpphdl_n1005, Vss) <+ cpphdl_channel(V(TRACK3, Vss), V(cpphdl_n1005, Vss), 0.0040000000000000001, 0.69999999999999996, 1.0);
        // device 512, IC IC88, analog/basic/mos_track_hold.hpp:31
        I(cpphdl_n1005, Vss) <+ 2e-14 * ddt(V(cpphdl_n1005, Vss)); // Bench initial voltage = 0.0 V.
        // device 513, IC IC88, analog/basic/mos_track_hold.hpp:32
        I(cpphdl_n2286, cpphdl_n1059) <+ cpphdl_channel(V(TRACK3, cpphdl_n1059), V(cpphdl_n2286, cpphdl_n1059), 0.029999999999999999, 0.69999999999999996, 1.0);
        // device 514, IC IC88, analog/basic/mos_track_hold.hpp:33
        I(cpphdl_n1059, cpphdl_n2286) <+ cpphdl_channel(V(cpphdl_n1005, cpphdl_n2286), V(cpphdl_n1059, cpphdl_n2286), 0.014999999999999999, 0.69999999999999996, -1.0);
        // device 515, IC IC88, analog/basic/mos_track_hold.hpp:37
        I(cpphdl_n1059, cpphdl_n1059) <+ cpphdl_channel(V(cpphdl_n1005, cpphdl_n1059), V(cpphdl_n1059, cpphdl_n1059), 0.016, 0.69999999999999996, 1.0);
        // device 516, IC IC88, analog/basic/mos_track_hold.hpp:38
        I(cpphdl_n1059, cpphdl_n1059) <+ cpphdl_channel(V(TRACK3, cpphdl_n1059), V(cpphdl_n1059, cpphdl_n1059), 0.0083999999999999995, 0.69999999999999996, -1.0);
        // device 517, IC IC88, analog/basic/mos_track_hold.hpp:39
        I(cpphdl_n1059, Vss) <+ 1.5000000000000001e-12 * ddt(V(cpphdl_n1059, Vss)); // Bench initial voltage = 0.0 V.
        // device 518, IC IC88, analog/basic/mos_track_hold.hpp:42
        I(TRACK3, cpphdl_n1059) <+ 2.0000000000000002e-15 * ddt(V(TRACK3, cpphdl_n1059)); // Bench initial voltage = -0.0 V.
        // device 519, IC IC88, analog/basic/mos_track_hold.hpp:43
        I(cpphdl_n1005, cpphdl_n1059) <+ 2.0000000000000002e-15 * ddt(V(cpphdl_n1005, cpphdl_n1059)); // Bench initial voltage = 0.0 V.
        // device 520, IC IC88, analog/basic/mos_track_hold.hpp:44
        I(cpphdl_n2286, cpphdl_n1059) <+ 1.0000000000000001e-15 * ddt(V(cpphdl_n2286, cpphdl_n1059)); // Bench initial voltage = 0.0 V.
        // device 521, IC IC91, analog/basic/inverter.hpp:11
        I(cpphdl_n1020, Vdd) <+ cpphdl_channel(V(BIT_N3_0, Vdd), V(cpphdl_n1020, Vdd), 0.080000000000000002, 0.69999999999999996, -1.0);
        // device 522, IC IC91, analog/basic/inverter.hpp:12
        I(cpphdl_n1020, Vss) <+ cpphdl_channel(V(BIT_N3_0, Vss), V(cpphdl_n1020, Vss), 0.080000000000000002, 0.69999999999999996, 1.0);
        // device 523, IC IC90, analog/basic/mos_r2r_dac.hpp:27
        I(cpphdl_n1020, Vss) <+ 2.9999999999999998e-15 * ddt(V(cpphdl_n1020, Vss)); // Bench initial voltage = 0.0 V.
        // device 524, IC IC90, analog/basic/mos_r2r_dac.hpp:28
        I(cpphdl_n1020, cpphdl_n1049) <+ V(cpphdl_n1020, cpphdl_n1049) / 2000.0;
        // device 525, IC IC90, analog/basic/mos_r2r_dac.hpp:29
        I(cpphdl_n1049, Vss) <+ 2.9999999999999998e-15 * ddt(V(cpphdl_n1049, Vss)); // Bench initial voltage = 0.0 V.
        // device 526, IC IC92, analog/basic/inverter.hpp:11
        I(cpphdl_n1024, Vdd) <+ cpphdl_channel(V(BIT_N3_1, Vdd), V(cpphdl_n1024, Vdd), 0.080000000000000002, 0.69999999999999996, -1.0);
        // device 527, IC IC92, analog/basic/inverter.hpp:12
        I(cpphdl_n1024, Vss) <+ cpphdl_channel(V(BIT_N3_1, Vss), V(cpphdl_n1024, Vss), 0.080000000000000002, 0.69999999999999996, 1.0);
        // device 528, IC IC90, analog/basic/mos_r2r_dac.hpp:27
        I(cpphdl_n1024, Vss) <+ 2.9999999999999998e-15 * ddt(V(cpphdl_n1024, Vss)); // Bench initial voltage = 0.0 V.
        // device 529, IC IC90, analog/basic/mos_r2r_dac.hpp:28
        I(cpphdl_n1024, cpphdl_n1050) <+ V(cpphdl_n1024, cpphdl_n1050) / 2000.0;
        // device 530, IC IC90, analog/basic/mos_r2r_dac.hpp:29
        I(cpphdl_n1050, Vss) <+ 2.9999999999999998e-15 * ddt(V(cpphdl_n1050, Vss)); // Bench initial voltage = 0.0 V.
        // device 531, IC IC90, analog/basic/mos_r2r_dac.hpp:31
        I(cpphdl_n1049, cpphdl_n1050) <+ V(cpphdl_n1049, cpphdl_n1050) / 1000.0;
        // device 532, IC IC93, analog/basic/inverter.hpp:11
        I(cpphdl_n1028, Vdd) <+ cpphdl_channel(V(BIT_N3_2, Vdd), V(cpphdl_n1028, Vdd), 0.080000000000000002, 0.69999999999999996, -1.0);
        // device 533, IC IC93, analog/basic/inverter.hpp:12
        I(cpphdl_n1028, Vss) <+ cpphdl_channel(V(BIT_N3_2, Vss), V(cpphdl_n1028, Vss), 0.080000000000000002, 0.69999999999999996, 1.0);
        // device 534, IC IC90, analog/basic/mos_r2r_dac.hpp:27
        I(cpphdl_n1028, Vss) <+ 2.9999999999999998e-15 * ddt(V(cpphdl_n1028, Vss)); // Bench initial voltage = 0.0 V.
        // device 535, IC IC90, analog/basic/mos_r2r_dac.hpp:28
        I(cpphdl_n1028, cpphdl_n1051) <+ V(cpphdl_n1028, cpphdl_n1051) / 2000.0;
        // device 536, IC IC90, analog/basic/mos_r2r_dac.hpp:29
        I(cpphdl_n1051, Vss) <+ 2.9999999999999998e-15 * ddt(V(cpphdl_n1051, Vss)); // Bench initial voltage = 0.0 V.
        // device 537, IC IC90, analog/basic/mos_r2r_dac.hpp:31
        I(cpphdl_n1050, cpphdl_n1051) <+ V(cpphdl_n1050, cpphdl_n1051) / 1000.0;
        // device 538, IC IC94, analog/basic/inverter.hpp:11
        I(cpphdl_n1032, Vdd) <+ cpphdl_channel(V(BIT_N3_3, Vdd), V(cpphdl_n1032, Vdd), 0.080000000000000002, 0.69999999999999996, -1.0);
        // device 539, IC IC94, analog/basic/inverter.hpp:12
        I(cpphdl_n1032, Vss) <+ cpphdl_channel(V(BIT_N3_3, Vss), V(cpphdl_n1032, Vss), 0.080000000000000002, 0.69999999999999996, 1.0);
        // device 540, IC IC90, analog/basic/mos_r2r_dac.hpp:27
        I(cpphdl_n1032, Vss) <+ 2.9999999999999998e-15 * ddt(V(cpphdl_n1032, Vss)); // Bench initial voltage = 0.0 V.
        // device 541, IC IC90, analog/basic/mos_r2r_dac.hpp:28
        I(cpphdl_n1032, cpphdl_n1052) <+ V(cpphdl_n1032, cpphdl_n1052) / 2000.0;
        // device 542, IC IC90, analog/basic/mos_r2r_dac.hpp:29
        I(cpphdl_n1052, Vss) <+ 2.9999999999999998e-15 * ddt(V(cpphdl_n1052, Vss)); // Bench initial voltage = 0.0 V.
        // device 543, IC IC90, analog/basic/mos_r2r_dac.hpp:31
        I(cpphdl_n1051, cpphdl_n1052) <+ V(cpphdl_n1051, cpphdl_n1052) / 1000.0;
        // device 544, IC IC95, analog/basic/inverter.hpp:11
        I(cpphdl_n1036, Vdd) <+ cpphdl_channel(V(BIT_N3_4, Vdd), V(cpphdl_n1036, Vdd), 0.080000000000000002, 0.69999999999999996, -1.0);
        // device 545, IC IC95, analog/basic/inverter.hpp:12
        I(cpphdl_n1036, Vss) <+ cpphdl_channel(V(BIT_N3_4, Vss), V(cpphdl_n1036, Vss), 0.080000000000000002, 0.69999999999999996, 1.0);
        // device 546, IC IC90, analog/basic/mos_r2r_dac.hpp:27
        I(cpphdl_n1036, Vss) <+ 2.9999999999999998e-15 * ddt(V(cpphdl_n1036, Vss)); // Bench initial voltage = 0.0 V.
        // device 547, IC IC90, analog/basic/mos_r2r_dac.hpp:28
        I(cpphdl_n1036, cpphdl_n1053) <+ V(cpphdl_n1036, cpphdl_n1053) / 2000.0;
        // device 548, IC IC90, analog/basic/mos_r2r_dac.hpp:29
        I(cpphdl_n1053, Vss) <+ 2.9999999999999998e-15 * ddt(V(cpphdl_n1053, Vss)); // Bench initial voltage = 0.0 V.
        // device 549, IC IC90, analog/basic/mos_r2r_dac.hpp:31
        I(cpphdl_n1052, cpphdl_n1053) <+ V(cpphdl_n1052, cpphdl_n1053) / 1000.0;
        // device 550, IC IC96, analog/basic/inverter.hpp:11
        I(cpphdl_n1040, Vdd) <+ cpphdl_channel(V(BIT_N3_5, Vdd), V(cpphdl_n1040, Vdd), 0.080000000000000002, 0.69999999999999996, -1.0);
        // device 551, IC IC96, analog/basic/inverter.hpp:12
        I(cpphdl_n1040, Vss) <+ cpphdl_channel(V(BIT_N3_5, Vss), V(cpphdl_n1040, Vss), 0.080000000000000002, 0.69999999999999996, 1.0);
        // device 552, IC IC90, analog/basic/mos_r2r_dac.hpp:27
        I(cpphdl_n1040, Vss) <+ 2.9999999999999998e-15 * ddt(V(cpphdl_n1040, Vss)); // Bench initial voltage = 0.0 V.
        // device 553, IC IC90, analog/basic/mos_r2r_dac.hpp:28
        I(cpphdl_n1040, cpphdl_n1054) <+ V(cpphdl_n1040, cpphdl_n1054) / 2000.0;
        // device 554, IC IC90, analog/basic/mos_r2r_dac.hpp:29
        I(cpphdl_n1054, Vss) <+ 2.9999999999999998e-15 * ddt(V(cpphdl_n1054, Vss)); // Bench initial voltage = 0.0 V.
        // device 555, IC IC90, analog/basic/mos_r2r_dac.hpp:31
        I(cpphdl_n1053, cpphdl_n1054) <+ V(cpphdl_n1053, cpphdl_n1054) / 1000.0;
        // device 556, IC IC97, analog/basic/inverter.hpp:11
        I(cpphdl_n1044, Vdd) <+ cpphdl_channel(V(BIT_N3_6, Vdd), V(cpphdl_n1044, Vdd), 0.080000000000000002, 0.69999999999999996, -1.0);
        // device 557, IC IC97, analog/basic/inverter.hpp:12
        I(cpphdl_n1044, Vss) <+ cpphdl_channel(V(BIT_N3_6, Vss), V(cpphdl_n1044, Vss), 0.080000000000000002, 0.69999999999999996, 1.0);
        // device 558, IC IC90, analog/basic/mos_r2r_dac.hpp:27
        I(cpphdl_n1044, Vss) <+ 2.9999999999999998e-15 * ddt(V(cpphdl_n1044, Vss)); // Bench initial voltage = 0.0 V.
        // device 559, IC IC90, analog/basic/mos_r2r_dac.hpp:28
        I(cpphdl_n1044, cpphdl_n1055) <+ V(cpphdl_n1044, cpphdl_n1055) / 2000.0;
        // device 560, IC IC90, analog/basic/mos_r2r_dac.hpp:29
        I(cpphdl_n1055, Vss) <+ 2.9999999999999998e-15 * ddt(V(cpphdl_n1055, Vss)); // Bench initial voltage = 0.0 V.
        // device 561, IC IC90, analog/basic/mos_r2r_dac.hpp:31
        I(cpphdl_n1054, cpphdl_n1055) <+ V(cpphdl_n1054, cpphdl_n1055) / 1000.0;
        // device 562, IC IC98, analog/basic/inverter.hpp:11
        I(cpphdl_n1048, Vdd) <+ cpphdl_channel(V(BIT_N3_7, Vdd), V(cpphdl_n1048, Vdd), 0.080000000000000002, 0.69999999999999996, -1.0);
        // device 563, IC IC98, analog/basic/inverter.hpp:12
        I(cpphdl_n1048, Vss) <+ cpphdl_channel(V(BIT_N3_7, Vss), V(cpphdl_n1048, Vss), 0.080000000000000002, 0.69999999999999996, 1.0);
        // device 564, IC IC90, analog/basic/mos_r2r_dac.hpp:27
        I(cpphdl_n1048, Vss) <+ 2.9999999999999998e-15 * ddt(V(cpphdl_n1048, Vss)); // Bench initial voltage = 0.0 V.
        // device 565, IC IC90, analog/basic/mos_r2r_dac.hpp:28
        I(cpphdl_n1048, cpphdl_n1060) <+ V(cpphdl_n1048, cpphdl_n1060) / 2000.0;
        // device 566, IC IC90, analog/basic/mos_r2r_dac.hpp:29
        I(cpphdl_n1060, Vss) <+ 2.9999999999999998e-15 * ddt(V(cpphdl_n1060, Vss)); // Bench initial voltage = 0.0 V.
        // device 567, IC IC90, analog/basic/mos_r2r_dac.hpp:31
        I(cpphdl_n1055, cpphdl_n1060) <+ V(cpphdl_n1055, cpphdl_n1060) / 1000.0;
        // device 568, IC IC90, analog/basic/mos_r2r_dac.hpp:33
        I(Vss, cpphdl_n1049) <+ V(Vss, cpphdl_n1049) / 2000.0;
        // device 569, IC IC99, analog/basic/nmos_resistor_amplifier.hpp:23
        I(Vdd, cpphdl_n1069) <+ V(Vdd, cpphdl_n1069) / 1000.0;
        // device 570, IC IC99, analog/basic/nmos_resistor_amplifier.hpp:24
        I(Vdd, cpphdl_n1068) <+ V(Vdd, cpphdl_n1068) / 1000.0;
        // device 571, IC IC99, analog/basic/nmos_resistor_amplifier.hpp:25
        I(cpphdl_n1069, cpphdl_n1063) <+ cpphdl_channel(V(cpphdl_n1059, cpphdl_n1063), V(cpphdl_n1069, cpphdl_n1063), 0.0074999999999999997, 0.69999999999999996, 1.0);
        // device 572, IC IC99, analog/basic/nmos_resistor_amplifier.hpp:26
        I(cpphdl_n1068, cpphdl_n1064) <+ cpphdl_channel(V(cpphdl_n1060, cpphdl_n1064), V(cpphdl_n1068, cpphdl_n1064), 0.0074999999999999997, 0.69999999999999996, 1.0);
        // device 573, IC IC99, analog/basic/nmos_resistor_amplifier.hpp:27
        I(cpphdl_n1065, cpphdl_n1063) <+ V(cpphdl_n1065, cpphdl_n1063) / 100.0;
        // device 574, IC IC99, analog/basic/nmos_resistor_amplifier.hpp:28
        I(cpphdl_n1065, cpphdl_n1064) <+ V(cpphdl_n1065, cpphdl_n1064) / 100.0;
        // device 575, IC IC99, analog/basic/nmos_resistor_amplifier.hpp:29
        I(Vss, cpphdl_n1065) <+ V(Vss, cpphdl_n1065) / 300.0;
        // device 576, IC IC99, analog/basic/nmos_resistor_amplifier.hpp:30
        I(cpphdl_n1069, Vdd) <+ 2.9999999999999998e-13 * ddt(V(cpphdl_n1069, Vdd)); // Bench initial voltage = 0.0 V.
        // device 577, IC IC99, analog/basic/nmos_resistor_amplifier.hpp:31
        I(cpphdl_n1068, Vdd) <+ 2.9999999999999998e-13 * ddt(V(cpphdl_n1068, Vdd)); // Bench initial voltage = 0.0 V.
        // device 578, IC IC99, analog/basic/nmos_resistor_amplifier.hpp:32
        I(cpphdl_n1065, Vss) <+ 4e-14 * ddt(V(cpphdl_n1065, Vss)); // Bench initial voltage = 0.0 V.
        // device 579, IC IC99, analog/basic/nmos_resistor_amplifier.hpp:34
        I(cpphdl_n1059, cpphdl_n1063) <+ 2e-14 * ddt(V(cpphdl_n1059, cpphdl_n1063)); // Bench initial voltage = 0.0 V.
        // device 580, IC IC99, analog/basic/nmos_resistor_amplifier.hpp:35
        I(cpphdl_n1060, cpphdl_n1064) <+ 2e-14 * ddt(V(cpphdl_n1060, cpphdl_n1064)); // Bench initial voltage = 0.0 V.
        // device 581, IC IC99, analog/basic/nmos_resistor_amplifier.hpp:36
        I(cpphdl_n1059, cpphdl_n1069) <+ 2.9999999999999998e-15 * ddt(V(cpphdl_n1059, cpphdl_n1069)); // Bench initial voltage = 0.0 V.
        // device 582, IC IC99, analog/basic/nmos_resistor_amplifier.hpp:37
        I(cpphdl_n1060, cpphdl_n1068) <+ 2.9999999999999998e-15 * ddt(V(cpphdl_n1060, cpphdl_n1068)); // Bench initial voltage = 0.0 V.
        // device 583, IC IC100, analog/basic/strongarm_comparator.hpp:28
        I(cpphdl_n1073, cpphdl_n1075) <+ cpphdl_channel(V(cpphdl_n1068, cpphdl_n1075), V(cpphdl_n1073, cpphdl_n1075), 0.0080000000000000002, 0.69999999999999996, 1.0);
        // device 584, IC IC100, analog/basic/strongarm_comparator.hpp:29
        I(cpphdl_n1074, cpphdl_n1075) <+ cpphdl_channel(V(cpphdl_n1069, cpphdl_n1075), V(cpphdl_n1074, cpphdl_n1075), 0.0080000000000000002, 0.69999999999999996, 1.0);
        // device 585, IC IC100, analog/basic/strongarm_comparator.hpp:30
        I(cpphdl_n1075, Vss) <+ cpphdl_channel(V(EVALUATE, Vss), V(cpphdl_n1075, Vss), 0.0080000000000000002, 0.69999999999999996, 1.0);
        // device 586, IC IC100, analog/basic/strongarm_comparator.hpp:33
        I(cpphdl_n1088, cpphdl_n1073) <+ cpphdl_channel(V(cpphdl_n1092, cpphdl_n1073), V(cpphdl_n1088, cpphdl_n1073), 0.0040000000000000001, 0.69999999999999996, 1.0);
        // device 587, IC IC100, analog/basic/strongarm_comparator.hpp:34
        I(cpphdl_n1092, cpphdl_n1074) <+ cpphdl_channel(V(cpphdl_n1088, cpphdl_n1074), V(cpphdl_n1092, cpphdl_n1074), 0.0040000000000000001, 0.69999999999999996, 1.0);
        // device 588, IC IC100, analog/basic/strongarm_comparator.hpp:35
        I(cpphdl_n1092, Vdd) <+ cpphdl_channel(V(cpphdl_n1088, Vdd), V(cpphdl_n1092, Vdd), 0.002, 0.69999999999999996, -1.0);
        // device 589, IC IC100, analog/basic/strongarm_comparator.hpp:36
        I(cpphdl_n1088, Vdd) <+ cpphdl_channel(V(cpphdl_n1092, Vdd), V(cpphdl_n1088, Vdd), 0.002, 0.69999999999999996, -1.0);
        // device 590, IC IC100, analog/basic/strongarm_comparator.hpp:38
        I(cpphdl_n1073, Vdd) <+ cpphdl_channel(V(EVALUATE, Vdd), V(cpphdl_n1073, Vdd), 0.002, 0.69999999999999996, -1.0);
        // device 591, IC IC100, analog/basic/strongarm_comparator.hpp:39
        I(cpphdl_n1074, Vdd) <+ cpphdl_channel(V(EVALUATE, Vdd), V(cpphdl_n1074, Vdd), 0.002, 0.69999999999999996, -1.0);
        // device 592, IC IC100, analog/basic/strongarm_comparator.hpp:40
        I(cpphdl_n1092, Vdd) <+ cpphdl_channel(V(EVALUATE, Vdd), V(cpphdl_n1092, Vdd), 0.002, 0.69999999999999996, -1.0);
        // device 593, IC IC100, analog/basic/strongarm_comparator.hpp:41
        I(cpphdl_n1088, Vdd) <+ cpphdl_channel(V(EVALUATE, Vdd), V(cpphdl_n1088, Vdd), 0.002, 0.69999999999999996, -1.0);
        // device 594, IC IC100, analog/basic/strongarm_comparator.hpp:42
        I(cpphdl_n1073, Vss) <+ 2.9999999999999998e-14 * ddt(V(cpphdl_n1073, Vss)); // Bench initial voltage = 0.0 V.
        // device 595, IC IC100, analog/basic/strongarm_comparator.hpp:43
        I(cpphdl_n1074, Vss) <+ 2.9999999999999998e-14 * ddt(V(cpphdl_n1074, Vss)); // Bench initial voltage = 0.0 V.
        // device 596, IC IC100, analog/basic/strongarm_comparator.hpp:44
        I(cpphdl_n1075, Vss) <+ 2.9999999999999998e-14 * ddt(V(cpphdl_n1075, Vss)); // Bench initial voltage = 0.0 V.
        // device 597, IC IC100, analog/basic/strongarm_comparator.hpp:45
        I(cpphdl_n1092, Vss) <+ 5.0000000000000002e-14 * ddt(V(cpphdl_n1092, Vss)); // Bench initial voltage = 0.0 V.
        // device 598, IC IC100, analog/basic/strongarm_comparator.hpp:46
        I(cpphdl_n1088, Vss) <+ 5.0000000000000002e-14 * ddt(V(cpphdl_n1088, Vss)); // Bench initial voltage = 0.0 V.
        // device 599, IC IC100, analog/basic/strongarm_comparator.hpp:47
        I(cpphdl_n1068, cpphdl_n1075) <+ 2e-14 * ddt(V(cpphdl_n1068, cpphdl_n1075)); // Bench initial voltage = 0.0 V.
        // device 600, IC IC100, analog/basic/strongarm_comparator.hpp:48
        I(cpphdl_n1069, cpphdl_n1075) <+ 2e-14 * ddt(V(cpphdl_n1069, cpphdl_n1075)); // Bench initial voltage = 0.0 V.
        // device 601, IC IC100, analog/basic/strongarm_comparator.hpp:49
        I(cpphdl_n1068, cpphdl_n1073) <+ 2.9999999999999998e-15 * ddt(V(cpphdl_n1068, cpphdl_n1073)); // Bench initial voltage = 0.0 V.
        // device 602, IC IC100, analog/basic/strongarm_comparator.hpp:50
        I(cpphdl_n1069, cpphdl_n1074) <+ 2.9999999999999998e-15 * ddt(V(cpphdl_n1069, cpphdl_n1074)); // Bench initial voltage = 0.0 V.
        // device 603, IC IC102, analog/basic/inverter.hpp:11
        I(cpphdl_n1096, Vdd) <+ cpphdl_channel(V(cpphdl_n1088, Vdd), V(cpphdl_n1096, Vdd), 0.001, 0.69999999999999996, -1.0);
        // device 604, IC IC102, analog/basic/inverter.hpp:12
        I(cpphdl_n1096, Vss) <+ cpphdl_channel(V(cpphdl_n1088, Vss), V(cpphdl_n1096, Vss), 0.001, 0.69999999999999996, 1.0);
        // device 605, IC IC104, analog/basic/inverter.hpp:11
        I(cpphdl_n1110, Vdd) <+ cpphdl_channel(V(cpphdl_n1096, Vdd), V(cpphdl_n1110, Vdd), 0.0040000000000000001, 0.69999999999999996, -1.0);
        // device 606, IC IC104, analog/basic/inverter.hpp:12
        I(cpphdl_n1110, Vss) <+ cpphdl_channel(V(cpphdl_n1096, Vss), V(cpphdl_n1110, Vss), 0.0040000000000000001, 0.69999999999999996, 1.0);
        // device 607, IC IC101, analog/basic/buffered_nand_latch.hpp:34
        I(cpphdl_n1088, Vss) <+ 2.0000000000000002e-15 * ddt(V(cpphdl_n1088, Vss)); // Bench initial voltage = 0.0 V.
        // device 608, IC IC101, analog/basic/buffered_nand_latch.hpp:35
        I(cpphdl_n1088, cpphdl_n1096) <+ 1.0000000000000001e-15 * ddt(V(cpphdl_n1088, cpphdl_n1096)); // Bench initial voltage = 0.0 V.
        // device 609, IC IC101, analog/basic/buffered_nand_latch.hpp:36
        I(cpphdl_n1096, Vss) <+ 5e-15 * ddt(V(cpphdl_n1096, Vss)); // Bench initial voltage = 0.0 V.
        // device 610, IC IC101, analog/basic/buffered_nand_latch.hpp:37
        I(cpphdl_n1096, Vss) <+ 8.0000000000000006e-15 * ddt(V(cpphdl_n1096, Vss)); // Bench initial voltage = 0.0 V.
        // device 611, IC IC101, analog/basic/buffered_nand_latch.hpp:38
        I(cpphdl_n1110, Vss) <+ 1e-14 * ddt(V(cpphdl_n1110, Vss)); // Bench initial voltage = 0.0 V.
        // device 612, IC IC103, analog/basic/inverter.hpp:11
        I(cpphdl_n1100, Vdd) <+ cpphdl_channel(V(cpphdl_n1092, Vdd), V(cpphdl_n1100, Vdd), 0.001, 0.69999999999999996, -1.0);
        // device 613, IC IC103, analog/basic/inverter.hpp:12
        I(cpphdl_n1100, Vss) <+ cpphdl_channel(V(cpphdl_n1092, Vss), V(cpphdl_n1100, Vss), 0.001, 0.69999999999999996, 1.0);
        // device 614, IC IC105, analog/basic/inverter.hpp:11
        I(cpphdl_n1116, Vdd) <+ cpphdl_channel(V(cpphdl_n1100, Vdd), V(cpphdl_n1116, Vdd), 0.0040000000000000001, 0.69999999999999996, -1.0);
        // device 615, IC IC105, analog/basic/inverter.hpp:12
        I(cpphdl_n1116, Vss) <+ cpphdl_channel(V(cpphdl_n1100, Vss), V(cpphdl_n1116, Vss), 0.0040000000000000001, 0.69999999999999996, 1.0);
        // device 616, IC IC101, analog/basic/buffered_nand_latch.hpp:34
        I(cpphdl_n1092, Vss) <+ 2.0000000000000002e-15 * ddt(V(cpphdl_n1092, Vss)); // Bench initial voltage = 0.0 V.
        // device 617, IC IC101, analog/basic/buffered_nand_latch.hpp:35
        I(cpphdl_n1092, cpphdl_n1100) <+ 1.0000000000000001e-15 * ddt(V(cpphdl_n1092, cpphdl_n1100)); // Bench initial voltage = 0.0 V.
        // device 618, IC IC101, analog/basic/buffered_nand_latch.hpp:36
        I(cpphdl_n1100, Vss) <+ 5e-15 * ddt(V(cpphdl_n1100, Vss)); // Bench initial voltage = 0.0 V.
        // device 619, IC IC101, analog/basic/buffered_nand_latch.hpp:37
        I(cpphdl_n1100, Vss) <+ 8.0000000000000006e-15 * ddt(V(cpphdl_n1100, Vss)); // Bench initial voltage = 0.0 V.
        // device 620, IC IC101, analog/basic/buffered_nand_latch.hpp:38
        I(cpphdl_n1116, Vss) <+ 1e-14 * ddt(V(cpphdl_n1116, Vss)); // Bench initial voltage = 0.0 V.
        // device 621, IC IC107, analog/basic/cmos_logic.hpp:17
        I(cpphdl_n2443, Vss) <+ 5.0000000000000002e-14 * ddt(V(cpphdl_n2443, Vss)); // Bench initial voltage = 0.0 V.
        // device 622, IC IC107, analog/basic/cmos_logic.hpp:18
        I(cpphdl_n2443, Vdd) <+ cpphdl_channel(V(cpphdl_n1110, Vdd), V(cpphdl_n2443, Vdd), 0.01, 0.69999999999999996, -1.0);
        // device 623, IC IC107, analog/basic/cmos_logic.hpp:19
        I(cpphdl_n2443, Vdd) <+ cpphdl_channel(V(cpphdl_n1118, Vdd), V(cpphdl_n2443, Vdd), 0.01, 0.69999999999999996, -1.0);
        // device 624, IC IC107, analog/basic/cmos_logic.hpp:20
        I(cpphdl_n2443, cpphdl_n1113) <+ cpphdl_channel(V(cpphdl_n1110, cpphdl_n1113), V(cpphdl_n2443, cpphdl_n1113), 0.01, 0.69999999999999996, 1.0);
        // device 625, IC IC107, analog/basic/cmos_logic.hpp:21
        I(cpphdl_n1113, Vss) <+ cpphdl_channel(V(cpphdl_n1118, Vss), V(cpphdl_n1113, Vss), 0.01, 0.69999999999999996, 1.0);
        // device 626, IC IC107, analog/basic/cmos_logic.hpp:27
        I(cpphdl_n1113, Vss) <+ 1e-14 * ddt(V(cpphdl_n1113, Vss)); // Bench initial voltage = 0.0 V.
        // device 627, IC IC108, analog/basic/cmos_logic.hpp:17
        I(cpphdl_n1118, Vss) <+ 5.0000000000000002e-14 * ddt(V(cpphdl_n1118, Vss)); // Bench initial voltage = 0.0 V.
        // device 628, IC IC108, analog/basic/cmos_logic.hpp:18
        I(cpphdl_n1118, Vdd) <+ cpphdl_channel(V(cpphdl_n1116, Vdd), V(cpphdl_n1118, Vdd), 0.01, 0.69999999999999996, -1.0);
        // device 629, IC IC108, analog/basic/cmos_logic.hpp:19
        I(cpphdl_n1118, Vdd) <+ cpphdl_channel(V(cpphdl_n2443, Vdd), V(cpphdl_n1118, Vdd), 0.01, 0.69999999999999996, -1.0);
        // device 630, IC IC108, analog/basic/cmos_logic.hpp:20
        I(cpphdl_n1118, cpphdl_n1119) <+ cpphdl_channel(V(cpphdl_n1116, cpphdl_n1119), V(cpphdl_n1118, cpphdl_n1119), 0.01, 0.69999999999999996, 1.0);
        // device 631, IC IC108, analog/basic/cmos_logic.hpp:21
        I(cpphdl_n1119, Vss) <+ cpphdl_channel(V(cpphdl_n2443, Vss), V(cpphdl_n1119, Vss), 0.01, 0.69999999999999996, 1.0);
        // device 632, IC IC108, analog/basic/cmos_logic.hpp:27
        I(cpphdl_n1119, Vss) <+ 1e-14 * ddt(V(cpphdl_n1119, Vss)); // Bench initial voltage = 0.0 V.
        // device 633, IC IC106, analog/basic/nand_latch.hpp:36
        I(cpphdl_n1110, Vss) <+ 2.9999999999999998e-15 * ddt(V(cpphdl_n1110, Vss)); // Bench initial voltage = 0.0 V.
        // device 634, IC IC106, analog/basic/nand_latch.hpp:37
        I(cpphdl_n1116, Vss) <+ 2.9999999999999998e-15 * ddt(V(cpphdl_n1116, Vss)); // Bench initial voltage = 0.0 V.
        // device 635, IC IC109, analog/basic/inverter.hpp:11
        I(cpphdl_n1124, Vdd) <+ cpphdl_channel(V(CLEAR, Vdd), V(cpphdl_n1124, Vdd), 0.01, 0.69999999999999996, -1.0);
        // device 636, IC IC109, analog/basic/inverter.hpp:12
        I(cpphdl_n1124, Vss) <+ cpphdl_channel(V(CLEAR, Vss), V(cpphdl_n1124, Vss), 0.01, 0.69999999999999996, 1.0);
        // device 637, IC IC106, analog/basic/nand_latch.hpp:58
        I(cpphdl_n1124, Vss) <+ 2.9999999999999998e-15 * ddt(V(cpphdl_n1124, Vss)); // Bench initial voltage = 0.0 V.
        // device 638, IC IC106, analog/basic/nand_latch.hpp:59
        I(cpphdl_n2443, Vss) <+ cpphdl_channel(V(CLEAR, Vss), V(cpphdl_n2443, Vss), 0.050000000000000003, 0.69999999999999996, 1.0);
        // device 639, IC IC106, analog/basic/nand_latch.hpp:60
        I(cpphdl_n1118, Vdd) <+ cpphdl_channel(V(cpphdl_n1124, Vdd), V(cpphdl_n1118, Vdd), 0.050000000000000003, 0.69999999999999996, -1.0);
        // device 640, IC IC112, analog/basic/inverter.hpp:11
        I(cpphdl_n1148, Vdd) <+ cpphdl_channel(V(TRACK4, Vdd), V(cpphdl_n1148, Vdd), 0.0040000000000000001, 0.69999999999999996, -1.0);
        // device 641, IC IC112, analog/basic/inverter.hpp:12
        I(cpphdl_n1148, Vss) <+ cpphdl_channel(V(TRACK4, Vss), V(cpphdl_n1148, Vss), 0.0040000000000000001, 0.69999999999999996, 1.0);
        // device 642, IC IC111, analog/basic/mos_track_hold.hpp:31
        I(cpphdl_n1148, Vss) <+ 2e-14 * ddt(V(cpphdl_n1148, Vss)); // Bench initial voltage = 0.0 V.
        // device 643, IC IC111, analog/basic/mos_track_hold.hpp:32
        I(cpphdl_n2286, cpphdl_n1202) <+ cpphdl_channel(V(TRACK4, cpphdl_n1202), V(cpphdl_n2286, cpphdl_n1202), 0.029999999999999999, 0.69999999999999996, 1.0);
        // device 644, IC IC111, analog/basic/mos_track_hold.hpp:33
        I(cpphdl_n1202, cpphdl_n2286) <+ cpphdl_channel(V(cpphdl_n1148, cpphdl_n2286), V(cpphdl_n1202, cpphdl_n2286), 0.014999999999999999, 0.69999999999999996, -1.0);
        // device 645, IC IC111, analog/basic/mos_track_hold.hpp:37
        I(cpphdl_n1202, cpphdl_n1202) <+ cpphdl_channel(V(cpphdl_n1148, cpphdl_n1202), V(cpphdl_n1202, cpphdl_n1202), 0.016, 0.69999999999999996, 1.0);
        // device 646, IC IC111, analog/basic/mos_track_hold.hpp:38
        I(cpphdl_n1202, cpphdl_n1202) <+ cpphdl_channel(V(TRACK4, cpphdl_n1202), V(cpphdl_n1202, cpphdl_n1202), 0.0083999999999999995, 0.69999999999999996, -1.0);
        // device 647, IC IC111, analog/basic/mos_track_hold.hpp:39
        I(cpphdl_n1202, Vss) <+ 1.5000000000000001e-12 * ddt(V(cpphdl_n1202, Vss)); // Bench initial voltage = 0.0 V.
        // device 648, IC IC111, analog/basic/mos_track_hold.hpp:42
        I(TRACK4, cpphdl_n1202) <+ 2.0000000000000002e-15 * ddt(V(TRACK4, cpphdl_n1202)); // Bench initial voltage = -0.0 V.
        // device 649, IC IC111, analog/basic/mos_track_hold.hpp:43
        I(cpphdl_n1148, cpphdl_n1202) <+ 2.0000000000000002e-15 * ddt(V(cpphdl_n1148, cpphdl_n1202)); // Bench initial voltage = 0.0 V.
        // device 650, IC IC111, analog/basic/mos_track_hold.hpp:44
        I(cpphdl_n2286, cpphdl_n1202) <+ 1.0000000000000001e-15 * ddt(V(cpphdl_n2286, cpphdl_n1202)); // Bench initial voltage = 0.0 V.
        // device 651, IC IC114, analog/basic/inverter.hpp:11
        I(cpphdl_n1163, Vdd) <+ cpphdl_channel(V(BIT_N4_0, Vdd), V(cpphdl_n1163, Vdd), 0.080000000000000002, 0.69999999999999996, -1.0);
        // device 652, IC IC114, analog/basic/inverter.hpp:12
        I(cpphdl_n1163, Vss) <+ cpphdl_channel(V(BIT_N4_0, Vss), V(cpphdl_n1163, Vss), 0.080000000000000002, 0.69999999999999996, 1.0);
        // device 653, IC IC113, analog/basic/mos_r2r_dac.hpp:27
        I(cpphdl_n1163, Vss) <+ 2.9999999999999998e-15 * ddt(V(cpphdl_n1163, Vss)); // Bench initial voltage = 0.0 V.
        // device 654, IC IC113, analog/basic/mos_r2r_dac.hpp:28
        I(cpphdl_n1163, cpphdl_n1192) <+ V(cpphdl_n1163, cpphdl_n1192) / 2000.0;
        // device 655, IC IC113, analog/basic/mos_r2r_dac.hpp:29
        I(cpphdl_n1192, Vss) <+ 2.9999999999999998e-15 * ddt(V(cpphdl_n1192, Vss)); // Bench initial voltage = 0.0 V.
        // device 656, IC IC115, analog/basic/inverter.hpp:11
        I(cpphdl_n1167, Vdd) <+ cpphdl_channel(V(BIT_N4_1, Vdd), V(cpphdl_n1167, Vdd), 0.080000000000000002, 0.69999999999999996, -1.0);
        // device 657, IC IC115, analog/basic/inverter.hpp:12
        I(cpphdl_n1167, Vss) <+ cpphdl_channel(V(BIT_N4_1, Vss), V(cpphdl_n1167, Vss), 0.080000000000000002, 0.69999999999999996, 1.0);
        // device 658, IC IC113, analog/basic/mos_r2r_dac.hpp:27
        I(cpphdl_n1167, Vss) <+ 2.9999999999999998e-15 * ddt(V(cpphdl_n1167, Vss)); // Bench initial voltage = 0.0 V.
        // device 659, IC IC113, analog/basic/mos_r2r_dac.hpp:28
        I(cpphdl_n1167, cpphdl_n1193) <+ V(cpphdl_n1167, cpphdl_n1193) / 2000.0;
        // device 660, IC IC113, analog/basic/mos_r2r_dac.hpp:29
        I(cpphdl_n1193, Vss) <+ 2.9999999999999998e-15 * ddt(V(cpphdl_n1193, Vss)); // Bench initial voltage = 0.0 V.
        // device 661, IC IC113, analog/basic/mos_r2r_dac.hpp:31
        I(cpphdl_n1192, cpphdl_n1193) <+ V(cpphdl_n1192, cpphdl_n1193) / 1000.0;
        // device 662, IC IC116, analog/basic/inverter.hpp:11
        I(cpphdl_n1171, Vdd) <+ cpphdl_channel(V(BIT_N4_2, Vdd), V(cpphdl_n1171, Vdd), 0.080000000000000002, 0.69999999999999996, -1.0);
        // device 663, IC IC116, analog/basic/inverter.hpp:12
        I(cpphdl_n1171, Vss) <+ cpphdl_channel(V(BIT_N4_2, Vss), V(cpphdl_n1171, Vss), 0.080000000000000002, 0.69999999999999996, 1.0);
        // device 664, IC IC113, analog/basic/mos_r2r_dac.hpp:27
        I(cpphdl_n1171, Vss) <+ 2.9999999999999998e-15 * ddt(V(cpphdl_n1171, Vss)); // Bench initial voltage = 0.0 V.
        // device 665, IC IC113, analog/basic/mos_r2r_dac.hpp:28
        I(cpphdl_n1171, cpphdl_n1194) <+ V(cpphdl_n1171, cpphdl_n1194) / 2000.0;
        // device 666, IC IC113, analog/basic/mos_r2r_dac.hpp:29
        I(cpphdl_n1194, Vss) <+ 2.9999999999999998e-15 * ddt(V(cpphdl_n1194, Vss)); // Bench initial voltage = 0.0 V.
        // device 667, IC IC113, analog/basic/mos_r2r_dac.hpp:31
        I(cpphdl_n1193, cpphdl_n1194) <+ V(cpphdl_n1193, cpphdl_n1194) / 1000.0;
        // device 668, IC IC117, analog/basic/inverter.hpp:11
        I(cpphdl_n1175, Vdd) <+ cpphdl_channel(V(BIT_N4_3, Vdd), V(cpphdl_n1175, Vdd), 0.080000000000000002, 0.69999999999999996, -1.0);
        // device 669, IC IC117, analog/basic/inverter.hpp:12
        I(cpphdl_n1175, Vss) <+ cpphdl_channel(V(BIT_N4_3, Vss), V(cpphdl_n1175, Vss), 0.080000000000000002, 0.69999999999999996, 1.0);
        // device 670, IC IC113, analog/basic/mos_r2r_dac.hpp:27
        I(cpphdl_n1175, Vss) <+ 2.9999999999999998e-15 * ddt(V(cpphdl_n1175, Vss)); // Bench initial voltage = 0.0 V.
        // device 671, IC IC113, analog/basic/mos_r2r_dac.hpp:28
        I(cpphdl_n1175, cpphdl_n1195) <+ V(cpphdl_n1175, cpphdl_n1195) / 2000.0;
        // device 672, IC IC113, analog/basic/mos_r2r_dac.hpp:29
        I(cpphdl_n1195, Vss) <+ 2.9999999999999998e-15 * ddt(V(cpphdl_n1195, Vss)); // Bench initial voltage = 0.0 V.
        // device 673, IC IC113, analog/basic/mos_r2r_dac.hpp:31
        I(cpphdl_n1194, cpphdl_n1195) <+ V(cpphdl_n1194, cpphdl_n1195) / 1000.0;
        // device 674, IC IC118, analog/basic/inverter.hpp:11
        I(cpphdl_n1179, Vdd) <+ cpphdl_channel(V(BIT_N4_4, Vdd), V(cpphdl_n1179, Vdd), 0.080000000000000002, 0.69999999999999996, -1.0);
        // device 675, IC IC118, analog/basic/inverter.hpp:12
        I(cpphdl_n1179, Vss) <+ cpphdl_channel(V(BIT_N4_4, Vss), V(cpphdl_n1179, Vss), 0.080000000000000002, 0.69999999999999996, 1.0);
        // device 676, IC IC113, analog/basic/mos_r2r_dac.hpp:27
        I(cpphdl_n1179, Vss) <+ 2.9999999999999998e-15 * ddt(V(cpphdl_n1179, Vss)); // Bench initial voltage = 0.0 V.
        // device 677, IC IC113, analog/basic/mos_r2r_dac.hpp:28
        I(cpphdl_n1179, cpphdl_n1196) <+ V(cpphdl_n1179, cpphdl_n1196) / 2000.0;
        // device 678, IC IC113, analog/basic/mos_r2r_dac.hpp:29
        I(cpphdl_n1196, Vss) <+ 2.9999999999999998e-15 * ddt(V(cpphdl_n1196, Vss)); // Bench initial voltage = 0.0 V.
        // device 679, IC IC113, analog/basic/mos_r2r_dac.hpp:31
        I(cpphdl_n1195, cpphdl_n1196) <+ V(cpphdl_n1195, cpphdl_n1196) / 1000.0;
        // device 680, IC IC119, analog/basic/inverter.hpp:11
        I(cpphdl_n1183, Vdd) <+ cpphdl_channel(V(BIT_N4_5, Vdd), V(cpphdl_n1183, Vdd), 0.080000000000000002, 0.69999999999999996, -1.0);
        // device 681, IC IC119, analog/basic/inverter.hpp:12
        I(cpphdl_n1183, Vss) <+ cpphdl_channel(V(BIT_N4_5, Vss), V(cpphdl_n1183, Vss), 0.080000000000000002, 0.69999999999999996, 1.0);
        // device 682, IC IC113, analog/basic/mos_r2r_dac.hpp:27
        I(cpphdl_n1183, Vss) <+ 2.9999999999999998e-15 * ddt(V(cpphdl_n1183, Vss)); // Bench initial voltage = 0.0 V.
        // device 683, IC IC113, analog/basic/mos_r2r_dac.hpp:28
        I(cpphdl_n1183, cpphdl_n1197) <+ V(cpphdl_n1183, cpphdl_n1197) / 2000.0;
        // device 684, IC IC113, analog/basic/mos_r2r_dac.hpp:29
        I(cpphdl_n1197, Vss) <+ 2.9999999999999998e-15 * ddt(V(cpphdl_n1197, Vss)); // Bench initial voltage = 0.0 V.
        // device 685, IC IC113, analog/basic/mos_r2r_dac.hpp:31
        I(cpphdl_n1196, cpphdl_n1197) <+ V(cpphdl_n1196, cpphdl_n1197) / 1000.0;
        // device 686, IC IC120, analog/basic/inverter.hpp:11
        I(cpphdl_n1187, Vdd) <+ cpphdl_channel(V(BIT_N4_6, Vdd), V(cpphdl_n1187, Vdd), 0.080000000000000002, 0.69999999999999996, -1.0);
        // device 687, IC IC120, analog/basic/inverter.hpp:12
        I(cpphdl_n1187, Vss) <+ cpphdl_channel(V(BIT_N4_6, Vss), V(cpphdl_n1187, Vss), 0.080000000000000002, 0.69999999999999996, 1.0);
        // device 688, IC IC113, analog/basic/mos_r2r_dac.hpp:27
        I(cpphdl_n1187, Vss) <+ 2.9999999999999998e-15 * ddt(V(cpphdl_n1187, Vss)); // Bench initial voltage = 0.0 V.
        // device 689, IC IC113, analog/basic/mos_r2r_dac.hpp:28
        I(cpphdl_n1187, cpphdl_n1198) <+ V(cpphdl_n1187, cpphdl_n1198) / 2000.0;
        // device 690, IC IC113, analog/basic/mos_r2r_dac.hpp:29
        I(cpphdl_n1198, Vss) <+ 2.9999999999999998e-15 * ddt(V(cpphdl_n1198, Vss)); // Bench initial voltage = 0.0 V.
        // device 691, IC IC113, analog/basic/mos_r2r_dac.hpp:31
        I(cpphdl_n1197, cpphdl_n1198) <+ V(cpphdl_n1197, cpphdl_n1198) / 1000.0;
        // device 692, IC IC121, analog/basic/inverter.hpp:11
        I(cpphdl_n1191, Vdd) <+ cpphdl_channel(V(BIT_N4_7, Vdd), V(cpphdl_n1191, Vdd), 0.080000000000000002, 0.69999999999999996, -1.0);
        // device 693, IC IC121, analog/basic/inverter.hpp:12
        I(cpphdl_n1191, Vss) <+ cpphdl_channel(V(BIT_N4_7, Vss), V(cpphdl_n1191, Vss), 0.080000000000000002, 0.69999999999999996, 1.0);
        // device 694, IC IC113, analog/basic/mos_r2r_dac.hpp:27
        I(cpphdl_n1191, Vss) <+ 2.9999999999999998e-15 * ddt(V(cpphdl_n1191, Vss)); // Bench initial voltage = 0.0 V.
        // device 695, IC IC113, analog/basic/mos_r2r_dac.hpp:28
        I(cpphdl_n1191, cpphdl_n1203) <+ V(cpphdl_n1191, cpphdl_n1203) / 2000.0;
        // device 696, IC IC113, analog/basic/mos_r2r_dac.hpp:29
        I(cpphdl_n1203, Vss) <+ 2.9999999999999998e-15 * ddt(V(cpphdl_n1203, Vss)); // Bench initial voltage = 0.0 V.
        // device 697, IC IC113, analog/basic/mos_r2r_dac.hpp:31
        I(cpphdl_n1198, cpphdl_n1203) <+ V(cpphdl_n1198, cpphdl_n1203) / 1000.0;
        // device 698, IC IC113, analog/basic/mos_r2r_dac.hpp:33
        I(Vss, cpphdl_n1192) <+ V(Vss, cpphdl_n1192) / 2000.0;
        // device 699, IC IC122, analog/basic/nmos_resistor_amplifier.hpp:23
        I(Vdd, cpphdl_n1212) <+ V(Vdd, cpphdl_n1212) / 1000.0;
        // device 700, IC IC122, analog/basic/nmos_resistor_amplifier.hpp:24
        I(Vdd, cpphdl_n1211) <+ V(Vdd, cpphdl_n1211) / 1000.0;
        // device 701, IC IC122, analog/basic/nmos_resistor_amplifier.hpp:25
        I(cpphdl_n1212, cpphdl_n1206) <+ cpphdl_channel(V(cpphdl_n1202, cpphdl_n1206), V(cpphdl_n1212, cpphdl_n1206), 0.0074999999999999997, 0.69999999999999996, 1.0);
        // device 702, IC IC122, analog/basic/nmos_resistor_amplifier.hpp:26
        I(cpphdl_n1211, cpphdl_n1207) <+ cpphdl_channel(V(cpphdl_n1203, cpphdl_n1207), V(cpphdl_n1211, cpphdl_n1207), 0.0074999999999999997, 0.69999999999999996, 1.0);
        // device 703, IC IC122, analog/basic/nmos_resistor_amplifier.hpp:27
        I(cpphdl_n1208, cpphdl_n1206) <+ V(cpphdl_n1208, cpphdl_n1206) / 100.0;
        // device 704, IC IC122, analog/basic/nmos_resistor_amplifier.hpp:28
        I(cpphdl_n1208, cpphdl_n1207) <+ V(cpphdl_n1208, cpphdl_n1207) / 100.0;
        // device 705, IC IC122, analog/basic/nmos_resistor_amplifier.hpp:29
        I(Vss, cpphdl_n1208) <+ V(Vss, cpphdl_n1208) / 300.0;
        // device 706, IC IC122, analog/basic/nmos_resistor_amplifier.hpp:30
        I(cpphdl_n1212, Vdd) <+ 2.9999999999999998e-13 * ddt(V(cpphdl_n1212, Vdd)); // Bench initial voltage = 0.0 V.
        // device 707, IC IC122, analog/basic/nmos_resistor_amplifier.hpp:31
        I(cpphdl_n1211, Vdd) <+ 2.9999999999999998e-13 * ddt(V(cpphdl_n1211, Vdd)); // Bench initial voltage = 0.0 V.
        // device 708, IC IC122, analog/basic/nmos_resistor_amplifier.hpp:32
        I(cpphdl_n1208, Vss) <+ 4e-14 * ddt(V(cpphdl_n1208, Vss)); // Bench initial voltage = 0.0 V.
        // device 709, IC IC122, analog/basic/nmos_resistor_amplifier.hpp:34
        I(cpphdl_n1202, cpphdl_n1206) <+ 2e-14 * ddt(V(cpphdl_n1202, cpphdl_n1206)); // Bench initial voltage = 0.0 V.
        // device 710, IC IC122, analog/basic/nmos_resistor_amplifier.hpp:35
        I(cpphdl_n1203, cpphdl_n1207) <+ 2e-14 * ddt(V(cpphdl_n1203, cpphdl_n1207)); // Bench initial voltage = 0.0 V.
        // device 711, IC IC122, analog/basic/nmos_resistor_amplifier.hpp:36
        I(cpphdl_n1202, cpphdl_n1212) <+ 2.9999999999999998e-15 * ddt(V(cpphdl_n1202, cpphdl_n1212)); // Bench initial voltage = 0.0 V.
        // device 712, IC IC122, analog/basic/nmos_resistor_amplifier.hpp:37
        I(cpphdl_n1203, cpphdl_n1211) <+ 2.9999999999999998e-15 * ddt(V(cpphdl_n1203, cpphdl_n1211)); // Bench initial voltage = 0.0 V.
        // device 713, IC IC123, analog/basic/strongarm_comparator.hpp:28
        I(cpphdl_n1216, cpphdl_n1218) <+ cpphdl_channel(V(cpphdl_n1211, cpphdl_n1218), V(cpphdl_n1216, cpphdl_n1218), 0.0080000000000000002, 0.69999999999999996, 1.0);
        // device 714, IC IC123, analog/basic/strongarm_comparator.hpp:29
        I(cpphdl_n1217, cpphdl_n1218) <+ cpphdl_channel(V(cpphdl_n1212, cpphdl_n1218), V(cpphdl_n1217, cpphdl_n1218), 0.0080000000000000002, 0.69999999999999996, 1.0);
        // device 715, IC IC123, analog/basic/strongarm_comparator.hpp:30
        I(cpphdl_n1218, Vss) <+ cpphdl_channel(V(EVALUATE, Vss), V(cpphdl_n1218, Vss), 0.0080000000000000002, 0.69999999999999996, 1.0);
        // device 716, IC IC123, analog/basic/strongarm_comparator.hpp:33
        I(cpphdl_n1231, cpphdl_n1216) <+ cpphdl_channel(V(cpphdl_n1235, cpphdl_n1216), V(cpphdl_n1231, cpphdl_n1216), 0.0040000000000000001, 0.69999999999999996, 1.0);
        // device 717, IC IC123, analog/basic/strongarm_comparator.hpp:34
        I(cpphdl_n1235, cpphdl_n1217) <+ cpphdl_channel(V(cpphdl_n1231, cpphdl_n1217), V(cpphdl_n1235, cpphdl_n1217), 0.0040000000000000001, 0.69999999999999996, 1.0);
        // device 718, IC IC123, analog/basic/strongarm_comparator.hpp:35
        I(cpphdl_n1235, Vdd) <+ cpphdl_channel(V(cpphdl_n1231, Vdd), V(cpphdl_n1235, Vdd), 0.002, 0.69999999999999996, -1.0);
        // device 719, IC IC123, analog/basic/strongarm_comparator.hpp:36
        I(cpphdl_n1231, Vdd) <+ cpphdl_channel(V(cpphdl_n1235, Vdd), V(cpphdl_n1231, Vdd), 0.002, 0.69999999999999996, -1.0);
        // device 720, IC IC123, analog/basic/strongarm_comparator.hpp:38
        I(cpphdl_n1216, Vdd) <+ cpphdl_channel(V(EVALUATE, Vdd), V(cpphdl_n1216, Vdd), 0.002, 0.69999999999999996, -1.0);
        // device 721, IC IC123, analog/basic/strongarm_comparator.hpp:39
        I(cpphdl_n1217, Vdd) <+ cpphdl_channel(V(EVALUATE, Vdd), V(cpphdl_n1217, Vdd), 0.002, 0.69999999999999996, -1.0);
        // device 722, IC IC123, analog/basic/strongarm_comparator.hpp:40
        I(cpphdl_n1235, Vdd) <+ cpphdl_channel(V(EVALUATE, Vdd), V(cpphdl_n1235, Vdd), 0.002, 0.69999999999999996, -1.0);
        // device 723, IC IC123, analog/basic/strongarm_comparator.hpp:41
        I(cpphdl_n1231, Vdd) <+ cpphdl_channel(V(EVALUATE, Vdd), V(cpphdl_n1231, Vdd), 0.002, 0.69999999999999996, -1.0);
        // device 724, IC IC123, analog/basic/strongarm_comparator.hpp:42
        I(cpphdl_n1216, Vss) <+ 2.9999999999999998e-14 * ddt(V(cpphdl_n1216, Vss)); // Bench initial voltage = 0.0 V.
        // device 725, IC IC123, analog/basic/strongarm_comparator.hpp:43
        I(cpphdl_n1217, Vss) <+ 2.9999999999999998e-14 * ddt(V(cpphdl_n1217, Vss)); // Bench initial voltage = 0.0 V.
        // device 726, IC IC123, analog/basic/strongarm_comparator.hpp:44
        I(cpphdl_n1218, Vss) <+ 2.9999999999999998e-14 * ddt(V(cpphdl_n1218, Vss)); // Bench initial voltage = 0.0 V.
        // device 727, IC IC123, analog/basic/strongarm_comparator.hpp:45
        I(cpphdl_n1235, Vss) <+ 5.0000000000000002e-14 * ddt(V(cpphdl_n1235, Vss)); // Bench initial voltage = 0.0 V.
        // device 728, IC IC123, analog/basic/strongarm_comparator.hpp:46
        I(cpphdl_n1231, Vss) <+ 5.0000000000000002e-14 * ddt(V(cpphdl_n1231, Vss)); // Bench initial voltage = 0.0 V.
        // device 729, IC IC123, analog/basic/strongarm_comparator.hpp:47
        I(cpphdl_n1211, cpphdl_n1218) <+ 2e-14 * ddt(V(cpphdl_n1211, cpphdl_n1218)); // Bench initial voltage = 0.0 V.
        // device 730, IC IC123, analog/basic/strongarm_comparator.hpp:48
        I(cpphdl_n1212, cpphdl_n1218) <+ 2e-14 * ddt(V(cpphdl_n1212, cpphdl_n1218)); // Bench initial voltage = 0.0 V.
        // device 731, IC IC123, analog/basic/strongarm_comparator.hpp:49
        I(cpphdl_n1211, cpphdl_n1216) <+ 2.9999999999999998e-15 * ddt(V(cpphdl_n1211, cpphdl_n1216)); // Bench initial voltage = 0.0 V.
        // device 732, IC IC123, analog/basic/strongarm_comparator.hpp:50
        I(cpphdl_n1212, cpphdl_n1217) <+ 2.9999999999999998e-15 * ddt(V(cpphdl_n1212, cpphdl_n1217)); // Bench initial voltage = 0.0 V.
        // device 733, IC IC125, analog/basic/inverter.hpp:11
        I(cpphdl_n1239, Vdd) <+ cpphdl_channel(V(cpphdl_n1231, Vdd), V(cpphdl_n1239, Vdd), 0.001, 0.69999999999999996, -1.0);
        // device 734, IC IC125, analog/basic/inverter.hpp:12
        I(cpphdl_n1239, Vss) <+ cpphdl_channel(V(cpphdl_n1231, Vss), V(cpphdl_n1239, Vss), 0.001, 0.69999999999999996, 1.0);
        // device 735, IC IC127, analog/basic/inverter.hpp:11
        I(cpphdl_n1253, Vdd) <+ cpphdl_channel(V(cpphdl_n1239, Vdd), V(cpphdl_n1253, Vdd), 0.0040000000000000001, 0.69999999999999996, -1.0);
        // device 736, IC IC127, analog/basic/inverter.hpp:12
        I(cpphdl_n1253, Vss) <+ cpphdl_channel(V(cpphdl_n1239, Vss), V(cpphdl_n1253, Vss), 0.0040000000000000001, 0.69999999999999996, 1.0);
        // device 737, IC IC124, analog/basic/buffered_nand_latch.hpp:34
        I(cpphdl_n1231, Vss) <+ 2.0000000000000002e-15 * ddt(V(cpphdl_n1231, Vss)); // Bench initial voltage = 0.0 V.
        // device 738, IC IC124, analog/basic/buffered_nand_latch.hpp:35
        I(cpphdl_n1231, cpphdl_n1239) <+ 1.0000000000000001e-15 * ddt(V(cpphdl_n1231, cpphdl_n1239)); // Bench initial voltage = 0.0 V.
        // device 739, IC IC124, analog/basic/buffered_nand_latch.hpp:36
        I(cpphdl_n1239, Vss) <+ 5e-15 * ddt(V(cpphdl_n1239, Vss)); // Bench initial voltage = 0.0 V.
        // device 740, IC IC124, analog/basic/buffered_nand_latch.hpp:37
        I(cpphdl_n1239, Vss) <+ 8.0000000000000006e-15 * ddt(V(cpphdl_n1239, Vss)); // Bench initial voltage = 0.0 V.
        // device 741, IC IC124, analog/basic/buffered_nand_latch.hpp:38
        I(cpphdl_n1253, Vss) <+ 1e-14 * ddt(V(cpphdl_n1253, Vss)); // Bench initial voltage = 0.0 V.
        // device 742, IC IC126, analog/basic/inverter.hpp:11
        I(cpphdl_n1243, Vdd) <+ cpphdl_channel(V(cpphdl_n1235, Vdd), V(cpphdl_n1243, Vdd), 0.001, 0.69999999999999996, -1.0);
        // device 743, IC IC126, analog/basic/inverter.hpp:12
        I(cpphdl_n1243, Vss) <+ cpphdl_channel(V(cpphdl_n1235, Vss), V(cpphdl_n1243, Vss), 0.001, 0.69999999999999996, 1.0);
        // device 744, IC IC128, analog/basic/inverter.hpp:11
        I(cpphdl_n1259, Vdd) <+ cpphdl_channel(V(cpphdl_n1243, Vdd), V(cpphdl_n1259, Vdd), 0.0040000000000000001, 0.69999999999999996, -1.0);
        // device 745, IC IC128, analog/basic/inverter.hpp:12
        I(cpphdl_n1259, Vss) <+ cpphdl_channel(V(cpphdl_n1243, Vss), V(cpphdl_n1259, Vss), 0.0040000000000000001, 0.69999999999999996, 1.0);
        // device 746, IC IC124, analog/basic/buffered_nand_latch.hpp:34
        I(cpphdl_n1235, Vss) <+ 2.0000000000000002e-15 * ddt(V(cpphdl_n1235, Vss)); // Bench initial voltage = 0.0 V.
        // device 747, IC IC124, analog/basic/buffered_nand_latch.hpp:35
        I(cpphdl_n1235, cpphdl_n1243) <+ 1.0000000000000001e-15 * ddt(V(cpphdl_n1235, cpphdl_n1243)); // Bench initial voltage = 0.0 V.
        // device 748, IC IC124, analog/basic/buffered_nand_latch.hpp:36
        I(cpphdl_n1243, Vss) <+ 5e-15 * ddt(V(cpphdl_n1243, Vss)); // Bench initial voltage = 0.0 V.
        // device 749, IC IC124, analog/basic/buffered_nand_latch.hpp:37
        I(cpphdl_n1243, Vss) <+ 8.0000000000000006e-15 * ddt(V(cpphdl_n1243, Vss)); // Bench initial voltage = 0.0 V.
        // device 750, IC IC124, analog/basic/buffered_nand_latch.hpp:38
        I(cpphdl_n1259, Vss) <+ 1e-14 * ddt(V(cpphdl_n1259, Vss)); // Bench initial voltage = 0.0 V.
        // device 751, IC IC130, analog/basic/cmos_logic.hpp:17
        I(cpphdl_n2448, Vss) <+ 5.0000000000000002e-14 * ddt(V(cpphdl_n2448, Vss)); // Bench initial voltage = 0.0 V.
        // device 752, IC IC130, analog/basic/cmos_logic.hpp:18
        I(cpphdl_n2448, Vdd) <+ cpphdl_channel(V(cpphdl_n1253, Vdd), V(cpphdl_n2448, Vdd), 0.01, 0.69999999999999996, -1.0);
        // device 753, IC IC130, analog/basic/cmos_logic.hpp:19
        I(cpphdl_n2448, Vdd) <+ cpphdl_channel(V(cpphdl_n1261, Vdd), V(cpphdl_n2448, Vdd), 0.01, 0.69999999999999996, -1.0);
        // device 754, IC IC130, analog/basic/cmos_logic.hpp:20
        I(cpphdl_n2448, cpphdl_n1256) <+ cpphdl_channel(V(cpphdl_n1253, cpphdl_n1256), V(cpphdl_n2448, cpphdl_n1256), 0.01, 0.69999999999999996, 1.0);
        // device 755, IC IC130, analog/basic/cmos_logic.hpp:21
        I(cpphdl_n1256, Vss) <+ cpphdl_channel(V(cpphdl_n1261, Vss), V(cpphdl_n1256, Vss), 0.01, 0.69999999999999996, 1.0);
        // device 756, IC IC130, analog/basic/cmos_logic.hpp:27
        I(cpphdl_n1256, Vss) <+ 1e-14 * ddt(V(cpphdl_n1256, Vss)); // Bench initial voltage = 0.0 V.
        // device 757, IC IC131, analog/basic/cmos_logic.hpp:17
        I(cpphdl_n1261, Vss) <+ 5.0000000000000002e-14 * ddt(V(cpphdl_n1261, Vss)); // Bench initial voltage = 0.0 V.
        // device 758, IC IC131, analog/basic/cmos_logic.hpp:18
        I(cpphdl_n1261, Vdd) <+ cpphdl_channel(V(cpphdl_n1259, Vdd), V(cpphdl_n1261, Vdd), 0.01, 0.69999999999999996, -1.0);
        // device 759, IC IC131, analog/basic/cmos_logic.hpp:19
        I(cpphdl_n1261, Vdd) <+ cpphdl_channel(V(cpphdl_n2448, Vdd), V(cpphdl_n1261, Vdd), 0.01, 0.69999999999999996, -1.0);
        // device 760, IC IC131, analog/basic/cmos_logic.hpp:20
        I(cpphdl_n1261, cpphdl_n1262) <+ cpphdl_channel(V(cpphdl_n1259, cpphdl_n1262), V(cpphdl_n1261, cpphdl_n1262), 0.01, 0.69999999999999996, 1.0);
        // device 761, IC IC131, analog/basic/cmos_logic.hpp:21
        I(cpphdl_n1262, Vss) <+ cpphdl_channel(V(cpphdl_n2448, Vss), V(cpphdl_n1262, Vss), 0.01, 0.69999999999999996, 1.0);
        // device 762, IC IC131, analog/basic/cmos_logic.hpp:27
        I(cpphdl_n1262, Vss) <+ 1e-14 * ddt(V(cpphdl_n1262, Vss)); // Bench initial voltage = 0.0 V.
        // device 763, IC IC129, analog/basic/nand_latch.hpp:36
        I(cpphdl_n1253, Vss) <+ 2.9999999999999998e-15 * ddt(V(cpphdl_n1253, Vss)); // Bench initial voltage = 0.0 V.
        // device 764, IC IC129, analog/basic/nand_latch.hpp:37
        I(cpphdl_n1259, Vss) <+ 2.9999999999999998e-15 * ddt(V(cpphdl_n1259, Vss)); // Bench initial voltage = 0.0 V.
        // device 765, IC IC132, analog/basic/inverter.hpp:11
        I(cpphdl_n1267, Vdd) <+ cpphdl_channel(V(CLEAR, Vdd), V(cpphdl_n1267, Vdd), 0.01, 0.69999999999999996, -1.0);
        // device 766, IC IC132, analog/basic/inverter.hpp:12
        I(cpphdl_n1267, Vss) <+ cpphdl_channel(V(CLEAR, Vss), V(cpphdl_n1267, Vss), 0.01, 0.69999999999999996, 1.0);
        // device 767, IC IC129, analog/basic/nand_latch.hpp:58
        I(cpphdl_n1267, Vss) <+ 2.9999999999999998e-15 * ddt(V(cpphdl_n1267, Vss)); // Bench initial voltage = 0.0 V.
        // device 768, IC IC129, analog/basic/nand_latch.hpp:59
        I(cpphdl_n2448, Vss) <+ cpphdl_channel(V(CLEAR, Vss), V(cpphdl_n2448, Vss), 0.050000000000000003, 0.69999999999999996, 1.0);
        // device 769, IC IC129, analog/basic/nand_latch.hpp:60
        I(cpphdl_n1261, Vdd) <+ cpphdl_channel(V(cpphdl_n1267, Vdd), V(cpphdl_n1261, Vdd), 0.050000000000000003, 0.69999999999999996, -1.0);
        // device 770, IC IC135, analog/basic/inverter.hpp:11
        I(cpphdl_n1291, Vdd) <+ cpphdl_channel(V(TRACK5, Vdd), V(cpphdl_n1291, Vdd), 0.0040000000000000001, 0.69999999999999996, -1.0);
        // device 771, IC IC135, analog/basic/inverter.hpp:12
        I(cpphdl_n1291, Vss) <+ cpphdl_channel(V(TRACK5, Vss), V(cpphdl_n1291, Vss), 0.0040000000000000001, 0.69999999999999996, 1.0);
        // device 772, IC IC134, analog/basic/mos_track_hold.hpp:31
        I(cpphdl_n1291, Vss) <+ 2e-14 * ddt(V(cpphdl_n1291, Vss)); // Bench initial voltage = 0.0 V.
        // device 773, IC IC134, analog/basic/mos_track_hold.hpp:32
        I(cpphdl_n2286, cpphdl_n1345) <+ cpphdl_channel(V(TRACK5, cpphdl_n1345), V(cpphdl_n2286, cpphdl_n1345), 0.029999999999999999, 0.69999999999999996, 1.0);
        // device 774, IC IC134, analog/basic/mos_track_hold.hpp:33
        I(cpphdl_n1345, cpphdl_n2286) <+ cpphdl_channel(V(cpphdl_n1291, cpphdl_n2286), V(cpphdl_n1345, cpphdl_n2286), 0.014999999999999999, 0.69999999999999996, -1.0);
        // device 775, IC IC134, analog/basic/mos_track_hold.hpp:37
        I(cpphdl_n1345, cpphdl_n1345) <+ cpphdl_channel(V(cpphdl_n1291, cpphdl_n1345), V(cpphdl_n1345, cpphdl_n1345), 0.016, 0.69999999999999996, 1.0);
        // device 776, IC IC134, analog/basic/mos_track_hold.hpp:38
        I(cpphdl_n1345, cpphdl_n1345) <+ cpphdl_channel(V(TRACK5, cpphdl_n1345), V(cpphdl_n1345, cpphdl_n1345), 0.0083999999999999995, 0.69999999999999996, -1.0);
        // device 777, IC IC134, analog/basic/mos_track_hold.hpp:39
        I(cpphdl_n1345, Vss) <+ 1.5000000000000001e-12 * ddt(V(cpphdl_n1345, Vss)); // Bench initial voltage = 0.0 V.
        // device 778, IC IC134, analog/basic/mos_track_hold.hpp:42
        I(TRACK5, cpphdl_n1345) <+ 2.0000000000000002e-15 * ddt(V(TRACK5, cpphdl_n1345)); // Bench initial voltage = -0.0 V.
        // device 779, IC IC134, analog/basic/mos_track_hold.hpp:43
        I(cpphdl_n1291, cpphdl_n1345) <+ 2.0000000000000002e-15 * ddt(V(cpphdl_n1291, cpphdl_n1345)); // Bench initial voltage = 0.0 V.
        // device 780, IC IC134, analog/basic/mos_track_hold.hpp:44
        I(cpphdl_n2286, cpphdl_n1345) <+ 1.0000000000000001e-15 * ddt(V(cpphdl_n2286, cpphdl_n1345)); // Bench initial voltage = 0.0 V.
        // device 781, IC IC137, analog/basic/inverter.hpp:11
        I(cpphdl_n1306, Vdd) <+ cpphdl_channel(V(BIT_N5_0, Vdd), V(cpphdl_n1306, Vdd), 0.080000000000000002, 0.69999999999999996, -1.0);
        // device 782, IC IC137, analog/basic/inverter.hpp:12
        I(cpphdl_n1306, Vss) <+ cpphdl_channel(V(BIT_N5_0, Vss), V(cpphdl_n1306, Vss), 0.080000000000000002, 0.69999999999999996, 1.0);
        // device 783, IC IC136, analog/basic/mos_r2r_dac.hpp:27
        I(cpphdl_n1306, Vss) <+ 2.9999999999999998e-15 * ddt(V(cpphdl_n1306, Vss)); // Bench initial voltage = 0.0 V.
        // device 784, IC IC136, analog/basic/mos_r2r_dac.hpp:28
        I(cpphdl_n1306, cpphdl_n1335) <+ V(cpphdl_n1306, cpphdl_n1335) / 2000.0;
        // device 785, IC IC136, analog/basic/mos_r2r_dac.hpp:29
        I(cpphdl_n1335, Vss) <+ 2.9999999999999998e-15 * ddt(V(cpphdl_n1335, Vss)); // Bench initial voltage = 0.0 V.
        // device 786, IC IC138, analog/basic/inverter.hpp:11
        I(cpphdl_n1310, Vdd) <+ cpphdl_channel(V(BIT_N5_1, Vdd), V(cpphdl_n1310, Vdd), 0.080000000000000002, 0.69999999999999996, -1.0);
        // device 787, IC IC138, analog/basic/inverter.hpp:12
        I(cpphdl_n1310, Vss) <+ cpphdl_channel(V(BIT_N5_1, Vss), V(cpphdl_n1310, Vss), 0.080000000000000002, 0.69999999999999996, 1.0);
        // device 788, IC IC136, analog/basic/mos_r2r_dac.hpp:27
        I(cpphdl_n1310, Vss) <+ 2.9999999999999998e-15 * ddt(V(cpphdl_n1310, Vss)); // Bench initial voltage = 0.0 V.
        // device 789, IC IC136, analog/basic/mos_r2r_dac.hpp:28
        I(cpphdl_n1310, cpphdl_n1336) <+ V(cpphdl_n1310, cpphdl_n1336) / 2000.0;
        // device 790, IC IC136, analog/basic/mos_r2r_dac.hpp:29
        I(cpphdl_n1336, Vss) <+ 2.9999999999999998e-15 * ddt(V(cpphdl_n1336, Vss)); // Bench initial voltage = 0.0 V.
        // device 791, IC IC136, analog/basic/mos_r2r_dac.hpp:31
        I(cpphdl_n1335, cpphdl_n1336) <+ V(cpphdl_n1335, cpphdl_n1336) / 1000.0;
        // device 792, IC IC139, analog/basic/inverter.hpp:11
        I(cpphdl_n1314, Vdd) <+ cpphdl_channel(V(BIT_N5_2, Vdd), V(cpphdl_n1314, Vdd), 0.080000000000000002, 0.69999999999999996, -1.0);
        // device 793, IC IC139, analog/basic/inverter.hpp:12
        I(cpphdl_n1314, Vss) <+ cpphdl_channel(V(BIT_N5_2, Vss), V(cpphdl_n1314, Vss), 0.080000000000000002, 0.69999999999999996, 1.0);
        // device 794, IC IC136, analog/basic/mos_r2r_dac.hpp:27
        I(cpphdl_n1314, Vss) <+ 2.9999999999999998e-15 * ddt(V(cpphdl_n1314, Vss)); // Bench initial voltage = 0.0 V.
        // device 795, IC IC136, analog/basic/mos_r2r_dac.hpp:28
        I(cpphdl_n1314, cpphdl_n1337) <+ V(cpphdl_n1314, cpphdl_n1337) / 2000.0;
        // device 796, IC IC136, analog/basic/mos_r2r_dac.hpp:29
        I(cpphdl_n1337, Vss) <+ 2.9999999999999998e-15 * ddt(V(cpphdl_n1337, Vss)); // Bench initial voltage = 0.0 V.
        // device 797, IC IC136, analog/basic/mos_r2r_dac.hpp:31
        I(cpphdl_n1336, cpphdl_n1337) <+ V(cpphdl_n1336, cpphdl_n1337) / 1000.0;
        // device 798, IC IC140, analog/basic/inverter.hpp:11
        I(cpphdl_n1318, Vdd) <+ cpphdl_channel(V(BIT_N5_3, Vdd), V(cpphdl_n1318, Vdd), 0.080000000000000002, 0.69999999999999996, -1.0);
        // device 799, IC IC140, analog/basic/inverter.hpp:12
        I(cpphdl_n1318, Vss) <+ cpphdl_channel(V(BIT_N5_3, Vss), V(cpphdl_n1318, Vss), 0.080000000000000002, 0.69999999999999996, 1.0);
        // device 800, IC IC136, analog/basic/mos_r2r_dac.hpp:27
        I(cpphdl_n1318, Vss) <+ 2.9999999999999998e-15 * ddt(V(cpphdl_n1318, Vss)); // Bench initial voltage = 0.0 V.
        // device 801, IC IC136, analog/basic/mos_r2r_dac.hpp:28
        I(cpphdl_n1318, cpphdl_n1338) <+ V(cpphdl_n1318, cpphdl_n1338) / 2000.0;
        // device 802, IC IC136, analog/basic/mos_r2r_dac.hpp:29
        I(cpphdl_n1338, Vss) <+ 2.9999999999999998e-15 * ddt(V(cpphdl_n1338, Vss)); // Bench initial voltage = 0.0 V.
        // device 803, IC IC136, analog/basic/mos_r2r_dac.hpp:31
        I(cpphdl_n1337, cpphdl_n1338) <+ V(cpphdl_n1337, cpphdl_n1338) / 1000.0;
        // device 804, IC IC141, analog/basic/inverter.hpp:11
        I(cpphdl_n1322, Vdd) <+ cpphdl_channel(V(BIT_N5_4, Vdd), V(cpphdl_n1322, Vdd), 0.080000000000000002, 0.69999999999999996, -1.0);
        // device 805, IC IC141, analog/basic/inverter.hpp:12
        I(cpphdl_n1322, Vss) <+ cpphdl_channel(V(BIT_N5_4, Vss), V(cpphdl_n1322, Vss), 0.080000000000000002, 0.69999999999999996, 1.0);
        // device 806, IC IC136, analog/basic/mos_r2r_dac.hpp:27
        I(cpphdl_n1322, Vss) <+ 2.9999999999999998e-15 * ddt(V(cpphdl_n1322, Vss)); // Bench initial voltage = 0.0 V.
        // device 807, IC IC136, analog/basic/mos_r2r_dac.hpp:28
        I(cpphdl_n1322, cpphdl_n1339) <+ V(cpphdl_n1322, cpphdl_n1339) / 2000.0;
        // device 808, IC IC136, analog/basic/mos_r2r_dac.hpp:29
        I(cpphdl_n1339, Vss) <+ 2.9999999999999998e-15 * ddt(V(cpphdl_n1339, Vss)); // Bench initial voltage = 0.0 V.
        // device 809, IC IC136, analog/basic/mos_r2r_dac.hpp:31
        I(cpphdl_n1338, cpphdl_n1339) <+ V(cpphdl_n1338, cpphdl_n1339) / 1000.0;
        // device 810, IC IC142, analog/basic/inverter.hpp:11
        I(cpphdl_n1326, Vdd) <+ cpphdl_channel(V(BIT_N5_5, Vdd), V(cpphdl_n1326, Vdd), 0.080000000000000002, 0.69999999999999996, -1.0);
        // device 811, IC IC142, analog/basic/inverter.hpp:12
        I(cpphdl_n1326, Vss) <+ cpphdl_channel(V(BIT_N5_5, Vss), V(cpphdl_n1326, Vss), 0.080000000000000002, 0.69999999999999996, 1.0);
        // device 812, IC IC136, analog/basic/mos_r2r_dac.hpp:27
        I(cpphdl_n1326, Vss) <+ 2.9999999999999998e-15 * ddt(V(cpphdl_n1326, Vss)); // Bench initial voltage = 0.0 V.
        // device 813, IC IC136, analog/basic/mos_r2r_dac.hpp:28
        I(cpphdl_n1326, cpphdl_n1340) <+ V(cpphdl_n1326, cpphdl_n1340) / 2000.0;
        // device 814, IC IC136, analog/basic/mos_r2r_dac.hpp:29
        I(cpphdl_n1340, Vss) <+ 2.9999999999999998e-15 * ddt(V(cpphdl_n1340, Vss)); // Bench initial voltage = 0.0 V.
        // device 815, IC IC136, analog/basic/mos_r2r_dac.hpp:31
        I(cpphdl_n1339, cpphdl_n1340) <+ V(cpphdl_n1339, cpphdl_n1340) / 1000.0;
        // device 816, IC IC143, analog/basic/inverter.hpp:11
        I(cpphdl_n1330, Vdd) <+ cpphdl_channel(V(BIT_N5_6, Vdd), V(cpphdl_n1330, Vdd), 0.080000000000000002, 0.69999999999999996, -1.0);
        // device 817, IC IC143, analog/basic/inverter.hpp:12
        I(cpphdl_n1330, Vss) <+ cpphdl_channel(V(BIT_N5_6, Vss), V(cpphdl_n1330, Vss), 0.080000000000000002, 0.69999999999999996, 1.0);
        // device 818, IC IC136, analog/basic/mos_r2r_dac.hpp:27
        I(cpphdl_n1330, Vss) <+ 2.9999999999999998e-15 * ddt(V(cpphdl_n1330, Vss)); // Bench initial voltage = 0.0 V.
        // device 819, IC IC136, analog/basic/mos_r2r_dac.hpp:28
        I(cpphdl_n1330, cpphdl_n1341) <+ V(cpphdl_n1330, cpphdl_n1341) / 2000.0;
        // device 820, IC IC136, analog/basic/mos_r2r_dac.hpp:29
        I(cpphdl_n1341, Vss) <+ 2.9999999999999998e-15 * ddt(V(cpphdl_n1341, Vss)); // Bench initial voltage = 0.0 V.
        // device 821, IC IC136, analog/basic/mos_r2r_dac.hpp:31
        I(cpphdl_n1340, cpphdl_n1341) <+ V(cpphdl_n1340, cpphdl_n1341) / 1000.0;
        // device 822, IC IC144, analog/basic/inverter.hpp:11
        I(cpphdl_n1334, Vdd) <+ cpphdl_channel(V(BIT_N5_7, Vdd), V(cpphdl_n1334, Vdd), 0.080000000000000002, 0.69999999999999996, -1.0);
        // device 823, IC IC144, analog/basic/inverter.hpp:12
        I(cpphdl_n1334, Vss) <+ cpphdl_channel(V(BIT_N5_7, Vss), V(cpphdl_n1334, Vss), 0.080000000000000002, 0.69999999999999996, 1.0);
        // device 824, IC IC136, analog/basic/mos_r2r_dac.hpp:27
        I(cpphdl_n1334, Vss) <+ 2.9999999999999998e-15 * ddt(V(cpphdl_n1334, Vss)); // Bench initial voltage = 0.0 V.
        // device 825, IC IC136, analog/basic/mos_r2r_dac.hpp:28
        I(cpphdl_n1334, cpphdl_n1346) <+ V(cpphdl_n1334, cpphdl_n1346) / 2000.0;
        // device 826, IC IC136, analog/basic/mos_r2r_dac.hpp:29
        I(cpphdl_n1346, Vss) <+ 2.9999999999999998e-15 * ddt(V(cpphdl_n1346, Vss)); // Bench initial voltage = 0.0 V.
        // device 827, IC IC136, analog/basic/mos_r2r_dac.hpp:31
        I(cpphdl_n1341, cpphdl_n1346) <+ V(cpphdl_n1341, cpphdl_n1346) / 1000.0;
        // device 828, IC IC136, analog/basic/mos_r2r_dac.hpp:33
        I(Vss, cpphdl_n1335) <+ V(Vss, cpphdl_n1335) / 2000.0;
        // device 829, IC IC145, analog/basic/nmos_resistor_amplifier.hpp:23
        I(Vdd, cpphdl_n1355) <+ V(Vdd, cpphdl_n1355) / 1000.0;
        // device 830, IC IC145, analog/basic/nmos_resistor_amplifier.hpp:24
        I(Vdd, cpphdl_n1354) <+ V(Vdd, cpphdl_n1354) / 1000.0;
        // device 831, IC IC145, analog/basic/nmos_resistor_amplifier.hpp:25
        I(cpphdl_n1355, cpphdl_n1349) <+ cpphdl_channel(V(cpphdl_n1345, cpphdl_n1349), V(cpphdl_n1355, cpphdl_n1349), 0.0074999999999999997, 0.69999999999999996, 1.0);
        // device 832, IC IC145, analog/basic/nmos_resistor_amplifier.hpp:26
        I(cpphdl_n1354, cpphdl_n1350) <+ cpphdl_channel(V(cpphdl_n1346, cpphdl_n1350), V(cpphdl_n1354, cpphdl_n1350), 0.0074999999999999997, 0.69999999999999996, 1.0);
        // device 833, IC IC145, analog/basic/nmos_resistor_amplifier.hpp:27
        I(cpphdl_n1351, cpphdl_n1349) <+ V(cpphdl_n1351, cpphdl_n1349) / 100.0;
        // device 834, IC IC145, analog/basic/nmos_resistor_amplifier.hpp:28
        I(cpphdl_n1351, cpphdl_n1350) <+ V(cpphdl_n1351, cpphdl_n1350) / 100.0;
        // device 835, IC IC145, analog/basic/nmos_resistor_amplifier.hpp:29
        I(Vss, cpphdl_n1351) <+ V(Vss, cpphdl_n1351) / 300.0;
        // device 836, IC IC145, analog/basic/nmos_resistor_amplifier.hpp:30
        I(cpphdl_n1355, Vdd) <+ 2.9999999999999998e-13 * ddt(V(cpphdl_n1355, Vdd)); // Bench initial voltage = 0.0 V.
        // device 837, IC IC145, analog/basic/nmos_resistor_amplifier.hpp:31
        I(cpphdl_n1354, Vdd) <+ 2.9999999999999998e-13 * ddt(V(cpphdl_n1354, Vdd)); // Bench initial voltage = 0.0 V.
        // device 838, IC IC145, analog/basic/nmos_resistor_amplifier.hpp:32
        I(cpphdl_n1351, Vss) <+ 4e-14 * ddt(V(cpphdl_n1351, Vss)); // Bench initial voltage = 0.0 V.
        // device 839, IC IC145, analog/basic/nmos_resistor_amplifier.hpp:34
        I(cpphdl_n1345, cpphdl_n1349) <+ 2e-14 * ddt(V(cpphdl_n1345, cpphdl_n1349)); // Bench initial voltage = 0.0 V.
        // device 840, IC IC145, analog/basic/nmos_resistor_amplifier.hpp:35
        I(cpphdl_n1346, cpphdl_n1350) <+ 2e-14 * ddt(V(cpphdl_n1346, cpphdl_n1350)); // Bench initial voltage = 0.0 V.
        // device 841, IC IC145, analog/basic/nmos_resistor_amplifier.hpp:36
        I(cpphdl_n1345, cpphdl_n1355) <+ 2.9999999999999998e-15 * ddt(V(cpphdl_n1345, cpphdl_n1355)); // Bench initial voltage = 0.0 V.
        // device 842, IC IC145, analog/basic/nmos_resistor_amplifier.hpp:37
        I(cpphdl_n1346, cpphdl_n1354) <+ 2.9999999999999998e-15 * ddt(V(cpphdl_n1346, cpphdl_n1354)); // Bench initial voltage = 0.0 V.
        // device 843, IC IC146, analog/basic/strongarm_comparator.hpp:28
        I(cpphdl_n1359, cpphdl_n1361) <+ cpphdl_channel(V(cpphdl_n1354, cpphdl_n1361), V(cpphdl_n1359, cpphdl_n1361), 0.0080000000000000002, 0.69999999999999996, 1.0);
        // device 844, IC IC146, analog/basic/strongarm_comparator.hpp:29
        I(cpphdl_n1360, cpphdl_n1361) <+ cpphdl_channel(V(cpphdl_n1355, cpphdl_n1361), V(cpphdl_n1360, cpphdl_n1361), 0.0080000000000000002, 0.69999999999999996, 1.0);
        // device 845, IC IC146, analog/basic/strongarm_comparator.hpp:30
        I(cpphdl_n1361, Vss) <+ cpphdl_channel(V(EVALUATE, Vss), V(cpphdl_n1361, Vss), 0.0080000000000000002, 0.69999999999999996, 1.0);
        // device 846, IC IC146, analog/basic/strongarm_comparator.hpp:33
        I(cpphdl_n1374, cpphdl_n1359) <+ cpphdl_channel(V(cpphdl_n1378, cpphdl_n1359), V(cpphdl_n1374, cpphdl_n1359), 0.0040000000000000001, 0.69999999999999996, 1.0);
        // device 847, IC IC146, analog/basic/strongarm_comparator.hpp:34
        I(cpphdl_n1378, cpphdl_n1360) <+ cpphdl_channel(V(cpphdl_n1374, cpphdl_n1360), V(cpphdl_n1378, cpphdl_n1360), 0.0040000000000000001, 0.69999999999999996, 1.0);
        // device 848, IC IC146, analog/basic/strongarm_comparator.hpp:35
        I(cpphdl_n1378, Vdd) <+ cpphdl_channel(V(cpphdl_n1374, Vdd), V(cpphdl_n1378, Vdd), 0.002, 0.69999999999999996, -1.0);
        // device 849, IC IC146, analog/basic/strongarm_comparator.hpp:36
        I(cpphdl_n1374, Vdd) <+ cpphdl_channel(V(cpphdl_n1378, Vdd), V(cpphdl_n1374, Vdd), 0.002, 0.69999999999999996, -1.0);
        // device 850, IC IC146, analog/basic/strongarm_comparator.hpp:38
        I(cpphdl_n1359, Vdd) <+ cpphdl_channel(V(EVALUATE, Vdd), V(cpphdl_n1359, Vdd), 0.002, 0.69999999999999996, -1.0);
        // device 851, IC IC146, analog/basic/strongarm_comparator.hpp:39
        I(cpphdl_n1360, Vdd) <+ cpphdl_channel(V(EVALUATE, Vdd), V(cpphdl_n1360, Vdd), 0.002, 0.69999999999999996, -1.0);
        // device 852, IC IC146, analog/basic/strongarm_comparator.hpp:40
        I(cpphdl_n1378, Vdd) <+ cpphdl_channel(V(EVALUATE, Vdd), V(cpphdl_n1378, Vdd), 0.002, 0.69999999999999996, -1.0);
        // device 853, IC IC146, analog/basic/strongarm_comparator.hpp:41
        I(cpphdl_n1374, Vdd) <+ cpphdl_channel(V(EVALUATE, Vdd), V(cpphdl_n1374, Vdd), 0.002, 0.69999999999999996, -1.0);
        // device 854, IC IC146, analog/basic/strongarm_comparator.hpp:42
        I(cpphdl_n1359, Vss) <+ 2.9999999999999998e-14 * ddt(V(cpphdl_n1359, Vss)); // Bench initial voltage = 0.0 V.
        // device 855, IC IC146, analog/basic/strongarm_comparator.hpp:43
        I(cpphdl_n1360, Vss) <+ 2.9999999999999998e-14 * ddt(V(cpphdl_n1360, Vss)); // Bench initial voltage = 0.0 V.
        // device 856, IC IC146, analog/basic/strongarm_comparator.hpp:44
        I(cpphdl_n1361, Vss) <+ 2.9999999999999998e-14 * ddt(V(cpphdl_n1361, Vss)); // Bench initial voltage = 0.0 V.
        // device 857, IC IC146, analog/basic/strongarm_comparator.hpp:45
        I(cpphdl_n1378, Vss) <+ 5.0000000000000002e-14 * ddt(V(cpphdl_n1378, Vss)); // Bench initial voltage = 0.0 V.
        // device 858, IC IC146, analog/basic/strongarm_comparator.hpp:46
        I(cpphdl_n1374, Vss) <+ 5.0000000000000002e-14 * ddt(V(cpphdl_n1374, Vss)); // Bench initial voltage = 0.0 V.
        // device 859, IC IC146, analog/basic/strongarm_comparator.hpp:47
        I(cpphdl_n1354, cpphdl_n1361) <+ 2e-14 * ddt(V(cpphdl_n1354, cpphdl_n1361)); // Bench initial voltage = 0.0 V.
        // device 860, IC IC146, analog/basic/strongarm_comparator.hpp:48
        I(cpphdl_n1355, cpphdl_n1361) <+ 2e-14 * ddt(V(cpphdl_n1355, cpphdl_n1361)); // Bench initial voltage = 0.0 V.
        // device 861, IC IC146, analog/basic/strongarm_comparator.hpp:49
        I(cpphdl_n1354, cpphdl_n1359) <+ 2.9999999999999998e-15 * ddt(V(cpphdl_n1354, cpphdl_n1359)); // Bench initial voltage = 0.0 V.
        // device 862, IC IC146, analog/basic/strongarm_comparator.hpp:50
        I(cpphdl_n1355, cpphdl_n1360) <+ 2.9999999999999998e-15 * ddt(V(cpphdl_n1355, cpphdl_n1360)); // Bench initial voltage = 0.0 V.
        // device 863, IC IC148, analog/basic/inverter.hpp:11
        I(cpphdl_n1382, Vdd) <+ cpphdl_channel(V(cpphdl_n1374, Vdd), V(cpphdl_n1382, Vdd), 0.001, 0.69999999999999996, -1.0);
        // device 864, IC IC148, analog/basic/inverter.hpp:12
        I(cpphdl_n1382, Vss) <+ cpphdl_channel(V(cpphdl_n1374, Vss), V(cpphdl_n1382, Vss), 0.001, 0.69999999999999996, 1.0);
        // device 865, IC IC150, analog/basic/inverter.hpp:11
        I(cpphdl_n1396, Vdd) <+ cpphdl_channel(V(cpphdl_n1382, Vdd), V(cpphdl_n1396, Vdd), 0.0040000000000000001, 0.69999999999999996, -1.0);
        // device 866, IC IC150, analog/basic/inverter.hpp:12
        I(cpphdl_n1396, Vss) <+ cpphdl_channel(V(cpphdl_n1382, Vss), V(cpphdl_n1396, Vss), 0.0040000000000000001, 0.69999999999999996, 1.0);
        // device 867, IC IC147, analog/basic/buffered_nand_latch.hpp:34
        I(cpphdl_n1374, Vss) <+ 2.0000000000000002e-15 * ddt(V(cpphdl_n1374, Vss)); // Bench initial voltage = 0.0 V.
        // device 868, IC IC147, analog/basic/buffered_nand_latch.hpp:35
        I(cpphdl_n1374, cpphdl_n1382) <+ 1.0000000000000001e-15 * ddt(V(cpphdl_n1374, cpphdl_n1382)); // Bench initial voltage = 0.0 V.
        // device 869, IC IC147, analog/basic/buffered_nand_latch.hpp:36
        I(cpphdl_n1382, Vss) <+ 5e-15 * ddt(V(cpphdl_n1382, Vss)); // Bench initial voltage = 0.0 V.
        // device 870, IC IC147, analog/basic/buffered_nand_latch.hpp:37
        I(cpphdl_n1382, Vss) <+ 8.0000000000000006e-15 * ddt(V(cpphdl_n1382, Vss)); // Bench initial voltage = 0.0 V.
        // device 871, IC IC147, analog/basic/buffered_nand_latch.hpp:38
        I(cpphdl_n1396, Vss) <+ 1e-14 * ddt(V(cpphdl_n1396, Vss)); // Bench initial voltage = 0.0 V.
        // device 872, IC IC149, analog/basic/inverter.hpp:11
        I(cpphdl_n1386, Vdd) <+ cpphdl_channel(V(cpphdl_n1378, Vdd), V(cpphdl_n1386, Vdd), 0.001, 0.69999999999999996, -1.0);
        // device 873, IC IC149, analog/basic/inverter.hpp:12
        I(cpphdl_n1386, Vss) <+ cpphdl_channel(V(cpphdl_n1378, Vss), V(cpphdl_n1386, Vss), 0.001, 0.69999999999999996, 1.0);
        // device 874, IC IC151, analog/basic/inverter.hpp:11
        I(cpphdl_n1402, Vdd) <+ cpphdl_channel(V(cpphdl_n1386, Vdd), V(cpphdl_n1402, Vdd), 0.0040000000000000001, 0.69999999999999996, -1.0);
        // device 875, IC IC151, analog/basic/inverter.hpp:12
        I(cpphdl_n1402, Vss) <+ cpphdl_channel(V(cpphdl_n1386, Vss), V(cpphdl_n1402, Vss), 0.0040000000000000001, 0.69999999999999996, 1.0);
        // device 876, IC IC147, analog/basic/buffered_nand_latch.hpp:34
        I(cpphdl_n1378, Vss) <+ 2.0000000000000002e-15 * ddt(V(cpphdl_n1378, Vss)); // Bench initial voltage = 0.0 V.
        // device 877, IC IC147, analog/basic/buffered_nand_latch.hpp:35
        I(cpphdl_n1378, cpphdl_n1386) <+ 1.0000000000000001e-15 * ddt(V(cpphdl_n1378, cpphdl_n1386)); // Bench initial voltage = 0.0 V.
        // device 878, IC IC147, analog/basic/buffered_nand_latch.hpp:36
        I(cpphdl_n1386, Vss) <+ 5e-15 * ddt(V(cpphdl_n1386, Vss)); // Bench initial voltage = 0.0 V.
        // device 879, IC IC147, analog/basic/buffered_nand_latch.hpp:37
        I(cpphdl_n1386, Vss) <+ 8.0000000000000006e-15 * ddt(V(cpphdl_n1386, Vss)); // Bench initial voltage = 0.0 V.
        // device 880, IC IC147, analog/basic/buffered_nand_latch.hpp:38
        I(cpphdl_n1402, Vss) <+ 1e-14 * ddt(V(cpphdl_n1402, Vss)); // Bench initial voltage = 0.0 V.
        // device 881, IC IC153, analog/basic/cmos_logic.hpp:17
        I(cpphdl_n2453, Vss) <+ 5.0000000000000002e-14 * ddt(V(cpphdl_n2453, Vss)); // Bench initial voltage = 0.0 V.
        // device 882, IC IC153, analog/basic/cmos_logic.hpp:18
        I(cpphdl_n2453, Vdd) <+ cpphdl_channel(V(cpphdl_n1396, Vdd), V(cpphdl_n2453, Vdd), 0.01, 0.69999999999999996, -1.0);
        // device 883, IC IC153, analog/basic/cmos_logic.hpp:19
        I(cpphdl_n2453, Vdd) <+ cpphdl_channel(V(cpphdl_n1404, Vdd), V(cpphdl_n2453, Vdd), 0.01, 0.69999999999999996, -1.0);
        // device 884, IC IC153, analog/basic/cmos_logic.hpp:20
        I(cpphdl_n2453, cpphdl_n1399) <+ cpphdl_channel(V(cpphdl_n1396, cpphdl_n1399), V(cpphdl_n2453, cpphdl_n1399), 0.01, 0.69999999999999996, 1.0);
        // device 885, IC IC153, analog/basic/cmos_logic.hpp:21
        I(cpphdl_n1399, Vss) <+ cpphdl_channel(V(cpphdl_n1404, Vss), V(cpphdl_n1399, Vss), 0.01, 0.69999999999999996, 1.0);
        // device 886, IC IC153, analog/basic/cmos_logic.hpp:27
        I(cpphdl_n1399, Vss) <+ 1e-14 * ddt(V(cpphdl_n1399, Vss)); // Bench initial voltage = 0.0 V.
        // device 887, IC IC154, analog/basic/cmos_logic.hpp:17
        I(cpphdl_n1404, Vss) <+ 5.0000000000000002e-14 * ddt(V(cpphdl_n1404, Vss)); // Bench initial voltage = 0.0 V.
        // device 888, IC IC154, analog/basic/cmos_logic.hpp:18
        I(cpphdl_n1404, Vdd) <+ cpphdl_channel(V(cpphdl_n1402, Vdd), V(cpphdl_n1404, Vdd), 0.01, 0.69999999999999996, -1.0);
        // device 889, IC IC154, analog/basic/cmos_logic.hpp:19
        I(cpphdl_n1404, Vdd) <+ cpphdl_channel(V(cpphdl_n2453, Vdd), V(cpphdl_n1404, Vdd), 0.01, 0.69999999999999996, -1.0);
        // device 890, IC IC154, analog/basic/cmos_logic.hpp:20
        I(cpphdl_n1404, cpphdl_n1405) <+ cpphdl_channel(V(cpphdl_n1402, cpphdl_n1405), V(cpphdl_n1404, cpphdl_n1405), 0.01, 0.69999999999999996, 1.0);
        // device 891, IC IC154, analog/basic/cmos_logic.hpp:21
        I(cpphdl_n1405, Vss) <+ cpphdl_channel(V(cpphdl_n2453, Vss), V(cpphdl_n1405, Vss), 0.01, 0.69999999999999996, 1.0);
        // device 892, IC IC154, analog/basic/cmos_logic.hpp:27
        I(cpphdl_n1405, Vss) <+ 1e-14 * ddt(V(cpphdl_n1405, Vss)); // Bench initial voltage = 0.0 V.
        // device 893, IC IC152, analog/basic/nand_latch.hpp:36
        I(cpphdl_n1396, Vss) <+ 2.9999999999999998e-15 * ddt(V(cpphdl_n1396, Vss)); // Bench initial voltage = 0.0 V.
        // device 894, IC IC152, analog/basic/nand_latch.hpp:37
        I(cpphdl_n1402, Vss) <+ 2.9999999999999998e-15 * ddt(V(cpphdl_n1402, Vss)); // Bench initial voltage = 0.0 V.
        // device 895, IC IC155, analog/basic/inverter.hpp:11
        I(cpphdl_n1410, Vdd) <+ cpphdl_channel(V(CLEAR, Vdd), V(cpphdl_n1410, Vdd), 0.01, 0.69999999999999996, -1.0);
        // device 896, IC IC155, analog/basic/inverter.hpp:12
        I(cpphdl_n1410, Vss) <+ cpphdl_channel(V(CLEAR, Vss), V(cpphdl_n1410, Vss), 0.01, 0.69999999999999996, 1.0);
        // device 897, IC IC152, analog/basic/nand_latch.hpp:58
        I(cpphdl_n1410, Vss) <+ 2.9999999999999998e-15 * ddt(V(cpphdl_n1410, Vss)); // Bench initial voltage = 0.0 V.
        // device 898, IC IC152, analog/basic/nand_latch.hpp:59
        I(cpphdl_n2453, Vss) <+ cpphdl_channel(V(CLEAR, Vss), V(cpphdl_n2453, Vss), 0.050000000000000003, 0.69999999999999996, 1.0);
        // device 899, IC IC152, analog/basic/nand_latch.hpp:60
        I(cpphdl_n1404, Vdd) <+ cpphdl_channel(V(cpphdl_n1410, Vdd), V(cpphdl_n1404, Vdd), 0.050000000000000003, 0.69999999999999996, -1.0);
        // device 900, IC IC158, analog/basic/inverter.hpp:11
        I(cpphdl_n1434, Vdd) <+ cpphdl_channel(V(TRACK6, Vdd), V(cpphdl_n1434, Vdd), 0.0040000000000000001, 0.69999999999999996, -1.0);
        // device 901, IC IC158, analog/basic/inverter.hpp:12
        I(cpphdl_n1434, Vss) <+ cpphdl_channel(V(TRACK6, Vss), V(cpphdl_n1434, Vss), 0.0040000000000000001, 0.69999999999999996, 1.0);
        // device 902, IC IC157, analog/basic/mos_track_hold.hpp:31
        I(cpphdl_n1434, Vss) <+ 2e-14 * ddt(V(cpphdl_n1434, Vss)); // Bench initial voltage = 0.0 V.
        // device 903, IC IC157, analog/basic/mos_track_hold.hpp:32
        I(cpphdl_n2286, cpphdl_n1488) <+ cpphdl_channel(V(TRACK6, cpphdl_n1488), V(cpphdl_n2286, cpphdl_n1488), 0.029999999999999999, 0.69999999999999996, 1.0);
        // device 904, IC IC157, analog/basic/mos_track_hold.hpp:33
        I(cpphdl_n1488, cpphdl_n2286) <+ cpphdl_channel(V(cpphdl_n1434, cpphdl_n2286), V(cpphdl_n1488, cpphdl_n2286), 0.014999999999999999, 0.69999999999999996, -1.0);
        // device 905, IC IC157, analog/basic/mos_track_hold.hpp:37
        I(cpphdl_n1488, cpphdl_n1488) <+ cpphdl_channel(V(cpphdl_n1434, cpphdl_n1488), V(cpphdl_n1488, cpphdl_n1488), 0.016, 0.69999999999999996, 1.0);
        // device 906, IC IC157, analog/basic/mos_track_hold.hpp:38
        I(cpphdl_n1488, cpphdl_n1488) <+ cpphdl_channel(V(TRACK6, cpphdl_n1488), V(cpphdl_n1488, cpphdl_n1488), 0.0083999999999999995, 0.69999999999999996, -1.0);
        // device 907, IC IC157, analog/basic/mos_track_hold.hpp:39
        I(cpphdl_n1488, Vss) <+ 1.5000000000000001e-12 * ddt(V(cpphdl_n1488, Vss)); // Bench initial voltage = 0.0 V.
        // device 908, IC IC157, analog/basic/mos_track_hold.hpp:42
        I(TRACK6, cpphdl_n1488) <+ 2.0000000000000002e-15 * ddt(V(TRACK6, cpphdl_n1488)); // Bench initial voltage = -0.0 V.
        // device 909, IC IC157, analog/basic/mos_track_hold.hpp:43
        I(cpphdl_n1434, cpphdl_n1488) <+ 2.0000000000000002e-15 * ddt(V(cpphdl_n1434, cpphdl_n1488)); // Bench initial voltage = 0.0 V.
        // device 910, IC IC157, analog/basic/mos_track_hold.hpp:44
        I(cpphdl_n2286, cpphdl_n1488) <+ 1.0000000000000001e-15 * ddt(V(cpphdl_n2286, cpphdl_n1488)); // Bench initial voltage = 0.0 V.
        // device 911, IC IC160, analog/basic/inverter.hpp:11
        I(cpphdl_n1449, Vdd) <+ cpphdl_channel(V(BIT_N6_0, Vdd), V(cpphdl_n1449, Vdd), 0.080000000000000002, 0.69999999999999996, -1.0);
        // device 912, IC IC160, analog/basic/inverter.hpp:12
        I(cpphdl_n1449, Vss) <+ cpphdl_channel(V(BIT_N6_0, Vss), V(cpphdl_n1449, Vss), 0.080000000000000002, 0.69999999999999996, 1.0);
        // device 913, IC IC159, analog/basic/mos_r2r_dac.hpp:27
        I(cpphdl_n1449, Vss) <+ 2.9999999999999998e-15 * ddt(V(cpphdl_n1449, Vss)); // Bench initial voltage = 0.0 V.
        // device 914, IC IC159, analog/basic/mos_r2r_dac.hpp:28
        I(cpphdl_n1449, cpphdl_n1478) <+ V(cpphdl_n1449, cpphdl_n1478) / 2000.0;
        // device 915, IC IC159, analog/basic/mos_r2r_dac.hpp:29
        I(cpphdl_n1478, Vss) <+ 2.9999999999999998e-15 * ddt(V(cpphdl_n1478, Vss)); // Bench initial voltage = 0.0 V.
        // device 916, IC IC161, analog/basic/inverter.hpp:11
        I(cpphdl_n1453, Vdd) <+ cpphdl_channel(V(BIT_N6_1, Vdd), V(cpphdl_n1453, Vdd), 0.080000000000000002, 0.69999999999999996, -1.0);
        // device 917, IC IC161, analog/basic/inverter.hpp:12
        I(cpphdl_n1453, Vss) <+ cpphdl_channel(V(BIT_N6_1, Vss), V(cpphdl_n1453, Vss), 0.080000000000000002, 0.69999999999999996, 1.0);
        // device 918, IC IC159, analog/basic/mos_r2r_dac.hpp:27
        I(cpphdl_n1453, Vss) <+ 2.9999999999999998e-15 * ddt(V(cpphdl_n1453, Vss)); // Bench initial voltage = 0.0 V.
        // device 919, IC IC159, analog/basic/mos_r2r_dac.hpp:28
        I(cpphdl_n1453, cpphdl_n1479) <+ V(cpphdl_n1453, cpphdl_n1479) / 2000.0;
        // device 920, IC IC159, analog/basic/mos_r2r_dac.hpp:29
        I(cpphdl_n1479, Vss) <+ 2.9999999999999998e-15 * ddt(V(cpphdl_n1479, Vss)); // Bench initial voltage = 0.0 V.
        // device 921, IC IC159, analog/basic/mos_r2r_dac.hpp:31
        I(cpphdl_n1478, cpphdl_n1479) <+ V(cpphdl_n1478, cpphdl_n1479) / 1000.0;
        // device 922, IC IC162, analog/basic/inverter.hpp:11
        I(cpphdl_n1457, Vdd) <+ cpphdl_channel(V(BIT_N6_2, Vdd), V(cpphdl_n1457, Vdd), 0.080000000000000002, 0.69999999999999996, -1.0);
        // device 923, IC IC162, analog/basic/inverter.hpp:12
        I(cpphdl_n1457, Vss) <+ cpphdl_channel(V(BIT_N6_2, Vss), V(cpphdl_n1457, Vss), 0.080000000000000002, 0.69999999999999996, 1.0);
        // device 924, IC IC159, analog/basic/mos_r2r_dac.hpp:27
        I(cpphdl_n1457, Vss) <+ 2.9999999999999998e-15 * ddt(V(cpphdl_n1457, Vss)); // Bench initial voltage = 0.0 V.
        // device 925, IC IC159, analog/basic/mos_r2r_dac.hpp:28
        I(cpphdl_n1457, cpphdl_n1480) <+ V(cpphdl_n1457, cpphdl_n1480) / 2000.0;
        // device 926, IC IC159, analog/basic/mos_r2r_dac.hpp:29
        I(cpphdl_n1480, Vss) <+ 2.9999999999999998e-15 * ddt(V(cpphdl_n1480, Vss)); // Bench initial voltage = 0.0 V.
        // device 927, IC IC159, analog/basic/mos_r2r_dac.hpp:31
        I(cpphdl_n1479, cpphdl_n1480) <+ V(cpphdl_n1479, cpphdl_n1480) / 1000.0;
        // device 928, IC IC163, analog/basic/inverter.hpp:11
        I(cpphdl_n1461, Vdd) <+ cpphdl_channel(V(BIT_N6_3, Vdd), V(cpphdl_n1461, Vdd), 0.080000000000000002, 0.69999999999999996, -1.0);
        // device 929, IC IC163, analog/basic/inverter.hpp:12
        I(cpphdl_n1461, Vss) <+ cpphdl_channel(V(BIT_N6_3, Vss), V(cpphdl_n1461, Vss), 0.080000000000000002, 0.69999999999999996, 1.0);
        // device 930, IC IC159, analog/basic/mos_r2r_dac.hpp:27
        I(cpphdl_n1461, Vss) <+ 2.9999999999999998e-15 * ddt(V(cpphdl_n1461, Vss)); // Bench initial voltage = 0.0 V.
        // device 931, IC IC159, analog/basic/mos_r2r_dac.hpp:28
        I(cpphdl_n1461, cpphdl_n1481) <+ V(cpphdl_n1461, cpphdl_n1481) / 2000.0;
        // device 932, IC IC159, analog/basic/mos_r2r_dac.hpp:29
        I(cpphdl_n1481, Vss) <+ 2.9999999999999998e-15 * ddt(V(cpphdl_n1481, Vss)); // Bench initial voltage = 0.0 V.
        // device 933, IC IC159, analog/basic/mos_r2r_dac.hpp:31
        I(cpphdl_n1480, cpphdl_n1481) <+ V(cpphdl_n1480, cpphdl_n1481) / 1000.0;
        // device 934, IC IC164, analog/basic/inverter.hpp:11
        I(cpphdl_n1465, Vdd) <+ cpphdl_channel(V(BIT_N6_4, Vdd), V(cpphdl_n1465, Vdd), 0.080000000000000002, 0.69999999999999996, -1.0);
        // device 935, IC IC164, analog/basic/inverter.hpp:12
        I(cpphdl_n1465, Vss) <+ cpphdl_channel(V(BIT_N6_4, Vss), V(cpphdl_n1465, Vss), 0.080000000000000002, 0.69999999999999996, 1.0);
        // device 936, IC IC159, analog/basic/mos_r2r_dac.hpp:27
        I(cpphdl_n1465, Vss) <+ 2.9999999999999998e-15 * ddt(V(cpphdl_n1465, Vss)); // Bench initial voltage = 0.0 V.
        // device 937, IC IC159, analog/basic/mos_r2r_dac.hpp:28
        I(cpphdl_n1465, cpphdl_n1482) <+ V(cpphdl_n1465, cpphdl_n1482) / 2000.0;
        // device 938, IC IC159, analog/basic/mos_r2r_dac.hpp:29
        I(cpphdl_n1482, Vss) <+ 2.9999999999999998e-15 * ddt(V(cpphdl_n1482, Vss)); // Bench initial voltage = 0.0 V.
        // device 939, IC IC159, analog/basic/mos_r2r_dac.hpp:31
        I(cpphdl_n1481, cpphdl_n1482) <+ V(cpphdl_n1481, cpphdl_n1482) / 1000.0;
        // device 940, IC IC165, analog/basic/inverter.hpp:11
        I(cpphdl_n1469, Vdd) <+ cpphdl_channel(V(BIT_N6_5, Vdd), V(cpphdl_n1469, Vdd), 0.080000000000000002, 0.69999999999999996, -1.0);
        // device 941, IC IC165, analog/basic/inverter.hpp:12
        I(cpphdl_n1469, Vss) <+ cpphdl_channel(V(BIT_N6_5, Vss), V(cpphdl_n1469, Vss), 0.080000000000000002, 0.69999999999999996, 1.0);
        // device 942, IC IC159, analog/basic/mos_r2r_dac.hpp:27
        I(cpphdl_n1469, Vss) <+ 2.9999999999999998e-15 * ddt(V(cpphdl_n1469, Vss)); // Bench initial voltage = 0.0 V.
        // device 943, IC IC159, analog/basic/mos_r2r_dac.hpp:28
        I(cpphdl_n1469, cpphdl_n1483) <+ V(cpphdl_n1469, cpphdl_n1483) / 2000.0;
        // device 944, IC IC159, analog/basic/mos_r2r_dac.hpp:29
        I(cpphdl_n1483, Vss) <+ 2.9999999999999998e-15 * ddt(V(cpphdl_n1483, Vss)); // Bench initial voltage = 0.0 V.
        // device 945, IC IC159, analog/basic/mos_r2r_dac.hpp:31
        I(cpphdl_n1482, cpphdl_n1483) <+ V(cpphdl_n1482, cpphdl_n1483) / 1000.0;
        // device 946, IC IC166, analog/basic/inverter.hpp:11
        I(cpphdl_n1473, Vdd) <+ cpphdl_channel(V(BIT_N6_6, Vdd), V(cpphdl_n1473, Vdd), 0.080000000000000002, 0.69999999999999996, -1.0);
        // device 947, IC IC166, analog/basic/inverter.hpp:12
        I(cpphdl_n1473, Vss) <+ cpphdl_channel(V(BIT_N6_6, Vss), V(cpphdl_n1473, Vss), 0.080000000000000002, 0.69999999999999996, 1.0);
        // device 948, IC IC159, analog/basic/mos_r2r_dac.hpp:27
        I(cpphdl_n1473, Vss) <+ 2.9999999999999998e-15 * ddt(V(cpphdl_n1473, Vss)); // Bench initial voltage = 0.0 V.
        // device 949, IC IC159, analog/basic/mos_r2r_dac.hpp:28
        I(cpphdl_n1473, cpphdl_n1484) <+ V(cpphdl_n1473, cpphdl_n1484) / 2000.0;
        // device 950, IC IC159, analog/basic/mos_r2r_dac.hpp:29
        I(cpphdl_n1484, Vss) <+ 2.9999999999999998e-15 * ddt(V(cpphdl_n1484, Vss)); // Bench initial voltage = 0.0 V.
        // device 951, IC IC159, analog/basic/mos_r2r_dac.hpp:31
        I(cpphdl_n1483, cpphdl_n1484) <+ V(cpphdl_n1483, cpphdl_n1484) / 1000.0;
        // device 952, IC IC167, analog/basic/inverter.hpp:11
        I(cpphdl_n1477, Vdd) <+ cpphdl_channel(V(BIT_N6_7, Vdd), V(cpphdl_n1477, Vdd), 0.080000000000000002, 0.69999999999999996, -1.0);
        // device 953, IC IC167, analog/basic/inverter.hpp:12
        I(cpphdl_n1477, Vss) <+ cpphdl_channel(V(BIT_N6_7, Vss), V(cpphdl_n1477, Vss), 0.080000000000000002, 0.69999999999999996, 1.0);
        // device 954, IC IC159, analog/basic/mos_r2r_dac.hpp:27
        I(cpphdl_n1477, Vss) <+ 2.9999999999999998e-15 * ddt(V(cpphdl_n1477, Vss)); // Bench initial voltage = 0.0 V.
        // device 955, IC IC159, analog/basic/mos_r2r_dac.hpp:28
        I(cpphdl_n1477, cpphdl_n1489) <+ V(cpphdl_n1477, cpphdl_n1489) / 2000.0;
        // device 956, IC IC159, analog/basic/mos_r2r_dac.hpp:29
        I(cpphdl_n1489, Vss) <+ 2.9999999999999998e-15 * ddt(V(cpphdl_n1489, Vss)); // Bench initial voltage = 0.0 V.
        // device 957, IC IC159, analog/basic/mos_r2r_dac.hpp:31
        I(cpphdl_n1484, cpphdl_n1489) <+ V(cpphdl_n1484, cpphdl_n1489) / 1000.0;
        // device 958, IC IC159, analog/basic/mos_r2r_dac.hpp:33
        I(Vss, cpphdl_n1478) <+ V(Vss, cpphdl_n1478) / 2000.0;
        // device 959, IC IC168, analog/basic/nmos_resistor_amplifier.hpp:23
        I(Vdd, cpphdl_n1498) <+ V(Vdd, cpphdl_n1498) / 1000.0;
        // device 960, IC IC168, analog/basic/nmos_resistor_amplifier.hpp:24
        I(Vdd, cpphdl_n1497) <+ V(Vdd, cpphdl_n1497) / 1000.0;
        // device 961, IC IC168, analog/basic/nmos_resistor_amplifier.hpp:25
        I(cpphdl_n1498, cpphdl_n1492) <+ cpphdl_channel(V(cpphdl_n1488, cpphdl_n1492), V(cpphdl_n1498, cpphdl_n1492), 0.0074999999999999997, 0.69999999999999996, 1.0);
        // device 962, IC IC168, analog/basic/nmos_resistor_amplifier.hpp:26
        I(cpphdl_n1497, cpphdl_n1493) <+ cpphdl_channel(V(cpphdl_n1489, cpphdl_n1493), V(cpphdl_n1497, cpphdl_n1493), 0.0074999999999999997, 0.69999999999999996, 1.0);
        // device 963, IC IC168, analog/basic/nmos_resistor_amplifier.hpp:27
        I(cpphdl_n1494, cpphdl_n1492) <+ V(cpphdl_n1494, cpphdl_n1492) / 100.0;
        // device 964, IC IC168, analog/basic/nmos_resistor_amplifier.hpp:28
        I(cpphdl_n1494, cpphdl_n1493) <+ V(cpphdl_n1494, cpphdl_n1493) / 100.0;
        // device 965, IC IC168, analog/basic/nmos_resistor_amplifier.hpp:29
        I(Vss, cpphdl_n1494) <+ V(Vss, cpphdl_n1494) / 300.0;
        // device 966, IC IC168, analog/basic/nmos_resistor_amplifier.hpp:30
        I(cpphdl_n1498, Vdd) <+ 2.9999999999999998e-13 * ddt(V(cpphdl_n1498, Vdd)); // Bench initial voltage = 0.0 V.
        // device 967, IC IC168, analog/basic/nmos_resistor_amplifier.hpp:31
        I(cpphdl_n1497, Vdd) <+ 2.9999999999999998e-13 * ddt(V(cpphdl_n1497, Vdd)); // Bench initial voltage = 0.0 V.
        // device 968, IC IC168, analog/basic/nmos_resistor_amplifier.hpp:32
        I(cpphdl_n1494, Vss) <+ 4e-14 * ddt(V(cpphdl_n1494, Vss)); // Bench initial voltage = 0.0 V.
        // device 969, IC IC168, analog/basic/nmos_resistor_amplifier.hpp:34
        I(cpphdl_n1488, cpphdl_n1492) <+ 2e-14 * ddt(V(cpphdl_n1488, cpphdl_n1492)); // Bench initial voltage = 0.0 V.
        // device 970, IC IC168, analog/basic/nmos_resistor_amplifier.hpp:35
        I(cpphdl_n1489, cpphdl_n1493) <+ 2e-14 * ddt(V(cpphdl_n1489, cpphdl_n1493)); // Bench initial voltage = 0.0 V.
        // device 971, IC IC168, analog/basic/nmos_resistor_amplifier.hpp:36
        I(cpphdl_n1488, cpphdl_n1498) <+ 2.9999999999999998e-15 * ddt(V(cpphdl_n1488, cpphdl_n1498)); // Bench initial voltage = 0.0 V.
        // device 972, IC IC168, analog/basic/nmos_resistor_amplifier.hpp:37
        I(cpphdl_n1489, cpphdl_n1497) <+ 2.9999999999999998e-15 * ddt(V(cpphdl_n1489, cpphdl_n1497)); // Bench initial voltage = 0.0 V.
        // device 973, IC IC169, analog/basic/strongarm_comparator.hpp:28
        I(cpphdl_n1502, cpphdl_n1504) <+ cpphdl_channel(V(cpphdl_n1497, cpphdl_n1504), V(cpphdl_n1502, cpphdl_n1504), 0.0080000000000000002, 0.69999999999999996, 1.0);
        // device 974, IC IC169, analog/basic/strongarm_comparator.hpp:29
        I(cpphdl_n1503, cpphdl_n1504) <+ cpphdl_channel(V(cpphdl_n1498, cpphdl_n1504), V(cpphdl_n1503, cpphdl_n1504), 0.0080000000000000002, 0.69999999999999996, 1.0);
        // device 975, IC IC169, analog/basic/strongarm_comparator.hpp:30
        I(cpphdl_n1504, Vss) <+ cpphdl_channel(V(EVALUATE, Vss), V(cpphdl_n1504, Vss), 0.0080000000000000002, 0.69999999999999996, 1.0);
        // device 976, IC IC169, analog/basic/strongarm_comparator.hpp:33
        I(cpphdl_n1517, cpphdl_n1502) <+ cpphdl_channel(V(cpphdl_n1521, cpphdl_n1502), V(cpphdl_n1517, cpphdl_n1502), 0.0040000000000000001, 0.69999999999999996, 1.0);
        // device 977, IC IC169, analog/basic/strongarm_comparator.hpp:34
        I(cpphdl_n1521, cpphdl_n1503) <+ cpphdl_channel(V(cpphdl_n1517, cpphdl_n1503), V(cpphdl_n1521, cpphdl_n1503), 0.0040000000000000001, 0.69999999999999996, 1.0);
        // device 978, IC IC169, analog/basic/strongarm_comparator.hpp:35
        I(cpphdl_n1521, Vdd) <+ cpphdl_channel(V(cpphdl_n1517, Vdd), V(cpphdl_n1521, Vdd), 0.002, 0.69999999999999996, -1.0);
        // device 979, IC IC169, analog/basic/strongarm_comparator.hpp:36
        I(cpphdl_n1517, Vdd) <+ cpphdl_channel(V(cpphdl_n1521, Vdd), V(cpphdl_n1517, Vdd), 0.002, 0.69999999999999996, -1.0);
        // device 980, IC IC169, analog/basic/strongarm_comparator.hpp:38
        I(cpphdl_n1502, Vdd) <+ cpphdl_channel(V(EVALUATE, Vdd), V(cpphdl_n1502, Vdd), 0.002, 0.69999999999999996, -1.0);
        // device 981, IC IC169, analog/basic/strongarm_comparator.hpp:39
        I(cpphdl_n1503, Vdd) <+ cpphdl_channel(V(EVALUATE, Vdd), V(cpphdl_n1503, Vdd), 0.002, 0.69999999999999996, -1.0);
        // device 982, IC IC169, analog/basic/strongarm_comparator.hpp:40
        I(cpphdl_n1521, Vdd) <+ cpphdl_channel(V(EVALUATE, Vdd), V(cpphdl_n1521, Vdd), 0.002, 0.69999999999999996, -1.0);
        // device 983, IC IC169, analog/basic/strongarm_comparator.hpp:41
        I(cpphdl_n1517, Vdd) <+ cpphdl_channel(V(EVALUATE, Vdd), V(cpphdl_n1517, Vdd), 0.002, 0.69999999999999996, -1.0);
        // device 984, IC IC169, analog/basic/strongarm_comparator.hpp:42
        I(cpphdl_n1502, Vss) <+ 2.9999999999999998e-14 * ddt(V(cpphdl_n1502, Vss)); // Bench initial voltage = 0.0 V.
        // device 985, IC IC169, analog/basic/strongarm_comparator.hpp:43
        I(cpphdl_n1503, Vss) <+ 2.9999999999999998e-14 * ddt(V(cpphdl_n1503, Vss)); // Bench initial voltage = 0.0 V.
        // device 986, IC IC169, analog/basic/strongarm_comparator.hpp:44
        I(cpphdl_n1504, Vss) <+ 2.9999999999999998e-14 * ddt(V(cpphdl_n1504, Vss)); // Bench initial voltage = 0.0 V.
        // device 987, IC IC169, analog/basic/strongarm_comparator.hpp:45
        I(cpphdl_n1521, Vss) <+ 5.0000000000000002e-14 * ddt(V(cpphdl_n1521, Vss)); // Bench initial voltage = 0.0 V.
        // device 988, IC IC169, analog/basic/strongarm_comparator.hpp:46
        I(cpphdl_n1517, Vss) <+ 5.0000000000000002e-14 * ddt(V(cpphdl_n1517, Vss)); // Bench initial voltage = 0.0 V.
        // device 989, IC IC169, analog/basic/strongarm_comparator.hpp:47
        I(cpphdl_n1497, cpphdl_n1504) <+ 2e-14 * ddt(V(cpphdl_n1497, cpphdl_n1504)); // Bench initial voltage = 0.0 V.
        // device 990, IC IC169, analog/basic/strongarm_comparator.hpp:48
        I(cpphdl_n1498, cpphdl_n1504) <+ 2e-14 * ddt(V(cpphdl_n1498, cpphdl_n1504)); // Bench initial voltage = 0.0 V.
        // device 991, IC IC169, analog/basic/strongarm_comparator.hpp:49
        I(cpphdl_n1497, cpphdl_n1502) <+ 2.9999999999999998e-15 * ddt(V(cpphdl_n1497, cpphdl_n1502)); // Bench initial voltage = 0.0 V.
        // device 992, IC IC169, analog/basic/strongarm_comparator.hpp:50
        I(cpphdl_n1498, cpphdl_n1503) <+ 2.9999999999999998e-15 * ddt(V(cpphdl_n1498, cpphdl_n1503)); // Bench initial voltage = 0.0 V.
        // device 993, IC IC171, analog/basic/inverter.hpp:11
        I(cpphdl_n1525, Vdd) <+ cpphdl_channel(V(cpphdl_n1517, Vdd), V(cpphdl_n1525, Vdd), 0.001, 0.69999999999999996, -1.0);
        // device 994, IC IC171, analog/basic/inverter.hpp:12
        I(cpphdl_n1525, Vss) <+ cpphdl_channel(V(cpphdl_n1517, Vss), V(cpphdl_n1525, Vss), 0.001, 0.69999999999999996, 1.0);
        // device 995, IC IC173, analog/basic/inverter.hpp:11
        I(cpphdl_n1539, Vdd) <+ cpphdl_channel(V(cpphdl_n1525, Vdd), V(cpphdl_n1539, Vdd), 0.0040000000000000001, 0.69999999999999996, -1.0);
        // device 996, IC IC173, analog/basic/inverter.hpp:12
        I(cpphdl_n1539, Vss) <+ cpphdl_channel(V(cpphdl_n1525, Vss), V(cpphdl_n1539, Vss), 0.0040000000000000001, 0.69999999999999996, 1.0);
        // device 997, IC IC170, analog/basic/buffered_nand_latch.hpp:34
        I(cpphdl_n1517, Vss) <+ 2.0000000000000002e-15 * ddt(V(cpphdl_n1517, Vss)); // Bench initial voltage = 0.0 V.
        // device 998, IC IC170, analog/basic/buffered_nand_latch.hpp:35
        I(cpphdl_n1517, cpphdl_n1525) <+ 1.0000000000000001e-15 * ddt(V(cpphdl_n1517, cpphdl_n1525)); // Bench initial voltage = 0.0 V.
        // device 999, IC IC170, analog/basic/buffered_nand_latch.hpp:36
        I(cpphdl_n1525, Vss) <+ 5e-15 * ddt(V(cpphdl_n1525, Vss)); // Bench initial voltage = 0.0 V.
        // device 1000, IC IC170, analog/basic/buffered_nand_latch.hpp:37
        I(cpphdl_n1525, Vss) <+ 8.0000000000000006e-15 * ddt(V(cpphdl_n1525, Vss)); // Bench initial voltage = 0.0 V.
        // device 1001, IC IC170, analog/basic/buffered_nand_latch.hpp:38
        I(cpphdl_n1539, Vss) <+ 1e-14 * ddt(V(cpphdl_n1539, Vss)); // Bench initial voltage = 0.0 V.
        // device 1002, IC IC172, analog/basic/inverter.hpp:11
        I(cpphdl_n1529, Vdd) <+ cpphdl_channel(V(cpphdl_n1521, Vdd), V(cpphdl_n1529, Vdd), 0.001, 0.69999999999999996, -1.0);
        // device 1003, IC IC172, analog/basic/inverter.hpp:12
        I(cpphdl_n1529, Vss) <+ cpphdl_channel(V(cpphdl_n1521, Vss), V(cpphdl_n1529, Vss), 0.001, 0.69999999999999996, 1.0);
        // device 1004, IC IC174, analog/basic/inverter.hpp:11
        I(cpphdl_n1545, Vdd) <+ cpphdl_channel(V(cpphdl_n1529, Vdd), V(cpphdl_n1545, Vdd), 0.0040000000000000001, 0.69999999999999996, -1.0);
        // device 1005, IC IC174, analog/basic/inverter.hpp:12
        I(cpphdl_n1545, Vss) <+ cpphdl_channel(V(cpphdl_n1529, Vss), V(cpphdl_n1545, Vss), 0.0040000000000000001, 0.69999999999999996, 1.0);
        // device 1006, IC IC170, analog/basic/buffered_nand_latch.hpp:34
        I(cpphdl_n1521, Vss) <+ 2.0000000000000002e-15 * ddt(V(cpphdl_n1521, Vss)); // Bench initial voltage = 0.0 V.
        // device 1007, IC IC170, analog/basic/buffered_nand_latch.hpp:35
        I(cpphdl_n1521, cpphdl_n1529) <+ 1.0000000000000001e-15 * ddt(V(cpphdl_n1521, cpphdl_n1529)); // Bench initial voltage = 0.0 V.
        // device 1008, IC IC170, analog/basic/buffered_nand_latch.hpp:36
        I(cpphdl_n1529, Vss) <+ 5e-15 * ddt(V(cpphdl_n1529, Vss)); // Bench initial voltage = 0.0 V.
        // device 1009, IC IC170, analog/basic/buffered_nand_latch.hpp:37
        I(cpphdl_n1529, Vss) <+ 8.0000000000000006e-15 * ddt(V(cpphdl_n1529, Vss)); // Bench initial voltage = 0.0 V.
        // device 1010, IC IC170, analog/basic/buffered_nand_latch.hpp:38
        I(cpphdl_n1545, Vss) <+ 1e-14 * ddt(V(cpphdl_n1545, Vss)); // Bench initial voltage = 0.0 V.
        // device 1011, IC IC176, analog/basic/cmos_logic.hpp:17
        I(cpphdl_n2458, Vss) <+ 5.0000000000000002e-14 * ddt(V(cpphdl_n2458, Vss)); // Bench initial voltage = 0.0 V.
        // device 1012, IC IC176, analog/basic/cmos_logic.hpp:18
        I(cpphdl_n2458, Vdd) <+ cpphdl_channel(V(cpphdl_n1539, Vdd), V(cpphdl_n2458, Vdd), 0.01, 0.69999999999999996, -1.0);
        // device 1013, IC IC176, analog/basic/cmos_logic.hpp:19
        I(cpphdl_n2458, Vdd) <+ cpphdl_channel(V(cpphdl_n1547, Vdd), V(cpphdl_n2458, Vdd), 0.01, 0.69999999999999996, -1.0);
        // device 1014, IC IC176, analog/basic/cmos_logic.hpp:20
        I(cpphdl_n2458, cpphdl_n1542) <+ cpphdl_channel(V(cpphdl_n1539, cpphdl_n1542), V(cpphdl_n2458, cpphdl_n1542), 0.01, 0.69999999999999996, 1.0);
        // device 1015, IC IC176, analog/basic/cmos_logic.hpp:21
        I(cpphdl_n1542, Vss) <+ cpphdl_channel(V(cpphdl_n1547, Vss), V(cpphdl_n1542, Vss), 0.01, 0.69999999999999996, 1.0);
        // device 1016, IC IC176, analog/basic/cmos_logic.hpp:27
        I(cpphdl_n1542, Vss) <+ 1e-14 * ddt(V(cpphdl_n1542, Vss)); // Bench initial voltage = 0.0 V.
        // device 1017, IC IC177, analog/basic/cmos_logic.hpp:17
        I(cpphdl_n1547, Vss) <+ 5.0000000000000002e-14 * ddt(V(cpphdl_n1547, Vss)); // Bench initial voltage = 0.0 V.
        // device 1018, IC IC177, analog/basic/cmos_logic.hpp:18
        I(cpphdl_n1547, Vdd) <+ cpphdl_channel(V(cpphdl_n1545, Vdd), V(cpphdl_n1547, Vdd), 0.01, 0.69999999999999996, -1.0);
        // device 1019, IC IC177, analog/basic/cmos_logic.hpp:19
        I(cpphdl_n1547, Vdd) <+ cpphdl_channel(V(cpphdl_n2458, Vdd), V(cpphdl_n1547, Vdd), 0.01, 0.69999999999999996, -1.0);
        // device 1020, IC IC177, analog/basic/cmos_logic.hpp:20
        I(cpphdl_n1547, cpphdl_n1548) <+ cpphdl_channel(V(cpphdl_n1545, cpphdl_n1548), V(cpphdl_n1547, cpphdl_n1548), 0.01, 0.69999999999999996, 1.0);
        // device 1021, IC IC177, analog/basic/cmos_logic.hpp:21
        I(cpphdl_n1548, Vss) <+ cpphdl_channel(V(cpphdl_n2458, Vss), V(cpphdl_n1548, Vss), 0.01, 0.69999999999999996, 1.0);
        // device 1022, IC IC177, analog/basic/cmos_logic.hpp:27
        I(cpphdl_n1548, Vss) <+ 1e-14 * ddt(V(cpphdl_n1548, Vss)); // Bench initial voltage = 0.0 V.
        // device 1023, IC IC175, analog/basic/nand_latch.hpp:36
        I(cpphdl_n1539, Vss) <+ 2.9999999999999998e-15 * ddt(V(cpphdl_n1539, Vss)); // Bench initial voltage = 0.0 V.
        // device 1024, IC IC175, analog/basic/nand_latch.hpp:37
        I(cpphdl_n1545, Vss) <+ 2.9999999999999998e-15 * ddt(V(cpphdl_n1545, Vss)); // Bench initial voltage = 0.0 V.
        // device 1025, IC IC178, analog/basic/inverter.hpp:11
        I(cpphdl_n1553, Vdd) <+ cpphdl_channel(V(CLEAR, Vdd), V(cpphdl_n1553, Vdd), 0.01, 0.69999999999999996, -1.0);
        // device 1026, IC IC178, analog/basic/inverter.hpp:12
        I(cpphdl_n1553, Vss) <+ cpphdl_channel(V(CLEAR, Vss), V(cpphdl_n1553, Vss), 0.01, 0.69999999999999996, 1.0);
        // device 1027, IC IC175, analog/basic/nand_latch.hpp:58
        I(cpphdl_n1553, Vss) <+ 2.9999999999999998e-15 * ddt(V(cpphdl_n1553, Vss)); // Bench initial voltage = 0.0 V.
        // device 1028, IC IC175, analog/basic/nand_latch.hpp:59
        I(cpphdl_n2458, Vss) <+ cpphdl_channel(V(CLEAR, Vss), V(cpphdl_n2458, Vss), 0.050000000000000003, 0.69999999999999996, 1.0);
        // device 1029, IC IC175, analog/basic/nand_latch.hpp:60
        I(cpphdl_n1547, Vdd) <+ cpphdl_channel(V(cpphdl_n1553, Vdd), V(cpphdl_n1547, Vdd), 0.050000000000000003, 0.69999999999999996, -1.0);
        // device 1030, IC IC181, analog/basic/inverter.hpp:11
        I(cpphdl_n1577, Vdd) <+ cpphdl_channel(V(TRACK7, Vdd), V(cpphdl_n1577, Vdd), 0.0040000000000000001, 0.69999999999999996, -1.0);
        // device 1031, IC IC181, analog/basic/inverter.hpp:12
        I(cpphdl_n1577, Vss) <+ cpphdl_channel(V(TRACK7, Vss), V(cpphdl_n1577, Vss), 0.0040000000000000001, 0.69999999999999996, 1.0);
        // device 1032, IC IC180, analog/basic/mos_track_hold.hpp:31
        I(cpphdl_n1577, Vss) <+ 2e-14 * ddt(V(cpphdl_n1577, Vss)); // Bench initial voltage = 0.0 V.
        // device 1033, IC IC180, analog/basic/mos_track_hold.hpp:32
        I(cpphdl_n2286, cpphdl_n1631) <+ cpphdl_channel(V(TRACK7, cpphdl_n1631), V(cpphdl_n2286, cpphdl_n1631), 0.029999999999999999, 0.69999999999999996, 1.0);
        // device 1034, IC IC180, analog/basic/mos_track_hold.hpp:33
        I(cpphdl_n1631, cpphdl_n2286) <+ cpphdl_channel(V(cpphdl_n1577, cpphdl_n2286), V(cpphdl_n1631, cpphdl_n2286), 0.014999999999999999, 0.69999999999999996, -1.0);
        // device 1035, IC IC180, analog/basic/mos_track_hold.hpp:37
        I(cpphdl_n1631, cpphdl_n1631) <+ cpphdl_channel(V(cpphdl_n1577, cpphdl_n1631), V(cpphdl_n1631, cpphdl_n1631), 0.016, 0.69999999999999996, 1.0);
        // device 1036, IC IC180, analog/basic/mos_track_hold.hpp:38
        I(cpphdl_n1631, cpphdl_n1631) <+ cpphdl_channel(V(TRACK7, cpphdl_n1631), V(cpphdl_n1631, cpphdl_n1631), 0.0083999999999999995, 0.69999999999999996, -1.0);
        // device 1037, IC IC180, analog/basic/mos_track_hold.hpp:39
        I(cpphdl_n1631, Vss) <+ 1.5000000000000001e-12 * ddt(V(cpphdl_n1631, Vss)); // Bench initial voltage = 0.0 V.
        // device 1038, IC IC180, analog/basic/mos_track_hold.hpp:42
        I(TRACK7, cpphdl_n1631) <+ 2.0000000000000002e-15 * ddt(V(TRACK7, cpphdl_n1631)); // Bench initial voltage = -0.0 V.
        // device 1039, IC IC180, analog/basic/mos_track_hold.hpp:43
        I(cpphdl_n1577, cpphdl_n1631) <+ 2.0000000000000002e-15 * ddt(V(cpphdl_n1577, cpphdl_n1631)); // Bench initial voltage = 0.0 V.
        // device 1040, IC IC180, analog/basic/mos_track_hold.hpp:44
        I(cpphdl_n2286, cpphdl_n1631) <+ 1.0000000000000001e-15 * ddt(V(cpphdl_n2286, cpphdl_n1631)); // Bench initial voltage = 0.0 V.
        // device 1041, IC IC183, analog/basic/inverter.hpp:11
        I(cpphdl_n1592, Vdd) <+ cpphdl_channel(V(BIT_N7_0, Vdd), V(cpphdl_n1592, Vdd), 0.080000000000000002, 0.69999999999999996, -1.0);
        // device 1042, IC IC183, analog/basic/inverter.hpp:12
        I(cpphdl_n1592, Vss) <+ cpphdl_channel(V(BIT_N7_0, Vss), V(cpphdl_n1592, Vss), 0.080000000000000002, 0.69999999999999996, 1.0);
        // device 1043, IC IC182, analog/basic/mos_r2r_dac.hpp:27
        I(cpphdl_n1592, Vss) <+ 2.9999999999999998e-15 * ddt(V(cpphdl_n1592, Vss)); // Bench initial voltage = 0.0 V.
        // device 1044, IC IC182, analog/basic/mos_r2r_dac.hpp:28
        I(cpphdl_n1592, cpphdl_n1621) <+ V(cpphdl_n1592, cpphdl_n1621) / 2000.0;
        // device 1045, IC IC182, analog/basic/mos_r2r_dac.hpp:29
        I(cpphdl_n1621, Vss) <+ 2.9999999999999998e-15 * ddt(V(cpphdl_n1621, Vss)); // Bench initial voltage = 0.0 V.
        // device 1046, IC IC184, analog/basic/inverter.hpp:11
        I(cpphdl_n1596, Vdd) <+ cpphdl_channel(V(BIT_N7_1, Vdd), V(cpphdl_n1596, Vdd), 0.080000000000000002, 0.69999999999999996, -1.0);
        // device 1047, IC IC184, analog/basic/inverter.hpp:12
        I(cpphdl_n1596, Vss) <+ cpphdl_channel(V(BIT_N7_1, Vss), V(cpphdl_n1596, Vss), 0.080000000000000002, 0.69999999999999996, 1.0);
        // device 1048, IC IC182, analog/basic/mos_r2r_dac.hpp:27
        I(cpphdl_n1596, Vss) <+ 2.9999999999999998e-15 * ddt(V(cpphdl_n1596, Vss)); // Bench initial voltage = 0.0 V.
        // device 1049, IC IC182, analog/basic/mos_r2r_dac.hpp:28
        I(cpphdl_n1596, cpphdl_n1622) <+ V(cpphdl_n1596, cpphdl_n1622) / 2000.0;
        // device 1050, IC IC182, analog/basic/mos_r2r_dac.hpp:29
        I(cpphdl_n1622, Vss) <+ 2.9999999999999998e-15 * ddt(V(cpphdl_n1622, Vss)); // Bench initial voltage = 0.0 V.
        // device 1051, IC IC182, analog/basic/mos_r2r_dac.hpp:31
        I(cpphdl_n1621, cpphdl_n1622) <+ V(cpphdl_n1621, cpphdl_n1622) / 1000.0;
        // device 1052, IC IC185, analog/basic/inverter.hpp:11
        I(cpphdl_n1600, Vdd) <+ cpphdl_channel(V(BIT_N7_2, Vdd), V(cpphdl_n1600, Vdd), 0.080000000000000002, 0.69999999999999996, -1.0);
        // device 1053, IC IC185, analog/basic/inverter.hpp:12
        I(cpphdl_n1600, Vss) <+ cpphdl_channel(V(BIT_N7_2, Vss), V(cpphdl_n1600, Vss), 0.080000000000000002, 0.69999999999999996, 1.0);
        // device 1054, IC IC182, analog/basic/mos_r2r_dac.hpp:27
        I(cpphdl_n1600, Vss) <+ 2.9999999999999998e-15 * ddt(V(cpphdl_n1600, Vss)); // Bench initial voltage = 0.0 V.
        // device 1055, IC IC182, analog/basic/mos_r2r_dac.hpp:28
        I(cpphdl_n1600, cpphdl_n1623) <+ V(cpphdl_n1600, cpphdl_n1623) / 2000.0;
        // device 1056, IC IC182, analog/basic/mos_r2r_dac.hpp:29
        I(cpphdl_n1623, Vss) <+ 2.9999999999999998e-15 * ddt(V(cpphdl_n1623, Vss)); // Bench initial voltage = 0.0 V.
        // device 1057, IC IC182, analog/basic/mos_r2r_dac.hpp:31
        I(cpphdl_n1622, cpphdl_n1623) <+ V(cpphdl_n1622, cpphdl_n1623) / 1000.0;
        // device 1058, IC IC186, analog/basic/inverter.hpp:11
        I(cpphdl_n1604, Vdd) <+ cpphdl_channel(V(BIT_N7_3, Vdd), V(cpphdl_n1604, Vdd), 0.080000000000000002, 0.69999999999999996, -1.0);
        // device 1059, IC IC186, analog/basic/inverter.hpp:12
        I(cpphdl_n1604, Vss) <+ cpphdl_channel(V(BIT_N7_3, Vss), V(cpphdl_n1604, Vss), 0.080000000000000002, 0.69999999999999996, 1.0);
        // device 1060, IC IC182, analog/basic/mos_r2r_dac.hpp:27
        I(cpphdl_n1604, Vss) <+ 2.9999999999999998e-15 * ddt(V(cpphdl_n1604, Vss)); // Bench initial voltage = 0.0 V.
        // device 1061, IC IC182, analog/basic/mos_r2r_dac.hpp:28
        I(cpphdl_n1604, cpphdl_n1624) <+ V(cpphdl_n1604, cpphdl_n1624) / 2000.0;
        // device 1062, IC IC182, analog/basic/mos_r2r_dac.hpp:29
        I(cpphdl_n1624, Vss) <+ 2.9999999999999998e-15 * ddt(V(cpphdl_n1624, Vss)); // Bench initial voltage = 0.0 V.
        // device 1063, IC IC182, analog/basic/mos_r2r_dac.hpp:31
        I(cpphdl_n1623, cpphdl_n1624) <+ V(cpphdl_n1623, cpphdl_n1624) / 1000.0;
        // device 1064, IC IC187, analog/basic/inverter.hpp:11
        I(cpphdl_n1608, Vdd) <+ cpphdl_channel(V(BIT_N7_4, Vdd), V(cpphdl_n1608, Vdd), 0.080000000000000002, 0.69999999999999996, -1.0);
        // device 1065, IC IC187, analog/basic/inverter.hpp:12
        I(cpphdl_n1608, Vss) <+ cpphdl_channel(V(BIT_N7_4, Vss), V(cpphdl_n1608, Vss), 0.080000000000000002, 0.69999999999999996, 1.0);
        // device 1066, IC IC182, analog/basic/mos_r2r_dac.hpp:27
        I(cpphdl_n1608, Vss) <+ 2.9999999999999998e-15 * ddt(V(cpphdl_n1608, Vss)); // Bench initial voltage = 0.0 V.
        // device 1067, IC IC182, analog/basic/mos_r2r_dac.hpp:28
        I(cpphdl_n1608, cpphdl_n1625) <+ V(cpphdl_n1608, cpphdl_n1625) / 2000.0;
        // device 1068, IC IC182, analog/basic/mos_r2r_dac.hpp:29
        I(cpphdl_n1625, Vss) <+ 2.9999999999999998e-15 * ddt(V(cpphdl_n1625, Vss)); // Bench initial voltage = 0.0 V.
        // device 1069, IC IC182, analog/basic/mos_r2r_dac.hpp:31
        I(cpphdl_n1624, cpphdl_n1625) <+ V(cpphdl_n1624, cpphdl_n1625) / 1000.0;
        // device 1070, IC IC188, analog/basic/inverter.hpp:11
        I(cpphdl_n1612, Vdd) <+ cpphdl_channel(V(BIT_N7_5, Vdd), V(cpphdl_n1612, Vdd), 0.080000000000000002, 0.69999999999999996, -1.0);
        // device 1071, IC IC188, analog/basic/inverter.hpp:12
        I(cpphdl_n1612, Vss) <+ cpphdl_channel(V(BIT_N7_5, Vss), V(cpphdl_n1612, Vss), 0.080000000000000002, 0.69999999999999996, 1.0);
        // device 1072, IC IC182, analog/basic/mos_r2r_dac.hpp:27
        I(cpphdl_n1612, Vss) <+ 2.9999999999999998e-15 * ddt(V(cpphdl_n1612, Vss)); // Bench initial voltage = 0.0 V.
        // device 1073, IC IC182, analog/basic/mos_r2r_dac.hpp:28
        I(cpphdl_n1612, cpphdl_n1626) <+ V(cpphdl_n1612, cpphdl_n1626) / 2000.0;
        // device 1074, IC IC182, analog/basic/mos_r2r_dac.hpp:29
        I(cpphdl_n1626, Vss) <+ 2.9999999999999998e-15 * ddt(V(cpphdl_n1626, Vss)); // Bench initial voltage = 0.0 V.
        // device 1075, IC IC182, analog/basic/mos_r2r_dac.hpp:31
        I(cpphdl_n1625, cpphdl_n1626) <+ V(cpphdl_n1625, cpphdl_n1626) / 1000.0;
        // device 1076, IC IC189, analog/basic/inverter.hpp:11
        I(cpphdl_n1616, Vdd) <+ cpphdl_channel(V(BIT_N7_6, Vdd), V(cpphdl_n1616, Vdd), 0.080000000000000002, 0.69999999999999996, -1.0);
        // device 1077, IC IC189, analog/basic/inverter.hpp:12
        I(cpphdl_n1616, Vss) <+ cpphdl_channel(V(BIT_N7_6, Vss), V(cpphdl_n1616, Vss), 0.080000000000000002, 0.69999999999999996, 1.0);
        // device 1078, IC IC182, analog/basic/mos_r2r_dac.hpp:27
        I(cpphdl_n1616, Vss) <+ 2.9999999999999998e-15 * ddt(V(cpphdl_n1616, Vss)); // Bench initial voltage = 0.0 V.
        // device 1079, IC IC182, analog/basic/mos_r2r_dac.hpp:28
        I(cpphdl_n1616, cpphdl_n1627) <+ V(cpphdl_n1616, cpphdl_n1627) / 2000.0;
        // device 1080, IC IC182, analog/basic/mos_r2r_dac.hpp:29
        I(cpphdl_n1627, Vss) <+ 2.9999999999999998e-15 * ddt(V(cpphdl_n1627, Vss)); // Bench initial voltage = 0.0 V.
        // device 1081, IC IC182, analog/basic/mos_r2r_dac.hpp:31
        I(cpphdl_n1626, cpphdl_n1627) <+ V(cpphdl_n1626, cpphdl_n1627) / 1000.0;
        // device 1082, IC IC190, analog/basic/inverter.hpp:11
        I(cpphdl_n1620, Vdd) <+ cpphdl_channel(V(BIT_N7_7, Vdd), V(cpphdl_n1620, Vdd), 0.080000000000000002, 0.69999999999999996, -1.0);
        // device 1083, IC IC190, analog/basic/inverter.hpp:12
        I(cpphdl_n1620, Vss) <+ cpphdl_channel(V(BIT_N7_7, Vss), V(cpphdl_n1620, Vss), 0.080000000000000002, 0.69999999999999996, 1.0);
        // device 1084, IC IC182, analog/basic/mos_r2r_dac.hpp:27
        I(cpphdl_n1620, Vss) <+ 2.9999999999999998e-15 * ddt(V(cpphdl_n1620, Vss)); // Bench initial voltage = 0.0 V.
        // device 1085, IC IC182, analog/basic/mos_r2r_dac.hpp:28
        I(cpphdl_n1620, cpphdl_n1632) <+ V(cpphdl_n1620, cpphdl_n1632) / 2000.0;
        // device 1086, IC IC182, analog/basic/mos_r2r_dac.hpp:29
        I(cpphdl_n1632, Vss) <+ 2.9999999999999998e-15 * ddt(V(cpphdl_n1632, Vss)); // Bench initial voltage = 0.0 V.
        // device 1087, IC IC182, analog/basic/mos_r2r_dac.hpp:31
        I(cpphdl_n1627, cpphdl_n1632) <+ V(cpphdl_n1627, cpphdl_n1632) / 1000.0;
        // device 1088, IC IC182, analog/basic/mos_r2r_dac.hpp:33
        I(Vss, cpphdl_n1621) <+ V(Vss, cpphdl_n1621) / 2000.0;
        // device 1089, IC IC191, analog/basic/nmos_resistor_amplifier.hpp:23
        I(Vdd, cpphdl_n1641) <+ V(Vdd, cpphdl_n1641) / 1000.0;
        // device 1090, IC IC191, analog/basic/nmos_resistor_amplifier.hpp:24
        I(Vdd, cpphdl_n1640) <+ V(Vdd, cpphdl_n1640) / 1000.0;
        // device 1091, IC IC191, analog/basic/nmos_resistor_amplifier.hpp:25
        I(cpphdl_n1641, cpphdl_n1635) <+ cpphdl_channel(V(cpphdl_n1631, cpphdl_n1635), V(cpphdl_n1641, cpphdl_n1635), 0.0074999999999999997, 0.69999999999999996, 1.0);
        // device 1092, IC IC191, analog/basic/nmos_resistor_amplifier.hpp:26
        I(cpphdl_n1640, cpphdl_n1636) <+ cpphdl_channel(V(cpphdl_n1632, cpphdl_n1636), V(cpphdl_n1640, cpphdl_n1636), 0.0074999999999999997, 0.69999999999999996, 1.0);
        // device 1093, IC IC191, analog/basic/nmos_resistor_amplifier.hpp:27
        I(cpphdl_n1637, cpphdl_n1635) <+ V(cpphdl_n1637, cpphdl_n1635) / 100.0;
        // device 1094, IC IC191, analog/basic/nmos_resistor_amplifier.hpp:28
        I(cpphdl_n1637, cpphdl_n1636) <+ V(cpphdl_n1637, cpphdl_n1636) / 100.0;
        // device 1095, IC IC191, analog/basic/nmos_resistor_amplifier.hpp:29
        I(Vss, cpphdl_n1637) <+ V(Vss, cpphdl_n1637) / 300.0;
        // device 1096, IC IC191, analog/basic/nmos_resistor_amplifier.hpp:30
        I(cpphdl_n1641, Vdd) <+ 2.9999999999999998e-13 * ddt(V(cpphdl_n1641, Vdd)); // Bench initial voltage = 0.0 V.
        // device 1097, IC IC191, analog/basic/nmos_resistor_amplifier.hpp:31
        I(cpphdl_n1640, Vdd) <+ 2.9999999999999998e-13 * ddt(V(cpphdl_n1640, Vdd)); // Bench initial voltage = 0.0 V.
        // device 1098, IC IC191, analog/basic/nmos_resistor_amplifier.hpp:32
        I(cpphdl_n1637, Vss) <+ 4e-14 * ddt(V(cpphdl_n1637, Vss)); // Bench initial voltage = 0.0 V.
        // device 1099, IC IC191, analog/basic/nmos_resistor_amplifier.hpp:34
        I(cpphdl_n1631, cpphdl_n1635) <+ 2e-14 * ddt(V(cpphdl_n1631, cpphdl_n1635)); // Bench initial voltage = 0.0 V.
        // device 1100, IC IC191, analog/basic/nmos_resistor_amplifier.hpp:35
        I(cpphdl_n1632, cpphdl_n1636) <+ 2e-14 * ddt(V(cpphdl_n1632, cpphdl_n1636)); // Bench initial voltage = 0.0 V.
        // device 1101, IC IC191, analog/basic/nmos_resistor_amplifier.hpp:36
        I(cpphdl_n1631, cpphdl_n1641) <+ 2.9999999999999998e-15 * ddt(V(cpphdl_n1631, cpphdl_n1641)); // Bench initial voltage = 0.0 V.
        // device 1102, IC IC191, analog/basic/nmos_resistor_amplifier.hpp:37
        I(cpphdl_n1632, cpphdl_n1640) <+ 2.9999999999999998e-15 * ddt(V(cpphdl_n1632, cpphdl_n1640)); // Bench initial voltage = 0.0 V.
        // device 1103, IC IC192, analog/basic/strongarm_comparator.hpp:28
        I(cpphdl_n1645, cpphdl_n1647) <+ cpphdl_channel(V(cpphdl_n1640, cpphdl_n1647), V(cpphdl_n1645, cpphdl_n1647), 0.0080000000000000002, 0.69999999999999996, 1.0);
        // device 1104, IC IC192, analog/basic/strongarm_comparator.hpp:29
        I(cpphdl_n1646, cpphdl_n1647) <+ cpphdl_channel(V(cpphdl_n1641, cpphdl_n1647), V(cpphdl_n1646, cpphdl_n1647), 0.0080000000000000002, 0.69999999999999996, 1.0);
        // device 1105, IC IC192, analog/basic/strongarm_comparator.hpp:30
        I(cpphdl_n1647, Vss) <+ cpphdl_channel(V(EVALUATE, Vss), V(cpphdl_n1647, Vss), 0.0080000000000000002, 0.69999999999999996, 1.0);
        // device 1106, IC IC192, analog/basic/strongarm_comparator.hpp:33
        I(cpphdl_n1660, cpphdl_n1645) <+ cpphdl_channel(V(cpphdl_n1664, cpphdl_n1645), V(cpphdl_n1660, cpphdl_n1645), 0.0040000000000000001, 0.69999999999999996, 1.0);
        // device 1107, IC IC192, analog/basic/strongarm_comparator.hpp:34
        I(cpphdl_n1664, cpphdl_n1646) <+ cpphdl_channel(V(cpphdl_n1660, cpphdl_n1646), V(cpphdl_n1664, cpphdl_n1646), 0.0040000000000000001, 0.69999999999999996, 1.0);
        // device 1108, IC IC192, analog/basic/strongarm_comparator.hpp:35
        I(cpphdl_n1664, Vdd) <+ cpphdl_channel(V(cpphdl_n1660, Vdd), V(cpphdl_n1664, Vdd), 0.002, 0.69999999999999996, -1.0);
        // device 1109, IC IC192, analog/basic/strongarm_comparator.hpp:36
        I(cpphdl_n1660, Vdd) <+ cpphdl_channel(V(cpphdl_n1664, Vdd), V(cpphdl_n1660, Vdd), 0.002, 0.69999999999999996, -1.0);
        // device 1110, IC IC192, analog/basic/strongarm_comparator.hpp:38
        I(cpphdl_n1645, Vdd) <+ cpphdl_channel(V(EVALUATE, Vdd), V(cpphdl_n1645, Vdd), 0.002, 0.69999999999999996, -1.0);
        // device 1111, IC IC192, analog/basic/strongarm_comparator.hpp:39
        I(cpphdl_n1646, Vdd) <+ cpphdl_channel(V(EVALUATE, Vdd), V(cpphdl_n1646, Vdd), 0.002, 0.69999999999999996, -1.0);
        // device 1112, IC IC192, analog/basic/strongarm_comparator.hpp:40
        I(cpphdl_n1664, Vdd) <+ cpphdl_channel(V(EVALUATE, Vdd), V(cpphdl_n1664, Vdd), 0.002, 0.69999999999999996, -1.0);
        // device 1113, IC IC192, analog/basic/strongarm_comparator.hpp:41
        I(cpphdl_n1660, Vdd) <+ cpphdl_channel(V(EVALUATE, Vdd), V(cpphdl_n1660, Vdd), 0.002, 0.69999999999999996, -1.0);
        // device 1114, IC IC192, analog/basic/strongarm_comparator.hpp:42
        I(cpphdl_n1645, Vss) <+ 2.9999999999999998e-14 * ddt(V(cpphdl_n1645, Vss)); // Bench initial voltage = 0.0 V.
        // device 1115, IC IC192, analog/basic/strongarm_comparator.hpp:43
        I(cpphdl_n1646, Vss) <+ 2.9999999999999998e-14 * ddt(V(cpphdl_n1646, Vss)); // Bench initial voltage = 0.0 V.
        // device 1116, IC IC192, analog/basic/strongarm_comparator.hpp:44
        I(cpphdl_n1647, Vss) <+ 2.9999999999999998e-14 * ddt(V(cpphdl_n1647, Vss)); // Bench initial voltage = 0.0 V.
        // device 1117, IC IC192, analog/basic/strongarm_comparator.hpp:45
        I(cpphdl_n1664, Vss) <+ 5.0000000000000002e-14 * ddt(V(cpphdl_n1664, Vss)); // Bench initial voltage = 0.0 V.
        // device 1118, IC IC192, analog/basic/strongarm_comparator.hpp:46
        I(cpphdl_n1660, Vss) <+ 5.0000000000000002e-14 * ddt(V(cpphdl_n1660, Vss)); // Bench initial voltage = 0.0 V.
        // device 1119, IC IC192, analog/basic/strongarm_comparator.hpp:47
        I(cpphdl_n1640, cpphdl_n1647) <+ 2e-14 * ddt(V(cpphdl_n1640, cpphdl_n1647)); // Bench initial voltage = 0.0 V.
        // device 1120, IC IC192, analog/basic/strongarm_comparator.hpp:48
        I(cpphdl_n1641, cpphdl_n1647) <+ 2e-14 * ddt(V(cpphdl_n1641, cpphdl_n1647)); // Bench initial voltage = 0.0 V.
        // device 1121, IC IC192, analog/basic/strongarm_comparator.hpp:49
        I(cpphdl_n1640, cpphdl_n1645) <+ 2.9999999999999998e-15 * ddt(V(cpphdl_n1640, cpphdl_n1645)); // Bench initial voltage = 0.0 V.
        // device 1122, IC IC192, analog/basic/strongarm_comparator.hpp:50
        I(cpphdl_n1641, cpphdl_n1646) <+ 2.9999999999999998e-15 * ddt(V(cpphdl_n1641, cpphdl_n1646)); // Bench initial voltage = 0.0 V.
        // device 1123, IC IC194, analog/basic/inverter.hpp:11
        I(cpphdl_n1668, Vdd) <+ cpphdl_channel(V(cpphdl_n1660, Vdd), V(cpphdl_n1668, Vdd), 0.001, 0.69999999999999996, -1.0);
        // device 1124, IC IC194, analog/basic/inverter.hpp:12
        I(cpphdl_n1668, Vss) <+ cpphdl_channel(V(cpphdl_n1660, Vss), V(cpphdl_n1668, Vss), 0.001, 0.69999999999999996, 1.0);
        // device 1125, IC IC196, analog/basic/inverter.hpp:11
        I(cpphdl_n1682, Vdd) <+ cpphdl_channel(V(cpphdl_n1668, Vdd), V(cpphdl_n1682, Vdd), 0.0040000000000000001, 0.69999999999999996, -1.0);
        // device 1126, IC IC196, analog/basic/inverter.hpp:12
        I(cpphdl_n1682, Vss) <+ cpphdl_channel(V(cpphdl_n1668, Vss), V(cpphdl_n1682, Vss), 0.0040000000000000001, 0.69999999999999996, 1.0);
        // device 1127, IC IC193, analog/basic/buffered_nand_latch.hpp:34
        I(cpphdl_n1660, Vss) <+ 2.0000000000000002e-15 * ddt(V(cpphdl_n1660, Vss)); // Bench initial voltage = 0.0 V.
        // device 1128, IC IC193, analog/basic/buffered_nand_latch.hpp:35
        I(cpphdl_n1660, cpphdl_n1668) <+ 1.0000000000000001e-15 * ddt(V(cpphdl_n1660, cpphdl_n1668)); // Bench initial voltage = 0.0 V.
        // device 1129, IC IC193, analog/basic/buffered_nand_latch.hpp:36
        I(cpphdl_n1668, Vss) <+ 5e-15 * ddt(V(cpphdl_n1668, Vss)); // Bench initial voltage = 0.0 V.
        // device 1130, IC IC193, analog/basic/buffered_nand_latch.hpp:37
        I(cpphdl_n1668, Vss) <+ 8.0000000000000006e-15 * ddt(V(cpphdl_n1668, Vss)); // Bench initial voltage = 0.0 V.
        // device 1131, IC IC193, analog/basic/buffered_nand_latch.hpp:38
        I(cpphdl_n1682, Vss) <+ 1e-14 * ddt(V(cpphdl_n1682, Vss)); // Bench initial voltage = 0.0 V.
        // device 1132, IC IC195, analog/basic/inverter.hpp:11
        I(cpphdl_n1672, Vdd) <+ cpphdl_channel(V(cpphdl_n1664, Vdd), V(cpphdl_n1672, Vdd), 0.001, 0.69999999999999996, -1.0);
        // device 1133, IC IC195, analog/basic/inverter.hpp:12
        I(cpphdl_n1672, Vss) <+ cpphdl_channel(V(cpphdl_n1664, Vss), V(cpphdl_n1672, Vss), 0.001, 0.69999999999999996, 1.0);
        // device 1134, IC IC197, analog/basic/inverter.hpp:11
        I(cpphdl_n1688, Vdd) <+ cpphdl_channel(V(cpphdl_n1672, Vdd), V(cpphdl_n1688, Vdd), 0.0040000000000000001, 0.69999999999999996, -1.0);
        // device 1135, IC IC197, analog/basic/inverter.hpp:12
        I(cpphdl_n1688, Vss) <+ cpphdl_channel(V(cpphdl_n1672, Vss), V(cpphdl_n1688, Vss), 0.0040000000000000001, 0.69999999999999996, 1.0);
        // device 1136, IC IC193, analog/basic/buffered_nand_latch.hpp:34
        I(cpphdl_n1664, Vss) <+ 2.0000000000000002e-15 * ddt(V(cpphdl_n1664, Vss)); // Bench initial voltage = 0.0 V.
        // device 1137, IC IC193, analog/basic/buffered_nand_latch.hpp:35
        I(cpphdl_n1664, cpphdl_n1672) <+ 1.0000000000000001e-15 * ddt(V(cpphdl_n1664, cpphdl_n1672)); // Bench initial voltage = 0.0 V.
        // device 1138, IC IC193, analog/basic/buffered_nand_latch.hpp:36
        I(cpphdl_n1672, Vss) <+ 5e-15 * ddt(V(cpphdl_n1672, Vss)); // Bench initial voltage = 0.0 V.
        // device 1139, IC IC193, analog/basic/buffered_nand_latch.hpp:37
        I(cpphdl_n1672, Vss) <+ 8.0000000000000006e-15 * ddt(V(cpphdl_n1672, Vss)); // Bench initial voltage = 0.0 V.
        // device 1140, IC IC193, analog/basic/buffered_nand_latch.hpp:38
        I(cpphdl_n1688, Vss) <+ 1e-14 * ddt(V(cpphdl_n1688, Vss)); // Bench initial voltage = 0.0 V.
        // device 1141, IC IC199, analog/basic/cmos_logic.hpp:17
        I(cpphdl_n2463, Vss) <+ 5.0000000000000002e-14 * ddt(V(cpphdl_n2463, Vss)); // Bench initial voltage = 0.0 V.
        // device 1142, IC IC199, analog/basic/cmos_logic.hpp:18
        I(cpphdl_n2463, Vdd) <+ cpphdl_channel(V(cpphdl_n1682, Vdd), V(cpphdl_n2463, Vdd), 0.01, 0.69999999999999996, -1.0);
        // device 1143, IC IC199, analog/basic/cmos_logic.hpp:19
        I(cpphdl_n2463, Vdd) <+ cpphdl_channel(V(cpphdl_n1690, Vdd), V(cpphdl_n2463, Vdd), 0.01, 0.69999999999999996, -1.0);
        // device 1144, IC IC199, analog/basic/cmos_logic.hpp:20
        I(cpphdl_n2463, cpphdl_n1685) <+ cpphdl_channel(V(cpphdl_n1682, cpphdl_n1685), V(cpphdl_n2463, cpphdl_n1685), 0.01, 0.69999999999999996, 1.0);
        // device 1145, IC IC199, analog/basic/cmos_logic.hpp:21
        I(cpphdl_n1685, Vss) <+ cpphdl_channel(V(cpphdl_n1690, Vss), V(cpphdl_n1685, Vss), 0.01, 0.69999999999999996, 1.0);
        // device 1146, IC IC199, analog/basic/cmos_logic.hpp:27
        I(cpphdl_n1685, Vss) <+ 1e-14 * ddt(V(cpphdl_n1685, Vss)); // Bench initial voltage = 0.0 V.
        // device 1147, IC IC200, analog/basic/cmos_logic.hpp:17
        I(cpphdl_n1690, Vss) <+ 5.0000000000000002e-14 * ddt(V(cpphdl_n1690, Vss)); // Bench initial voltage = 0.0 V.
        // device 1148, IC IC200, analog/basic/cmos_logic.hpp:18
        I(cpphdl_n1690, Vdd) <+ cpphdl_channel(V(cpphdl_n1688, Vdd), V(cpphdl_n1690, Vdd), 0.01, 0.69999999999999996, -1.0);
        // device 1149, IC IC200, analog/basic/cmos_logic.hpp:19
        I(cpphdl_n1690, Vdd) <+ cpphdl_channel(V(cpphdl_n2463, Vdd), V(cpphdl_n1690, Vdd), 0.01, 0.69999999999999996, -1.0);
        // device 1150, IC IC200, analog/basic/cmos_logic.hpp:20
        I(cpphdl_n1690, cpphdl_n1691) <+ cpphdl_channel(V(cpphdl_n1688, cpphdl_n1691), V(cpphdl_n1690, cpphdl_n1691), 0.01, 0.69999999999999996, 1.0);
        // device 1151, IC IC200, analog/basic/cmos_logic.hpp:21
        I(cpphdl_n1691, Vss) <+ cpphdl_channel(V(cpphdl_n2463, Vss), V(cpphdl_n1691, Vss), 0.01, 0.69999999999999996, 1.0);
        // device 1152, IC IC200, analog/basic/cmos_logic.hpp:27
        I(cpphdl_n1691, Vss) <+ 1e-14 * ddt(V(cpphdl_n1691, Vss)); // Bench initial voltage = 0.0 V.
        // device 1153, IC IC198, analog/basic/nand_latch.hpp:36
        I(cpphdl_n1682, Vss) <+ 2.9999999999999998e-15 * ddt(V(cpphdl_n1682, Vss)); // Bench initial voltage = 0.0 V.
        // device 1154, IC IC198, analog/basic/nand_latch.hpp:37
        I(cpphdl_n1688, Vss) <+ 2.9999999999999998e-15 * ddt(V(cpphdl_n1688, Vss)); // Bench initial voltage = 0.0 V.
        // device 1155, IC IC201, analog/basic/inverter.hpp:11
        I(cpphdl_n1696, Vdd) <+ cpphdl_channel(V(CLEAR, Vdd), V(cpphdl_n1696, Vdd), 0.01, 0.69999999999999996, -1.0);
        // device 1156, IC IC201, analog/basic/inverter.hpp:12
        I(cpphdl_n1696, Vss) <+ cpphdl_channel(V(CLEAR, Vss), V(cpphdl_n1696, Vss), 0.01, 0.69999999999999996, 1.0);
        // device 1157, IC IC198, analog/basic/nand_latch.hpp:58
        I(cpphdl_n1696, Vss) <+ 2.9999999999999998e-15 * ddt(V(cpphdl_n1696, Vss)); // Bench initial voltage = 0.0 V.
        // device 1158, IC IC198, analog/basic/nand_latch.hpp:59
        I(cpphdl_n2463, Vss) <+ cpphdl_channel(V(CLEAR, Vss), V(cpphdl_n2463, Vss), 0.050000000000000003, 0.69999999999999996, 1.0);
        // device 1159, IC IC198, analog/basic/nand_latch.hpp:60
        I(cpphdl_n1690, Vdd) <+ cpphdl_channel(V(cpphdl_n1696, Vdd), V(cpphdl_n1690, Vdd), 0.050000000000000003, 0.69999999999999996, -1.0);
        // device 1160, IC IC204, analog/basic/inverter.hpp:11
        I(cpphdl_n1720, Vdd) <+ cpphdl_channel(V(TRACK8, Vdd), V(cpphdl_n1720, Vdd), 0.0040000000000000001, 0.69999999999999996, -1.0);
        // device 1161, IC IC204, analog/basic/inverter.hpp:12
        I(cpphdl_n1720, Vss) <+ cpphdl_channel(V(TRACK8, Vss), V(cpphdl_n1720, Vss), 0.0040000000000000001, 0.69999999999999996, 1.0);
        // device 1162, IC IC203, analog/basic/mos_track_hold.hpp:31
        I(cpphdl_n1720, Vss) <+ 2e-14 * ddt(V(cpphdl_n1720, Vss)); // Bench initial voltage = 0.0 V.
        // device 1163, IC IC203, analog/basic/mos_track_hold.hpp:32
        I(cpphdl_n2286, cpphdl_n1774) <+ cpphdl_channel(V(TRACK8, cpphdl_n1774), V(cpphdl_n2286, cpphdl_n1774), 0.029999999999999999, 0.69999999999999996, 1.0);
        // device 1164, IC IC203, analog/basic/mos_track_hold.hpp:33
        I(cpphdl_n1774, cpphdl_n2286) <+ cpphdl_channel(V(cpphdl_n1720, cpphdl_n2286), V(cpphdl_n1774, cpphdl_n2286), 0.014999999999999999, 0.69999999999999996, -1.0);
        // device 1165, IC IC203, analog/basic/mos_track_hold.hpp:37
        I(cpphdl_n1774, cpphdl_n1774) <+ cpphdl_channel(V(cpphdl_n1720, cpphdl_n1774), V(cpphdl_n1774, cpphdl_n1774), 0.016, 0.69999999999999996, 1.0);
        // device 1166, IC IC203, analog/basic/mos_track_hold.hpp:38
        I(cpphdl_n1774, cpphdl_n1774) <+ cpphdl_channel(V(TRACK8, cpphdl_n1774), V(cpphdl_n1774, cpphdl_n1774), 0.0083999999999999995, 0.69999999999999996, -1.0);
        // device 1167, IC IC203, analog/basic/mos_track_hold.hpp:39
        I(cpphdl_n1774, Vss) <+ 1.5000000000000001e-12 * ddt(V(cpphdl_n1774, Vss)); // Bench initial voltage = 0.0 V.
        // device 1168, IC IC203, analog/basic/mos_track_hold.hpp:42
        I(TRACK8, cpphdl_n1774) <+ 2.0000000000000002e-15 * ddt(V(TRACK8, cpphdl_n1774)); // Bench initial voltage = -0.0 V.
        // device 1169, IC IC203, analog/basic/mos_track_hold.hpp:43
        I(cpphdl_n1720, cpphdl_n1774) <+ 2.0000000000000002e-15 * ddt(V(cpphdl_n1720, cpphdl_n1774)); // Bench initial voltage = 0.0 V.
        // device 1170, IC IC203, analog/basic/mos_track_hold.hpp:44
        I(cpphdl_n2286, cpphdl_n1774) <+ 1.0000000000000001e-15 * ddt(V(cpphdl_n2286, cpphdl_n1774)); // Bench initial voltage = 0.0 V.
        // device 1171, IC IC206, analog/basic/inverter.hpp:11
        I(cpphdl_n1735, Vdd) <+ cpphdl_channel(V(BIT_N8_0, Vdd), V(cpphdl_n1735, Vdd), 0.080000000000000002, 0.69999999999999996, -1.0);
        // device 1172, IC IC206, analog/basic/inverter.hpp:12
        I(cpphdl_n1735, Vss) <+ cpphdl_channel(V(BIT_N8_0, Vss), V(cpphdl_n1735, Vss), 0.080000000000000002, 0.69999999999999996, 1.0);
        // device 1173, IC IC205, analog/basic/mos_r2r_dac.hpp:27
        I(cpphdl_n1735, Vss) <+ 2.9999999999999998e-15 * ddt(V(cpphdl_n1735, Vss)); // Bench initial voltage = 0.0 V.
        // device 1174, IC IC205, analog/basic/mos_r2r_dac.hpp:28
        I(cpphdl_n1735, cpphdl_n1764) <+ V(cpphdl_n1735, cpphdl_n1764) / 2000.0;
        // device 1175, IC IC205, analog/basic/mos_r2r_dac.hpp:29
        I(cpphdl_n1764, Vss) <+ 2.9999999999999998e-15 * ddt(V(cpphdl_n1764, Vss)); // Bench initial voltage = 0.0 V.
        // device 1176, IC IC207, analog/basic/inverter.hpp:11
        I(cpphdl_n1739, Vdd) <+ cpphdl_channel(V(BIT_N8_1, Vdd), V(cpphdl_n1739, Vdd), 0.080000000000000002, 0.69999999999999996, -1.0);
        // device 1177, IC IC207, analog/basic/inverter.hpp:12
        I(cpphdl_n1739, Vss) <+ cpphdl_channel(V(BIT_N8_1, Vss), V(cpphdl_n1739, Vss), 0.080000000000000002, 0.69999999999999996, 1.0);
        // device 1178, IC IC205, analog/basic/mos_r2r_dac.hpp:27
        I(cpphdl_n1739, Vss) <+ 2.9999999999999998e-15 * ddt(V(cpphdl_n1739, Vss)); // Bench initial voltage = 0.0 V.
        // device 1179, IC IC205, analog/basic/mos_r2r_dac.hpp:28
        I(cpphdl_n1739, cpphdl_n1765) <+ V(cpphdl_n1739, cpphdl_n1765) / 2000.0;
        // device 1180, IC IC205, analog/basic/mos_r2r_dac.hpp:29
        I(cpphdl_n1765, Vss) <+ 2.9999999999999998e-15 * ddt(V(cpphdl_n1765, Vss)); // Bench initial voltage = 0.0 V.
        // device 1181, IC IC205, analog/basic/mos_r2r_dac.hpp:31
        I(cpphdl_n1764, cpphdl_n1765) <+ V(cpphdl_n1764, cpphdl_n1765) / 1000.0;
        // device 1182, IC IC208, analog/basic/inverter.hpp:11
        I(cpphdl_n1743, Vdd) <+ cpphdl_channel(V(BIT_N8_2, Vdd), V(cpphdl_n1743, Vdd), 0.080000000000000002, 0.69999999999999996, -1.0);
        // device 1183, IC IC208, analog/basic/inverter.hpp:12
        I(cpphdl_n1743, Vss) <+ cpphdl_channel(V(BIT_N8_2, Vss), V(cpphdl_n1743, Vss), 0.080000000000000002, 0.69999999999999996, 1.0);
        // device 1184, IC IC205, analog/basic/mos_r2r_dac.hpp:27
        I(cpphdl_n1743, Vss) <+ 2.9999999999999998e-15 * ddt(V(cpphdl_n1743, Vss)); // Bench initial voltage = 0.0 V.
        // device 1185, IC IC205, analog/basic/mos_r2r_dac.hpp:28
        I(cpphdl_n1743, cpphdl_n1766) <+ V(cpphdl_n1743, cpphdl_n1766) / 2000.0;
        // device 1186, IC IC205, analog/basic/mos_r2r_dac.hpp:29
        I(cpphdl_n1766, Vss) <+ 2.9999999999999998e-15 * ddt(V(cpphdl_n1766, Vss)); // Bench initial voltage = 0.0 V.
        // device 1187, IC IC205, analog/basic/mos_r2r_dac.hpp:31
        I(cpphdl_n1765, cpphdl_n1766) <+ V(cpphdl_n1765, cpphdl_n1766) / 1000.0;
        // device 1188, IC IC209, analog/basic/inverter.hpp:11
        I(cpphdl_n1747, Vdd) <+ cpphdl_channel(V(BIT_N8_3, Vdd), V(cpphdl_n1747, Vdd), 0.080000000000000002, 0.69999999999999996, -1.0);
        // device 1189, IC IC209, analog/basic/inverter.hpp:12
        I(cpphdl_n1747, Vss) <+ cpphdl_channel(V(BIT_N8_3, Vss), V(cpphdl_n1747, Vss), 0.080000000000000002, 0.69999999999999996, 1.0);
        // device 1190, IC IC205, analog/basic/mos_r2r_dac.hpp:27
        I(cpphdl_n1747, Vss) <+ 2.9999999999999998e-15 * ddt(V(cpphdl_n1747, Vss)); // Bench initial voltage = 0.0 V.
        // device 1191, IC IC205, analog/basic/mos_r2r_dac.hpp:28
        I(cpphdl_n1747, cpphdl_n1767) <+ V(cpphdl_n1747, cpphdl_n1767) / 2000.0;
        // device 1192, IC IC205, analog/basic/mos_r2r_dac.hpp:29
        I(cpphdl_n1767, Vss) <+ 2.9999999999999998e-15 * ddt(V(cpphdl_n1767, Vss)); // Bench initial voltage = 0.0 V.
        // device 1193, IC IC205, analog/basic/mos_r2r_dac.hpp:31
        I(cpphdl_n1766, cpphdl_n1767) <+ V(cpphdl_n1766, cpphdl_n1767) / 1000.0;
        // device 1194, IC IC210, analog/basic/inverter.hpp:11
        I(cpphdl_n1751, Vdd) <+ cpphdl_channel(V(BIT_N8_4, Vdd), V(cpphdl_n1751, Vdd), 0.080000000000000002, 0.69999999999999996, -1.0);
        // device 1195, IC IC210, analog/basic/inverter.hpp:12
        I(cpphdl_n1751, Vss) <+ cpphdl_channel(V(BIT_N8_4, Vss), V(cpphdl_n1751, Vss), 0.080000000000000002, 0.69999999999999996, 1.0);
        // device 1196, IC IC205, analog/basic/mos_r2r_dac.hpp:27
        I(cpphdl_n1751, Vss) <+ 2.9999999999999998e-15 * ddt(V(cpphdl_n1751, Vss)); // Bench initial voltage = 0.0 V.
        // device 1197, IC IC205, analog/basic/mos_r2r_dac.hpp:28
        I(cpphdl_n1751, cpphdl_n1768) <+ V(cpphdl_n1751, cpphdl_n1768) / 2000.0;
        // device 1198, IC IC205, analog/basic/mos_r2r_dac.hpp:29
        I(cpphdl_n1768, Vss) <+ 2.9999999999999998e-15 * ddt(V(cpphdl_n1768, Vss)); // Bench initial voltage = 0.0 V.
        // device 1199, IC IC205, analog/basic/mos_r2r_dac.hpp:31
        I(cpphdl_n1767, cpphdl_n1768) <+ V(cpphdl_n1767, cpphdl_n1768) / 1000.0;
        // device 1200, IC IC211, analog/basic/inverter.hpp:11
        I(cpphdl_n1755, Vdd) <+ cpphdl_channel(V(BIT_N8_5, Vdd), V(cpphdl_n1755, Vdd), 0.080000000000000002, 0.69999999999999996, -1.0);
        // device 1201, IC IC211, analog/basic/inverter.hpp:12
        I(cpphdl_n1755, Vss) <+ cpphdl_channel(V(BIT_N8_5, Vss), V(cpphdl_n1755, Vss), 0.080000000000000002, 0.69999999999999996, 1.0);
        // device 1202, IC IC205, analog/basic/mos_r2r_dac.hpp:27
        I(cpphdl_n1755, Vss) <+ 2.9999999999999998e-15 * ddt(V(cpphdl_n1755, Vss)); // Bench initial voltage = 0.0 V.
        // device 1203, IC IC205, analog/basic/mos_r2r_dac.hpp:28
        I(cpphdl_n1755, cpphdl_n1769) <+ V(cpphdl_n1755, cpphdl_n1769) / 2000.0;
        // device 1204, IC IC205, analog/basic/mos_r2r_dac.hpp:29
        I(cpphdl_n1769, Vss) <+ 2.9999999999999998e-15 * ddt(V(cpphdl_n1769, Vss)); // Bench initial voltage = 0.0 V.
        // device 1205, IC IC205, analog/basic/mos_r2r_dac.hpp:31
        I(cpphdl_n1768, cpphdl_n1769) <+ V(cpphdl_n1768, cpphdl_n1769) / 1000.0;
        // device 1206, IC IC212, analog/basic/inverter.hpp:11
        I(cpphdl_n1759, Vdd) <+ cpphdl_channel(V(BIT_N8_6, Vdd), V(cpphdl_n1759, Vdd), 0.080000000000000002, 0.69999999999999996, -1.0);
        // device 1207, IC IC212, analog/basic/inverter.hpp:12
        I(cpphdl_n1759, Vss) <+ cpphdl_channel(V(BIT_N8_6, Vss), V(cpphdl_n1759, Vss), 0.080000000000000002, 0.69999999999999996, 1.0);
        // device 1208, IC IC205, analog/basic/mos_r2r_dac.hpp:27
        I(cpphdl_n1759, Vss) <+ 2.9999999999999998e-15 * ddt(V(cpphdl_n1759, Vss)); // Bench initial voltage = 0.0 V.
        // device 1209, IC IC205, analog/basic/mos_r2r_dac.hpp:28
        I(cpphdl_n1759, cpphdl_n1770) <+ V(cpphdl_n1759, cpphdl_n1770) / 2000.0;
        // device 1210, IC IC205, analog/basic/mos_r2r_dac.hpp:29
        I(cpphdl_n1770, Vss) <+ 2.9999999999999998e-15 * ddt(V(cpphdl_n1770, Vss)); // Bench initial voltage = 0.0 V.
        // device 1211, IC IC205, analog/basic/mos_r2r_dac.hpp:31
        I(cpphdl_n1769, cpphdl_n1770) <+ V(cpphdl_n1769, cpphdl_n1770) / 1000.0;
        // device 1212, IC IC213, analog/basic/inverter.hpp:11
        I(cpphdl_n1763, Vdd) <+ cpphdl_channel(V(BIT_N8_7, Vdd), V(cpphdl_n1763, Vdd), 0.080000000000000002, 0.69999999999999996, -1.0);
        // device 1213, IC IC213, analog/basic/inverter.hpp:12
        I(cpphdl_n1763, Vss) <+ cpphdl_channel(V(BIT_N8_7, Vss), V(cpphdl_n1763, Vss), 0.080000000000000002, 0.69999999999999996, 1.0);
        // device 1214, IC IC205, analog/basic/mos_r2r_dac.hpp:27
        I(cpphdl_n1763, Vss) <+ 2.9999999999999998e-15 * ddt(V(cpphdl_n1763, Vss)); // Bench initial voltage = 0.0 V.
        // device 1215, IC IC205, analog/basic/mos_r2r_dac.hpp:28
        I(cpphdl_n1763, cpphdl_n1775) <+ V(cpphdl_n1763, cpphdl_n1775) / 2000.0;
        // device 1216, IC IC205, analog/basic/mos_r2r_dac.hpp:29
        I(cpphdl_n1775, Vss) <+ 2.9999999999999998e-15 * ddt(V(cpphdl_n1775, Vss)); // Bench initial voltage = 0.0 V.
        // device 1217, IC IC205, analog/basic/mos_r2r_dac.hpp:31
        I(cpphdl_n1770, cpphdl_n1775) <+ V(cpphdl_n1770, cpphdl_n1775) / 1000.0;
        // device 1218, IC IC205, analog/basic/mos_r2r_dac.hpp:33
        I(Vss, cpphdl_n1764) <+ V(Vss, cpphdl_n1764) / 2000.0;
        // device 1219, IC IC214, analog/basic/nmos_resistor_amplifier.hpp:23
        I(Vdd, cpphdl_n1784) <+ V(Vdd, cpphdl_n1784) / 1000.0;
        // device 1220, IC IC214, analog/basic/nmos_resistor_amplifier.hpp:24
        I(Vdd, cpphdl_n1783) <+ V(Vdd, cpphdl_n1783) / 1000.0;
        // device 1221, IC IC214, analog/basic/nmos_resistor_amplifier.hpp:25
        I(cpphdl_n1784, cpphdl_n1778) <+ cpphdl_channel(V(cpphdl_n1774, cpphdl_n1778), V(cpphdl_n1784, cpphdl_n1778), 0.0074999999999999997, 0.69999999999999996, 1.0);
        // device 1222, IC IC214, analog/basic/nmos_resistor_amplifier.hpp:26
        I(cpphdl_n1783, cpphdl_n1779) <+ cpphdl_channel(V(cpphdl_n1775, cpphdl_n1779), V(cpphdl_n1783, cpphdl_n1779), 0.0074999999999999997, 0.69999999999999996, 1.0);
        // device 1223, IC IC214, analog/basic/nmos_resistor_amplifier.hpp:27
        I(cpphdl_n1780, cpphdl_n1778) <+ V(cpphdl_n1780, cpphdl_n1778) / 100.0;
        // device 1224, IC IC214, analog/basic/nmos_resistor_amplifier.hpp:28
        I(cpphdl_n1780, cpphdl_n1779) <+ V(cpphdl_n1780, cpphdl_n1779) / 100.0;
        // device 1225, IC IC214, analog/basic/nmos_resistor_amplifier.hpp:29
        I(Vss, cpphdl_n1780) <+ V(Vss, cpphdl_n1780) / 300.0;
        // device 1226, IC IC214, analog/basic/nmos_resistor_amplifier.hpp:30
        I(cpphdl_n1784, Vdd) <+ 2.9999999999999998e-13 * ddt(V(cpphdl_n1784, Vdd)); // Bench initial voltage = 0.0 V.
        // device 1227, IC IC214, analog/basic/nmos_resistor_amplifier.hpp:31
        I(cpphdl_n1783, Vdd) <+ 2.9999999999999998e-13 * ddt(V(cpphdl_n1783, Vdd)); // Bench initial voltage = 0.0 V.
        // device 1228, IC IC214, analog/basic/nmos_resistor_amplifier.hpp:32
        I(cpphdl_n1780, Vss) <+ 4e-14 * ddt(V(cpphdl_n1780, Vss)); // Bench initial voltage = 0.0 V.
        // device 1229, IC IC214, analog/basic/nmos_resistor_amplifier.hpp:34
        I(cpphdl_n1774, cpphdl_n1778) <+ 2e-14 * ddt(V(cpphdl_n1774, cpphdl_n1778)); // Bench initial voltage = 0.0 V.
        // device 1230, IC IC214, analog/basic/nmos_resistor_amplifier.hpp:35
        I(cpphdl_n1775, cpphdl_n1779) <+ 2e-14 * ddt(V(cpphdl_n1775, cpphdl_n1779)); // Bench initial voltage = 0.0 V.
        // device 1231, IC IC214, analog/basic/nmos_resistor_amplifier.hpp:36
        I(cpphdl_n1774, cpphdl_n1784) <+ 2.9999999999999998e-15 * ddt(V(cpphdl_n1774, cpphdl_n1784)); // Bench initial voltage = 0.0 V.
        // device 1232, IC IC214, analog/basic/nmos_resistor_amplifier.hpp:37
        I(cpphdl_n1775, cpphdl_n1783) <+ 2.9999999999999998e-15 * ddt(V(cpphdl_n1775, cpphdl_n1783)); // Bench initial voltage = 0.0 V.
        // device 1233, IC IC215, analog/basic/strongarm_comparator.hpp:28
        I(cpphdl_n1788, cpphdl_n1790) <+ cpphdl_channel(V(cpphdl_n1783, cpphdl_n1790), V(cpphdl_n1788, cpphdl_n1790), 0.0080000000000000002, 0.69999999999999996, 1.0);
        // device 1234, IC IC215, analog/basic/strongarm_comparator.hpp:29
        I(cpphdl_n1789, cpphdl_n1790) <+ cpphdl_channel(V(cpphdl_n1784, cpphdl_n1790), V(cpphdl_n1789, cpphdl_n1790), 0.0080000000000000002, 0.69999999999999996, 1.0);
        // device 1235, IC IC215, analog/basic/strongarm_comparator.hpp:30
        I(cpphdl_n1790, Vss) <+ cpphdl_channel(V(EVALUATE, Vss), V(cpphdl_n1790, Vss), 0.0080000000000000002, 0.69999999999999996, 1.0);
        // device 1236, IC IC215, analog/basic/strongarm_comparator.hpp:33
        I(cpphdl_n1803, cpphdl_n1788) <+ cpphdl_channel(V(cpphdl_n1807, cpphdl_n1788), V(cpphdl_n1803, cpphdl_n1788), 0.0040000000000000001, 0.69999999999999996, 1.0);
        // device 1237, IC IC215, analog/basic/strongarm_comparator.hpp:34
        I(cpphdl_n1807, cpphdl_n1789) <+ cpphdl_channel(V(cpphdl_n1803, cpphdl_n1789), V(cpphdl_n1807, cpphdl_n1789), 0.0040000000000000001, 0.69999999999999996, 1.0);
        // device 1238, IC IC215, analog/basic/strongarm_comparator.hpp:35
        I(cpphdl_n1807, Vdd) <+ cpphdl_channel(V(cpphdl_n1803, Vdd), V(cpphdl_n1807, Vdd), 0.002, 0.69999999999999996, -1.0);
        // device 1239, IC IC215, analog/basic/strongarm_comparator.hpp:36
        I(cpphdl_n1803, Vdd) <+ cpphdl_channel(V(cpphdl_n1807, Vdd), V(cpphdl_n1803, Vdd), 0.002, 0.69999999999999996, -1.0);
        // device 1240, IC IC215, analog/basic/strongarm_comparator.hpp:38
        I(cpphdl_n1788, Vdd) <+ cpphdl_channel(V(EVALUATE, Vdd), V(cpphdl_n1788, Vdd), 0.002, 0.69999999999999996, -1.0);
        // device 1241, IC IC215, analog/basic/strongarm_comparator.hpp:39
        I(cpphdl_n1789, Vdd) <+ cpphdl_channel(V(EVALUATE, Vdd), V(cpphdl_n1789, Vdd), 0.002, 0.69999999999999996, -1.0);
        // device 1242, IC IC215, analog/basic/strongarm_comparator.hpp:40
        I(cpphdl_n1807, Vdd) <+ cpphdl_channel(V(EVALUATE, Vdd), V(cpphdl_n1807, Vdd), 0.002, 0.69999999999999996, -1.0);
        // device 1243, IC IC215, analog/basic/strongarm_comparator.hpp:41
        I(cpphdl_n1803, Vdd) <+ cpphdl_channel(V(EVALUATE, Vdd), V(cpphdl_n1803, Vdd), 0.002, 0.69999999999999996, -1.0);
        // device 1244, IC IC215, analog/basic/strongarm_comparator.hpp:42
        I(cpphdl_n1788, Vss) <+ 2.9999999999999998e-14 * ddt(V(cpphdl_n1788, Vss)); // Bench initial voltage = 0.0 V.
        // device 1245, IC IC215, analog/basic/strongarm_comparator.hpp:43
        I(cpphdl_n1789, Vss) <+ 2.9999999999999998e-14 * ddt(V(cpphdl_n1789, Vss)); // Bench initial voltage = 0.0 V.
        // device 1246, IC IC215, analog/basic/strongarm_comparator.hpp:44
        I(cpphdl_n1790, Vss) <+ 2.9999999999999998e-14 * ddt(V(cpphdl_n1790, Vss)); // Bench initial voltage = 0.0 V.
        // device 1247, IC IC215, analog/basic/strongarm_comparator.hpp:45
        I(cpphdl_n1807, Vss) <+ 5.0000000000000002e-14 * ddt(V(cpphdl_n1807, Vss)); // Bench initial voltage = 0.0 V.
        // device 1248, IC IC215, analog/basic/strongarm_comparator.hpp:46
        I(cpphdl_n1803, Vss) <+ 5.0000000000000002e-14 * ddt(V(cpphdl_n1803, Vss)); // Bench initial voltage = 0.0 V.
        // device 1249, IC IC215, analog/basic/strongarm_comparator.hpp:47
        I(cpphdl_n1783, cpphdl_n1790) <+ 2e-14 * ddt(V(cpphdl_n1783, cpphdl_n1790)); // Bench initial voltage = 0.0 V.
        // device 1250, IC IC215, analog/basic/strongarm_comparator.hpp:48
        I(cpphdl_n1784, cpphdl_n1790) <+ 2e-14 * ddt(V(cpphdl_n1784, cpphdl_n1790)); // Bench initial voltage = 0.0 V.
        // device 1251, IC IC215, analog/basic/strongarm_comparator.hpp:49
        I(cpphdl_n1783, cpphdl_n1788) <+ 2.9999999999999998e-15 * ddt(V(cpphdl_n1783, cpphdl_n1788)); // Bench initial voltage = 0.0 V.
        // device 1252, IC IC215, analog/basic/strongarm_comparator.hpp:50
        I(cpphdl_n1784, cpphdl_n1789) <+ 2.9999999999999998e-15 * ddt(V(cpphdl_n1784, cpphdl_n1789)); // Bench initial voltage = 0.0 V.
        // device 1253, IC IC217, analog/basic/inverter.hpp:11
        I(cpphdl_n1811, Vdd) <+ cpphdl_channel(V(cpphdl_n1803, Vdd), V(cpphdl_n1811, Vdd), 0.001, 0.69999999999999996, -1.0);
        // device 1254, IC IC217, analog/basic/inverter.hpp:12
        I(cpphdl_n1811, Vss) <+ cpphdl_channel(V(cpphdl_n1803, Vss), V(cpphdl_n1811, Vss), 0.001, 0.69999999999999996, 1.0);
        // device 1255, IC IC219, analog/basic/inverter.hpp:11
        I(cpphdl_n1825, Vdd) <+ cpphdl_channel(V(cpphdl_n1811, Vdd), V(cpphdl_n1825, Vdd), 0.0040000000000000001, 0.69999999999999996, -1.0);
        // device 1256, IC IC219, analog/basic/inverter.hpp:12
        I(cpphdl_n1825, Vss) <+ cpphdl_channel(V(cpphdl_n1811, Vss), V(cpphdl_n1825, Vss), 0.0040000000000000001, 0.69999999999999996, 1.0);
        // device 1257, IC IC216, analog/basic/buffered_nand_latch.hpp:34
        I(cpphdl_n1803, Vss) <+ 2.0000000000000002e-15 * ddt(V(cpphdl_n1803, Vss)); // Bench initial voltage = 0.0 V.
        // device 1258, IC IC216, analog/basic/buffered_nand_latch.hpp:35
        I(cpphdl_n1803, cpphdl_n1811) <+ 1.0000000000000001e-15 * ddt(V(cpphdl_n1803, cpphdl_n1811)); // Bench initial voltage = 0.0 V.
        // device 1259, IC IC216, analog/basic/buffered_nand_latch.hpp:36
        I(cpphdl_n1811, Vss) <+ 5e-15 * ddt(V(cpphdl_n1811, Vss)); // Bench initial voltage = 0.0 V.
        // device 1260, IC IC216, analog/basic/buffered_nand_latch.hpp:37
        I(cpphdl_n1811, Vss) <+ 8.0000000000000006e-15 * ddt(V(cpphdl_n1811, Vss)); // Bench initial voltage = 0.0 V.
        // device 1261, IC IC216, analog/basic/buffered_nand_latch.hpp:38
        I(cpphdl_n1825, Vss) <+ 1e-14 * ddt(V(cpphdl_n1825, Vss)); // Bench initial voltage = 0.0 V.
        // device 1262, IC IC218, analog/basic/inverter.hpp:11
        I(cpphdl_n1815, Vdd) <+ cpphdl_channel(V(cpphdl_n1807, Vdd), V(cpphdl_n1815, Vdd), 0.001, 0.69999999999999996, -1.0);
        // device 1263, IC IC218, analog/basic/inverter.hpp:12
        I(cpphdl_n1815, Vss) <+ cpphdl_channel(V(cpphdl_n1807, Vss), V(cpphdl_n1815, Vss), 0.001, 0.69999999999999996, 1.0);
        // device 1264, IC IC220, analog/basic/inverter.hpp:11
        I(cpphdl_n1831, Vdd) <+ cpphdl_channel(V(cpphdl_n1815, Vdd), V(cpphdl_n1831, Vdd), 0.0040000000000000001, 0.69999999999999996, -1.0);
        // device 1265, IC IC220, analog/basic/inverter.hpp:12
        I(cpphdl_n1831, Vss) <+ cpphdl_channel(V(cpphdl_n1815, Vss), V(cpphdl_n1831, Vss), 0.0040000000000000001, 0.69999999999999996, 1.0);
        // device 1266, IC IC216, analog/basic/buffered_nand_latch.hpp:34
        I(cpphdl_n1807, Vss) <+ 2.0000000000000002e-15 * ddt(V(cpphdl_n1807, Vss)); // Bench initial voltage = 0.0 V.
        // device 1267, IC IC216, analog/basic/buffered_nand_latch.hpp:35
        I(cpphdl_n1807, cpphdl_n1815) <+ 1.0000000000000001e-15 * ddt(V(cpphdl_n1807, cpphdl_n1815)); // Bench initial voltage = 0.0 V.
        // device 1268, IC IC216, analog/basic/buffered_nand_latch.hpp:36
        I(cpphdl_n1815, Vss) <+ 5e-15 * ddt(V(cpphdl_n1815, Vss)); // Bench initial voltage = 0.0 V.
        // device 1269, IC IC216, analog/basic/buffered_nand_latch.hpp:37
        I(cpphdl_n1815, Vss) <+ 8.0000000000000006e-15 * ddt(V(cpphdl_n1815, Vss)); // Bench initial voltage = 0.0 V.
        // device 1270, IC IC216, analog/basic/buffered_nand_latch.hpp:38
        I(cpphdl_n1831, Vss) <+ 1e-14 * ddt(V(cpphdl_n1831, Vss)); // Bench initial voltage = 0.0 V.
        // device 1271, IC IC222, analog/basic/cmos_logic.hpp:17
        I(cpphdl_n2468, Vss) <+ 5.0000000000000002e-14 * ddt(V(cpphdl_n2468, Vss)); // Bench initial voltage = 0.0 V.
        // device 1272, IC IC222, analog/basic/cmos_logic.hpp:18
        I(cpphdl_n2468, Vdd) <+ cpphdl_channel(V(cpphdl_n1825, Vdd), V(cpphdl_n2468, Vdd), 0.01, 0.69999999999999996, -1.0);
        // device 1273, IC IC222, analog/basic/cmos_logic.hpp:19
        I(cpphdl_n2468, Vdd) <+ cpphdl_channel(V(cpphdl_n1833, Vdd), V(cpphdl_n2468, Vdd), 0.01, 0.69999999999999996, -1.0);
        // device 1274, IC IC222, analog/basic/cmos_logic.hpp:20
        I(cpphdl_n2468, cpphdl_n1828) <+ cpphdl_channel(V(cpphdl_n1825, cpphdl_n1828), V(cpphdl_n2468, cpphdl_n1828), 0.01, 0.69999999999999996, 1.0);
        // device 1275, IC IC222, analog/basic/cmos_logic.hpp:21
        I(cpphdl_n1828, Vss) <+ cpphdl_channel(V(cpphdl_n1833, Vss), V(cpphdl_n1828, Vss), 0.01, 0.69999999999999996, 1.0);
        // device 1276, IC IC222, analog/basic/cmos_logic.hpp:27
        I(cpphdl_n1828, Vss) <+ 1e-14 * ddt(V(cpphdl_n1828, Vss)); // Bench initial voltage = 0.0 V.
        // device 1277, IC IC223, analog/basic/cmos_logic.hpp:17
        I(cpphdl_n1833, Vss) <+ 5.0000000000000002e-14 * ddt(V(cpphdl_n1833, Vss)); // Bench initial voltage = 0.0 V.
        // device 1278, IC IC223, analog/basic/cmos_logic.hpp:18
        I(cpphdl_n1833, Vdd) <+ cpphdl_channel(V(cpphdl_n1831, Vdd), V(cpphdl_n1833, Vdd), 0.01, 0.69999999999999996, -1.0);
        // device 1279, IC IC223, analog/basic/cmos_logic.hpp:19
        I(cpphdl_n1833, Vdd) <+ cpphdl_channel(V(cpphdl_n2468, Vdd), V(cpphdl_n1833, Vdd), 0.01, 0.69999999999999996, -1.0);
        // device 1280, IC IC223, analog/basic/cmos_logic.hpp:20
        I(cpphdl_n1833, cpphdl_n1834) <+ cpphdl_channel(V(cpphdl_n1831, cpphdl_n1834), V(cpphdl_n1833, cpphdl_n1834), 0.01, 0.69999999999999996, 1.0);
        // device 1281, IC IC223, analog/basic/cmos_logic.hpp:21
        I(cpphdl_n1834, Vss) <+ cpphdl_channel(V(cpphdl_n2468, Vss), V(cpphdl_n1834, Vss), 0.01, 0.69999999999999996, 1.0);
        // device 1282, IC IC223, analog/basic/cmos_logic.hpp:27
        I(cpphdl_n1834, Vss) <+ 1e-14 * ddt(V(cpphdl_n1834, Vss)); // Bench initial voltage = 0.0 V.
        // device 1283, IC IC221, analog/basic/nand_latch.hpp:36
        I(cpphdl_n1825, Vss) <+ 2.9999999999999998e-15 * ddt(V(cpphdl_n1825, Vss)); // Bench initial voltage = 0.0 V.
        // device 1284, IC IC221, analog/basic/nand_latch.hpp:37
        I(cpphdl_n1831, Vss) <+ 2.9999999999999998e-15 * ddt(V(cpphdl_n1831, Vss)); // Bench initial voltage = 0.0 V.
        // device 1285, IC IC224, analog/basic/inverter.hpp:11
        I(cpphdl_n1839, Vdd) <+ cpphdl_channel(V(CLEAR, Vdd), V(cpphdl_n1839, Vdd), 0.01, 0.69999999999999996, -1.0);
        // device 1286, IC IC224, analog/basic/inverter.hpp:12
        I(cpphdl_n1839, Vss) <+ cpphdl_channel(V(CLEAR, Vss), V(cpphdl_n1839, Vss), 0.01, 0.69999999999999996, 1.0);
        // device 1287, IC IC221, analog/basic/nand_latch.hpp:58
        I(cpphdl_n1839, Vss) <+ 2.9999999999999998e-15 * ddt(V(cpphdl_n1839, Vss)); // Bench initial voltage = 0.0 V.
        // device 1288, IC IC221, analog/basic/nand_latch.hpp:59
        I(cpphdl_n2468, Vss) <+ cpphdl_channel(V(CLEAR, Vss), V(cpphdl_n2468, Vss), 0.050000000000000003, 0.69999999999999996, 1.0);
        // device 1289, IC IC221, analog/basic/nand_latch.hpp:60
        I(cpphdl_n1833, Vdd) <+ cpphdl_channel(V(cpphdl_n1839, Vdd), V(cpphdl_n1833, Vdd), 0.050000000000000003, 0.69999999999999996, -1.0);
        // device 1290, IC IC227, analog/basic/inverter.hpp:11
        I(cpphdl_n1863, Vdd) <+ cpphdl_channel(V(TRACK9, Vdd), V(cpphdl_n1863, Vdd), 0.0040000000000000001, 0.69999999999999996, -1.0);
        // device 1291, IC IC227, analog/basic/inverter.hpp:12
        I(cpphdl_n1863, Vss) <+ cpphdl_channel(V(TRACK9, Vss), V(cpphdl_n1863, Vss), 0.0040000000000000001, 0.69999999999999996, 1.0);
        // device 1292, IC IC226, analog/basic/mos_track_hold.hpp:31
        I(cpphdl_n1863, Vss) <+ 2e-14 * ddt(V(cpphdl_n1863, Vss)); // Bench initial voltage = 0.0 V.
        // device 1293, IC IC226, analog/basic/mos_track_hold.hpp:32
        I(cpphdl_n2286, cpphdl_n1917) <+ cpphdl_channel(V(TRACK9, cpphdl_n1917), V(cpphdl_n2286, cpphdl_n1917), 0.029999999999999999, 0.69999999999999996, 1.0);
        // device 1294, IC IC226, analog/basic/mos_track_hold.hpp:33
        I(cpphdl_n1917, cpphdl_n2286) <+ cpphdl_channel(V(cpphdl_n1863, cpphdl_n2286), V(cpphdl_n1917, cpphdl_n2286), 0.014999999999999999, 0.69999999999999996, -1.0);
        // device 1295, IC IC226, analog/basic/mos_track_hold.hpp:37
        I(cpphdl_n1917, cpphdl_n1917) <+ cpphdl_channel(V(cpphdl_n1863, cpphdl_n1917), V(cpphdl_n1917, cpphdl_n1917), 0.016, 0.69999999999999996, 1.0);
        // device 1296, IC IC226, analog/basic/mos_track_hold.hpp:38
        I(cpphdl_n1917, cpphdl_n1917) <+ cpphdl_channel(V(TRACK9, cpphdl_n1917), V(cpphdl_n1917, cpphdl_n1917), 0.0083999999999999995, 0.69999999999999996, -1.0);
        // device 1297, IC IC226, analog/basic/mos_track_hold.hpp:39
        I(cpphdl_n1917, Vss) <+ 1.5000000000000001e-12 * ddt(V(cpphdl_n1917, Vss)); // Bench initial voltage = 0.0 V.
        // device 1298, IC IC226, analog/basic/mos_track_hold.hpp:42
        I(TRACK9, cpphdl_n1917) <+ 2.0000000000000002e-15 * ddt(V(TRACK9, cpphdl_n1917)); // Bench initial voltage = -0.0 V.
        // device 1299, IC IC226, analog/basic/mos_track_hold.hpp:43
        I(cpphdl_n1863, cpphdl_n1917) <+ 2.0000000000000002e-15 * ddt(V(cpphdl_n1863, cpphdl_n1917)); // Bench initial voltage = 0.0 V.
        // device 1300, IC IC226, analog/basic/mos_track_hold.hpp:44
        I(cpphdl_n2286, cpphdl_n1917) <+ 1.0000000000000001e-15 * ddt(V(cpphdl_n2286, cpphdl_n1917)); // Bench initial voltage = 0.0 V.
        // device 1301, IC IC229, analog/basic/inverter.hpp:11
        I(cpphdl_n1878, Vdd) <+ cpphdl_channel(V(BIT_N9_0, Vdd), V(cpphdl_n1878, Vdd), 0.080000000000000002, 0.69999999999999996, -1.0);
        // device 1302, IC IC229, analog/basic/inverter.hpp:12
        I(cpphdl_n1878, Vss) <+ cpphdl_channel(V(BIT_N9_0, Vss), V(cpphdl_n1878, Vss), 0.080000000000000002, 0.69999999999999996, 1.0);
        // device 1303, IC IC228, analog/basic/mos_r2r_dac.hpp:27
        I(cpphdl_n1878, Vss) <+ 2.9999999999999998e-15 * ddt(V(cpphdl_n1878, Vss)); // Bench initial voltage = 0.0 V.
        // device 1304, IC IC228, analog/basic/mos_r2r_dac.hpp:28
        I(cpphdl_n1878, cpphdl_n1907) <+ V(cpphdl_n1878, cpphdl_n1907) / 2000.0;
        // device 1305, IC IC228, analog/basic/mos_r2r_dac.hpp:29
        I(cpphdl_n1907, Vss) <+ 2.9999999999999998e-15 * ddt(V(cpphdl_n1907, Vss)); // Bench initial voltage = 0.0 V.
        // device 1306, IC IC230, analog/basic/inverter.hpp:11
        I(cpphdl_n1882, Vdd) <+ cpphdl_channel(V(BIT_N9_1, Vdd), V(cpphdl_n1882, Vdd), 0.080000000000000002, 0.69999999999999996, -1.0);
        // device 1307, IC IC230, analog/basic/inverter.hpp:12
        I(cpphdl_n1882, Vss) <+ cpphdl_channel(V(BIT_N9_1, Vss), V(cpphdl_n1882, Vss), 0.080000000000000002, 0.69999999999999996, 1.0);
        // device 1308, IC IC228, analog/basic/mos_r2r_dac.hpp:27
        I(cpphdl_n1882, Vss) <+ 2.9999999999999998e-15 * ddt(V(cpphdl_n1882, Vss)); // Bench initial voltage = 0.0 V.
        // device 1309, IC IC228, analog/basic/mos_r2r_dac.hpp:28
        I(cpphdl_n1882, cpphdl_n1908) <+ V(cpphdl_n1882, cpphdl_n1908) / 2000.0;
        // device 1310, IC IC228, analog/basic/mos_r2r_dac.hpp:29
        I(cpphdl_n1908, Vss) <+ 2.9999999999999998e-15 * ddt(V(cpphdl_n1908, Vss)); // Bench initial voltage = 0.0 V.
        // device 1311, IC IC228, analog/basic/mos_r2r_dac.hpp:31
        I(cpphdl_n1907, cpphdl_n1908) <+ V(cpphdl_n1907, cpphdl_n1908) / 1000.0;
        // device 1312, IC IC231, analog/basic/inverter.hpp:11
        I(cpphdl_n1886, Vdd) <+ cpphdl_channel(V(BIT_N9_2, Vdd), V(cpphdl_n1886, Vdd), 0.080000000000000002, 0.69999999999999996, -1.0);
        // device 1313, IC IC231, analog/basic/inverter.hpp:12
        I(cpphdl_n1886, Vss) <+ cpphdl_channel(V(BIT_N9_2, Vss), V(cpphdl_n1886, Vss), 0.080000000000000002, 0.69999999999999996, 1.0);
        // device 1314, IC IC228, analog/basic/mos_r2r_dac.hpp:27
        I(cpphdl_n1886, Vss) <+ 2.9999999999999998e-15 * ddt(V(cpphdl_n1886, Vss)); // Bench initial voltage = 0.0 V.
        // device 1315, IC IC228, analog/basic/mos_r2r_dac.hpp:28
        I(cpphdl_n1886, cpphdl_n1909) <+ V(cpphdl_n1886, cpphdl_n1909) / 2000.0;
        // device 1316, IC IC228, analog/basic/mos_r2r_dac.hpp:29
        I(cpphdl_n1909, Vss) <+ 2.9999999999999998e-15 * ddt(V(cpphdl_n1909, Vss)); // Bench initial voltage = 0.0 V.
        // device 1317, IC IC228, analog/basic/mos_r2r_dac.hpp:31
        I(cpphdl_n1908, cpphdl_n1909) <+ V(cpphdl_n1908, cpphdl_n1909) / 1000.0;
        // device 1318, IC IC232, analog/basic/inverter.hpp:11
        I(cpphdl_n1890, Vdd) <+ cpphdl_channel(V(BIT_N9_3, Vdd), V(cpphdl_n1890, Vdd), 0.080000000000000002, 0.69999999999999996, -1.0);
        // device 1319, IC IC232, analog/basic/inverter.hpp:12
        I(cpphdl_n1890, Vss) <+ cpphdl_channel(V(BIT_N9_3, Vss), V(cpphdl_n1890, Vss), 0.080000000000000002, 0.69999999999999996, 1.0);
        // device 1320, IC IC228, analog/basic/mos_r2r_dac.hpp:27
        I(cpphdl_n1890, Vss) <+ 2.9999999999999998e-15 * ddt(V(cpphdl_n1890, Vss)); // Bench initial voltage = 0.0 V.
        // device 1321, IC IC228, analog/basic/mos_r2r_dac.hpp:28
        I(cpphdl_n1890, cpphdl_n1910) <+ V(cpphdl_n1890, cpphdl_n1910) / 2000.0;
        // device 1322, IC IC228, analog/basic/mos_r2r_dac.hpp:29
        I(cpphdl_n1910, Vss) <+ 2.9999999999999998e-15 * ddt(V(cpphdl_n1910, Vss)); // Bench initial voltage = 0.0 V.
        // device 1323, IC IC228, analog/basic/mos_r2r_dac.hpp:31
        I(cpphdl_n1909, cpphdl_n1910) <+ V(cpphdl_n1909, cpphdl_n1910) / 1000.0;
        // device 1324, IC IC233, analog/basic/inverter.hpp:11
        I(cpphdl_n1894, Vdd) <+ cpphdl_channel(V(BIT_N9_4, Vdd), V(cpphdl_n1894, Vdd), 0.080000000000000002, 0.69999999999999996, -1.0);
        // device 1325, IC IC233, analog/basic/inverter.hpp:12
        I(cpphdl_n1894, Vss) <+ cpphdl_channel(V(BIT_N9_4, Vss), V(cpphdl_n1894, Vss), 0.080000000000000002, 0.69999999999999996, 1.0);
        // device 1326, IC IC228, analog/basic/mos_r2r_dac.hpp:27
        I(cpphdl_n1894, Vss) <+ 2.9999999999999998e-15 * ddt(V(cpphdl_n1894, Vss)); // Bench initial voltage = 0.0 V.
        // device 1327, IC IC228, analog/basic/mos_r2r_dac.hpp:28
        I(cpphdl_n1894, cpphdl_n1911) <+ V(cpphdl_n1894, cpphdl_n1911) / 2000.0;
        // device 1328, IC IC228, analog/basic/mos_r2r_dac.hpp:29
        I(cpphdl_n1911, Vss) <+ 2.9999999999999998e-15 * ddt(V(cpphdl_n1911, Vss)); // Bench initial voltage = 0.0 V.
        // device 1329, IC IC228, analog/basic/mos_r2r_dac.hpp:31
        I(cpphdl_n1910, cpphdl_n1911) <+ V(cpphdl_n1910, cpphdl_n1911) / 1000.0;
        // device 1330, IC IC234, analog/basic/inverter.hpp:11
        I(cpphdl_n1898, Vdd) <+ cpphdl_channel(V(BIT_N9_5, Vdd), V(cpphdl_n1898, Vdd), 0.080000000000000002, 0.69999999999999996, -1.0);
        // device 1331, IC IC234, analog/basic/inverter.hpp:12
        I(cpphdl_n1898, Vss) <+ cpphdl_channel(V(BIT_N9_5, Vss), V(cpphdl_n1898, Vss), 0.080000000000000002, 0.69999999999999996, 1.0);
        // device 1332, IC IC228, analog/basic/mos_r2r_dac.hpp:27
        I(cpphdl_n1898, Vss) <+ 2.9999999999999998e-15 * ddt(V(cpphdl_n1898, Vss)); // Bench initial voltage = 0.0 V.
        // device 1333, IC IC228, analog/basic/mos_r2r_dac.hpp:28
        I(cpphdl_n1898, cpphdl_n1912) <+ V(cpphdl_n1898, cpphdl_n1912) / 2000.0;
        // device 1334, IC IC228, analog/basic/mos_r2r_dac.hpp:29
        I(cpphdl_n1912, Vss) <+ 2.9999999999999998e-15 * ddt(V(cpphdl_n1912, Vss)); // Bench initial voltage = 0.0 V.
        // device 1335, IC IC228, analog/basic/mos_r2r_dac.hpp:31
        I(cpphdl_n1911, cpphdl_n1912) <+ V(cpphdl_n1911, cpphdl_n1912) / 1000.0;
        // device 1336, IC IC235, analog/basic/inverter.hpp:11
        I(cpphdl_n1902, Vdd) <+ cpphdl_channel(V(BIT_N9_6, Vdd), V(cpphdl_n1902, Vdd), 0.080000000000000002, 0.69999999999999996, -1.0);
        // device 1337, IC IC235, analog/basic/inverter.hpp:12
        I(cpphdl_n1902, Vss) <+ cpphdl_channel(V(BIT_N9_6, Vss), V(cpphdl_n1902, Vss), 0.080000000000000002, 0.69999999999999996, 1.0);
        // device 1338, IC IC228, analog/basic/mos_r2r_dac.hpp:27
        I(cpphdl_n1902, Vss) <+ 2.9999999999999998e-15 * ddt(V(cpphdl_n1902, Vss)); // Bench initial voltage = 0.0 V.
        // device 1339, IC IC228, analog/basic/mos_r2r_dac.hpp:28
        I(cpphdl_n1902, cpphdl_n1913) <+ V(cpphdl_n1902, cpphdl_n1913) / 2000.0;
        // device 1340, IC IC228, analog/basic/mos_r2r_dac.hpp:29
        I(cpphdl_n1913, Vss) <+ 2.9999999999999998e-15 * ddt(V(cpphdl_n1913, Vss)); // Bench initial voltage = 0.0 V.
        // device 1341, IC IC228, analog/basic/mos_r2r_dac.hpp:31
        I(cpphdl_n1912, cpphdl_n1913) <+ V(cpphdl_n1912, cpphdl_n1913) / 1000.0;
        // device 1342, IC IC236, analog/basic/inverter.hpp:11
        I(cpphdl_n1906, Vdd) <+ cpphdl_channel(V(BIT_N9_7, Vdd), V(cpphdl_n1906, Vdd), 0.080000000000000002, 0.69999999999999996, -1.0);
        // device 1343, IC IC236, analog/basic/inverter.hpp:12
        I(cpphdl_n1906, Vss) <+ cpphdl_channel(V(BIT_N9_7, Vss), V(cpphdl_n1906, Vss), 0.080000000000000002, 0.69999999999999996, 1.0);
        // device 1344, IC IC228, analog/basic/mos_r2r_dac.hpp:27
        I(cpphdl_n1906, Vss) <+ 2.9999999999999998e-15 * ddt(V(cpphdl_n1906, Vss)); // Bench initial voltage = 0.0 V.
        // device 1345, IC IC228, analog/basic/mos_r2r_dac.hpp:28
        I(cpphdl_n1906, cpphdl_n1918) <+ V(cpphdl_n1906, cpphdl_n1918) / 2000.0;
        // device 1346, IC IC228, analog/basic/mos_r2r_dac.hpp:29
        I(cpphdl_n1918, Vss) <+ 2.9999999999999998e-15 * ddt(V(cpphdl_n1918, Vss)); // Bench initial voltage = 0.0 V.
        // device 1347, IC IC228, analog/basic/mos_r2r_dac.hpp:31
        I(cpphdl_n1913, cpphdl_n1918) <+ V(cpphdl_n1913, cpphdl_n1918) / 1000.0;
        // device 1348, IC IC228, analog/basic/mos_r2r_dac.hpp:33
        I(Vss, cpphdl_n1907) <+ V(Vss, cpphdl_n1907) / 2000.0;
        // device 1349, IC IC237, analog/basic/nmos_resistor_amplifier.hpp:23
        I(Vdd, cpphdl_n1927) <+ V(Vdd, cpphdl_n1927) / 1000.0;
        // device 1350, IC IC237, analog/basic/nmos_resistor_amplifier.hpp:24
        I(Vdd, cpphdl_n1926) <+ V(Vdd, cpphdl_n1926) / 1000.0;
        // device 1351, IC IC237, analog/basic/nmos_resistor_amplifier.hpp:25
        I(cpphdl_n1927, cpphdl_n1921) <+ cpphdl_channel(V(cpphdl_n1917, cpphdl_n1921), V(cpphdl_n1927, cpphdl_n1921), 0.0074999999999999997, 0.69999999999999996, 1.0);
        // device 1352, IC IC237, analog/basic/nmos_resistor_amplifier.hpp:26
        I(cpphdl_n1926, cpphdl_n1922) <+ cpphdl_channel(V(cpphdl_n1918, cpphdl_n1922), V(cpphdl_n1926, cpphdl_n1922), 0.0074999999999999997, 0.69999999999999996, 1.0);
        // device 1353, IC IC237, analog/basic/nmos_resistor_amplifier.hpp:27
        I(cpphdl_n1923, cpphdl_n1921) <+ V(cpphdl_n1923, cpphdl_n1921) / 100.0;
        // device 1354, IC IC237, analog/basic/nmos_resistor_amplifier.hpp:28
        I(cpphdl_n1923, cpphdl_n1922) <+ V(cpphdl_n1923, cpphdl_n1922) / 100.0;
        // device 1355, IC IC237, analog/basic/nmos_resistor_amplifier.hpp:29
        I(Vss, cpphdl_n1923) <+ V(Vss, cpphdl_n1923) / 300.0;
        // device 1356, IC IC237, analog/basic/nmos_resistor_amplifier.hpp:30
        I(cpphdl_n1927, Vdd) <+ 2.9999999999999998e-13 * ddt(V(cpphdl_n1927, Vdd)); // Bench initial voltage = 0.0 V.
        // device 1357, IC IC237, analog/basic/nmos_resistor_amplifier.hpp:31
        I(cpphdl_n1926, Vdd) <+ 2.9999999999999998e-13 * ddt(V(cpphdl_n1926, Vdd)); // Bench initial voltage = 0.0 V.
        // device 1358, IC IC237, analog/basic/nmos_resistor_amplifier.hpp:32
        I(cpphdl_n1923, Vss) <+ 4e-14 * ddt(V(cpphdl_n1923, Vss)); // Bench initial voltage = 0.0 V.
        // device 1359, IC IC237, analog/basic/nmos_resistor_amplifier.hpp:34
        I(cpphdl_n1917, cpphdl_n1921) <+ 2e-14 * ddt(V(cpphdl_n1917, cpphdl_n1921)); // Bench initial voltage = 0.0 V.
        // device 1360, IC IC237, analog/basic/nmos_resistor_amplifier.hpp:35
        I(cpphdl_n1918, cpphdl_n1922) <+ 2e-14 * ddt(V(cpphdl_n1918, cpphdl_n1922)); // Bench initial voltage = 0.0 V.
        // device 1361, IC IC237, analog/basic/nmos_resistor_amplifier.hpp:36
        I(cpphdl_n1917, cpphdl_n1927) <+ 2.9999999999999998e-15 * ddt(V(cpphdl_n1917, cpphdl_n1927)); // Bench initial voltage = 0.0 V.
        // device 1362, IC IC237, analog/basic/nmos_resistor_amplifier.hpp:37
        I(cpphdl_n1918, cpphdl_n1926) <+ 2.9999999999999998e-15 * ddt(V(cpphdl_n1918, cpphdl_n1926)); // Bench initial voltage = 0.0 V.
        // device 1363, IC IC238, analog/basic/strongarm_comparator.hpp:28
        I(cpphdl_n1931, cpphdl_n1933) <+ cpphdl_channel(V(cpphdl_n1926, cpphdl_n1933), V(cpphdl_n1931, cpphdl_n1933), 0.0080000000000000002, 0.69999999999999996, 1.0);
        // device 1364, IC IC238, analog/basic/strongarm_comparator.hpp:29
        I(cpphdl_n1932, cpphdl_n1933) <+ cpphdl_channel(V(cpphdl_n1927, cpphdl_n1933), V(cpphdl_n1932, cpphdl_n1933), 0.0080000000000000002, 0.69999999999999996, 1.0);
        // device 1365, IC IC238, analog/basic/strongarm_comparator.hpp:30
        I(cpphdl_n1933, Vss) <+ cpphdl_channel(V(EVALUATE, Vss), V(cpphdl_n1933, Vss), 0.0080000000000000002, 0.69999999999999996, 1.0);
        // device 1366, IC IC238, analog/basic/strongarm_comparator.hpp:33
        I(cpphdl_n1946, cpphdl_n1931) <+ cpphdl_channel(V(cpphdl_n1950, cpphdl_n1931), V(cpphdl_n1946, cpphdl_n1931), 0.0040000000000000001, 0.69999999999999996, 1.0);
        // device 1367, IC IC238, analog/basic/strongarm_comparator.hpp:34
        I(cpphdl_n1950, cpphdl_n1932) <+ cpphdl_channel(V(cpphdl_n1946, cpphdl_n1932), V(cpphdl_n1950, cpphdl_n1932), 0.0040000000000000001, 0.69999999999999996, 1.0);
        // device 1368, IC IC238, analog/basic/strongarm_comparator.hpp:35
        I(cpphdl_n1950, Vdd) <+ cpphdl_channel(V(cpphdl_n1946, Vdd), V(cpphdl_n1950, Vdd), 0.002, 0.69999999999999996, -1.0);
        // device 1369, IC IC238, analog/basic/strongarm_comparator.hpp:36
        I(cpphdl_n1946, Vdd) <+ cpphdl_channel(V(cpphdl_n1950, Vdd), V(cpphdl_n1946, Vdd), 0.002, 0.69999999999999996, -1.0);
        // device 1370, IC IC238, analog/basic/strongarm_comparator.hpp:38
        I(cpphdl_n1931, Vdd) <+ cpphdl_channel(V(EVALUATE, Vdd), V(cpphdl_n1931, Vdd), 0.002, 0.69999999999999996, -1.0);
        // device 1371, IC IC238, analog/basic/strongarm_comparator.hpp:39
        I(cpphdl_n1932, Vdd) <+ cpphdl_channel(V(EVALUATE, Vdd), V(cpphdl_n1932, Vdd), 0.002, 0.69999999999999996, -1.0);
        // device 1372, IC IC238, analog/basic/strongarm_comparator.hpp:40
        I(cpphdl_n1950, Vdd) <+ cpphdl_channel(V(EVALUATE, Vdd), V(cpphdl_n1950, Vdd), 0.002, 0.69999999999999996, -1.0);
        // device 1373, IC IC238, analog/basic/strongarm_comparator.hpp:41
        I(cpphdl_n1946, Vdd) <+ cpphdl_channel(V(EVALUATE, Vdd), V(cpphdl_n1946, Vdd), 0.002, 0.69999999999999996, -1.0);
        // device 1374, IC IC238, analog/basic/strongarm_comparator.hpp:42
        I(cpphdl_n1931, Vss) <+ 2.9999999999999998e-14 * ddt(V(cpphdl_n1931, Vss)); // Bench initial voltage = 0.0 V.
        // device 1375, IC IC238, analog/basic/strongarm_comparator.hpp:43
        I(cpphdl_n1932, Vss) <+ 2.9999999999999998e-14 * ddt(V(cpphdl_n1932, Vss)); // Bench initial voltage = 0.0 V.
        // device 1376, IC IC238, analog/basic/strongarm_comparator.hpp:44
        I(cpphdl_n1933, Vss) <+ 2.9999999999999998e-14 * ddt(V(cpphdl_n1933, Vss)); // Bench initial voltage = 0.0 V.
        // device 1377, IC IC238, analog/basic/strongarm_comparator.hpp:45
        I(cpphdl_n1950, Vss) <+ 5.0000000000000002e-14 * ddt(V(cpphdl_n1950, Vss)); // Bench initial voltage = 0.0 V.
        // device 1378, IC IC238, analog/basic/strongarm_comparator.hpp:46
        I(cpphdl_n1946, Vss) <+ 5.0000000000000002e-14 * ddt(V(cpphdl_n1946, Vss)); // Bench initial voltage = 0.0 V.
        // device 1379, IC IC238, analog/basic/strongarm_comparator.hpp:47
        I(cpphdl_n1926, cpphdl_n1933) <+ 2e-14 * ddt(V(cpphdl_n1926, cpphdl_n1933)); // Bench initial voltage = 0.0 V.
        // device 1380, IC IC238, analog/basic/strongarm_comparator.hpp:48
        I(cpphdl_n1927, cpphdl_n1933) <+ 2e-14 * ddt(V(cpphdl_n1927, cpphdl_n1933)); // Bench initial voltage = 0.0 V.
        // device 1381, IC IC238, analog/basic/strongarm_comparator.hpp:49
        I(cpphdl_n1926, cpphdl_n1931) <+ 2.9999999999999998e-15 * ddt(V(cpphdl_n1926, cpphdl_n1931)); // Bench initial voltage = 0.0 V.
        // device 1382, IC IC238, analog/basic/strongarm_comparator.hpp:50
        I(cpphdl_n1927, cpphdl_n1932) <+ 2.9999999999999998e-15 * ddt(V(cpphdl_n1927, cpphdl_n1932)); // Bench initial voltage = 0.0 V.
        // device 1383, IC IC240, analog/basic/inverter.hpp:11
        I(cpphdl_n1954, Vdd) <+ cpphdl_channel(V(cpphdl_n1946, Vdd), V(cpphdl_n1954, Vdd), 0.001, 0.69999999999999996, -1.0);
        // device 1384, IC IC240, analog/basic/inverter.hpp:12
        I(cpphdl_n1954, Vss) <+ cpphdl_channel(V(cpphdl_n1946, Vss), V(cpphdl_n1954, Vss), 0.001, 0.69999999999999996, 1.0);
        // device 1385, IC IC242, analog/basic/inverter.hpp:11
        I(cpphdl_n1968, Vdd) <+ cpphdl_channel(V(cpphdl_n1954, Vdd), V(cpphdl_n1968, Vdd), 0.0040000000000000001, 0.69999999999999996, -1.0);
        // device 1386, IC IC242, analog/basic/inverter.hpp:12
        I(cpphdl_n1968, Vss) <+ cpphdl_channel(V(cpphdl_n1954, Vss), V(cpphdl_n1968, Vss), 0.0040000000000000001, 0.69999999999999996, 1.0);
        // device 1387, IC IC239, analog/basic/buffered_nand_latch.hpp:34
        I(cpphdl_n1946, Vss) <+ 2.0000000000000002e-15 * ddt(V(cpphdl_n1946, Vss)); // Bench initial voltage = 0.0 V.
        // device 1388, IC IC239, analog/basic/buffered_nand_latch.hpp:35
        I(cpphdl_n1946, cpphdl_n1954) <+ 1.0000000000000001e-15 * ddt(V(cpphdl_n1946, cpphdl_n1954)); // Bench initial voltage = 0.0 V.
        // device 1389, IC IC239, analog/basic/buffered_nand_latch.hpp:36
        I(cpphdl_n1954, Vss) <+ 5e-15 * ddt(V(cpphdl_n1954, Vss)); // Bench initial voltage = 0.0 V.
        // device 1390, IC IC239, analog/basic/buffered_nand_latch.hpp:37
        I(cpphdl_n1954, Vss) <+ 8.0000000000000006e-15 * ddt(V(cpphdl_n1954, Vss)); // Bench initial voltage = 0.0 V.
        // device 1391, IC IC239, analog/basic/buffered_nand_latch.hpp:38
        I(cpphdl_n1968, Vss) <+ 1e-14 * ddt(V(cpphdl_n1968, Vss)); // Bench initial voltage = 0.0 V.
        // device 1392, IC IC241, analog/basic/inverter.hpp:11
        I(cpphdl_n1958, Vdd) <+ cpphdl_channel(V(cpphdl_n1950, Vdd), V(cpphdl_n1958, Vdd), 0.001, 0.69999999999999996, -1.0);
        // device 1393, IC IC241, analog/basic/inverter.hpp:12
        I(cpphdl_n1958, Vss) <+ cpphdl_channel(V(cpphdl_n1950, Vss), V(cpphdl_n1958, Vss), 0.001, 0.69999999999999996, 1.0);
        // device 1394, IC IC243, analog/basic/inverter.hpp:11
        I(cpphdl_n1974, Vdd) <+ cpphdl_channel(V(cpphdl_n1958, Vdd), V(cpphdl_n1974, Vdd), 0.0040000000000000001, 0.69999999999999996, -1.0);
        // device 1395, IC IC243, analog/basic/inverter.hpp:12
        I(cpphdl_n1974, Vss) <+ cpphdl_channel(V(cpphdl_n1958, Vss), V(cpphdl_n1974, Vss), 0.0040000000000000001, 0.69999999999999996, 1.0);
        // device 1396, IC IC239, analog/basic/buffered_nand_latch.hpp:34
        I(cpphdl_n1950, Vss) <+ 2.0000000000000002e-15 * ddt(V(cpphdl_n1950, Vss)); // Bench initial voltage = 0.0 V.
        // device 1397, IC IC239, analog/basic/buffered_nand_latch.hpp:35
        I(cpphdl_n1950, cpphdl_n1958) <+ 1.0000000000000001e-15 * ddt(V(cpphdl_n1950, cpphdl_n1958)); // Bench initial voltage = 0.0 V.
        // device 1398, IC IC239, analog/basic/buffered_nand_latch.hpp:36
        I(cpphdl_n1958, Vss) <+ 5e-15 * ddt(V(cpphdl_n1958, Vss)); // Bench initial voltage = 0.0 V.
        // device 1399, IC IC239, analog/basic/buffered_nand_latch.hpp:37
        I(cpphdl_n1958, Vss) <+ 8.0000000000000006e-15 * ddt(V(cpphdl_n1958, Vss)); // Bench initial voltage = 0.0 V.
        // device 1400, IC IC239, analog/basic/buffered_nand_latch.hpp:38
        I(cpphdl_n1974, Vss) <+ 1e-14 * ddt(V(cpphdl_n1974, Vss)); // Bench initial voltage = 0.0 V.
        // device 1401, IC IC245, analog/basic/cmos_logic.hpp:17
        I(cpphdl_n2473, Vss) <+ 5.0000000000000002e-14 * ddt(V(cpphdl_n2473, Vss)); // Bench initial voltage = 0.0 V.
        // device 1402, IC IC245, analog/basic/cmos_logic.hpp:18
        I(cpphdl_n2473, Vdd) <+ cpphdl_channel(V(cpphdl_n1968, Vdd), V(cpphdl_n2473, Vdd), 0.01, 0.69999999999999996, -1.0);
        // device 1403, IC IC245, analog/basic/cmos_logic.hpp:19
        I(cpphdl_n2473, Vdd) <+ cpphdl_channel(V(cpphdl_n1976, Vdd), V(cpphdl_n2473, Vdd), 0.01, 0.69999999999999996, -1.0);
        // device 1404, IC IC245, analog/basic/cmos_logic.hpp:20
        I(cpphdl_n2473, cpphdl_n1971) <+ cpphdl_channel(V(cpphdl_n1968, cpphdl_n1971), V(cpphdl_n2473, cpphdl_n1971), 0.01, 0.69999999999999996, 1.0);
        // device 1405, IC IC245, analog/basic/cmos_logic.hpp:21
        I(cpphdl_n1971, Vss) <+ cpphdl_channel(V(cpphdl_n1976, Vss), V(cpphdl_n1971, Vss), 0.01, 0.69999999999999996, 1.0);
        // device 1406, IC IC245, analog/basic/cmos_logic.hpp:27
        I(cpphdl_n1971, Vss) <+ 1e-14 * ddt(V(cpphdl_n1971, Vss)); // Bench initial voltage = 0.0 V.
        // device 1407, IC IC246, analog/basic/cmos_logic.hpp:17
        I(cpphdl_n1976, Vss) <+ 5.0000000000000002e-14 * ddt(V(cpphdl_n1976, Vss)); // Bench initial voltage = 0.0 V.
        // device 1408, IC IC246, analog/basic/cmos_logic.hpp:18
        I(cpphdl_n1976, Vdd) <+ cpphdl_channel(V(cpphdl_n1974, Vdd), V(cpphdl_n1976, Vdd), 0.01, 0.69999999999999996, -1.0);
        // device 1409, IC IC246, analog/basic/cmos_logic.hpp:19
        I(cpphdl_n1976, Vdd) <+ cpphdl_channel(V(cpphdl_n2473, Vdd), V(cpphdl_n1976, Vdd), 0.01, 0.69999999999999996, -1.0);
        // device 1410, IC IC246, analog/basic/cmos_logic.hpp:20
        I(cpphdl_n1976, cpphdl_n1977) <+ cpphdl_channel(V(cpphdl_n1974, cpphdl_n1977), V(cpphdl_n1976, cpphdl_n1977), 0.01, 0.69999999999999996, 1.0);
        // device 1411, IC IC246, analog/basic/cmos_logic.hpp:21
        I(cpphdl_n1977, Vss) <+ cpphdl_channel(V(cpphdl_n2473, Vss), V(cpphdl_n1977, Vss), 0.01, 0.69999999999999996, 1.0);
        // device 1412, IC IC246, analog/basic/cmos_logic.hpp:27
        I(cpphdl_n1977, Vss) <+ 1e-14 * ddt(V(cpphdl_n1977, Vss)); // Bench initial voltage = 0.0 V.
        // device 1413, IC IC244, analog/basic/nand_latch.hpp:36
        I(cpphdl_n1968, Vss) <+ 2.9999999999999998e-15 * ddt(V(cpphdl_n1968, Vss)); // Bench initial voltage = 0.0 V.
        // device 1414, IC IC244, analog/basic/nand_latch.hpp:37
        I(cpphdl_n1974, Vss) <+ 2.9999999999999998e-15 * ddt(V(cpphdl_n1974, Vss)); // Bench initial voltage = 0.0 V.
        // device 1415, IC IC247, analog/basic/inverter.hpp:11
        I(cpphdl_n1982, Vdd) <+ cpphdl_channel(V(CLEAR, Vdd), V(cpphdl_n1982, Vdd), 0.01, 0.69999999999999996, -1.0);
        // device 1416, IC IC247, analog/basic/inverter.hpp:12
        I(cpphdl_n1982, Vss) <+ cpphdl_channel(V(CLEAR, Vss), V(cpphdl_n1982, Vss), 0.01, 0.69999999999999996, 1.0);
        // device 1417, IC IC244, analog/basic/nand_latch.hpp:58
        I(cpphdl_n1982, Vss) <+ 2.9999999999999998e-15 * ddt(V(cpphdl_n1982, Vss)); // Bench initial voltage = 0.0 V.
        // device 1418, IC IC244, analog/basic/nand_latch.hpp:59
        I(cpphdl_n2473, Vss) <+ cpphdl_channel(V(CLEAR, Vss), V(cpphdl_n2473, Vss), 0.050000000000000003, 0.69999999999999996, 1.0);
        // device 1419, IC IC244, analog/basic/nand_latch.hpp:60
        I(cpphdl_n1976, Vdd) <+ cpphdl_channel(V(cpphdl_n1982, Vdd), V(cpphdl_n1976, Vdd), 0.050000000000000003, 0.69999999999999996, -1.0);
        // device 1420, IC IC250, analog/basic/inverter.hpp:11
        I(cpphdl_n2006, Vdd) <+ cpphdl_channel(V(TRACK10, Vdd), V(cpphdl_n2006, Vdd), 0.0040000000000000001, 0.69999999999999996, -1.0);
        // device 1421, IC IC250, analog/basic/inverter.hpp:12
        I(cpphdl_n2006, Vss) <+ cpphdl_channel(V(TRACK10, Vss), V(cpphdl_n2006, Vss), 0.0040000000000000001, 0.69999999999999996, 1.0);
        // device 1422, IC IC249, analog/basic/mos_track_hold.hpp:31
        I(cpphdl_n2006, Vss) <+ 2e-14 * ddt(V(cpphdl_n2006, Vss)); // Bench initial voltage = 0.0 V.
        // device 1423, IC IC249, analog/basic/mos_track_hold.hpp:32
        I(cpphdl_n2286, cpphdl_n2060) <+ cpphdl_channel(V(TRACK10, cpphdl_n2060), V(cpphdl_n2286, cpphdl_n2060), 0.029999999999999999, 0.69999999999999996, 1.0);
        // device 1424, IC IC249, analog/basic/mos_track_hold.hpp:33
        I(cpphdl_n2060, cpphdl_n2286) <+ cpphdl_channel(V(cpphdl_n2006, cpphdl_n2286), V(cpphdl_n2060, cpphdl_n2286), 0.014999999999999999, 0.69999999999999996, -1.0);
        // device 1425, IC IC249, analog/basic/mos_track_hold.hpp:37
        I(cpphdl_n2060, cpphdl_n2060) <+ cpphdl_channel(V(cpphdl_n2006, cpphdl_n2060), V(cpphdl_n2060, cpphdl_n2060), 0.016, 0.69999999999999996, 1.0);
        // device 1426, IC IC249, analog/basic/mos_track_hold.hpp:38
        I(cpphdl_n2060, cpphdl_n2060) <+ cpphdl_channel(V(TRACK10, cpphdl_n2060), V(cpphdl_n2060, cpphdl_n2060), 0.0083999999999999995, 0.69999999999999996, -1.0);
        // device 1427, IC IC249, analog/basic/mos_track_hold.hpp:39
        I(cpphdl_n2060, Vss) <+ 1.5000000000000001e-12 * ddt(V(cpphdl_n2060, Vss)); // Bench initial voltage = 0.0 V.
        // device 1428, IC IC249, analog/basic/mos_track_hold.hpp:42
        I(TRACK10, cpphdl_n2060) <+ 2.0000000000000002e-15 * ddt(V(TRACK10, cpphdl_n2060)); // Bench initial voltage = -0.0 V.
        // device 1429, IC IC249, analog/basic/mos_track_hold.hpp:43
        I(cpphdl_n2006, cpphdl_n2060) <+ 2.0000000000000002e-15 * ddt(V(cpphdl_n2006, cpphdl_n2060)); // Bench initial voltage = 0.0 V.
        // device 1430, IC IC249, analog/basic/mos_track_hold.hpp:44
        I(cpphdl_n2286, cpphdl_n2060) <+ 1.0000000000000001e-15 * ddt(V(cpphdl_n2286, cpphdl_n2060)); // Bench initial voltage = 0.0 V.
        // device 1431, IC IC252, analog/basic/inverter.hpp:11
        I(cpphdl_n2021, Vdd) <+ cpphdl_channel(V(BIT_N10_0, Vdd), V(cpphdl_n2021, Vdd), 0.080000000000000002, 0.69999999999999996, -1.0);
        // device 1432, IC IC252, analog/basic/inverter.hpp:12
        I(cpphdl_n2021, Vss) <+ cpphdl_channel(V(BIT_N10_0, Vss), V(cpphdl_n2021, Vss), 0.080000000000000002, 0.69999999999999996, 1.0);
        // device 1433, IC IC251, analog/basic/mos_r2r_dac.hpp:27
        I(cpphdl_n2021, Vss) <+ 2.9999999999999998e-15 * ddt(V(cpphdl_n2021, Vss)); // Bench initial voltage = 0.0 V.
        // device 1434, IC IC251, analog/basic/mos_r2r_dac.hpp:28
        I(cpphdl_n2021, cpphdl_n2050) <+ V(cpphdl_n2021, cpphdl_n2050) / 2000.0;
        // device 1435, IC IC251, analog/basic/mos_r2r_dac.hpp:29
        I(cpphdl_n2050, Vss) <+ 2.9999999999999998e-15 * ddt(V(cpphdl_n2050, Vss)); // Bench initial voltage = 0.0 V.
        // device 1436, IC IC253, analog/basic/inverter.hpp:11
        I(cpphdl_n2025, Vdd) <+ cpphdl_channel(V(BIT_N10_1, Vdd), V(cpphdl_n2025, Vdd), 0.080000000000000002, 0.69999999999999996, -1.0);
        // device 1437, IC IC253, analog/basic/inverter.hpp:12
        I(cpphdl_n2025, Vss) <+ cpphdl_channel(V(BIT_N10_1, Vss), V(cpphdl_n2025, Vss), 0.080000000000000002, 0.69999999999999996, 1.0);
        // device 1438, IC IC251, analog/basic/mos_r2r_dac.hpp:27
        I(cpphdl_n2025, Vss) <+ 2.9999999999999998e-15 * ddt(V(cpphdl_n2025, Vss)); // Bench initial voltage = 0.0 V.
        // device 1439, IC IC251, analog/basic/mos_r2r_dac.hpp:28
        I(cpphdl_n2025, cpphdl_n2051) <+ V(cpphdl_n2025, cpphdl_n2051) / 2000.0;
        // device 1440, IC IC251, analog/basic/mos_r2r_dac.hpp:29
        I(cpphdl_n2051, Vss) <+ 2.9999999999999998e-15 * ddt(V(cpphdl_n2051, Vss)); // Bench initial voltage = 0.0 V.
        // device 1441, IC IC251, analog/basic/mos_r2r_dac.hpp:31
        I(cpphdl_n2050, cpphdl_n2051) <+ V(cpphdl_n2050, cpphdl_n2051) / 1000.0;
        // device 1442, IC IC254, analog/basic/inverter.hpp:11
        I(cpphdl_n2029, Vdd) <+ cpphdl_channel(V(BIT_N10_2, Vdd), V(cpphdl_n2029, Vdd), 0.080000000000000002, 0.69999999999999996, -1.0);
        // device 1443, IC IC254, analog/basic/inverter.hpp:12
        I(cpphdl_n2029, Vss) <+ cpphdl_channel(V(BIT_N10_2, Vss), V(cpphdl_n2029, Vss), 0.080000000000000002, 0.69999999999999996, 1.0);
        // device 1444, IC IC251, analog/basic/mos_r2r_dac.hpp:27
        I(cpphdl_n2029, Vss) <+ 2.9999999999999998e-15 * ddt(V(cpphdl_n2029, Vss)); // Bench initial voltage = 0.0 V.
        // device 1445, IC IC251, analog/basic/mos_r2r_dac.hpp:28
        I(cpphdl_n2029, cpphdl_n2052) <+ V(cpphdl_n2029, cpphdl_n2052) / 2000.0;
        // device 1446, IC IC251, analog/basic/mos_r2r_dac.hpp:29
        I(cpphdl_n2052, Vss) <+ 2.9999999999999998e-15 * ddt(V(cpphdl_n2052, Vss)); // Bench initial voltage = 0.0 V.
        // device 1447, IC IC251, analog/basic/mos_r2r_dac.hpp:31
        I(cpphdl_n2051, cpphdl_n2052) <+ V(cpphdl_n2051, cpphdl_n2052) / 1000.0;
        // device 1448, IC IC255, analog/basic/inverter.hpp:11
        I(cpphdl_n2033, Vdd) <+ cpphdl_channel(V(BIT_N10_3, Vdd), V(cpphdl_n2033, Vdd), 0.080000000000000002, 0.69999999999999996, -1.0);
        // device 1449, IC IC255, analog/basic/inverter.hpp:12
        I(cpphdl_n2033, Vss) <+ cpphdl_channel(V(BIT_N10_3, Vss), V(cpphdl_n2033, Vss), 0.080000000000000002, 0.69999999999999996, 1.0);
        // device 1450, IC IC251, analog/basic/mos_r2r_dac.hpp:27
        I(cpphdl_n2033, Vss) <+ 2.9999999999999998e-15 * ddt(V(cpphdl_n2033, Vss)); // Bench initial voltage = 0.0 V.
        // device 1451, IC IC251, analog/basic/mos_r2r_dac.hpp:28
        I(cpphdl_n2033, cpphdl_n2053) <+ V(cpphdl_n2033, cpphdl_n2053) / 2000.0;
        // device 1452, IC IC251, analog/basic/mos_r2r_dac.hpp:29
        I(cpphdl_n2053, Vss) <+ 2.9999999999999998e-15 * ddt(V(cpphdl_n2053, Vss)); // Bench initial voltage = 0.0 V.
        // device 1453, IC IC251, analog/basic/mos_r2r_dac.hpp:31
        I(cpphdl_n2052, cpphdl_n2053) <+ V(cpphdl_n2052, cpphdl_n2053) / 1000.0;
        // device 1454, IC IC256, analog/basic/inverter.hpp:11
        I(cpphdl_n2037, Vdd) <+ cpphdl_channel(V(BIT_N10_4, Vdd), V(cpphdl_n2037, Vdd), 0.080000000000000002, 0.69999999999999996, -1.0);
        // device 1455, IC IC256, analog/basic/inverter.hpp:12
        I(cpphdl_n2037, Vss) <+ cpphdl_channel(V(BIT_N10_4, Vss), V(cpphdl_n2037, Vss), 0.080000000000000002, 0.69999999999999996, 1.0);
        // device 1456, IC IC251, analog/basic/mos_r2r_dac.hpp:27
        I(cpphdl_n2037, Vss) <+ 2.9999999999999998e-15 * ddt(V(cpphdl_n2037, Vss)); // Bench initial voltage = 0.0 V.
        // device 1457, IC IC251, analog/basic/mos_r2r_dac.hpp:28
        I(cpphdl_n2037, cpphdl_n2054) <+ V(cpphdl_n2037, cpphdl_n2054) / 2000.0;
        // device 1458, IC IC251, analog/basic/mos_r2r_dac.hpp:29
        I(cpphdl_n2054, Vss) <+ 2.9999999999999998e-15 * ddt(V(cpphdl_n2054, Vss)); // Bench initial voltage = 0.0 V.
        // device 1459, IC IC251, analog/basic/mos_r2r_dac.hpp:31
        I(cpphdl_n2053, cpphdl_n2054) <+ V(cpphdl_n2053, cpphdl_n2054) / 1000.0;
        // device 1460, IC IC257, analog/basic/inverter.hpp:11
        I(cpphdl_n2041, Vdd) <+ cpphdl_channel(V(BIT_N10_5, Vdd), V(cpphdl_n2041, Vdd), 0.080000000000000002, 0.69999999999999996, -1.0);
        // device 1461, IC IC257, analog/basic/inverter.hpp:12
        I(cpphdl_n2041, Vss) <+ cpphdl_channel(V(BIT_N10_5, Vss), V(cpphdl_n2041, Vss), 0.080000000000000002, 0.69999999999999996, 1.0);
        // device 1462, IC IC251, analog/basic/mos_r2r_dac.hpp:27
        I(cpphdl_n2041, Vss) <+ 2.9999999999999998e-15 * ddt(V(cpphdl_n2041, Vss)); // Bench initial voltage = 0.0 V.
        // device 1463, IC IC251, analog/basic/mos_r2r_dac.hpp:28
        I(cpphdl_n2041, cpphdl_n2055) <+ V(cpphdl_n2041, cpphdl_n2055) / 2000.0;
        // device 1464, IC IC251, analog/basic/mos_r2r_dac.hpp:29
        I(cpphdl_n2055, Vss) <+ 2.9999999999999998e-15 * ddt(V(cpphdl_n2055, Vss)); // Bench initial voltage = 0.0 V.
        // device 1465, IC IC251, analog/basic/mos_r2r_dac.hpp:31
        I(cpphdl_n2054, cpphdl_n2055) <+ V(cpphdl_n2054, cpphdl_n2055) / 1000.0;
        // device 1466, IC IC258, analog/basic/inverter.hpp:11
        I(cpphdl_n2045, Vdd) <+ cpphdl_channel(V(BIT_N10_6, Vdd), V(cpphdl_n2045, Vdd), 0.080000000000000002, 0.69999999999999996, -1.0);
        // device 1467, IC IC258, analog/basic/inverter.hpp:12
        I(cpphdl_n2045, Vss) <+ cpphdl_channel(V(BIT_N10_6, Vss), V(cpphdl_n2045, Vss), 0.080000000000000002, 0.69999999999999996, 1.0);
        // device 1468, IC IC251, analog/basic/mos_r2r_dac.hpp:27
        I(cpphdl_n2045, Vss) <+ 2.9999999999999998e-15 * ddt(V(cpphdl_n2045, Vss)); // Bench initial voltage = 0.0 V.
        // device 1469, IC IC251, analog/basic/mos_r2r_dac.hpp:28
        I(cpphdl_n2045, cpphdl_n2056) <+ V(cpphdl_n2045, cpphdl_n2056) / 2000.0;
        // device 1470, IC IC251, analog/basic/mos_r2r_dac.hpp:29
        I(cpphdl_n2056, Vss) <+ 2.9999999999999998e-15 * ddt(V(cpphdl_n2056, Vss)); // Bench initial voltage = 0.0 V.
        // device 1471, IC IC251, analog/basic/mos_r2r_dac.hpp:31
        I(cpphdl_n2055, cpphdl_n2056) <+ V(cpphdl_n2055, cpphdl_n2056) / 1000.0;
        // device 1472, IC IC259, analog/basic/inverter.hpp:11
        I(cpphdl_n2049, Vdd) <+ cpphdl_channel(V(BIT_N10_7, Vdd), V(cpphdl_n2049, Vdd), 0.080000000000000002, 0.69999999999999996, -1.0);
        // device 1473, IC IC259, analog/basic/inverter.hpp:12
        I(cpphdl_n2049, Vss) <+ cpphdl_channel(V(BIT_N10_7, Vss), V(cpphdl_n2049, Vss), 0.080000000000000002, 0.69999999999999996, 1.0);
        // device 1474, IC IC251, analog/basic/mos_r2r_dac.hpp:27
        I(cpphdl_n2049, Vss) <+ 2.9999999999999998e-15 * ddt(V(cpphdl_n2049, Vss)); // Bench initial voltage = 0.0 V.
        // device 1475, IC IC251, analog/basic/mos_r2r_dac.hpp:28
        I(cpphdl_n2049, cpphdl_n2061) <+ V(cpphdl_n2049, cpphdl_n2061) / 2000.0;
        // device 1476, IC IC251, analog/basic/mos_r2r_dac.hpp:29
        I(cpphdl_n2061, Vss) <+ 2.9999999999999998e-15 * ddt(V(cpphdl_n2061, Vss)); // Bench initial voltage = 0.0 V.
        // device 1477, IC IC251, analog/basic/mos_r2r_dac.hpp:31
        I(cpphdl_n2056, cpphdl_n2061) <+ V(cpphdl_n2056, cpphdl_n2061) / 1000.0;
        // device 1478, IC IC251, analog/basic/mos_r2r_dac.hpp:33
        I(Vss, cpphdl_n2050) <+ V(Vss, cpphdl_n2050) / 2000.0;
        // device 1479, IC IC260, analog/basic/nmos_resistor_amplifier.hpp:23
        I(Vdd, cpphdl_n2070) <+ V(Vdd, cpphdl_n2070) / 1000.0;
        // device 1480, IC IC260, analog/basic/nmos_resistor_amplifier.hpp:24
        I(Vdd, cpphdl_n2069) <+ V(Vdd, cpphdl_n2069) / 1000.0;
        // device 1481, IC IC260, analog/basic/nmos_resistor_amplifier.hpp:25
        I(cpphdl_n2070, cpphdl_n2064) <+ cpphdl_channel(V(cpphdl_n2060, cpphdl_n2064), V(cpphdl_n2070, cpphdl_n2064), 0.0074999999999999997, 0.69999999999999996, 1.0);
        // device 1482, IC IC260, analog/basic/nmos_resistor_amplifier.hpp:26
        I(cpphdl_n2069, cpphdl_n2065) <+ cpphdl_channel(V(cpphdl_n2061, cpphdl_n2065), V(cpphdl_n2069, cpphdl_n2065), 0.0074999999999999997, 0.69999999999999996, 1.0);
        // device 1483, IC IC260, analog/basic/nmos_resistor_amplifier.hpp:27
        I(cpphdl_n2066, cpphdl_n2064) <+ V(cpphdl_n2066, cpphdl_n2064) / 100.0;
        // device 1484, IC IC260, analog/basic/nmos_resistor_amplifier.hpp:28
        I(cpphdl_n2066, cpphdl_n2065) <+ V(cpphdl_n2066, cpphdl_n2065) / 100.0;
        // device 1485, IC IC260, analog/basic/nmos_resistor_amplifier.hpp:29
        I(Vss, cpphdl_n2066) <+ V(Vss, cpphdl_n2066) / 300.0;
        // device 1486, IC IC260, analog/basic/nmos_resistor_amplifier.hpp:30
        I(cpphdl_n2070, Vdd) <+ 2.9999999999999998e-13 * ddt(V(cpphdl_n2070, Vdd)); // Bench initial voltage = 0.0 V.
        // device 1487, IC IC260, analog/basic/nmos_resistor_amplifier.hpp:31
        I(cpphdl_n2069, Vdd) <+ 2.9999999999999998e-13 * ddt(V(cpphdl_n2069, Vdd)); // Bench initial voltage = 0.0 V.
        // device 1488, IC IC260, analog/basic/nmos_resistor_amplifier.hpp:32
        I(cpphdl_n2066, Vss) <+ 4e-14 * ddt(V(cpphdl_n2066, Vss)); // Bench initial voltage = 0.0 V.
        // device 1489, IC IC260, analog/basic/nmos_resistor_amplifier.hpp:34
        I(cpphdl_n2060, cpphdl_n2064) <+ 2e-14 * ddt(V(cpphdl_n2060, cpphdl_n2064)); // Bench initial voltage = 0.0 V.
        // device 1490, IC IC260, analog/basic/nmos_resistor_amplifier.hpp:35
        I(cpphdl_n2061, cpphdl_n2065) <+ 2e-14 * ddt(V(cpphdl_n2061, cpphdl_n2065)); // Bench initial voltage = 0.0 V.
        // device 1491, IC IC260, analog/basic/nmos_resistor_amplifier.hpp:36
        I(cpphdl_n2060, cpphdl_n2070) <+ 2.9999999999999998e-15 * ddt(V(cpphdl_n2060, cpphdl_n2070)); // Bench initial voltage = 0.0 V.
        // device 1492, IC IC260, analog/basic/nmos_resistor_amplifier.hpp:37
        I(cpphdl_n2061, cpphdl_n2069) <+ 2.9999999999999998e-15 * ddt(V(cpphdl_n2061, cpphdl_n2069)); // Bench initial voltage = 0.0 V.
        // device 1493, IC IC261, analog/basic/strongarm_comparator.hpp:28
        I(cpphdl_n2074, cpphdl_n2076) <+ cpphdl_channel(V(cpphdl_n2069, cpphdl_n2076), V(cpphdl_n2074, cpphdl_n2076), 0.0080000000000000002, 0.69999999999999996, 1.0);
        // device 1494, IC IC261, analog/basic/strongarm_comparator.hpp:29
        I(cpphdl_n2075, cpphdl_n2076) <+ cpphdl_channel(V(cpphdl_n2070, cpphdl_n2076), V(cpphdl_n2075, cpphdl_n2076), 0.0080000000000000002, 0.69999999999999996, 1.0);
        // device 1495, IC IC261, analog/basic/strongarm_comparator.hpp:30
        I(cpphdl_n2076, Vss) <+ cpphdl_channel(V(EVALUATE, Vss), V(cpphdl_n2076, Vss), 0.0080000000000000002, 0.69999999999999996, 1.0);
        // device 1496, IC IC261, analog/basic/strongarm_comparator.hpp:33
        I(cpphdl_n2089, cpphdl_n2074) <+ cpphdl_channel(V(cpphdl_n2093, cpphdl_n2074), V(cpphdl_n2089, cpphdl_n2074), 0.0040000000000000001, 0.69999999999999996, 1.0);
        // device 1497, IC IC261, analog/basic/strongarm_comparator.hpp:34
        I(cpphdl_n2093, cpphdl_n2075) <+ cpphdl_channel(V(cpphdl_n2089, cpphdl_n2075), V(cpphdl_n2093, cpphdl_n2075), 0.0040000000000000001, 0.69999999999999996, 1.0);
        // device 1498, IC IC261, analog/basic/strongarm_comparator.hpp:35
        I(cpphdl_n2093, Vdd) <+ cpphdl_channel(V(cpphdl_n2089, Vdd), V(cpphdl_n2093, Vdd), 0.002, 0.69999999999999996, -1.0);
        // device 1499, IC IC261, analog/basic/strongarm_comparator.hpp:36
        I(cpphdl_n2089, Vdd) <+ cpphdl_channel(V(cpphdl_n2093, Vdd), V(cpphdl_n2089, Vdd), 0.002, 0.69999999999999996, -1.0);
        // device 1500, IC IC261, analog/basic/strongarm_comparator.hpp:38
        I(cpphdl_n2074, Vdd) <+ cpphdl_channel(V(EVALUATE, Vdd), V(cpphdl_n2074, Vdd), 0.002, 0.69999999999999996, -1.0);
        // device 1501, IC IC261, analog/basic/strongarm_comparator.hpp:39
        I(cpphdl_n2075, Vdd) <+ cpphdl_channel(V(EVALUATE, Vdd), V(cpphdl_n2075, Vdd), 0.002, 0.69999999999999996, -1.0);
        // device 1502, IC IC261, analog/basic/strongarm_comparator.hpp:40
        I(cpphdl_n2093, Vdd) <+ cpphdl_channel(V(EVALUATE, Vdd), V(cpphdl_n2093, Vdd), 0.002, 0.69999999999999996, -1.0);
        // device 1503, IC IC261, analog/basic/strongarm_comparator.hpp:41
        I(cpphdl_n2089, Vdd) <+ cpphdl_channel(V(EVALUATE, Vdd), V(cpphdl_n2089, Vdd), 0.002, 0.69999999999999996, -1.0);
        // device 1504, IC IC261, analog/basic/strongarm_comparator.hpp:42
        I(cpphdl_n2074, Vss) <+ 2.9999999999999998e-14 * ddt(V(cpphdl_n2074, Vss)); // Bench initial voltage = 0.0 V.
        // device 1505, IC IC261, analog/basic/strongarm_comparator.hpp:43
        I(cpphdl_n2075, Vss) <+ 2.9999999999999998e-14 * ddt(V(cpphdl_n2075, Vss)); // Bench initial voltage = 0.0 V.
        // device 1506, IC IC261, analog/basic/strongarm_comparator.hpp:44
        I(cpphdl_n2076, Vss) <+ 2.9999999999999998e-14 * ddt(V(cpphdl_n2076, Vss)); // Bench initial voltage = 0.0 V.
        // device 1507, IC IC261, analog/basic/strongarm_comparator.hpp:45
        I(cpphdl_n2093, Vss) <+ 5.0000000000000002e-14 * ddt(V(cpphdl_n2093, Vss)); // Bench initial voltage = 0.0 V.
        // device 1508, IC IC261, analog/basic/strongarm_comparator.hpp:46
        I(cpphdl_n2089, Vss) <+ 5.0000000000000002e-14 * ddt(V(cpphdl_n2089, Vss)); // Bench initial voltage = 0.0 V.
        // device 1509, IC IC261, analog/basic/strongarm_comparator.hpp:47
        I(cpphdl_n2069, cpphdl_n2076) <+ 2e-14 * ddt(V(cpphdl_n2069, cpphdl_n2076)); // Bench initial voltage = 0.0 V.
        // device 1510, IC IC261, analog/basic/strongarm_comparator.hpp:48
        I(cpphdl_n2070, cpphdl_n2076) <+ 2e-14 * ddt(V(cpphdl_n2070, cpphdl_n2076)); // Bench initial voltage = 0.0 V.
        // device 1511, IC IC261, analog/basic/strongarm_comparator.hpp:49
        I(cpphdl_n2069, cpphdl_n2074) <+ 2.9999999999999998e-15 * ddt(V(cpphdl_n2069, cpphdl_n2074)); // Bench initial voltage = 0.0 V.
        // device 1512, IC IC261, analog/basic/strongarm_comparator.hpp:50
        I(cpphdl_n2070, cpphdl_n2075) <+ 2.9999999999999998e-15 * ddt(V(cpphdl_n2070, cpphdl_n2075)); // Bench initial voltage = 0.0 V.
        // device 1513, IC IC263, analog/basic/inverter.hpp:11
        I(cpphdl_n2097, Vdd) <+ cpphdl_channel(V(cpphdl_n2089, Vdd), V(cpphdl_n2097, Vdd), 0.001, 0.69999999999999996, -1.0);
        // device 1514, IC IC263, analog/basic/inverter.hpp:12
        I(cpphdl_n2097, Vss) <+ cpphdl_channel(V(cpphdl_n2089, Vss), V(cpphdl_n2097, Vss), 0.001, 0.69999999999999996, 1.0);
        // device 1515, IC IC265, analog/basic/inverter.hpp:11
        I(cpphdl_n2111, Vdd) <+ cpphdl_channel(V(cpphdl_n2097, Vdd), V(cpphdl_n2111, Vdd), 0.0040000000000000001, 0.69999999999999996, -1.0);
        // device 1516, IC IC265, analog/basic/inverter.hpp:12
        I(cpphdl_n2111, Vss) <+ cpphdl_channel(V(cpphdl_n2097, Vss), V(cpphdl_n2111, Vss), 0.0040000000000000001, 0.69999999999999996, 1.0);
        // device 1517, IC IC262, analog/basic/buffered_nand_latch.hpp:34
        I(cpphdl_n2089, Vss) <+ 2.0000000000000002e-15 * ddt(V(cpphdl_n2089, Vss)); // Bench initial voltage = 0.0 V.
        // device 1518, IC IC262, analog/basic/buffered_nand_latch.hpp:35
        I(cpphdl_n2089, cpphdl_n2097) <+ 1.0000000000000001e-15 * ddt(V(cpphdl_n2089, cpphdl_n2097)); // Bench initial voltage = 0.0 V.
        // device 1519, IC IC262, analog/basic/buffered_nand_latch.hpp:36
        I(cpphdl_n2097, Vss) <+ 5e-15 * ddt(V(cpphdl_n2097, Vss)); // Bench initial voltage = 0.0 V.
        // device 1520, IC IC262, analog/basic/buffered_nand_latch.hpp:37
        I(cpphdl_n2097, Vss) <+ 8.0000000000000006e-15 * ddt(V(cpphdl_n2097, Vss)); // Bench initial voltage = 0.0 V.
        // device 1521, IC IC262, analog/basic/buffered_nand_latch.hpp:38
        I(cpphdl_n2111, Vss) <+ 1e-14 * ddt(V(cpphdl_n2111, Vss)); // Bench initial voltage = 0.0 V.
        // device 1522, IC IC264, analog/basic/inverter.hpp:11
        I(cpphdl_n2101, Vdd) <+ cpphdl_channel(V(cpphdl_n2093, Vdd), V(cpphdl_n2101, Vdd), 0.001, 0.69999999999999996, -1.0);
        // device 1523, IC IC264, analog/basic/inverter.hpp:12
        I(cpphdl_n2101, Vss) <+ cpphdl_channel(V(cpphdl_n2093, Vss), V(cpphdl_n2101, Vss), 0.001, 0.69999999999999996, 1.0);
        // device 1524, IC IC266, analog/basic/inverter.hpp:11
        I(cpphdl_n2117, Vdd) <+ cpphdl_channel(V(cpphdl_n2101, Vdd), V(cpphdl_n2117, Vdd), 0.0040000000000000001, 0.69999999999999996, -1.0);
        // device 1525, IC IC266, analog/basic/inverter.hpp:12
        I(cpphdl_n2117, Vss) <+ cpphdl_channel(V(cpphdl_n2101, Vss), V(cpphdl_n2117, Vss), 0.0040000000000000001, 0.69999999999999996, 1.0);
        // device 1526, IC IC262, analog/basic/buffered_nand_latch.hpp:34
        I(cpphdl_n2093, Vss) <+ 2.0000000000000002e-15 * ddt(V(cpphdl_n2093, Vss)); // Bench initial voltage = 0.0 V.
        // device 1527, IC IC262, analog/basic/buffered_nand_latch.hpp:35
        I(cpphdl_n2093, cpphdl_n2101) <+ 1.0000000000000001e-15 * ddt(V(cpphdl_n2093, cpphdl_n2101)); // Bench initial voltage = 0.0 V.
        // device 1528, IC IC262, analog/basic/buffered_nand_latch.hpp:36
        I(cpphdl_n2101, Vss) <+ 5e-15 * ddt(V(cpphdl_n2101, Vss)); // Bench initial voltage = 0.0 V.
        // device 1529, IC IC262, analog/basic/buffered_nand_latch.hpp:37
        I(cpphdl_n2101, Vss) <+ 8.0000000000000006e-15 * ddt(V(cpphdl_n2101, Vss)); // Bench initial voltage = 0.0 V.
        // device 1530, IC IC262, analog/basic/buffered_nand_latch.hpp:38
        I(cpphdl_n2117, Vss) <+ 1e-14 * ddt(V(cpphdl_n2117, Vss)); // Bench initial voltage = 0.0 V.
        // device 1531, IC IC268, analog/basic/cmos_logic.hpp:17
        I(cpphdl_n2478, Vss) <+ 5.0000000000000002e-14 * ddt(V(cpphdl_n2478, Vss)); // Bench initial voltage = 0.0 V.
        // device 1532, IC IC268, analog/basic/cmos_logic.hpp:18
        I(cpphdl_n2478, Vdd) <+ cpphdl_channel(V(cpphdl_n2111, Vdd), V(cpphdl_n2478, Vdd), 0.01, 0.69999999999999996, -1.0);
        // device 1533, IC IC268, analog/basic/cmos_logic.hpp:19
        I(cpphdl_n2478, Vdd) <+ cpphdl_channel(V(cpphdl_n2119, Vdd), V(cpphdl_n2478, Vdd), 0.01, 0.69999999999999996, -1.0);
        // device 1534, IC IC268, analog/basic/cmos_logic.hpp:20
        I(cpphdl_n2478, cpphdl_n2114) <+ cpphdl_channel(V(cpphdl_n2111, cpphdl_n2114), V(cpphdl_n2478, cpphdl_n2114), 0.01, 0.69999999999999996, 1.0);
        // device 1535, IC IC268, analog/basic/cmos_logic.hpp:21
        I(cpphdl_n2114, Vss) <+ cpphdl_channel(V(cpphdl_n2119, Vss), V(cpphdl_n2114, Vss), 0.01, 0.69999999999999996, 1.0);
        // device 1536, IC IC268, analog/basic/cmos_logic.hpp:27
        I(cpphdl_n2114, Vss) <+ 1e-14 * ddt(V(cpphdl_n2114, Vss)); // Bench initial voltage = 0.0 V.
        // device 1537, IC IC269, analog/basic/cmos_logic.hpp:17
        I(cpphdl_n2119, Vss) <+ 5.0000000000000002e-14 * ddt(V(cpphdl_n2119, Vss)); // Bench initial voltage = 0.0 V.
        // device 1538, IC IC269, analog/basic/cmos_logic.hpp:18
        I(cpphdl_n2119, Vdd) <+ cpphdl_channel(V(cpphdl_n2117, Vdd), V(cpphdl_n2119, Vdd), 0.01, 0.69999999999999996, -1.0);
        // device 1539, IC IC269, analog/basic/cmos_logic.hpp:19
        I(cpphdl_n2119, Vdd) <+ cpphdl_channel(V(cpphdl_n2478, Vdd), V(cpphdl_n2119, Vdd), 0.01, 0.69999999999999996, -1.0);
        // device 1540, IC IC269, analog/basic/cmos_logic.hpp:20
        I(cpphdl_n2119, cpphdl_n2120) <+ cpphdl_channel(V(cpphdl_n2117, cpphdl_n2120), V(cpphdl_n2119, cpphdl_n2120), 0.01, 0.69999999999999996, 1.0);
        // device 1541, IC IC269, analog/basic/cmos_logic.hpp:21
        I(cpphdl_n2120, Vss) <+ cpphdl_channel(V(cpphdl_n2478, Vss), V(cpphdl_n2120, Vss), 0.01, 0.69999999999999996, 1.0);
        // device 1542, IC IC269, analog/basic/cmos_logic.hpp:27
        I(cpphdl_n2120, Vss) <+ 1e-14 * ddt(V(cpphdl_n2120, Vss)); // Bench initial voltage = 0.0 V.
        // device 1543, IC IC267, analog/basic/nand_latch.hpp:36
        I(cpphdl_n2111, Vss) <+ 2.9999999999999998e-15 * ddt(V(cpphdl_n2111, Vss)); // Bench initial voltage = 0.0 V.
        // device 1544, IC IC267, analog/basic/nand_latch.hpp:37
        I(cpphdl_n2117, Vss) <+ 2.9999999999999998e-15 * ddt(V(cpphdl_n2117, Vss)); // Bench initial voltage = 0.0 V.
        // device 1545, IC IC270, analog/basic/inverter.hpp:11
        I(cpphdl_n2125, Vdd) <+ cpphdl_channel(V(CLEAR, Vdd), V(cpphdl_n2125, Vdd), 0.01, 0.69999999999999996, -1.0);
        // device 1546, IC IC270, analog/basic/inverter.hpp:12
        I(cpphdl_n2125, Vss) <+ cpphdl_channel(V(CLEAR, Vss), V(cpphdl_n2125, Vss), 0.01, 0.69999999999999996, 1.0);
        // device 1547, IC IC267, analog/basic/nand_latch.hpp:58
        I(cpphdl_n2125, Vss) <+ 2.9999999999999998e-15 * ddt(V(cpphdl_n2125, Vss)); // Bench initial voltage = 0.0 V.
        // device 1548, IC IC267, analog/basic/nand_latch.hpp:59
        I(cpphdl_n2478, Vss) <+ cpphdl_channel(V(CLEAR, Vss), V(cpphdl_n2478, Vss), 0.050000000000000003, 0.69999999999999996, 1.0);
        // device 1549, IC IC267, analog/basic/nand_latch.hpp:60
        I(cpphdl_n2119, Vdd) <+ cpphdl_channel(V(cpphdl_n2125, Vdd), V(cpphdl_n2119, Vdd), 0.050000000000000003, 0.69999999999999996, -1.0);
        // device 1550, IC IC273, analog/basic/inverter.hpp:11
        I(cpphdl_n2149, Vdd) <+ cpphdl_channel(V(TRACK11, Vdd), V(cpphdl_n2149, Vdd), 0.0040000000000000001, 0.69999999999999996, -1.0);
        // device 1551, IC IC273, analog/basic/inverter.hpp:12
        I(cpphdl_n2149, Vss) <+ cpphdl_channel(V(TRACK11, Vss), V(cpphdl_n2149, Vss), 0.0040000000000000001, 0.69999999999999996, 1.0);
        // device 1552, IC IC272, analog/basic/mos_track_hold.hpp:31
        I(cpphdl_n2149, Vss) <+ 2e-14 * ddt(V(cpphdl_n2149, Vss)); // Bench initial voltage = 0.0 V.
        // device 1553, IC IC272, analog/basic/mos_track_hold.hpp:32
        I(cpphdl_n2286, cpphdl_n2203) <+ cpphdl_channel(V(TRACK11, cpphdl_n2203), V(cpphdl_n2286, cpphdl_n2203), 0.029999999999999999, 0.69999999999999996, 1.0);
        // device 1554, IC IC272, analog/basic/mos_track_hold.hpp:33
        I(cpphdl_n2203, cpphdl_n2286) <+ cpphdl_channel(V(cpphdl_n2149, cpphdl_n2286), V(cpphdl_n2203, cpphdl_n2286), 0.014999999999999999, 0.69999999999999996, -1.0);
        // device 1555, IC IC272, analog/basic/mos_track_hold.hpp:37
        I(cpphdl_n2203, cpphdl_n2203) <+ cpphdl_channel(V(cpphdl_n2149, cpphdl_n2203), V(cpphdl_n2203, cpphdl_n2203), 0.016, 0.69999999999999996, 1.0);
        // device 1556, IC IC272, analog/basic/mos_track_hold.hpp:38
        I(cpphdl_n2203, cpphdl_n2203) <+ cpphdl_channel(V(TRACK11, cpphdl_n2203), V(cpphdl_n2203, cpphdl_n2203), 0.0083999999999999995, 0.69999999999999996, -1.0);
        // device 1557, IC IC272, analog/basic/mos_track_hold.hpp:39
        I(cpphdl_n2203, Vss) <+ 1.5000000000000001e-12 * ddt(V(cpphdl_n2203, Vss)); // Bench initial voltage = 0.0 V.
        // device 1558, IC IC272, analog/basic/mos_track_hold.hpp:42
        I(TRACK11, cpphdl_n2203) <+ 2.0000000000000002e-15 * ddt(V(TRACK11, cpphdl_n2203)); // Bench initial voltage = -0.0 V.
        // device 1559, IC IC272, analog/basic/mos_track_hold.hpp:43
        I(cpphdl_n2149, cpphdl_n2203) <+ 2.0000000000000002e-15 * ddt(V(cpphdl_n2149, cpphdl_n2203)); // Bench initial voltage = 0.0 V.
        // device 1560, IC IC272, analog/basic/mos_track_hold.hpp:44
        I(cpphdl_n2286, cpphdl_n2203) <+ 1.0000000000000001e-15 * ddt(V(cpphdl_n2286, cpphdl_n2203)); // Bench initial voltage = 0.0 V.
        // device 1561, IC IC275, analog/basic/inverter.hpp:11
        I(cpphdl_n2164, Vdd) <+ cpphdl_channel(V(BIT_N11_0, Vdd), V(cpphdl_n2164, Vdd), 0.080000000000000002, 0.69999999999999996, -1.0);
        // device 1562, IC IC275, analog/basic/inverter.hpp:12
        I(cpphdl_n2164, Vss) <+ cpphdl_channel(V(BIT_N11_0, Vss), V(cpphdl_n2164, Vss), 0.080000000000000002, 0.69999999999999996, 1.0);
        // device 1563, IC IC274, analog/basic/mos_r2r_dac.hpp:27
        I(cpphdl_n2164, Vss) <+ 2.9999999999999998e-15 * ddt(V(cpphdl_n2164, Vss)); // Bench initial voltage = 0.0 V.
        // device 1564, IC IC274, analog/basic/mos_r2r_dac.hpp:28
        I(cpphdl_n2164, cpphdl_n2193) <+ V(cpphdl_n2164, cpphdl_n2193) / 2000.0;
        // device 1565, IC IC274, analog/basic/mos_r2r_dac.hpp:29
        I(cpphdl_n2193, Vss) <+ 2.9999999999999998e-15 * ddt(V(cpphdl_n2193, Vss)); // Bench initial voltage = 0.0 V.
        // device 1566, IC IC276, analog/basic/inverter.hpp:11
        I(cpphdl_n2168, Vdd) <+ cpphdl_channel(V(BIT_N11_1, Vdd), V(cpphdl_n2168, Vdd), 0.080000000000000002, 0.69999999999999996, -1.0);
        // device 1567, IC IC276, analog/basic/inverter.hpp:12
        I(cpphdl_n2168, Vss) <+ cpphdl_channel(V(BIT_N11_1, Vss), V(cpphdl_n2168, Vss), 0.080000000000000002, 0.69999999999999996, 1.0);
        // device 1568, IC IC274, analog/basic/mos_r2r_dac.hpp:27
        I(cpphdl_n2168, Vss) <+ 2.9999999999999998e-15 * ddt(V(cpphdl_n2168, Vss)); // Bench initial voltage = 0.0 V.
        // device 1569, IC IC274, analog/basic/mos_r2r_dac.hpp:28
        I(cpphdl_n2168, cpphdl_n2194) <+ V(cpphdl_n2168, cpphdl_n2194) / 2000.0;
        // device 1570, IC IC274, analog/basic/mos_r2r_dac.hpp:29
        I(cpphdl_n2194, Vss) <+ 2.9999999999999998e-15 * ddt(V(cpphdl_n2194, Vss)); // Bench initial voltage = 0.0 V.
        // device 1571, IC IC274, analog/basic/mos_r2r_dac.hpp:31
        I(cpphdl_n2193, cpphdl_n2194) <+ V(cpphdl_n2193, cpphdl_n2194) / 1000.0;
        // device 1572, IC IC277, analog/basic/inverter.hpp:11
        I(cpphdl_n2172, Vdd) <+ cpphdl_channel(V(BIT_N11_2, Vdd), V(cpphdl_n2172, Vdd), 0.080000000000000002, 0.69999999999999996, -1.0);
        // device 1573, IC IC277, analog/basic/inverter.hpp:12
        I(cpphdl_n2172, Vss) <+ cpphdl_channel(V(BIT_N11_2, Vss), V(cpphdl_n2172, Vss), 0.080000000000000002, 0.69999999999999996, 1.0);
        // device 1574, IC IC274, analog/basic/mos_r2r_dac.hpp:27
        I(cpphdl_n2172, Vss) <+ 2.9999999999999998e-15 * ddt(V(cpphdl_n2172, Vss)); // Bench initial voltage = 0.0 V.
        // device 1575, IC IC274, analog/basic/mos_r2r_dac.hpp:28
        I(cpphdl_n2172, cpphdl_n2195) <+ V(cpphdl_n2172, cpphdl_n2195) / 2000.0;
        // device 1576, IC IC274, analog/basic/mos_r2r_dac.hpp:29
        I(cpphdl_n2195, Vss) <+ 2.9999999999999998e-15 * ddt(V(cpphdl_n2195, Vss)); // Bench initial voltage = 0.0 V.
        // device 1577, IC IC274, analog/basic/mos_r2r_dac.hpp:31
        I(cpphdl_n2194, cpphdl_n2195) <+ V(cpphdl_n2194, cpphdl_n2195) / 1000.0;
        // device 1578, IC IC278, analog/basic/inverter.hpp:11
        I(cpphdl_n2176, Vdd) <+ cpphdl_channel(V(BIT_N11_3, Vdd), V(cpphdl_n2176, Vdd), 0.080000000000000002, 0.69999999999999996, -1.0);
        // device 1579, IC IC278, analog/basic/inverter.hpp:12
        I(cpphdl_n2176, Vss) <+ cpphdl_channel(V(BIT_N11_3, Vss), V(cpphdl_n2176, Vss), 0.080000000000000002, 0.69999999999999996, 1.0);
        // device 1580, IC IC274, analog/basic/mos_r2r_dac.hpp:27
        I(cpphdl_n2176, Vss) <+ 2.9999999999999998e-15 * ddt(V(cpphdl_n2176, Vss)); // Bench initial voltage = 0.0 V.
        // device 1581, IC IC274, analog/basic/mos_r2r_dac.hpp:28
        I(cpphdl_n2176, cpphdl_n2196) <+ V(cpphdl_n2176, cpphdl_n2196) / 2000.0;
        // device 1582, IC IC274, analog/basic/mos_r2r_dac.hpp:29
        I(cpphdl_n2196, Vss) <+ 2.9999999999999998e-15 * ddt(V(cpphdl_n2196, Vss)); // Bench initial voltage = 0.0 V.
        // device 1583, IC IC274, analog/basic/mos_r2r_dac.hpp:31
        I(cpphdl_n2195, cpphdl_n2196) <+ V(cpphdl_n2195, cpphdl_n2196) / 1000.0;
        // device 1584, IC IC279, analog/basic/inverter.hpp:11
        I(cpphdl_n2180, Vdd) <+ cpphdl_channel(V(BIT_N11_4, Vdd), V(cpphdl_n2180, Vdd), 0.080000000000000002, 0.69999999999999996, -1.0);
        // device 1585, IC IC279, analog/basic/inverter.hpp:12
        I(cpphdl_n2180, Vss) <+ cpphdl_channel(V(BIT_N11_4, Vss), V(cpphdl_n2180, Vss), 0.080000000000000002, 0.69999999999999996, 1.0);
        // device 1586, IC IC274, analog/basic/mos_r2r_dac.hpp:27
        I(cpphdl_n2180, Vss) <+ 2.9999999999999998e-15 * ddt(V(cpphdl_n2180, Vss)); // Bench initial voltage = 0.0 V.
        // device 1587, IC IC274, analog/basic/mos_r2r_dac.hpp:28
        I(cpphdl_n2180, cpphdl_n2197) <+ V(cpphdl_n2180, cpphdl_n2197) / 2000.0;
        // device 1588, IC IC274, analog/basic/mos_r2r_dac.hpp:29
        I(cpphdl_n2197, Vss) <+ 2.9999999999999998e-15 * ddt(V(cpphdl_n2197, Vss)); // Bench initial voltage = 0.0 V.
        // device 1589, IC IC274, analog/basic/mos_r2r_dac.hpp:31
        I(cpphdl_n2196, cpphdl_n2197) <+ V(cpphdl_n2196, cpphdl_n2197) / 1000.0;
        // device 1590, IC IC280, analog/basic/inverter.hpp:11
        I(cpphdl_n2184, Vdd) <+ cpphdl_channel(V(BIT_N11_5, Vdd), V(cpphdl_n2184, Vdd), 0.080000000000000002, 0.69999999999999996, -1.0);
        // device 1591, IC IC280, analog/basic/inverter.hpp:12
        I(cpphdl_n2184, Vss) <+ cpphdl_channel(V(BIT_N11_5, Vss), V(cpphdl_n2184, Vss), 0.080000000000000002, 0.69999999999999996, 1.0);
        // device 1592, IC IC274, analog/basic/mos_r2r_dac.hpp:27
        I(cpphdl_n2184, Vss) <+ 2.9999999999999998e-15 * ddt(V(cpphdl_n2184, Vss)); // Bench initial voltage = 0.0 V.
        // device 1593, IC IC274, analog/basic/mos_r2r_dac.hpp:28
        I(cpphdl_n2184, cpphdl_n2198) <+ V(cpphdl_n2184, cpphdl_n2198) / 2000.0;
        // device 1594, IC IC274, analog/basic/mos_r2r_dac.hpp:29
        I(cpphdl_n2198, Vss) <+ 2.9999999999999998e-15 * ddt(V(cpphdl_n2198, Vss)); // Bench initial voltage = 0.0 V.
        // device 1595, IC IC274, analog/basic/mos_r2r_dac.hpp:31
        I(cpphdl_n2197, cpphdl_n2198) <+ V(cpphdl_n2197, cpphdl_n2198) / 1000.0;
        // device 1596, IC IC281, analog/basic/inverter.hpp:11
        I(cpphdl_n2188, Vdd) <+ cpphdl_channel(V(BIT_N11_6, Vdd), V(cpphdl_n2188, Vdd), 0.080000000000000002, 0.69999999999999996, -1.0);
        // device 1597, IC IC281, analog/basic/inverter.hpp:12
        I(cpphdl_n2188, Vss) <+ cpphdl_channel(V(BIT_N11_6, Vss), V(cpphdl_n2188, Vss), 0.080000000000000002, 0.69999999999999996, 1.0);
        // device 1598, IC IC274, analog/basic/mos_r2r_dac.hpp:27
        I(cpphdl_n2188, Vss) <+ 2.9999999999999998e-15 * ddt(V(cpphdl_n2188, Vss)); // Bench initial voltage = 0.0 V.
        // device 1599, IC IC274, analog/basic/mos_r2r_dac.hpp:28
        I(cpphdl_n2188, cpphdl_n2199) <+ V(cpphdl_n2188, cpphdl_n2199) / 2000.0;
        // device 1600, IC IC274, analog/basic/mos_r2r_dac.hpp:29
        I(cpphdl_n2199, Vss) <+ 2.9999999999999998e-15 * ddt(V(cpphdl_n2199, Vss)); // Bench initial voltage = 0.0 V.
        // device 1601, IC IC274, analog/basic/mos_r2r_dac.hpp:31
        I(cpphdl_n2198, cpphdl_n2199) <+ V(cpphdl_n2198, cpphdl_n2199) / 1000.0;
        // device 1602, IC IC282, analog/basic/inverter.hpp:11
        I(cpphdl_n2192, Vdd) <+ cpphdl_channel(V(BIT_N11_7, Vdd), V(cpphdl_n2192, Vdd), 0.080000000000000002, 0.69999999999999996, -1.0);
        // device 1603, IC IC282, analog/basic/inverter.hpp:12
        I(cpphdl_n2192, Vss) <+ cpphdl_channel(V(BIT_N11_7, Vss), V(cpphdl_n2192, Vss), 0.080000000000000002, 0.69999999999999996, 1.0);
        // device 1604, IC IC274, analog/basic/mos_r2r_dac.hpp:27
        I(cpphdl_n2192, Vss) <+ 2.9999999999999998e-15 * ddt(V(cpphdl_n2192, Vss)); // Bench initial voltage = 0.0 V.
        // device 1605, IC IC274, analog/basic/mos_r2r_dac.hpp:28
        I(cpphdl_n2192, cpphdl_n2204) <+ V(cpphdl_n2192, cpphdl_n2204) / 2000.0;
        // device 1606, IC IC274, analog/basic/mos_r2r_dac.hpp:29
        I(cpphdl_n2204, Vss) <+ 2.9999999999999998e-15 * ddt(V(cpphdl_n2204, Vss)); // Bench initial voltage = 0.0 V.
        // device 1607, IC IC274, analog/basic/mos_r2r_dac.hpp:31
        I(cpphdl_n2199, cpphdl_n2204) <+ V(cpphdl_n2199, cpphdl_n2204) / 1000.0;
        // device 1608, IC IC274, analog/basic/mos_r2r_dac.hpp:33
        I(Vss, cpphdl_n2193) <+ V(Vss, cpphdl_n2193) / 2000.0;
        // device 1609, IC IC283, analog/basic/nmos_resistor_amplifier.hpp:23
        I(Vdd, cpphdl_n2213) <+ V(Vdd, cpphdl_n2213) / 1000.0;
        // device 1610, IC IC283, analog/basic/nmos_resistor_amplifier.hpp:24
        I(Vdd, cpphdl_n2212) <+ V(Vdd, cpphdl_n2212) / 1000.0;
        // device 1611, IC IC283, analog/basic/nmos_resistor_amplifier.hpp:25
        I(cpphdl_n2213, cpphdl_n2207) <+ cpphdl_channel(V(cpphdl_n2203, cpphdl_n2207), V(cpphdl_n2213, cpphdl_n2207), 0.0074999999999999997, 0.69999999999999996, 1.0);
        // device 1612, IC IC283, analog/basic/nmos_resistor_amplifier.hpp:26
        I(cpphdl_n2212, cpphdl_n2208) <+ cpphdl_channel(V(cpphdl_n2204, cpphdl_n2208), V(cpphdl_n2212, cpphdl_n2208), 0.0074999999999999997, 0.69999999999999996, 1.0);
        // device 1613, IC IC283, analog/basic/nmos_resistor_amplifier.hpp:27
        I(cpphdl_n2209, cpphdl_n2207) <+ V(cpphdl_n2209, cpphdl_n2207) / 100.0;
        // device 1614, IC IC283, analog/basic/nmos_resistor_amplifier.hpp:28
        I(cpphdl_n2209, cpphdl_n2208) <+ V(cpphdl_n2209, cpphdl_n2208) / 100.0;
        // device 1615, IC IC283, analog/basic/nmos_resistor_amplifier.hpp:29
        I(Vss, cpphdl_n2209) <+ V(Vss, cpphdl_n2209) / 300.0;
        // device 1616, IC IC283, analog/basic/nmos_resistor_amplifier.hpp:30
        I(cpphdl_n2213, Vdd) <+ 2.9999999999999998e-13 * ddt(V(cpphdl_n2213, Vdd)); // Bench initial voltage = 0.0 V.
        // device 1617, IC IC283, analog/basic/nmos_resistor_amplifier.hpp:31
        I(cpphdl_n2212, Vdd) <+ 2.9999999999999998e-13 * ddt(V(cpphdl_n2212, Vdd)); // Bench initial voltage = 0.0 V.
        // device 1618, IC IC283, analog/basic/nmos_resistor_amplifier.hpp:32
        I(cpphdl_n2209, Vss) <+ 4e-14 * ddt(V(cpphdl_n2209, Vss)); // Bench initial voltage = 0.0 V.
        // device 1619, IC IC283, analog/basic/nmos_resistor_amplifier.hpp:34
        I(cpphdl_n2203, cpphdl_n2207) <+ 2e-14 * ddt(V(cpphdl_n2203, cpphdl_n2207)); // Bench initial voltage = 0.0 V.
        // device 1620, IC IC283, analog/basic/nmos_resistor_amplifier.hpp:35
        I(cpphdl_n2204, cpphdl_n2208) <+ 2e-14 * ddt(V(cpphdl_n2204, cpphdl_n2208)); // Bench initial voltage = 0.0 V.
        // device 1621, IC IC283, analog/basic/nmos_resistor_amplifier.hpp:36
        I(cpphdl_n2203, cpphdl_n2213) <+ 2.9999999999999998e-15 * ddt(V(cpphdl_n2203, cpphdl_n2213)); // Bench initial voltage = 0.0 V.
        // device 1622, IC IC283, analog/basic/nmos_resistor_amplifier.hpp:37
        I(cpphdl_n2204, cpphdl_n2212) <+ 2.9999999999999998e-15 * ddt(V(cpphdl_n2204, cpphdl_n2212)); // Bench initial voltage = 0.0 V.
        // device 1623, IC IC284, analog/basic/strongarm_comparator.hpp:28
        I(cpphdl_n2217, cpphdl_n2219) <+ cpphdl_channel(V(cpphdl_n2212, cpphdl_n2219), V(cpphdl_n2217, cpphdl_n2219), 0.0080000000000000002, 0.69999999999999996, 1.0);
        // device 1624, IC IC284, analog/basic/strongarm_comparator.hpp:29
        I(cpphdl_n2218, cpphdl_n2219) <+ cpphdl_channel(V(cpphdl_n2213, cpphdl_n2219), V(cpphdl_n2218, cpphdl_n2219), 0.0080000000000000002, 0.69999999999999996, 1.0);
        // device 1625, IC IC284, analog/basic/strongarm_comparator.hpp:30
        I(cpphdl_n2219, Vss) <+ cpphdl_channel(V(EVALUATE, Vss), V(cpphdl_n2219, Vss), 0.0080000000000000002, 0.69999999999999996, 1.0);
        // device 1626, IC IC284, analog/basic/strongarm_comparator.hpp:33
        I(cpphdl_n2232, cpphdl_n2217) <+ cpphdl_channel(V(cpphdl_n2236, cpphdl_n2217), V(cpphdl_n2232, cpphdl_n2217), 0.0040000000000000001, 0.69999999999999996, 1.0);
        // device 1627, IC IC284, analog/basic/strongarm_comparator.hpp:34
        I(cpphdl_n2236, cpphdl_n2218) <+ cpphdl_channel(V(cpphdl_n2232, cpphdl_n2218), V(cpphdl_n2236, cpphdl_n2218), 0.0040000000000000001, 0.69999999999999996, 1.0);
        // device 1628, IC IC284, analog/basic/strongarm_comparator.hpp:35
        I(cpphdl_n2236, Vdd) <+ cpphdl_channel(V(cpphdl_n2232, Vdd), V(cpphdl_n2236, Vdd), 0.002, 0.69999999999999996, -1.0);
        // device 1629, IC IC284, analog/basic/strongarm_comparator.hpp:36
        I(cpphdl_n2232, Vdd) <+ cpphdl_channel(V(cpphdl_n2236, Vdd), V(cpphdl_n2232, Vdd), 0.002, 0.69999999999999996, -1.0);
        // device 1630, IC IC284, analog/basic/strongarm_comparator.hpp:38
        I(cpphdl_n2217, Vdd) <+ cpphdl_channel(V(EVALUATE, Vdd), V(cpphdl_n2217, Vdd), 0.002, 0.69999999999999996, -1.0);
        // device 1631, IC IC284, analog/basic/strongarm_comparator.hpp:39
        I(cpphdl_n2218, Vdd) <+ cpphdl_channel(V(EVALUATE, Vdd), V(cpphdl_n2218, Vdd), 0.002, 0.69999999999999996, -1.0);
        // device 1632, IC IC284, analog/basic/strongarm_comparator.hpp:40
        I(cpphdl_n2236, Vdd) <+ cpphdl_channel(V(EVALUATE, Vdd), V(cpphdl_n2236, Vdd), 0.002, 0.69999999999999996, -1.0);
        // device 1633, IC IC284, analog/basic/strongarm_comparator.hpp:41
        I(cpphdl_n2232, Vdd) <+ cpphdl_channel(V(EVALUATE, Vdd), V(cpphdl_n2232, Vdd), 0.002, 0.69999999999999996, -1.0);
        // device 1634, IC IC284, analog/basic/strongarm_comparator.hpp:42
        I(cpphdl_n2217, Vss) <+ 2.9999999999999998e-14 * ddt(V(cpphdl_n2217, Vss)); // Bench initial voltage = 0.0 V.
        // device 1635, IC IC284, analog/basic/strongarm_comparator.hpp:43
        I(cpphdl_n2218, Vss) <+ 2.9999999999999998e-14 * ddt(V(cpphdl_n2218, Vss)); // Bench initial voltage = 0.0 V.
        // device 1636, IC IC284, analog/basic/strongarm_comparator.hpp:44
        I(cpphdl_n2219, Vss) <+ 2.9999999999999998e-14 * ddt(V(cpphdl_n2219, Vss)); // Bench initial voltage = 0.0 V.
        // device 1637, IC IC284, analog/basic/strongarm_comparator.hpp:45
        I(cpphdl_n2236, Vss) <+ 5.0000000000000002e-14 * ddt(V(cpphdl_n2236, Vss)); // Bench initial voltage = 0.0 V.
        // device 1638, IC IC284, analog/basic/strongarm_comparator.hpp:46
        I(cpphdl_n2232, Vss) <+ 5.0000000000000002e-14 * ddt(V(cpphdl_n2232, Vss)); // Bench initial voltage = 0.0 V.
        // device 1639, IC IC284, analog/basic/strongarm_comparator.hpp:47
        I(cpphdl_n2212, cpphdl_n2219) <+ 2e-14 * ddt(V(cpphdl_n2212, cpphdl_n2219)); // Bench initial voltage = 0.0 V.
        // device 1640, IC IC284, analog/basic/strongarm_comparator.hpp:48
        I(cpphdl_n2213, cpphdl_n2219) <+ 2e-14 * ddt(V(cpphdl_n2213, cpphdl_n2219)); // Bench initial voltage = 0.0 V.
        // device 1641, IC IC284, analog/basic/strongarm_comparator.hpp:49
        I(cpphdl_n2212, cpphdl_n2217) <+ 2.9999999999999998e-15 * ddt(V(cpphdl_n2212, cpphdl_n2217)); // Bench initial voltage = 0.0 V.
        // device 1642, IC IC284, analog/basic/strongarm_comparator.hpp:50
        I(cpphdl_n2213, cpphdl_n2218) <+ 2.9999999999999998e-15 * ddt(V(cpphdl_n2213, cpphdl_n2218)); // Bench initial voltage = 0.0 V.
        // device 1643, IC IC286, analog/basic/inverter.hpp:11
        I(cpphdl_n2240, Vdd) <+ cpphdl_channel(V(cpphdl_n2232, Vdd), V(cpphdl_n2240, Vdd), 0.001, 0.69999999999999996, -1.0);
        // device 1644, IC IC286, analog/basic/inverter.hpp:12
        I(cpphdl_n2240, Vss) <+ cpphdl_channel(V(cpphdl_n2232, Vss), V(cpphdl_n2240, Vss), 0.001, 0.69999999999999996, 1.0);
        // device 1645, IC IC288, analog/basic/inverter.hpp:11
        I(cpphdl_n2254, Vdd) <+ cpphdl_channel(V(cpphdl_n2240, Vdd), V(cpphdl_n2254, Vdd), 0.0040000000000000001, 0.69999999999999996, -1.0);
        // device 1646, IC IC288, analog/basic/inverter.hpp:12
        I(cpphdl_n2254, Vss) <+ cpphdl_channel(V(cpphdl_n2240, Vss), V(cpphdl_n2254, Vss), 0.0040000000000000001, 0.69999999999999996, 1.0);
        // device 1647, IC IC285, analog/basic/buffered_nand_latch.hpp:34
        I(cpphdl_n2232, Vss) <+ 2.0000000000000002e-15 * ddt(V(cpphdl_n2232, Vss)); // Bench initial voltage = 0.0 V.
        // device 1648, IC IC285, analog/basic/buffered_nand_latch.hpp:35
        I(cpphdl_n2232, cpphdl_n2240) <+ 1.0000000000000001e-15 * ddt(V(cpphdl_n2232, cpphdl_n2240)); // Bench initial voltage = 0.0 V.
        // device 1649, IC IC285, analog/basic/buffered_nand_latch.hpp:36
        I(cpphdl_n2240, Vss) <+ 5e-15 * ddt(V(cpphdl_n2240, Vss)); // Bench initial voltage = 0.0 V.
        // device 1650, IC IC285, analog/basic/buffered_nand_latch.hpp:37
        I(cpphdl_n2240, Vss) <+ 8.0000000000000006e-15 * ddt(V(cpphdl_n2240, Vss)); // Bench initial voltage = 0.0 V.
        // device 1651, IC IC285, analog/basic/buffered_nand_latch.hpp:38
        I(cpphdl_n2254, Vss) <+ 1e-14 * ddt(V(cpphdl_n2254, Vss)); // Bench initial voltage = 0.0 V.
        // device 1652, IC IC287, analog/basic/inverter.hpp:11
        I(cpphdl_n2244, Vdd) <+ cpphdl_channel(V(cpphdl_n2236, Vdd), V(cpphdl_n2244, Vdd), 0.001, 0.69999999999999996, -1.0);
        // device 1653, IC IC287, analog/basic/inverter.hpp:12
        I(cpphdl_n2244, Vss) <+ cpphdl_channel(V(cpphdl_n2236, Vss), V(cpphdl_n2244, Vss), 0.001, 0.69999999999999996, 1.0);
        // device 1654, IC IC289, analog/basic/inverter.hpp:11
        I(cpphdl_n2260, Vdd) <+ cpphdl_channel(V(cpphdl_n2244, Vdd), V(cpphdl_n2260, Vdd), 0.0040000000000000001, 0.69999999999999996, -1.0);
        // device 1655, IC IC289, analog/basic/inverter.hpp:12
        I(cpphdl_n2260, Vss) <+ cpphdl_channel(V(cpphdl_n2244, Vss), V(cpphdl_n2260, Vss), 0.0040000000000000001, 0.69999999999999996, 1.0);
        // device 1656, IC IC285, analog/basic/buffered_nand_latch.hpp:34
        I(cpphdl_n2236, Vss) <+ 2.0000000000000002e-15 * ddt(V(cpphdl_n2236, Vss)); // Bench initial voltage = 0.0 V.
        // device 1657, IC IC285, analog/basic/buffered_nand_latch.hpp:35
        I(cpphdl_n2236, cpphdl_n2244) <+ 1.0000000000000001e-15 * ddt(V(cpphdl_n2236, cpphdl_n2244)); // Bench initial voltage = 0.0 V.
        // device 1658, IC IC285, analog/basic/buffered_nand_latch.hpp:36
        I(cpphdl_n2244, Vss) <+ 5e-15 * ddt(V(cpphdl_n2244, Vss)); // Bench initial voltage = 0.0 V.
        // device 1659, IC IC285, analog/basic/buffered_nand_latch.hpp:37
        I(cpphdl_n2244, Vss) <+ 8.0000000000000006e-15 * ddt(V(cpphdl_n2244, Vss)); // Bench initial voltage = 0.0 V.
        // device 1660, IC IC285, analog/basic/buffered_nand_latch.hpp:38
        I(cpphdl_n2260, Vss) <+ 1e-14 * ddt(V(cpphdl_n2260, Vss)); // Bench initial voltage = 0.0 V.
        // device 1661, IC IC291, analog/basic/cmos_logic.hpp:17
        I(cpphdl_n2483, Vss) <+ 5.0000000000000002e-14 * ddt(V(cpphdl_n2483, Vss)); // Bench initial voltage = 0.0 V.
        // device 1662, IC IC291, analog/basic/cmos_logic.hpp:18
        I(cpphdl_n2483, Vdd) <+ cpphdl_channel(V(cpphdl_n2254, Vdd), V(cpphdl_n2483, Vdd), 0.01, 0.69999999999999996, -1.0);
        // device 1663, IC IC291, analog/basic/cmos_logic.hpp:19
        I(cpphdl_n2483, Vdd) <+ cpphdl_channel(V(cpphdl_n2262, Vdd), V(cpphdl_n2483, Vdd), 0.01, 0.69999999999999996, -1.0);
        // device 1664, IC IC291, analog/basic/cmos_logic.hpp:20
        I(cpphdl_n2483, cpphdl_n2257) <+ cpphdl_channel(V(cpphdl_n2254, cpphdl_n2257), V(cpphdl_n2483, cpphdl_n2257), 0.01, 0.69999999999999996, 1.0);
        // device 1665, IC IC291, analog/basic/cmos_logic.hpp:21
        I(cpphdl_n2257, Vss) <+ cpphdl_channel(V(cpphdl_n2262, Vss), V(cpphdl_n2257, Vss), 0.01, 0.69999999999999996, 1.0);
        // device 1666, IC IC291, analog/basic/cmos_logic.hpp:27
        I(cpphdl_n2257, Vss) <+ 1e-14 * ddt(V(cpphdl_n2257, Vss)); // Bench initial voltage = 0.0 V.
        // device 1667, IC IC292, analog/basic/cmos_logic.hpp:17
        I(cpphdl_n2262, Vss) <+ 5.0000000000000002e-14 * ddt(V(cpphdl_n2262, Vss)); // Bench initial voltage = 0.0 V.
        // device 1668, IC IC292, analog/basic/cmos_logic.hpp:18
        I(cpphdl_n2262, Vdd) <+ cpphdl_channel(V(cpphdl_n2260, Vdd), V(cpphdl_n2262, Vdd), 0.01, 0.69999999999999996, -1.0);
        // device 1669, IC IC292, analog/basic/cmos_logic.hpp:19
        I(cpphdl_n2262, Vdd) <+ cpphdl_channel(V(cpphdl_n2483, Vdd), V(cpphdl_n2262, Vdd), 0.01, 0.69999999999999996, -1.0);
        // device 1670, IC IC292, analog/basic/cmos_logic.hpp:20
        I(cpphdl_n2262, cpphdl_n2263) <+ cpphdl_channel(V(cpphdl_n2260, cpphdl_n2263), V(cpphdl_n2262, cpphdl_n2263), 0.01, 0.69999999999999996, 1.0);
        // device 1671, IC IC292, analog/basic/cmos_logic.hpp:21
        I(cpphdl_n2263, Vss) <+ cpphdl_channel(V(cpphdl_n2483, Vss), V(cpphdl_n2263, Vss), 0.01, 0.69999999999999996, 1.0);
        // device 1672, IC IC292, analog/basic/cmos_logic.hpp:27
        I(cpphdl_n2263, Vss) <+ 1e-14 * ddt(V(cpphdl_n2263, Vss)); // Bench initial voltage = 0.0 V.
        // device 1673, IC IC290, analog/basic/nand_latch.hpp:36
        I(cpphdl_n2254, Vss) <+ 2.9999999999999998e-15 * ddt(V(cpphdl_n2254, Vss)); // Bench initial voltage = 0.0 V.
        // device 1674, IC IC290, analog/basic/nand_latch.hpp:37
        I(cpphdl_n2260, Vss) <+ 2.9999999999999998e-15 * ddt(V(cpphdl_n2260, Vss)); // Bench initial voltage = 0.0 V.
        // device 1675, IC IC293, analog/basic/inverter.hpp:11
        I(cpphdl_n2268, Vdd) <+ cpphdl_channel(V(CLEAR, Vdd), V(cpphdl_n2268, Vdd), 0.01, 0.69999999999999996, -1.0);
        // device 1676, IC IC293, analog/basic/inverter.hpp:12
        I(cpphdl_n2268, Vss) <+ cpphdl_channel(V(CLEAR, Vss), V(cpphdl_n2268, Vss), 0.01, 0.69999999999999996, 1.0);
        // device 1677, IC IC290, analog/basic/nand_latch.hpp:58
        I(cpphdl_n2268, Vss) <+ 2.9999999999999998e-15 * ddt(V(cpphdl_n2268, Vss)); // Bench initial voltage = 0.0 V.
        // device 1678, IC IC290, analog/basic/nand_latch.hpp:59
        I(cpphdl_n2483, Vss) <+ cpphdl_channel(V(CLEAR, Vss), V(cpphdl_n2483, Vss), 0.050000000000000003, 0.69999999999999996, 1.0);
        // device 1679, IC IC290, analog/basic/nand_latch.hpp:60
        I(cpphdl_n2262, Vdd) <+ cpphdl_channel(V(cpphdl_n2268, Vdd), V(cpphdl_n2262, Vdd), 0.050000000000000003, 0.69999999999999996, -1.0);
        // device 1680, IC IC296, analog/basic/inverter.hpp:11
        I(cpphdl_n2292, Vdd) <+ cpphdl_channel(V(TRACK12, Vdd), V(cpphdl_n2292, Vdd), 0.0040000000000000001, 0.69999999999999996, -1.0);
        // device 1681, IC IC296, analog/basic/inverter.hpp:12
        I(cpphdl_n2292, Vss) <+ cpphdl_channel(V(TRACK12, Vss), V(cpphdl_n2292, Vss), 0.0040000000000000001, 0.69999999999999996, 1.0);
        // device 1682, IC IC295, analog/basic/mos_track_hold.hpp:31
        I(cpphdl_n2292, Vss) <+ 2e-14 * ddt(V(cpphdl_n2292, Vss)); // Bench initial voltage = 0.0 V.
        // device 1683, IC IC295, analog/basic/mos_track_hold.hpp:32
        I(cpphdl_n2286, cpphdl_n2346) <+ cpphdl_channel(V(TRACK12, cpphdl_n2346), V(cpphdl_n2286, cpphdl_n2346), 0.029999999999999999, 0.69999999999999996, 1.0);
        // device 1684, IC IC295, analog/basic/mos_track_hold.hpp:33
        I(cpphdl_n2346, cpphdl_n2286) <+ cpphdl_channel(V(cpphdl_n2292, cpphdl_n2286), V(cpphdl_n2346, cpphdl_n2286), 0.014999999999999999, 0.69999999999999996, -1.0);
        // device 1685, IC IC295, analog/basic/mos_track_hold.hpp:37
        I(cpphdl_n2346, cpphdl_n2346) <+ cpphdl_channel(V(cpphdl_n2292, cpphdl_n2346), V(cpphdl_n2346, cpphdl_n2346), 0.016, 0.69999999999999996, 1.0);
        // device 1686, IC IC295, analog/basic/mos_track_hold.hpp:38
        I(cpphdl_n2346, cpphdl_n2346) <+ cpphdl_channel(V(TRACK12, cpphdl_n2346), V(cpphdl_n2346, cpphdl_n2346), 0.0083999999999999995, 0.69999999999999996, -1.0);
        // device 1687, IC IC295, analog/basic/mos_track_hold.hpp:39
        I(cpphdl_n2346, Vss) <+ 1.5000000000000001e-12 * ddt(V(cpphdl_n2346, Vss)); // Bench initial voltage = 0.0 V.
        // device 1688, IC IC295, analog/basic/mos_track_hold.hpp:42
        I(TRACK12, cpphdl_n2346) <+ 2.0000000000000002e-15 * ddt(V(TRACK12, cpphdl_n2346)); // Bench initial voltage = -0.0 V.
        // device 1689, IC IC295, analog/basic/mos_track_hold.hpp:43
        I(cpphdl_n2292, cpphdl_n2346) <+ 2.0000000000000002e-15 * ddt(V(cpphdl_n2292, cpphdl_n2346)); // Bench initial voltage = 0.0 V.
        // device 1690, IC IC295, analog/basic/mos_track_hold.hpp:44
        I(cpphdl_n2286, cpphdl_n2346) <+ 1.0000000000000001e-15 * ddt(V(cpphdl_n2286, cpphdl_n2346)); // Bench initial voltage = 0.0 V.
        // device 1691, IC IC298, analog/basic/inverter.hpp:11
        I(cpphdl_n2307, Vdd) <+ cpphdl_channel(V(BIT_N12_0, Vdd), V(cpphdl_n2307, Vdd), 0.080000000000000002, 0.69999999999999996, -1.0);
        // device 1692, IC IC298, analog/basic/inverter.hpp:12
        I(cpphdl_n2307, Vss) <+ cpphdl_channel(V(BIT_N12_0, Vss), V(cpphdl_n2307, Vss), 0.080000000000000002, 0.69999999999999996, 1.0);
        // device 1693, IC IC297, analog/basic/mos_r2r_dac.hpp:27
        I(cpphdl_n2307, Vss) <+ 2.9999999999999998e-15 * ddt(V(cpphdl_n2307, Vss)); // Bench initial voltage = 0.0 V.
        // device 1694, IC IC297, analog/basic/mos_r2r_dac.hpp:28
        I(cpphdl_n2307, cpphdl_n2336) <+ V(cpphdl_n2307, cpphdl_n2336) / 2000.0;
        // device 1695, IC IC297, analog/basic/mos_r2r_dac.hpp:29
        I(cpphdl_n2336, Vss) <+ 2.9999999999999998e-15 * ddt(V(cpphdl_n2336, Vss)); // Bench initial voltage = 0.0 V.
        // device 1696, IC IC299, analog/basic/inverter.hpp:11
        I(cpphdl_n2311, Vdd) <+ cpphdl_channel(V(BIT_N12_1, Vdd), V(cpphdl_n2311, Vdd), 0.080000000000000002, 0.69999999999999996, -1.0);
        // device 1697, IC IC299, analog/basic/inverter.hpp:12
        I(cpphdl_n2311, Vss) <+ cpphdl_channel(V(BIT_N12_1, Vss), V(cpphdl_n2311, Vss), 0.080000000000000002, 0.69999999999999996, 1.0);
        // device 1698, IC IC297, analog/basic/mos_r2r_dac.hpp:27
        I(cpphdl_n2311, Vss) <+ 2.9999999999999998e-15 * ddt(V(cpphdl_n2311, Vss)); // Bench initial voltage = 0.0 V.
        // device 1699, IC IC297, analog/basic/mos_r2r_dac.hpp:28
        I(cpphdl_n2311, cpphdl_n2337) <+ V(cpphdl_n2311, cpphdl_n2337) / 2000.0;
        // device 1700, IC IC297, analog/basic/mos_r2r_dac.hpp:29
        I(cpphdl_n2337, Vss) <+ 2.9999999999999998e-15 * ddt(V(cpphdl_n2337, Vss)); // Bench initial voltage = 0.0 V.
        // device 1701, IC IC297, analog/basic/mos_r2r_dac.hpp:31
        I(cpphdl_n2336, cpphdl_n2337) <+ V(cpphdl_n2336, cpphdl_n2337) / 1000.0;
        // device 1702, IC IC300, analog/basic/inverter.hpp:11
        I(cpphdl_n2315, Vdd) <+ cpphdl_channel(V(BIT_N12_2, Vdd), V(cpphdl_n2315, Vdd), 0.080000000000000002, 0.69999999999999996, -1.0);
        // device 1703, IC IC300, analog/basic/inverter.hpp:12
        I(cpphdl_n2315, Vss) <+ cpphdl_channel(V(BIT_N12_2, Vss), V(cpphdl_n2315, Vss), 0.080000000000000002, 0.69999999999999996, 1.0);
        // device 1704, IC IC297, analog/basic/mos_r2r_dac.hpp:27
        I(cpphdl_n2315, Vss) <+ 2.9999999999999998e-15 * ddt(V(cpphdl_n2315, Vss)); // Bench initial voltage = 0.0 V.
        // device 1705, IC IC297, analog/basic/mos_r2r_dac.hpp:28
        I(cpphdl_n2315, cpphdl_n2338) <+ V(cpphdl_n2315, cpphdl_n2338) / 2000.0;
        // device 1706, IC IC297, analog/basic/mos_r2r_dac.hpp:29
        I(cpphdl_n2338, Vss) <+ 2.9999999999999998e-15 * ddt(V(cpphdl_n2338, Vss)); // Bench initial voltage = 0.0 V.
        // device 1707, IC IC297, analog/basic/mos_r2r_dac.hpp:31
        I(cpphdl_n2337, cpphdl_n2338) <+ V(cpphdl_n2337, cpphdl_n2338) / 1000.0;
        // device 1708, IC IC301, analog/basic/inverter.hpp:11
        I(cpphdl_n2319, Vdd) <+ cpphdl_channel(V(BIT_N12_3, Vdd), V(cpphdl_n2319, Vdd), 0.080000000000000002, 0.69999999999999996, -1.0);
        // device 1709, IC IC301, analog/basic/inverter.hpp:12
        I(cpphdl_n2319, Vss) <+ cpphdl_channel(V(BIT_N12_3, Vss), V(cpphdl_n2319, Vss), 0.080000000000000002, 0.69999999999999996, 1.0);
        // device 1710, IC IC297, analog/basic/mos_r2r_dac.hpp:27
        I(cpphdl_n2319, Vss) <+ 2.9999999999999998e-15 * ddt(V(cpphdl_n2319, Vss)); // Bench initial voltage = 0.0 V.
        // device 1711, IC IC297, analog/basic/mos_r2r_dac.hpp:28
        I(cpphdl_n2319, cpphdl_n2339) <+ V(cpphdl_n2319, cpphdl_n2339) / 2000.0;
        // device 1712, IC IC297, analog/basic/mos_r2r_dac.hpp:29
        I(cpphdl_n2339, Vss) <+ 2.9999999999999998e-15 * ddt(V(cpphdl_n2339, Vss)); // Bench initial voltage = 0.0 V.
        // device 1713, IC IC297, analog/basic/mos_r2r_dac.hpp:31
        I(cpphdl_n2338, cpphdl_n2339) <+ V(cpphdl_n2338, cpphdl_n2339) / 1000.0;
        // device 1714, IC IC302, analog/basic/inverter.hpp:11
        I(cpphdl_n2323, Vdd) <+ cpphdl_channel(V(BIT_N12_4, Vdd), V(cpphdl_n2323, Vdd), 0.080000000000000002, 0.69999999999999996, -1.0);
        // device 1715, IC IC302, analog/basic/inverter.hpp:12
        I(cpphdl_n2323, Vss) <+ cpphdl_channel(V(BIT_N12_4, Vss), V(cpphdl_n2323, Vss), 0.080000000000000002, 0.69999999999999996, 1.0);
        // device 1716, IC IC297, analog/basic/mos_r2r_dac.hpp:27
        I(cpphdl_n2323, Vss) <+ 2.9999999999999998e-15 * ddt(V(cpphdl_n2323, Vss)); // Bench initial voltage = 0.0 V.
        // device 1717, IC IC297, analog/basic/mos_r2r_dac.hpp:28
        I(cpphdl_n2323, cpphdl_n2340) <+ V(cpphdl_n2323, cpphdl_n2340) / 2000.0;
        // device 1718, IC IC297, analog/basic/mos_r2r_dac.hpp:29
        I(cpphdl_n2340, Vss) <+ 2.9999999999999998e-15 * ddt(V(cpphdl_n2340, Vss)); // Bench initial voltage = 0.0 V.
        // device 1719, IC IC297, analog/basic/mos_r2r_dac.hpp:31
        I(cpphdl_n2339, cpphdl_n2340) <+ V(cpphdl_n2339, cpphdl_n2340) / 1000.0;
        // device 1720, IC IC303, analog/basic/inverter.hpp:11
        I(cpphdl_n2327, Vdd) <+ cpphdl_channel(V(BIT_N12_5, Vdd), V(cpphdl_n2327, Vdd), 0.080000000000000002, 0.69999999999999996, -1.0);
        // device 1721, IC IC303, analog/basic/inverter.hpp:12
        I(cpphdl_n2327, Vss) <+ cpphdl_channel(V(BIT_N12_5, Vss), V(cpphdl_n2327, Vss), 0.080000000000000002, 0.69999999999999996, 1.0);
        // device 1722, IC IC297, analog/basic/mos_r2r_dac.hpp:27
        I(cpphdl_n2327, Vss) <+ 2.9999999999999998e-15 * ddt(V(cpphdl_n2327, Vss)); // Bench initial voltage = 0.0 V.
        // device 1723, IC IC297, analog/basic/mos_r2r_dac.hpp:28
        I(cpphdl_n2327, cpphdl_n2341) <+ V(cpphdl_n2327, cpphdl_n2341) / 2000.0;
        // device 1724, IC IC297, analog/basic/mos_r2r_dac.hpp:29
        I(cpphdl_n2341, Vss) <+ 2.9999999999999998e-15 * ddt(V(cpphdl_n2341, Vss)); // Bench initial voltage = 0.0 V.
        // device 1725, IC IC297, analog/basic/mos_r2r_dac.hpp:31
        I(cpphdl_n2340, cpphdl_n2341) <+ V(cpphdl_n2340, cpphdl_n2341) / 1000.0;
        // device 1726, IC IC304, analog/basic/inverter.hpp:11
        I(cpphdl_n2331, Vdd) <+ cpphdl_channel(V(BIT_N12_6, Vdd), V(cpphdl_n2331, Vdd), 0.080000000000000002, 0.69999999999999996, -1.0);
        // device 1727, IC IC304, analog/basic/inverter.hpp:12
        I(cpphdl_n2331, Vss) <+ cpphdl_channel(V(BIT_N12_6, Vss), V(cpphdl_n2331, Vss), 0.080000000000000002, 0.69999999999999996, 1.0);
        // device 1728, IC IC297, analog/basic/mos_r2r_dac.hpp:27
        I(cpphdl_n2331, Vss) <+ 2.9999999999999998e-15 * ddt(V(cpphdl_n2331, Vss)); // Bench initial voltage = 0.0 V.
        // device 1729, IC IC297, analog/basic/mos_r2r_dac.hpp:28
        I(cpphdl_n2331, cpphdl_n2342) <+ V(cpphdl_n2331, cpphdl_n2342) / 2000.0;
        // device 1730, IC IC297, analog/basic/mos_r2r_dac.hpp:29
        I(cpphdl_n2342, Vss) <+ 2.9999999999999998e-15 * ddt(V(cpphdl_n2342, Vss)); // Bench initial voltage = 0.0 V.
        // device 1731, IC IC297, analog/basic/mos_r2r_dac.hpp:31
        I(cpphdl_n2341, cpphdl_n2342) <+ V(cpphdl_n2341, cpphdl_n2342) / 1000.0;
        // device 1732, IC IC305, analog/basic/inverter.hpp:11
        I(cpphdl_n2335, Vdd) <+ cpphdl_channel(V(BIT_N12_7, Vdd), V(cpphdl_n2335, Vdd), 0.080000000000000002, 0.69999999999999996, -1.0);
        // device 1733, IC IC305, analog/basic/inverter.hpp:12
        I(cpphdl_n2335, Vss) <+ cpphdl_channel(V(BIT_N12_7, Vss), V(cpphdl_n2335, Vss), 0.080000000000000002, 0.69999999999999996, 1.0);
        // device 1734, IC IC297, analog/basic/mos_r2r_dac.hpp:27
        I(cpphdl_n2335, Vss) <+ 2.9999999999999998e-15 * ddt(V(cpphdl_n2335, Vss)); // Bench initial voltage = 0.0 V.
        // device 1735, IC IC297, analog/basic/mos_r2r_dac.hpp:28
        I(cpphdl_n2335, cpphdl_n2347) <+ V(cpphdl_n2335, cpphdl_n2347) / 2000.0;
        // device 1736, IC IC297, analog/basic/mos_r2r_dac.hpp:29
        I(cpphdl_n2347, Vss) <+ 2.9999999999999998e-15 * ddt(V(cpphdl_n2347, Vss)); // Bench initial voltage = 0.0 V.
        // device 1737, IC IC297, analog/basic/mos_r2r_dac.hpp:31
        I(cpphdl_n2342, cpphdl_n2347) <+ V(cpphdl_n2342, cpphdl_n2347) / 1000.0;
        // device 1738, IC IC297, analog/basic/mos_r2r_dac.hpp:33
        I(Vss, cpphdl_n2336) <+ V(Vss, cpphdl_n2336) / 2000.0;
        // device 1739, IC IC306, analog/basic/nmos_resistor_amplifier.hpp:23
        I(Vdd, cpphdl_n2356) <+ V(Vdd, cpphdl_n2356) / 1000.0;
        // device 1740, IC IC306, analog/basic/nmos_resistor_amplifier.hpp:24
        I(Vdd, cpphdl_n2355) <+ V(Vdd, cpphdl_n2355) / 1000.0;
        // device 1741, IC IC306, analog/basic/nmos_resistor_amplifier.hpp:25
        I(cpphdl_n2356, cpphdl_n2350) <+ cpphdl_channel(V(cpphdl_n2346, cpphdl_n2350), V(cpphdl_n2356, cpphdl_n2350), 0.0074999999999999997, 0.69999999999999996, 1.0);
        // device 1742, IC IC306, analog/basic/nmos_resistor_amplifier.hpp:26
        I(cpphdl_n2355, cpphdl_n2351) <+ cpphdl_channel(V(cpphdl_n2347, cpphdl_n2351), V(cpphdl_n2355, cpphdl_n2351), 0.0074999999999999997, 0.69999999999999996, 1.0);
        // device 1743, IC IC306, analog/basic/nmos_resistor_amplifier.hpp:27
        I(cpphdl_n2352, cpphdl_n2350) <+ V(cpphdl_n2352, cpphdl_n2350) / 100.0;
        // device 1744, IC IC306, analog/basic/nmos_resistor_amplifier.hpp:28
        I(cpphdl_n2352, cpphdl_n2351) <+ V(cpphdl_n2352, cpphdl_n2351) / 100.0;
        // device 1745, IC IC306, analog/basic/nmos_resistor_amplifier.hpp:29
        I(Vss, cpphdl_n2352) <+ V(Vss, cpphdl_n2352) / 300.0;
        // device 1746, IC IC306, analog/basic/nmos_resistor_amplifier.hpp:30
        I(cpphdl_n2356, Vdd) <+ 2.9999999999999998e-13 * ddt(V(cpphdl_n2356, Vdd)); // Bench initial voltage = 0.0 V.
        // device 1747, IC IC306, analog/basic/nmos_resistor_amplifier.hpp:31
        I(cpphdl_n2355, Vdd) <+ 2.9999999999999998e-13 * ddt(V(cpphdl_n2355, Vdd)); // Bench initial voltage = 0.0 V.
        // device 1748, IC IC306, analog/basic/nmos_resistor_amplifier.hpp:32
        I(cpphdl_n2352, Vss) <+ 4e-14 * ddt(V(cpphdl_n2352, Vss)); // Bench initial voltage = 0.0 V.
        // device 1749, IC IC306, analog/basic/nmos_resistor_amplifier.hpp:34
        I(cpphdl_n2346, cpphdl_n2350) <+ 2e-14 * ddt(V(cpphdl_n2346, cpphdl_n2350)); // Bench initial voltage = 0.0 V.
        // device 1750, IC IC306, analog/basic/nmos_resistor_amplifier.hpp:35
        I(cpphdl_n2347, cpphdl_n2351) <+ 2e-14 * ddt(V(cpphdl_n2347, cpphdl_n2351)); // Bench initial voltage = 0.0 V.
        // device 1751, IC IC306, analog/basic/nmos_resistor_amplifier.hpp:36
        I(cpphdl_n2346, cpphdl_n2356) <+ 2.9999999999999998e-15 * ddt(V(cpphdl_n2346, cpphdl_n2356)); // Bench initial voltage = 0.0 V.
        // device 1752, IC IC306, analog/basic/nmos_resistor_amplifier.hpp:37
        I(cpphdl_n2347, cpphdl_n2355) <+ 2.9999999999999998e-15 * ddt(V(cpphdl_n2347, cpphdl_n2355)); // Bench initial voltage = 0.0 V.
        // device 1753, IC IC307, analog/basic/strongarm_comparator.hpp:28
        I(cpphdl_n2360, cpphdl_n2362) <+ cpphdl_channel(V(cpphdl_n2355, cpphdl_n2362), V(cpphdl_n2360, cpphdl_n2362), 0.0080000000000000002, 0.69999999999999996, 1.0);
        // device 1754, IC IC307, analog/basic/strongarm_comparator.hpp:29
        I(cpphdl_n2361, cpphdl_n2362) <+ cpphdl_channel(V(cpphdl_n2356, cpphdl_n2362), V(cpphdl_n2361, cpphdl_n2362), 0.0080000000000000002, 0.69999999999999996, 1.0);
        // device 1755, IC IC307, analog/basic/strongarm_comparator.hpp:30
        I(cpphdl_n2362, Vss) <+ cpphdl_channel(V(EVALUATE, Vss), V(cpphdl_n2362, Vss), 0.0080000000000000002, 0.69999999999999996, 1.0);
        // device 1756, IC IC307, analog/basic/strongarm_comparator.hpp:33
        I(cpphdl_n2375, cpphdl_n2360) <+ cpphdl_channel(V(cpphdl_n2379, cpphdl_n2360), V(cpphdl_n2375, cpphdl_n2360), 0.0040000000000000001, 0.69999999999999996, 1.0);
        // device 1757, IC IC307, analog/basic/strongarm_comparator.hpp:34
        I(cpphdl_n2379, cpphdl_n2361) <+ cpphdl_channel(V(cpphdl_n2375, cpphdl_n2361), V(cpphdl_n2379, cpphdl_n2361), 0.0040000000000000001, 0.69999999999999996, 1.0);
        // device 1758, IC IC307, analog/basic/strongarm_comparator.hpp:35
        I(cpphdl_n2379, Vdd) <+ cpphdl_channel(V(cpphdl_n2375, Vdd), V(cpphdl_n2379, Vdd), 0.002, 0.69999999999999996, -1.0);
        // device 1759, IC IC307, analog/basic/strongarm_comparator.hpp:36
        I(cpphdl_n2375, Vdd) <+ cpphdl_channel(V(cpphdl_n2379, Vdd), V(cpphdl_n2375, Vdd), 0.002, 0.69999999999999996, -1.0);
        // device 1760, IC IC307, analog/basic/strongarm_comparator.hpp:38
        I(cpphdl_n2360, Vdd) <+ cpphdl_channel(V(EVALUATE, Vdd), V(cpphdl_n2360, Vdd), 0.002, 0.69999999999999996, -1.0);
        // device 1761, IC IC307, analog/basic/strongarm_comparator.hpp:39
        I(cpphdl_n2361, Vdd) <+ cpphdl_channel(V(EVALUATE, Vdd), V(cpphdl_n2361, Vdd), 0.002, 0.69999999999999996, -1.0);
        // device 1762, IC IC307, analog/basic/strongarm_comparator.hpp:40
        I(cpphdl_n2379, Vdd) <+ cpphdl_channel(V(EVALUATE, Vdd), V(cpphdl_n2379, Vdd), 0.002, 0.69999999999999996, -1.0);
        // device 1763, IC IC307, analog/basic/strongarm_comparator.hpp:41
        I(cpphdl_n2375, Vdd) <+ cpphdl_channel(V(EVALUATE, Vdd), V(cpphdl_n2375, Vdd), 0.002, 0.69999999999999996, -1.0);
        // device 1764, IC IC307, analog/basic/strongarm_comparator.hpp:42
        I(cpphdl_n2360, Vss) <+ 2.9999999999999998e-14 * ddt(V(cpphdl_n2360, Vss)); // Bench initial voltage = 0.0 V.
        // device 1765, IC IC307, analog/basic/strongarm_comparator.hpp:43
        I(cpphdl_n2361, Vss) <+ 2.9999999999999998e-14 * ddt(V(cpphdl_n2361, Vss)); // Bench initial voltage = 0.0 V.
        // device 1766, IC IC307, analog/basic/strongarm_comparator.hpp:44
        I(cpphdl_n2362, Vss) <+ 2.9999999999999998e-14 * ddt(V(cpphdl_n2362, Vss)); // Bench initial voltage = 0.0 V.
        // device 1767, IC IC307, analog/basic/strongarm_comparator.hpp:45
        I(cpphdl_n2379, Vss) <+ 5.0000000000000002e-14 * ddt(V(cpphdl_n2379, Vss)); // Bench initial voltage = 0.0 V.
        // device 1768, IC IC307, analog/basic/strongarm_comparator.hpp:46
        I(cpphdl_n2375, Vss) <+ 5.0000000000000002e-14 * ddt(V(cpphdl_n2375, Vss)); // Bench initial voltage = 0.0 V.
        // device 1769, IC IC307, analog/basic/strongarm_comparator.hpp:47
        I(cpphdl_n2355, cpphdl_n2362) <+ 2e-14 * ddt(V(cpphdl_n2355, cpphdl_n2362)); // Bench initial voltage = 0.0 V.
        // device 1770, IC IC307, analog/basic/strongarm_comparator.hpp:48
        I(cpphdl_n2356, cpphdl_n2362) <+ 2e-14 * ddt(V(cpphdl_n2356, cpphdl_n2362)); // Bench initial voltage = 0.0 V.
        // device 1771, IC IC307, analog/basic/strongarm_comparator.hpp:49
        I(cpphdl_n2355, cpphdl_n2360) <+ 2.9999999999999998e-15 * ddt(V(cpphdl_n2355, cpphdl_n2360)); // Bench initial voltage = 0.0 V.
        // device 1772, IC IC307, analog/basic/strongarm_comparator.hpp:50
        I(cpphdl_n2356, cpphdl_n2361) <+ 2.9999999999999998e-15 * ddt(V(cpphdl_n2356, cpphdl_n2361)); // Bench initial voltage = 0.0 V.
        // device 1773, IC IC309, analog/basic/inverter.hpp:11
        I(cpphdl_n2383, Vdd) <+ cpphdl_channel(V(cpphdl_n2375, Vdd), V(cpphdl_n2383, Vdd), 0.001, 0.69999999999999996, -1.0);
        // device 1774, IC IC309, analog/basic/inverter.hpp:12
        I(cpphdl_n2383, Vss) <+ cpphdl_channel(V(cpphdl_n2375, Vss), V(cpphdl_n2383, Vss), 0.001, 0.69999999999999996, 1.0);
        // device 1775, IC IC311, analog/basic/inverter.hpp:11
        I(cpphdl_n2397, Vdd) <+ cpphdl_channel(V(cpphdl_n2383, Vdd), V(cpphdl_n2397, Vdd), 0.0040000000000000001, 0.69999999999999996, -1.0);
        // device 1776, IC IC311, analog/basic/inverter.hpp:12
        I(cpphdl_n2397, Vss) <+ cpphdl_channel(V(cpphdl_n2383, Vss), V(cpphdl_n2397, Vss), 0.0040000000000000001, 0.69999999999999996, 1.0);
        // device 1777, IC IC308, analog/basic/buffered_nand_latch.hpp:34
        I(cpphdl_n2375, Vss) <+ 2.0000000000000002e-15 * ddt(V(cpphdl_n2375, Vss)); // Bench initial voltage = 0.0 V.
        // device 1778, IC IC308, analog/basic/buffered_nand_latch.hpp:35
        I(cpphdl_n2375, cpphdl_n2383) <+ 1.0000000000000001e-15 * ddt(V(cpphdl_n2375, cpphdl_n2383)); // Bench initial voltage = 0.0 V.
        // device 1779, IC IC308, analog/basic/buffered_nand_latch.hpp:36
        I(cpphdl_n2383, Vss) <+ 5e-15 * ddt(V(cpphdl_n2383, Vss)); // Bench initial voltage = 0.0 V.
        // device 1780, IC IC308, analog/basic/buffered_nand_latch.hpp:37
        I(cpphdl_n2383, Vss) <+ 8.0000000000000006e-15 * ddt(V(cpphdl_n2383, Vss)); // Bench initial voltage = 0.0 V.
        // device 1781, IC IC308, analog/basic/buffered_nand_latch.hpp:38
        I(cpphdl_n2397, Vss) <+ 1e-14 * ddt(V(cpphdl_n2397, Vss)); // Bench initial voltage = 0.0 V.
        // device 1782, IC IC310, analog/basic/inverter.hpp:11
        I(cpphdl_n2387, Vdd) <+ cpphdl_channel(V(cpphdl_n2379, Vdd), V(cpphdl_n2387, Vdd), 0.001, 0.69999999999999996, -1.0);
        // device 1783, IC IC310, analog/basic/inverter.hpp:12
        I(cpphdl_n2387, Vss) <+ cpphdl_channel(V(cpphdl_n2379, Vss), V(cpphdl_n2387, Vss), 0.001, 0.69999999999999996, 1.0);
        // device 1784, IC IC312, analog/basic/inverter.hpp:11
        I(cpphdl_n2403, Vdd) <+ cpphdl_channel(V(cpphdl_n2387, Vdd), V(cpphdl_n2403, Vdd), 0.0040000000000000001, 0.69999999999999996, -1.0);
        // device 1785, IC IC312, analog/basic/inverter.hpp:12
        I(cpphdl_n2403, Vss) <+ cpphdl_channel(V(cpphdl_n2387, Vss), V(cpphdl_n2403, Vss), 0.0040000000000000001, 0.69999999999999996, 1.0);
        // device 1786, IC IC308, analog/basic/buffered_nand_latch.hpp:34
        I(cpphdl_n2379, Vss) <+ 2.0000000000000002e-15 * ddt(V(cpphdl_n2379, Vss)); // Bench initial voltage = 0.0 V.
        // device 1787, IC IC308, analog/basic/buffered_nand_latch.hpp:35
        I(cpphdl_n2379, cpphdl_n2387) <+ 1.0000000000000001e-15 * ddt(V(cpphdl_n2379, cpphdl_n2387)); // Bench initial voltage = 0.0 V.
        // device 1788, IC IC308, analog/basic/buffered_nand_latch.hpp:36
        I(cpphdl_n2387, Vss) <+ 5e-15 * ddt(V(cpphdl_n2387, Vss)); // Bench initial voltage = 0.0 V.
        // device 1789, IC IC308, analog/basic/buffered_nand_latch.hpp:37
        I(cpphdl_n2387, Vss) <+ 8.0000000000000006e-15 * ddt(V(cpphdl_n2387, Vss)); // Bench initial voltage = 0.0 V.
        // device 1790, IC IC308, analog/basic/buffered_nand_latch.hpp:38
        I(cpphdl_n2403, Vss) <+ 1e-14 * ddt(V(cpphdl_n2403, Vss)); // Bench initial voltage = 0.0 V.
        // device 1791, IC IC314, analog/basic/cmos_logic.hpp:17
        I(cpphdl_n2488, Vss) <+ 5.0000000000000002e-14 * ddt(V(cpphdl_n2488, Vss)); // Bench initial voltage = 0.0 V.
        // device 1792, IC IC314, analog/basic/cmos_logic.hpp:18
        I(cpphdl_n2488, Vdd) <+ cpphdl_channel(V(cpphdl_n2397, Vdd), V(cpphdl_n2488, Vdd), 0.01, 0.69999999999999996, -1.0);
        // device 1793, IC IC314, analog/basic/cmos_logic.hpp:19
        I(cpphdl_n2488, Vdd) <+ cpphdl_channel(V(cpphdl_n2405, Vdd), V(cpphdl_n2488, Vdd), 0.01, 0.69999999999999996, -1.0);
        // device 1794, IC IC314, analog/basic/cmos_logic.hpp:20
        I(cpphdl_n2488, cpphdl_n2400) <+ cpphdl_channel(V(cpphdl_n2397, cpphdl_n2400), V(cpphdl_n2488, cpphdl_n2400), 0.01, 0.69999999999999996, 1.0);
        // device 1795, IC IC314, analog/basic/cmos_logic.hpp:21
        I(cpphdl_n2400, Vss) <+ cpphdl_channel(V(cpphdl_n2405, Vss), V(cpphdl_n2400, Vss), 0.01, 0.69999999999999996, 1.0);
        // device 1796, IC IC314, analog/basic/cmos_logic.hpp:27
        I(cpphdl_n2400, Vss) <+ 1e-14 * ddt(V(cpphdl_n2400, Vss)); // Bench initial voltage = 0.0 V.
        // device 1797, IC IC315, analog/basic/cmos_logic.hpp:17
        I(cpphdl_n2405, Vss) <+ 5.0000000000000002e-14 * ddt(V(cpphdl_n2405, Vss)); // Bench initial voltage = 0.0 V.
        // device 1798, IC IC315, analog/basic/cmos_logic.hpp:18
        I(cpphdl_n2405, Vdd) <+ cpphdl_channel(V(cpphdl_n2403, Vdd), V(cpphdl_n2405, Vdd), 0.01, 0.69999999999999996, -1.0);
        // device 1799, IC IC315, analog/basic/cmos_logic.hpp:19
        I(cpphdl_n2405, Vdd) <+ cpphdl_channel(V(cpphdl_n2488, Vdd), V(cpphdl_n2405, Vdd), 0.01, 0.69999999999999996, -1.0);
        // device 1800, IC IC315, analog/basic/cmos_logic.hpp:20
        I(cpphdl_n2405, cpphdl_n2406) <+ cpphdl_channel(V(cpphdl_n2403, cpphdl_n2406), V(cpphdl_n2405, cpphdl_n2406), 0.01, 0.69999999999999996, 1.0);
        // device 1801, IC IC315, analog/basic/cmos_logic.hpp:21
        I(cpphdl_n2406, Vss) <+ cpphdl_channel(V(cpphdl_n2488, Vss), V(cpphdl_n2406, Vss), 0.01, 0.69999999999999996, 1.0);
        // device 1802, IC IC315, analog/basic/cmos_logic.hpp:27
        I(cpphdl_n2406, Vss) <+ 1e-14 * ddt(V(cpphdl_n2406, Vss)); // Bench initial voltage = 0.0 V.
        // device 1803, IC IC313, analog/basic/nand_latch.hpp:36
        I(cpphdl_n2397, Vss) <+ 2.9999999999999998e-15 * ddt(V(cpphdl_n2397, Vss)); // Bench initial voltage = 0.0 V.
        // device 1804, IC IC313, analog/basic/nand_latch.hpp:37
        I(cpphdl_n2403, Vss) <+ 2.9999999999999998e-15 * ddt(V(cpphdl_n2403, Vss)); // Bench initial voltage = 0.0 V.
        // device 1805, IC IC316, analog/basic/inverter.hpp:11
        I(cpphdl_n2411, Vdd) <+ cpphdl_channel(V(CLEAR, Vdd), V(cpphdl_n2411, Vdd), 0.01, 0.69999999999999996, -1.0);
        // device 1806, IC IC316, analog/basic/inverter.hpp:12
        I(cpphdl_n2411, Vss) <+ cpphdl_channel(V(CLEAR, Vss), V(cpphdl_n2411, Vss), 0.01, 0.69999999999999996, 1.0);
        // device 1807, IC IC313, analog/basic/nand_latch.hpp:58
        I(cpphdl_n2411, Vss) <+ 2.9999999999999998e-15 * ddt(V(cpphdl_n2411, Vss)); // Bench initial voltage = 0.0 V.
        // device 1808, IC IC313, analog/basic/nand_latch.hpp:59
        I(cpphdl_n2488, Vss) <+ cpphdl_channel(V(CLEAR, Vss), V(cpphdl_n2488, Vss), 0.050000000000000003, 0.69999999999999996, 1.0);
        // device 1809, IC IC313, analog/basic/nand_latch.hpp:60
        I(cpphdl_n2405, Vdd) <+ cpphdl_channel(V(cpphdl_n2411, Vdd), V(cpphdl_n2405, Vdd), 0.050000000000000003, 0.69999999999999996, -1.0);
        // device 1810, IC IC317, analog/basic/level_down.hpp:23
        I(cpphdl_n2430, Vlogic) <+ cpphdl_channel(V(Vss, Vlogic), V(cpphdl_n2430, Vlogic), 0.00050000000000000001, 0.34999999999999998, -1.0);
        // device 1811, IC IC317, analog/basic/level_down.hpp:24
        I(cpphdl_n2430, Vss) <+ cpphdl_channel(V(cpphdl_n2428, Vss), V(cpphdl_n2430, Vss), 0.0040000000000000001, 0.69999999999999996, 1.0);
        // device 1812, IC IC317, analog/basic/level_down.hpp:25
        I(CORE_DECISION0, Vlogic) <+ cpphdl_channel(V(cpphdl_n2430, Vlogic), V(CORE_DECISION0, Vlogic), 0.0050000000000000001, 0.34999999999999998, -1.0);
        // device 1813, IC IC317, analog/basic/level_down.hpp:26
        I(CORE_DECISION0, Vss) <+ cpphdl_channel(V(cpphdl_n2430, Vss), V(CORE_DECISION0, Vss), 0.01, 0.34999999999999998, 1.0);
        // device 1814, IC IC317, analog/basic/level_down.hpp:27
        I(cpphdl_n2428, Vss) <+ 5e-15 * ddt(V(cpphdl_n2428, Vss)); // Bench initial voltage = 0.0 V.
        // device 1815, IC IC317, analog/basic/level_down.hpp:28
        I(cpphdl_n2428, Vlogic) <+ 5e-15 * ddt(V(cpphdl_n2428, Vlogic)); // Bench initial voltage = 0.0 V.
        // device 1816, IC IC317, analog/basic/level_down.hpp:29
        I(cpphdl_n2428, cpphdl_n2430) <+ 2.0000000000000002e-15 * ddt(V(cpphdl_n2428, cpphdl_n2430)); // Bench initial voltage = 0.0 V.
        // device 1817, IC IC317, analog/basic/level_down.hpp:30
        I(cpphdl_n2430, Vss) <+ 8e-14 * ddt(V(cpphdl_n2430, Vss)); // Bench initial voltage = 0.0 V.
        // device 1818, IC IC317, analog/basic/level_down.hpp:31
        I(cpphdl_n2430, Vlogic) <+ 5e-15 * ddt(V(cpphdl_n2430, Vlogic)); // Bench initial voltage = 0.0 V.
        // device 1819, IC IC317, analog/basic/level_down.hpp:32
        I(cpphdl_n2430, CORE_DECISION0) <+ 2.0000000000000002e-15 * ddt(V(cpphdl_n2430, CORE_DECISION0)); // Bench initial voltage = 0.0 V.
        // device 1820, IC IC317, analog/basic/level_down.hpp:33
        I(CORE_DECISION0, Vss) <+ 1e-14 * ddt(V(CORE_DECISION0, Vss)); // Bench initial voltage = 0.0 V.
        // device 1821, IC IC318, analog/basic/level_down.hpp:23
        I(cpphdl_n2435, Vlogic) <+ cpphdl_channel(V(Vss, Vlogic), V(cpphdl_n2435, Vlogic), 0.00050000000000000001, 0.34999999999999998, -1.0);
        // device 1822, IC IC318, analog/basic/level_down.hpp:24
        I(cpphdl_n2435, Vss) <+ cpphdl_channel(V(cpphdl_n2433, Vss), V(cpphdl_n2435, Vss), 0.0040000000000000001, 0.69999999999999996, 1.0);
        // device 1823, IC IC318, analog/basic/level_down.hpp:25
        I(CORE_DECISION1, Vlogic) <+ cpphdl_channel(V(cpphdl_n2435, Vlogic), V(CORE_DECISION1, Vlogic), 0.0050000000000000001, 0.34999999999999998, -1.0);
        // device 1824, IC IC318, analog/basic/level_down.hpp:26
        I(CORE_DECISION1, Vss) <+ cpphdl_channel(V(cpphdl_n2435, Vss), V(CORE_DECISION1, Vss), 0.01, 0.34999999999999998, 1.0);
        // device 1825, IC IC318, analog/basic/level_down.hpp:27
        I(cpphdl_n2433, Vss) <+ 5e-15 * ddt(V(cpphdl_n2433, Vss)); // Bench initial voltage = 0.0 V.
        // device 1826, IC IC318, analog/basic/level_down.hpp:28
        I(cpphdl_n2433, Vlogic) <+ 5e-15 * ddt(V(cpphdl_n2433, Vlogic)); // Bench initial voltage = 0.0 V.
        // device 1827, IC IC318, analog/basic/level_down.hpp:29
        I(cpphdl_n2433, cpphdl_n2435) <+ 2.0000000000000002e-15 * ddt(V(cpphdl_n2433, cpphdl_n2435)); // Bench initial voltage = 0.0 V.
        // device 1828, IC IC318, analog/basic/level_down.hpp:30
        I(cpphdl_n2435, Vss) <+ 8e-14 * ddt(V(cpphdl_n2435, Vss)); // Bench initial voltage = 0.0 V.
        // device 1829, IC IC318, analog/basic/level_down.hpp:31
        I(cpphdl_n2435, Vlogic) <+ 5e-15 * ddt(V(cpphdl_n2435, Vlogic)); // Bench initial voltage = 0.0 V.
        // device 1830, IC IC318, analog/basic/level_down.hpp:32
        I(cpphdl_n2435, CORE_DECISION1) <+ 2.0000000000000002e-15 * ddt(V(cpphdl_n2435, CORE_DECISION1)); // Bench initial voltage = 0.0 V.
        // device 1831, IC IC318, analog/basic/level_down.hpp:33
        I(CORE_DECISION1, Vss) <+ 1e-14 * ddt(V(CORE_DECISION1, Vss)); // Bench initial voltage = 0.0 V.
        // device 1832, IC IC319, analog/basic/level_down.hpp:23
        I(cpphdl_n2440, Vlogic) <+ cpphdl_channel(V(Vss, Vlogic), V(cpphdl_n2440, Vlogic), 0.00050000000000000001, 0.34999999999999998, -1.0);
        // device 1833, IC IC319, analog/basic/level_down.hpp:24
        I(cpphdl_n2440, Vss) <+ cpphdl_channel(V(cpphdl_n2438, Vss), V(cpphdl_n2440, Vss), 0.0040000000000000001, 0.69999999999999996, 1.0);
        // device 1834, IC IC319, analog/basic/level_down.hpp:25
        I(CORE_DECISION2, Vlogic) <+ cpphdl_channel(V(cpphdl_n2440, Vlogic), V(CORE_DECISION2, Vlogic), 0.0050000000000000001, 0.34999999999999998, -1.0);
        // device 1835, IC IC319, analog/basic/level_down.hpp:26
        I(CORE_DECISION2, Vss) <+ cpphdl_channel(V(cpphdl_n2440, Vss), V(CORE_DECISION2, Vss), 0.01, 0.34999999999999998, 1.0);
        // device 1836, IC IC319, analog/basic/level_down.hpp:27
        I(cpphdl_n2438, Vss) <+ 5e-15 * ddt(V(cpphdl_n2438, Vss)); // Bench initial voltage = 0.0 V.
        // device 1837, IC IC319, analog/basic/level_down.hpp:28
        I(cpphdl_n2438, Vlogic) <+ 5e-15 * ddt(V(cpphdl_n2438, Vlogic)); // Bench initial voltage = 0.0 V.
        // device 1838, IC IC319, analog/basic/level_down.hpp:29
        I(cpphdl_n2438, cpphdl_n2440) <+ 2.0000000000000002e-15 * ddt(V(cpphdl_n2438, cpphdl_n2440)); // Bench initial voltage = 0.0 V.
        // device 1839, IC IC319, analog/basic/level_down.hpp:30
        I(cpphdl_n2440, Vss) <+ 8e-14 * ddt(V(cpphdl_n2440, Vss)); // Bench initial voltage = 0.0 V.
        // device 1840, IC IC319, analog/basic/level_down.hpp:31
        I(cpphdl_n2440, Vlogic) <+ 5e-15 * ddt(V(cpphdl_n2440, Vlogic)); // Bench initial voltage = 0.0 V.
        // device 1841, IC IC319, analog/basic/level_down.hpp:32
        I(cpphdl_n2440, CORE_DECISION2) <+ 2.0000000000000002e-15 * ddt(V(cpphdl_n2440, CORE_DECISION2)); // Bench initial voltage = 0.0 V.
        // device 1842, IC IC319, analog/basic/level_down.hpp:33
        I(CORE_DECISION2, Vss) <+ 1e-14 * ddt(V(CORE_DECISION2, Vss)); // Bench initial voltage = 0.0 V.
        // device 1843, IC IC320, analog/basic/level_down.hpp:23
        I(cpphdl_n2445, Vlogic) <+ cpphdl_channel(V(Vss, Vlogic), V(cpphdl_n2445, Vlogic), 0.00050000000000000001, 0.34999999999999998, -1.0);
        // device 1844, IC IC320, analog/basic/level_down.hpp:24
        I(cpphdl_n2445, Vss) <+ cpphdl_channel(V(cpphdl_n2443, Vss), V(cpphdl_n2445, Vss), 0.0040000000000000001, 0.69999999999999996, 1.0);
        // device 1845, IC IC320, analog/basic/level_down.hpp:25
        I(CORE_DECISION3, Vlogic) <+ cpphdl_channel(V(cpphdl_n2445, Vlogic), V(CORE_DECISION3, Vlogic), 0.0050000000000000001, 0.34999999999999998, -1.0);
        // device 1846, IC IC320, analog/basic/level_down.hpp:26
        I(CORE_DECISION3, Vss) <+ cpphdl_channel(V(cpphdl_n2445, Vss), V(CORE_DECISION3, Vss), 0.01, 0.34999999999999998, 1.0);
        // device 1847, IC IC320, analog/basic/level_down.hpp:27
        I(cpphdl_n2443, Vss) <+ 5e-15 * ddt(V(cpphdl_n2443, Vss)); // Bench initial voltage = 0.0 V.
        // device 1848, IC IC320, analog/basic/level_down.hpp:28
        I(cpphdl_n2443, Vlogic) <+ 5e-15 * ddt(V(cpphdl_n2443, Vlogic)); // Bench initial voltage = 0.0 V.
        // device 1849, IC IC320, analog/basic/level_down.hpp:29
        I(cpphdl_n2443, cpphdl_n2445) <+ 2.0000000000000002e-15 * ddt(V(cpphdl_n2443, cpphdl_n2445)); // Bench initial voltage = 0.0 V.
        // device 1850, IC IC320, analog/basic/level_down.hpp:30
        I(cpphdl_n2445, Vss) <+ 8e-14 * ddt(V(cpphdl_n2445, Vss)); // Bench initial voltage = 0.0 V.
        // device 1851, IC IC320, analog/basic/level_down.hpp:31
        I(cpphdl_n2445, Vlogic) <+ 5e-15 * ddt(V(cpphdl_n2445, Vlogic)); // Bench initial voltage = 0.0 V.
        // device 1852, IC IC320, analog/basic/level_down.hpp:32
        I(cpphdl_n2445, CORE_DECISION3) <+ 2.0000000000000002e-15 * ddt(V(cpphdl_n2445, CORE_DECISION3)); // Bench initial voltage = 0.0 V.
        // device 1853, IC IC320, analog/basic/level_down.hpp:33
        I(CORE_DECISION3, Vss) <+ 1e-14 * ddt(V(CORE_DECISION3, Vss)); // Bench initial voltage = 0.0 V.
        // device 1854, IC IC321, analog/basic/level_down.hpp:23
        I(cpphdl_n2450, Vlogic) <+ cpphdl_channel(V(Vss, Vlogic), V(cpphdl_n2450, Vlogic), 0.00050000000000000001, 0.34999999999999998, -1.0);
        // device 1855, IC IC321, analog/basic/level_down.hpp:24
        I(cpphdl_n2450, Vss) <+ cpphdl_channel(V(cpphdl_n2448, Vss), V(cpphdl_n2450, Vss), 0.0040000000000000001, 0.69999999999999996, 1.0);
        // device 1856, IC IC321, analog/basic/level_down.hpp:25
        I(CORE_DECISION4, Vlogic) <+ cpphdl_channel(V(cpphdl_n2450, Vlogic), V(CORE_DECISION4, Vlogic), 0.0050000000000000001, 0.34999999999999998, -1.0);
        // device 1857, IC IC321, analog/basic/level_down.hpp:26
        I(CORE_DECISION4, Vss) <+ cpphdl_channel(V(cpphdl_n2450, Vss), V(CORE_DECISION4, Vss), 0.01, 0.34999999999999998, 1.0);
        // device 1858, IC IC321, analog/basic/level_down.hpp:27
        I(cpphdl_n2448, Vss) <+ 5e-15 * ddt(V(cpphdl_n2448, Vss)); // Bench initial voltage = 0.0 V.
        // device 1859, IC IC321, analog/basic/level_down.hpp:28
        I(cpphdl_n2448, Vlogic) <+ 5e-15 * ddt(V(cpphdl_n2448, Vlogic)); // Bench initial voltage = 0.0 V.
        // device 1860, IC IC321, analog/basic/level_down.hpp:29
        I(cpphdl_n2448, cpphdl_n2450) <+ 2.0000000000000002e-15 * ddt(V(cpphdl_n2448, cpphdl_n2450)); // Bench initial voltage = 0.0 V.
        // device 1861, IC IC321, analog/basic/level_down.hpp:30
        I(cpphdl_n2450, Vss) <+ 8e-14 * ddt(V(cpphdl_n2450, Vss)); // Bench initial voltage = 0.0 V.
        // device 1862, IC IC321, analog/basic/level_down.hpp:31
        I(cpphdl_n2450, Vlogic) <+ 5e-15 * ddt(V(cpphdl_n2450, Vlogic)); // Bench initial voltage = 0.0 V.
        // device 1863, IC IC321, analog/basic/level_down.hpp:32
        I(cpphdl_n2450, CORE_DECISION4) <+ 2.0000000000000002e-15 * ddt(V(cpphdl_n2450, CORE_DECISION4)); // Bench initial voltage = 0.0 V.
        // device 1864, IC IC321, analog/basic/level_down.hpp:33
        I(CORE_DECISION4, Vss) <+ 1e-14 * ddt(V(CORE_DECISION4, Vss)); // Bench initial voltage = 0.0 V.
        // device 1865, IC IC322, analog/basic/level_down.hpp:23
        I(cpphdl_n2455, Vlogic) <+ cpphdl_channel(V(Vss, Vlogic), V(cpphdl_n2455, Vlogic), 0.00050000000000000001, 0.34999999999999998, -1.0);
        // device 1866, IC IC322, analog/basic/level_down.hpp:24
        I(cpphdl_n2455, Vss) <+ cpphdl_channel(V(cpphdl_n2453, Vss), V(cpphdl_n2455, Vss), 0.0040000000000000001, 0.69999999999999996, 1.0);
        // device 1867, IC IC322, analog/basic/level_down.hpp:25
        I(CORE_DECISION5, Vlogic) <+ cpphdl_channel(V(cpphdl_n2455, Vlogic), V(CORE_DECISION5, Vlogic), 0.0050000000000000001, 0.34999999999999998, -1.0);
        // device 1868, IC IC322, analog/basic/level_down.hpp:26
        I(CORE_DECISION5, Vss) <+ cpphdl_channel(V(cpphdl_n2455, Vss), V(CORE_DECISION5, Vss), 0.01, 0.34999999999999998, 1.0);
        // device 1869, IC IC322, analog/basic/level_down.hpp:27
        I(cpphdl_n2453, Vss) <+ 5e-15 * ddt(V(cpphdl_n2453, Vss)); // Bench initial voltage = 0.0 V.
        // device 1870, IC IC322, analog/basic/level_down.hpp:28
        I(cpphdl_n2453, Vlogic) <+ 5e-15 * ddt(V(cpphdl_n2453, Vlogic)); // Bench initial voltage = 0.0 V.
        // device 1871, IC IC322, analog/basic/level_down.hpp:29
        I(cpphdl_n2453, cpphdl_n2455) <+ 2.0000000000000002e-15 * ddt(V(cpphdl_n2453, cpphdl_n2455)); // Bench initial voltage = 0.0 V.
        // device 1872, IC IC322, analog/basic/level_down.hpp:30
        I(cpphdl_n2455, Vss) <+ 8e-14 * ddt(V(cpphdl_n2455, Vss)); // Bench initial voltage = 0.0 V.
        // device 1873, IC IC322, analog/basic/level_down.hpp:31
        I(cpphdl_n2455, Vlogic) <+ 5e-15 * ddt(V(cpphdl_n2455, Vlogic)); // Bench initial voltage = 0.0 V.
        // device 1874, IC IC322, analog/basic/level_down.hpp:32
        I(cpphdl_n2455, CORE_DECISION5) <+ 2.0000000000000002e-15 * ddt(V(cpphdl_n2455, CORE_DECISION5)); // Bench initial voltage = 0.0 V.
        // device 1875, IC IC322, analog/basic/level_down.hpp:33
        I(CORE_DECISION5, Vss) <+ 1e-14 * ddt(V(CORE_DECISION5, Vss)); // Bench initial voltage = 0.0 V.
        // device 1876, IC IC323, analog/basic/level_down.hpp:23
        I(cpphdl_n2460, Vlogic) <+ cpphdl_channel(V(Vss, Vlogic), V(cpphdl_n2460, Vlogic), 0.00050000000000000001, 0.34999999999999998, -1.0);
        // device 1877, IC IC323, analog/basic/level_down.hpp:24
        I(cpphdl_n2460, Vss) <+ cpphdl_channel(V(cpphdl_n2458, Vss), V(cpphdl_n2460, Vss), 0.0040000000000000001, 0.69999999999999996, 1.0);
        // device 1878, IC IC323, analog/basic/level_down.hpp:25
        I(CORE_DECISION6, Vlogic) <+ cpphdl_channel(V(cpphdl_n2460, Vlogic), V(CORE_DECISION6, Vlogic), 0.0050000000000000001, 0.34999999999999998, -1.0);
        // device 1879, IC IC323, analog/basic/level_down.hpp:26
        I(CORE_DECISION6, Vss) <+ cpphdl_channel(V(cpphdl_n2460, Vss), V(CORE_DECISION6, Vss), 0.01, 0.34999999999999998, 1.0);
        // device 1880, IC IC323, analog/basic/level_down.hpp:27
        I(cpphdl_n2458, Vss) <+ 5e-15 * ddt(V(cpphdl_n2458, Vss)); // Bench initial voltage = 0.0 V.
        // device 1881, IC IC323, analog/basic/level_down.hpp:28
        I(cpphdl_n2458, Vlogic) <+ 5e-15 * ddt(V(cpphdl_n2458, Vlogic)); // Bench initial voltage = 0.0 V.
        // device 1882, IC IC323, analog/basic/level_down.hpp:29
        I(cpphdl_n2458, cpphdl_n2460) <+ 2.0000000000000002e-15 * ddt(V(cpphdl_n2458, cpphdl_n2460)); // Bench initial voltage = 0.0 V.
        // device 1883, IC IC323, analog/basic/level_down.hpp:30
        I(cpphdl_n2460, Vss) <+ 8e-14 * ddt(V(cpphdl_n2460, Vss)); // Bench initial voltage = 0.0 V.
        // device 1884, IC IC323, analog/basic/level_down.hpp:31
        I(cpphdl_n2460, Vlogic) <+ 5e-15 * ddt(V(cpphdl_n2460, Vlogic)); // Bench initial voltage = 0.0 V.
        // device 1885, IC IC323, analog/basic/level_down.hpp:32
        I(cpphdl_n2460, CORE_DECISION6) <+ 2.0000000000000002e-15 * ddt(V(cpphdl_n2460, CORE_DECISION6)); // Bench initial voltage = 0.0 V.
        // device 1886, IC IC323, analog/basic/level_down.hpp:33
        I(CORE_DECISION6, Vss) <+ 1e-14 * ddt(V(CORE_DECISION6, Vss)); // Bench initial voltage = 0.0 V.
        // device 1887, IC IC324, analog/basic/level_down.hpp:23
        I(cpphdl_n2465, Vlogic) <+ cpphdl_channel(V(Vss, Vlogic), V(cpphdl_n2465, Vlogic), 0.00050000000000000001, 0.34999999999999998, -1.0);
        // device 1888, IC IC324, analog/basic/level_down.hpp:24
        I(cpphdl_n2465, Vss) <+ cpphdl_channel(V(cpphdl_n2463, Vss), V(cpphdl_n2465, Vss), 0.0040000000000000001, 0.69999999999999996, 1.0);
        // device 1889, IC IC324, analog/basic/level_down.hpp:25
        I(CORE_DECISION7, Vlogic) <+ cpphdl_channel(V(cpphdl_n2465, Vlogic), V(CORE_DECISION7, Vlogic), 0.0050000000000000001, 0.34999999999999998, -1.0);
        // device 1890, IC IC324, analog/basic/level_down.hpp:26
        I(CORE_DECISION7, Vss) <+ cpphdl_channel(V(cpphdl_n2465, Vss), V(CORE_DECISION7, Vss), 0.01, 0.34999999999999998, 1.0);
        // device 1891, IC IC324, analog/basic/level_down.hpp:27
        I(cpphdl_n2463, Vss) <+ 5e-15 * ddt(V(cpphdl_n2463, Vss)); // Bench initial voltage = 0.0 V.
        // device 1892, IC IC324, analog/basic/level_down.hpp:28
        I(cpphdl_n2463, Vlogic) <+ 5e-15 * ddt(V(cpphdl_n2463, Vlogic)); // Bench initial voltage = 0.0 V.
        // device 1893, IC IC324, analog/basic/level_down.hpp:29
        I(cpphdl_n2463, cpphdl_n2465) <+ 2.0000000000000002e-15 * ddt(V(cpphdl_n2463, cpphdl_n2465)); // Bench initial voltage = 0.0 V.
        // device 1894, IC IC324, analog/basic/level_down.hpp:30
        I(cpphdl_n2465, Vss) <+ 8e-14 * ddt(V(cpphdl_n2465, Vss)); // Bench initial voltage = 0.0 V.
        // device 1895, IC IC324, analog/basic/level_down.hpp:31
        I(cpphdl_n2465, Vlogic) <+ 5e-15 * ddt(V(cpphdl_n2465, Vlogic)); // Bench initial voltage = 0.0 V.
        // device 1896, IC IC324, analog/basic/level_down.hpp:32
        I(cpphdl_n2465, CORE_DECISION7) <+ 2.0000000000000002e-15 * ddt(V(cpphdl_n2465, CORE_DECISION7)); // Bench initial voltage = 0.0 V.
        // device 1897, IC IC324, analog/basic/level_down.hpp:33
        I(CORE_DECISION7, Vss) <+ 1e-14 * ddt(V(CORE_DECISION7, Vss)); // Bench initial voltage = 0.0 V.
        // device 1898, IC IC325, analog/basic/level_down.hpp:23
        I(cpphdl_n2470, Vlogic) <+ cpphdl_channel(V(Vss, Vlogic), V(cpphdl_n2470, Vlogic), 0.00050000000000000001, 0.34999999999999998, -1.0);
        // device 1899, IC IC325, analog/basic/level_down.hpp:24
        I(cpphdl_n2470, Vss) <+ cpphdl_channel(V(cpphdl_n2468, Vss), V(cpphdl_n2470, Vss), 0.0040000000000000001, 0.69999999999999996, 1.0);
        // device 1900, IC IC325, analog/basic/level_down.hpp:25
        I(CORE_DECISION8, Vlogic) <+ cpphdl_channel(V(cpphdl_n2470, Vlogic), V(CORE_DECISION8, Vlogic), 0.0050000000000000001, 0.34999999999999998, -1.0);
        // device 1901, IC IC325, analog/basic/level_down.hpp:26
        I(CORE_DECISION8, Vss) <+ cpphdl_channel(V(cpphdl_n2470, Vss), V(CORE_DECISION8, Vss), 0.01, 0.34999999999999998, 1.0);
        // device 1902, IC IC325, analog/basic/level_down.hpp:27
        I(cpphdl_n2468, Vss) <+ 5e-15 * ddt(V(cpphdl_n2468, Vss)); // Bench initial voltage = 0.0 V.
        // device 1903, IC IC325, analog/basic/level_down.hpp:28
        I(cpphdl_n2468, Vlogic) <+ 5e-15 * ddt(V(cpphdl_n2468, Vlogic)); // Bench initial voltage = 0.0 V.
        // device 1904, IC IC325, analog/basic/level_down.hpp:29
        I(cpphdl_n2468, cpphdl_n2470) <+ 2.0000000000000002e-15 * ddt(V(cpphdl_n2468, cpphdl_n2470)); // Bench initial voltage = 0.0 V.
        // device 1905, IC IC325, analog/basic/level_down.hpp:30
        I(cpphdl_n2470, Vss) <+ 8e-14 * ddt(V(cpphdl_n2470, Vss)); // Bench initial voltage = 0.0 V.
        // device 1906, IC IC325, analog/basic/level_down.hpp:31
        I(cpphdl_n2470, Vlogic) <+ 5e-15 * ddt(V(cpphdl_n2470, Vlogic)); // Bench initial voltage = 0.0 V.
        // device 1907, IC IC325, analog/basic/level_down.hpp:32
        I(cpphdl_n2470, CORE_DECISION8) <+ 2.0000000000000002e-15 * ddt(V(cpphdl_n2470, CORE_DECISION8)); // Bench initial voltage = 0.0 V.
        // device 1908, IC IC325, analog/basic/level_down.hpp:33
        I(CORE_DECISION8, Vss) <+ 1e-14 * ddt(V(CORE_DECISION8, Vss)); // Bench initial voltage = 0.0 V.
        // device 1909, IC IC326, analog/basic/level_down.hpp:23
        I(cpphdl_n2475, Vlogic) <+ cpphdl_channel(V(Vss, Vlogic), V(cpphdl_n2475, Vlogic), 0.00050000000000000001, 0.34999999999999998, -1.0);
        // device 1910, IC IC326, analog/basic/level_down.hpp:24
        I(cpphdl_n2475, Vss) <+ cpphdl_channel(V(cpphdl_n2473, Vss), V(cpphdl_n2475, Vss), 0.0040000000000000001, 0.69999999999999996, 1.0);
        // device 1911, IC IC326, analog/basic/level_down.hpp:25
        I(CORE_DECISION9, Vlogic) <+ cpphdl_channel(V(cpphdl_n2475, Vlogic), V(CORE_DECISION9, Vlogic), 0.0050000000000000001, 0.34999999999999998, -1.0);
        // device 1912, IC IC326, analog/basic/level_down.hpp:26
        I(CORE_DECISION9, Vss) <+ cpphdl_channel(V(cpphdl_n2475, Vss), V(CORE_DECISION9, Vss), 0.01, 0.34999999999999998, 1.0);
        // device 1913, IC IC326, analog/basic/level_down.hpp:27
        I(cpphdl_n2473, Vss) <+ 5e-15 * ddt(V(cpphdl_n2473, Vss)); // Bench initial voltage = 0.0 V.
        // device 1914, IC IC326, analog/basic/level_down.hpp:28
        I(cpphdl_n2473, Vlogic) <+ 5e-15 * ddt(V(cpphdl_n2473, Vlogic)); // Bench initial voltage = 0.0 V.
        // device 1915, IC IC326, analog/basic/level_down.hpp:29
        I(cpphdl_n2473, cpphdl_n2475) <+ 2.0000000000000002e-15 * ddt(V(cpphdl_n2473, cpphdl_n2475)); // Bench initial voltage = 0.0 V.
        // device 1916, IC IC326, analog/basic/level_down.hpp:30
        I(cpphdl_n2475, Vss) <+ 8e-14 * ddt(V(cpphdl_n2475, Vss)); // Bench initial voltage = 0.0 V.
        // device 1917, IC IC326, analog/basic/level_down.hpp:31
        I(cpphdl_n2475, Vlogic) <+ 5e-15 * ddt(V(cpphdl_n2475, Vlogic)); // Bench initial voltage = 0.0 V.
        // device 1918, IC IC326, analog/basic/level_down.hpp:32
        I(cpphdl_n2475, CORE_DECISION9) <+ 2.0000000000000002e-15 * ddt(V(cpphdl_n2475, CORE_DECISION9)); // Bench initial voltage = 0.0 V.
        // device 1919, IC IC326, analog/basic/level_down.hpp:33
        I(CORE_DECISION9, Vss) <+ 1e-14 * ddt(V(CORE_DECISION9, Vss)); // Bench initial voltage = 0.0 V.
        // device 1920, IC IC327, analog/basic/level_down.hpp:23
        I(cpphdl_n2480, Vlogic) <+ cpphdl_channel(V(Vss, Vlogic), V(cpphdl_n2480, Vlogic), 0.00050000000000000001, 0.34999999999999998, -1.0);
        // device 1921, IC IC327, analog/basic/level_down.hpp:24
        I(cpphdl_n2480, Vss) <+ cpphdl_channel(V(cpphdl_n2478, Vss), V(cpphdl_n2480, Vss), 0.0040000000000000001, 0.69999999999999996, 1.0);
        // device 1922, IC IC327, analog/basic/level_down.hpp:25
        I(CORE_DECISION10, Vlogic) <+ cpphdl_channel(V(cpphdl_n2480, Vlogic), V(CORE_DECISION10, Vlogic), 0.0050000000000000001, 0.34999999999999998, -1.0);
        // device 1923, IC IC327, analog/basic/level_down.hpp:26
        I(CORE_DECISION10, Vss) <+ cpphdl_channel(V(cpphdl_n2480, Vss), V(CORE_DECISION10, Vss), 0.01, 0.34999999999999998, 1.0);
        // device 1924, IC IC327, analog/basic/level_down.hpp:27
        I(cpphdl_n2478, Vss) <+ 5e-15 * ddt(V(cpphdl_n2478, Vss)); // Bench initial voltage = 0.0 V.
        // device 1925, IC IC327, analog/basic/level_down.hpp:28
        I(cpphdl_n2478, Vlogic) <+ 5e-15 * ddt(V(cpphdl_n2478, Vlogic)); // Bench initial voltage = 0.0 V.
        // device 1926, IC IC327, analog/basic/level_down.hpp:29
        I(cpphdl_n2478, cpphdl_n2480) <+ 2.0000000000000002e-15 * ddt(V(cpphdl_n2478, cpphdl_n2480)); // Bench initial voltage = 0.0 V.
        // device 1927, IC IC327, analog/basic/level_down.hpp:30
        I(cpphdl_n2480, Vss) <+ 8e-14 * ddt(V(cpphdl_n2480, Vss)); // Bench initial voltage = 0.0 V.
        // device 1928, IC IC327, analog/basic/level_down.hpp:31
        I(cpphdl_n2480, Vlogic) <+ 5e-15 * ddt(V(cpphdl_n2480, Vlogic)); // Bench initial voltage = 0.0 V.
        // device 1929, IC IC327, analog/basic/level_down.hpp:32
        I(cpphdl_n2480, CORE_DECISION10) <+ 2.0000000000000002e-15 * ddt(V(cpphdl_n2480, CORE_DECISION10)); // Bench initial voltage = 0.0 V.
        // device 1930, IC IC327, analog/basic/level_down.hpp:33
        I(CORE_DECISION10, Vss) <+ 1e-14 * ddt(V(CORE_DECISION10, Vss)); // Bench initial voltage = 0.0 V.
        // device 1931, IC IC328, analog/basic/level_down.hpp:23
        I(cpphdl_n2485, Vlogic) <+ cpphdl_channel(V(Vss, Vlogic), V(cpphdl_n2485, Vlogic), 0.00050000000000000001, 0.34999999999999998, -1.0);
        // device 1932, IC IC328, analog/basic/level_down.hpp:24
        I(cpphdl_n2485, Vss) <+ cpphdl_channel(V(cpphdl_n2483, Vss), V(cpphdl_n2485, Vss), 0.0040000000000000001, 0.69999999999999996, 1.0);
        // device 1933, IC IC328, analog/basic/level_down.hpp:25
        I(CORE_DECISION11, Vlogic) <+ cpphdl_channel(V(cpphdl_n2485, Vlogic), V(CORE_DECISION11, Vlogic), 0.0050000000000000001, 0.34999999999999998, -1.0);
        // device 1934, IC IC328, analog/basic/level_down.hpp:26
        I(CORE_DECISION11, Vss) <+ cpphdl_channel(V(cpphdl_n2485, Vss), V(CORE_DECISION11, Vss), 0.01, 0.34999999999999998, 1.0);
        // device 1935, IC IC328, analog/basic/level_down.hpp:27
        I(cpphdl_n2483, Vss) <+ 5e-15 * ddt(V(cpphdl_n2483, Vss)); // Bench initial voltage = 0.0 V.
        // device 1936, IC IC328, analog/basic/level_down.hpp:28
        I(cpphdl_n2483, Vlogic) <+ 5e-15 * ddt(V(cpphdl_n2483, Vlogic)); // Bench initial voltage = 0.0 V.
        // device 1937, IC IC328, analog/basic/level_down.hpp:29
        I(cpphdl_n2483, cpphdl_n2485) <+ 2.0000000000000002e-15 * ddt(V(cpphdl_n2483, cpphdl_n2485)); // Bench initial voltage = 0.0 V.
        // device 1938, IC IC328, analog/basic/level_down.hpp:30
        I(cpphdl_n2485, Vss) <+ 8e-14 * ddt(V(cpphdl_n2485, Vss)); // Bench initial voltage = 0.0 V.
        // device 1939, IC IC328, analog/basic/level_down.hpp:31
        I(cpphdl_n2485, Vlogic) <+ 5e-15 * ddt(V(cpphdl_n2485, Vlogic)); // Bench initial voltage = 0.0 V.
        // device 1940, IC IC328, analog/basic/level_down.hpp:32
        I(cpphdl_n2485, CORE_DECISION11) <+ 2.0000000000000002e-15 * ddt(V(cpphdl_n2485, CORE_DECISION11)); // Bench initial voltage = 0.0 V.
        // device 1941, IC IC328, analog/basic/level_down.hpp:33
        I(CORE_DECISION11, Vss) <+ 1e-14 * ddt(V(CORE_DECISION11, Vss)); // Bench initial voltage = 0.0 V.
        // device 1942, IC IC329, analog/basic/level_down.hpp:23
        I(cpphdl_n2490, Vlogic) <+ cpphdl_channel(V(Vss, Vlogic), V(cpphdl_n2490, Vlogic), 0.00050000000000000001, 0.34999999999999998, -1.0);
        // device 1943, IC IC329, analog/basic/level_down.hpp:24
        I(cpphdl_n2490, Vss) <+ cpphdl_channel(V(cpphdl_n2488, Vss), V(cpphdl_n2490, Vss), 0.0040000000000000001, 0.69999999999999996, 1.0);
        // device 1944, IC IC329, analog/basic/level_down.hpp:25
        I(CORE_DECISION12, Vlogic) <+ cpphdl_channel(V(cpphdl_n2490, Vlogic), V(CORE_DECISION12, Vlogic), 0.0050000000000000001, 0.34999999999999998, -1.0);
        // device 1945, IC IC329, analog/basic/level_down.hpp:26
        I(CORE_DECISION12, Vss) <+ cpphdl_channel(V(cpphdl_n2490, Vss), V(CORE_DECISION12, Vss), 0.01, 0.34999999999999998, 1.0);
        // device 1946, IC IC329, analog/basic/level_down.hpp:27
        I(cpphdl_n2488, Vss) <+ 5e-15 * ddt(V(cpphdl_n2488, Vss)); // Bench initial voltage = 0.0 V.
        // device 1947, IC IC329, analog/basic/level_down.hpp:28
        I(cpphdl_n2488, Vlogic) <+ 5e-15 * ddt(V(cpphdl_n2488, Vlogic)); // Bench initial voltage = 0.0 V.
        // device 1948, IC IC329, analog/basic/level_down.hpp:29
        I(cpphdl_n2488, cpphdl_n2490) <+ 2.0000000000000002e-15 * ddt(V(cpphdl_n2488, cpphdl_n2490)); // Bench initial voltage = 0.0 V.
        // device 1949, IC IC329, analog/basic/level_down.hpp:30
        I(cpphdl_n2490, Vss) <+ 8e-14 * ddt(V(cpphdl_n2490, Vss)); // Bench initial voltage = 0.0 V.
        // device 1950, IC IC329, analog/basic/level_down.hpp:31
        I(cpphdl_n2490, Vlogic) <+ 5e-15 * ddt(V(cpphdl_n2490, Vlogic)); // Bench initial voltage = 0.0 V.
        // device 1951, IC IC329, analog/basic/level_down.hpp:32
        I(cpphdl_n2490, CORE_DECISION12) <+ 2.0000000000000002e-15 * ddt(V(cpphdl_n2490, CORE_DECISION12)); // Bench initial voltage = 0.0 V.
        // device 1952, IC IC329, analog/basic/level_down.hpp:33
        I(CORE_DECISION12, Vss) <+ 1e-14 * ddt(V(CORE_DECISION12, Vss)); // Bench initial voltage = 0.0 V.
    end
endmodule
