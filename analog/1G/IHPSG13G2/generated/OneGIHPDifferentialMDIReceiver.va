// SIMULATION APPROXIMATION: controlled conductances are not physical MOS devices.
// Generated from elaborated C++HDL IC purposes; all contributions coexist.
// Capacitor initialization belongs to the host analysis; declared initial voltages appear below.
`include "disciplines.vams"

module OneGIHPDifferentialMDIReceiver(Vdd, Vss, Vlogic, VREF, EVALUATE, CLEAR, P, N, SELECT_N0, SELECT_N1, SELECT_N2, SELECT_N3, SELECT_N4, TRACK0, CORE_DECISION0, BIT_N0_0, BIT_N0_1, BIT_N0_2, BIT_N0_3, BIT_N0_4, BIT_N0_5, BIT_N0_6, BIT_N0_7, TRACK1, CORE_DECISION1, BIT_N1_0, BIT_N1_1, BIT_N1_2, BIT_N1_3, BIT_N1_4, BIT_N1_5, BIT_N1_6, BIT_N1_7, TRACK2, CORE_DECISION2, BIT_N2_0, BIT_N2_1, BIT_N2_2, BIT_N2_3, BIT_N2_4, BIT_N2_5, BIT_N2_6, BIT_N2_7, TRACK3, CORE_DECISION3, BIT_N3_0, BIT_N3_1, BIT_N3_2, BIT_N3_3, BIT_N3_4, BIT_N3_5, BIT_N3_6, BIT_N3_7, TRACK4, CORE_DECISION4, BIT_N4_0, BIT_N4_1, BIT_N4_2, BIT_N4_3, BIT_N4_4, BIT_N4_5, BIT_N4_6, BIT_N4_7, TRACK5, CORE_DECISION5, BIT_N5_0, BIT_N5_1, BIT_N5_2, BIT_N5_3, BIT_N5_4, BIT_N5_5, BIT_N5_6, BIT_N5_7, TRACK6, CORE_DECISION6, BIT_N6_0, BIT_N6_1, BIT_N6_2, BIT_N6_3, BIT_N6_4, BIT_N6_5, BIT_N6_6, BIT_N6_7, TRACK7, CORE_DECISION7, BIT_N7_0, BIT_N7_1, BIT_N7_2, BIT_N7_3, BIT_N7_4, BIT_N7_5, BIT_N7_6, BIT_N7_7, TRACK8, CORE_DECISION8, BIT_N8_0, BIT_N8_1, BIT_N8_2, BIT_N8_3, BIT_N8_4, BIT_N8_5, BIT_N8_6, BIT_N8_7, TRACK9, CORE_DECISION9, BIT_N9_0, BIT_N9_1, BIT_N9_2, BIT_N9_3, BIT_N9_4, BIT_N9_5, BIT_N9_6, BIT_N9_7, TRACK10, CORE_DECISION10, BIT_N10_0, BIT_N10_1, BIT_N10_2, BIT_N10_3, BIT_N10_4, BIT_N10_5, BIT_N10_6, BIT_N10_7, TRACK11, CORE_DECISION11, BIT_N11_0, BIT_N11_1, BIT_N11_2, BIT_N11_3, BIT_N11_4, BIT_N11_5, BIT_N11_6, BIT_N11_7, TRACK12, CORE_DECISION12, BIT_N12_0, BIT_N12_1, BIT_N12_2, BIT_N12_3, BIT_N12_4, BIT_N12_5, BIT_N12_6, BIT_N12_7, TRACK13, CORE_DECISION13, BIT_N13_0, BIT_N13_1, BIT_N13_2, BIT_N13_3, BIT_N13_4, BIT_N13_5, BIT_N13_6, BIT_N13_7, TRACK14, CORE_DECISION14, BIT_N14_0, BIT_N14_1, BIT_N14_2, BIT_N14_3, BIT_N14_4, BIT_N14_5, BIT_N14_6, BIT_N14_7, TRACK15, CORE_DECISION15, BIT_N15_0, BIT_N15_1, BIT_N15_2, BIT_N15_3, BIT_N15_4, BIT_N15_5, BIT_N15_6, BIT_N15_7);
    inout Vdd, Vss, Vlogic, VREF, EVALUATE, CLEAR, P, N, SELECT_N0, SELECT_N1, SELECT_N2, SELECT_N3, SELECT_N4, TRACK0, CORE_DECISION0, BIT_N0_0, BIT_N0_1, BIT_N0_2, BIT_N0_3, BIT_N0_4, BIT_N0_5, BIT_N0_6, BIT_N0_7, TRACK1, CORE_DECISION1, BIT_N1_0, BIT_N1_1, BIT_N1_2, BIT_N1_3, BIT_N1_4, BIT_N1_5, BIT_N1_6, BIT_N1_7, TRACK2, CORE_DECISION2, BIT_N2_0, BIT_N2_1, BIT_N2_2, BIT_N2_3, BIT_N2_4, BIT_N2_5, BIT_N2_6, BIT_N2_7, TRACK3, CORE_DECISION3, BIT_N3_0, BIT_N3_1, BIT_N3_2, BIT_N3_3, BIT_N3_4, BIT_N3_5, BIT_N3_6, BIT_N3_7, TRACK4, CORE_DECISION4, BIT_N4_0, BIT_N4_1, BIT_N4_2, BIT_N4_3, BIT_N4_4, BIT_N4_5, BIT_N4_6, BIT_N4_7, TRACK5, CORE_DECISION5, BIT_N5_0, BIT_N5_1, BIT_N5_2, BIT_N5_3, BIT_N5_4, BIT_N5_5, BIT_N5_6, BIT_N5_7, TRACK6, CORE_DECISION6, BIT_N6_0, BIT_N6_1, BIT_N6_2, BIT_N6_3, BIT_N6_4, BIT_N6_5, BIT_N6_6, BIT_N6_7, TRACK7, CORE_DECISION7, BIT_N7_0, BIT_N7_1, BIT_N7_2, BIT_N7_3, BIT_N7_4, BIT_N7_5, BIT_N7_6, BIT_N7_7, TRACK8, CORE_DECISION8, BIT_N8_0, BIT_N8_1, BIT_N8_2, BIT_N8_3, BIT_N8_4, BIT_N8_5, BIT_N8_6, BIT_N8_7, TRACK9, CORE_DECISION9, BIT_N9_0, BIT_N9_1, BIT_N9_2, BIT_N9_3, BIT_N9_4, BIT_N9_5, BIT_N9_6, BIT_N9_7, TRACK10, CORE_DECISION10, BIT_N10_0, BIT_N10_1, BIT_N10_2, BIT_N10_3, BIT_N10_4, BIT_N10_5, BIT_N10_6, BIT_N10_7, TRACK11, CORE_DECISION11, BIT_N11_0, BIT_N11_1, BIT_N11_2, BIT_N11_3, BIT_N11_4, BIT_N11_5, BIT_N11_6, BIT_N11_7, TRACK12, CORE_DECISION12, BIT_N12_0, BIT_N12_1, BIT_N12_2, BIT_N12_3, BIT_N12_4, BIT_N12_5, BIT_N12_6, BIT_N12_7, TRACK13, CORE_DECISION13, BIT_N13_0, BIT_N13_1, BIT_N13_2, BIT_N13_3, BIT_N13_4, BIT_N13_5, BIT_N13_6, BIT_N13_7, TRACK14, CORE_DECISION14, BIT_N14_0, BIT_N14_1, BIT_N14_2, BIT_N14_3, BIT_N14_4, BIT_N14_5, BIT_N14_6, BIT_N14_7, TRACK15, CORE_DECISION15, BIT_N15_0, BIT_N15_1, BIT_N15_2, BIT_N15_3, BIT_N15_4, BIT_N15_5, BIT_N15_6, BIT_N15_7;
    electrical Vdd, Vss, Vlogic, VREF, EVALUATE, CLEAR, P, N, SELECT_N0, SELECT_N1, SELECT_N2, SELECT_N3, SELECT_N4, TRACK0, CORE_DECISION0, BIT_N0_0, BIT_N0_1, BIT_N0_2, BIT_N0_3, BIT_N0_4, BIT_N0_5, BIT_N0_6, BIT_N0_7, TRACK1, CORE_DECISION1, BIT_N1_0, BIT_N1_1, BIT_N1_2, BIT_N1_3, BIT_N1_4, BIT_N1_5, BIT_N1_6, BIT_N1_7, TRACK2, CORE_DECISION2, BIT_N2_0, BIT_N2_1, BIT_N2_2, BIT_N2_3, BIT_N2_4, BIT_N2_5, BIT_N2_6, BIT_N2_7, TRACK3, CORE_DECISION3, BIT_N3_0, BIT_N3_1, BIT_N3_2, BIT_N3_3, BIT_N3_4, BIT_N3_5, BIT_N3_6, BIT_N3_7, TRACK4, CORE_DECISION4, BIT_N4_0, BIT_N4_1, BIT_N4_2, BIT_N4_3, BIT_N4_4, BIT_N4_5, BIT_N4_6, BIT_N4_7, TRACK5, CORE_DECISION5, BIT_N5_0, BIT_N5_1, BIT_N5_2, BIT_N5_3, BIT_N5_4, BIT_N5_5, BIT_N5_6, BIT_N5_7, TRACK6, CORE_DECISION6, BIT_N6_0, BIT_N6_1, BIT_N6_2, BIT_N6_3, BIT_N6_4, BIT_N6_5, BIT_N6_6, BIT_N6_7, TRACK7, CORE_DECISION7, BIT_N7_0, BIT_N7_1, BIT_N7_2, BIT_N7_3, BIT_N7_4, BIT_N7_5, BIT_N7_6, BIT_N7_7, TRACK8, CORE_DECISION8, BIT_N8_0, BIT_N8_1, BIT_N8_2, BIT_N8_3, BIT_N8_4, BIT_N8_5, BIT_N8_6, BIT_N8_7, TRACK9, CORE_DECISION9, BIT_N9_0, BIT_N9_1, BIT_N9_2, BIT_N9_3, BIT_N9_4, BIT_N9_5, BIT_N9_6, BIT_N9_7, TRACK10, CORE_DECISION10, BIT_N10_0, BIT_N10_1, BIT_N10_2, BIT_N10_3, BIT_N10_4, BIT_N10_5, BIT_N10_6, BIT_N10_7, TRACK11, CORE_DECISION11, BIT_N11_0, BIT_N11_1, BIT_N11_2, BIT_N11_3, BIT_N11_4, BIT_N11_5, BIT_N11_6, BIT_N11_7, TRACK12, CORE_DECISION12, BIT_N12_0, BIT_N12_1, BIT_N12_2, BIT_N12_3, BIT_N12_4, BIT_N12_5, BIT_N12_6, BIT_N12_7, TRACK13, CORE_DECISION13, BIT_N13_0, BIT_N13_1, BIT_N13_2, BIT_N13_3, BIT_N13_4, BIT_N13_5, BIT_N13_6, BIT_N13_7, TRACK14, CORE_DECISION14, BIT_N14_0, BIT_N14_1, BIT_N14_2, BIT_N14_3, BIT_N14_4, BIT_N14_5, BIT_N14_6, BIT_N14_7, TRACK15, CORE_DECISION15, BIT_N15_0, BIT_N15_1, BIT_N15_2, BIT_N15_3, BIT_N15_4, BIT_N15_5, BIT_N15_6, BIT_N15_7;
    electrical cpphdl_n180;
    electrical cpphdl_n367;
    electrical cpphdl_n368;
    electrical cpphdl_n371;
    electrical cpphdl_n372;
    electrical cpphdl_n373;
    electrical cpphdl_n376;
    electrical cpphdl_n377;
    electrical cpphdl_n380;
    electrical cpphdl_n381;
    electrical cpphdl_n397;
    electrical cpphdl_n398;
    electrical cpphdl_n399;
    electrical cpphdl_n400;
    electrical cpphdl_n401;
    electrical cpphdl_n402;
    electrical cpphdl_n403;
    electrical cpphdl_n404;
    electrical cpphdl_n405;
    electrical cpphdl_n406;
    electrical cpphdl_n407;
    electrical cpphdl_n408;
    electrical cpphdl_n409;
    electrical cpphdl_n410;
    electrical cpphdl_n411;
    electrical cpphdl_n412;
    electrical cpphdl_n416;
    electrical cpphdl_n420;
    electrical cpphdl_n424;
    electrical cpphdl_n428;
    electrical cpphdl_n432;
    electrical cpphdl_n433;
    electrical cpphdl_n434;
    electrical cpphdl_n435;
    electrical cpphdl_n436;
    electrical cpphdl_n439;
    electrical cpphdl_n440;
    electrical cpphdl_n442;
    electrical cpphdl_n443;
    electrical cpphdl_n444;
    electrical cpphdl_n445;
    electrical cpphdl_n446;
    electrical cpphdl_n447;
    electrical cpphdl_n448;
    electrical cpphdl_n449;
    electrical cpphdl_n450;
    electrical cpphdl_n453;
    electrical cpphdl_n669;
    electrical cpphdl_n684;
    electrical cpphdl_n688;
    electrical cpphdl_n692;
    electrical cpphdl_n696;
    electrical cpphdl_n700;
    electrical cpphdl_n704;
    electrical cpphdl_n708;
    electrical cpphdl_n712;
    electrical cpphdl_n713;
    electrical cpphdl_n714;
    electrical cpphdl_n715;
    electrical cpphdl_n716;
    electrical cpphdl_n717;
    electrical cpphdl_n718;
    electrical cpphdl_n719;
    electrical cpphdl_n723;
    electrical cpphdl_n724;
    electrical cpphdl_n727;
    electrical cpphdl_n728;
    electrical cpphdl_n729;
    electrical cpphdl_n732;
    electrical cpphdl_n733;
    electrical cpphdl_n737;
    electrical cpphdl_n738;
    electrical cpphdl_n739;
    electrical cpphdl_n752;
    electrical cpphdl_n756;
    electrical cpphdl_n760;
    electrical cpphdl_n764;
    electrical cpphdl_n774;
    electrical cpphdl_n777;
    electrical cpphdl_n780;
    electrical cpphdl_n782;
    electrical cpphdl_n783;
    electrical cpphdl_n788;
    electrical cpphdl_n812;
    electrical cpphdl_n827;
    electrical cpphdl_n831;
    electrical cpphdl_n835;
    electrical cpphdl_n839;
    electrical cpphdl_n843;
    electrical cpphdl_n847;
    electrical cpphdl_n851;
    electrical cpphdl_n855;
    electrical cpphdl_n856;
    electrical cpphdl_n857;
    electrical cpphdl_n858;
    electrical cpphdl_n859;
    electrical cpphdl_n860;
    electrical cpphdl_n861;
    electrical cpphdl_n862;
    electrical cpphdl_n866;
    electrical cpphdl_n867;
    electrical cpphdl_n870;
    electrical cpphdl_n871;
    electrical cpphdl_n872;
    electrical cpphdl_n875;
    electrical cpphdl_n876;
    electrical cpphdl_n880;
    electrical cpphdl_n881;
    electrical cpphdl_n882;
    electrical cpphdl_n895;
    electrical cpphdl_n899;
    electrical cpphdl_n903;
    electrical cpphdl_n907;
    electrical cpphdl_n917;
    electrical cpphdl_n920;
    electrical cpphdl_n923;
    electrical cpphdl_n925;
    electrical cpphdl_n926;
    electrical cpphdl_n931;
    electrical cpphdl_n955;
    electrical cpphdl_n970;
    electrical cpphdl_n974;
    electrical cpphdl_n978;
    electrical cpphdl_n982;
    electrical cpphdl_n986;
    electrical cpphdl_n990;
    electrical cpphdl_n994;
    electrical cpphdl_n998;
    electrical cpphdl_n999;
    electrical cpphdl_n1000;
    electrical cpphdl_n1001;
    electrical cpphdl_n1002;
    electrical cpphdl_n1003;
    electrical cpphdl_n1004;
    electrical cpphdl_n1005;
    electrical cpphdl_n1009;
    electrical cpphdl_n1010;
    electrical cpphdl_n1013;
    electrical cpphdl_n1014;
    electrical cpphdl_n1015;
    electrical cpphdl_n1018;
    electrical cpphdl_n1019;
    electrical cpphdl_n1023;
    electrical cpphdl_n1024;
    electrical cpphdl_n1025;
    electrical cpphdl_n1038;
    electrical cpphdl_n1042;
    electrical cpphdl_n1046;
    electrical cpphdl_n1050;
    electrical cpphdl_n1060;
    electrical cpphdl_n1063;
    electrical cpphdl_n1066;
    electrical cpphdl_n1068;
    electrical cpphdl_n1069;
    electrical cpphdl_n1074;
    electrical cpphdl_n1098;
    electrical cpphdl_n1113;
    electrical cpphdl_n1117;
    electrical cpphdl_n1121;
    electrical cpphdl_n1125;
    electrical cpphdl_n1129;
    electrical cpphdl_n1133;
    electrical cpphdl_n1137;
    electrical cpphdl_n1141;
    electrical cpphdl_n1142;
    electrical cpphdl_n1143;
    electrical cpphdl_n1144;
    electrical cpphdl_n1145;
    electrical cpphdl_n1146;
    electrical cpphdl_n1147;
    electrical cpphdl_n1148;
    electrical cpphdl_n1152;
    electrical cpphdl_n1153;
    electrical cpphdl_n1156;
    electrical cpphdl_n1157;
    electrical cpphdl_n1158;
    electrical cpphdl_n1161;
    electrical cpphdl_n1162;
    electrical cpphdl_n1166;
    electrical cpphdl_n1167;
    electrical cpphdl_n1168;
    electrical cpphdl_n1181;
    electrical cpphdl_n1185;
    electrical cpphdl_n1189;
    electrical cpphdl_n1193;
    electrical cpphdl_n1203;
    electrical cpphdl_n1206;
    electrical cpphdl_n1209;
    electrical cpphdl_n1211;
    electrical cpphdl_n1212;
    electrical cpphdl_n1217;
    electrical cpphdl_n1241;
    electrical cpphdl_n1256;
    electrical cpphdl_n1260;
    electrical cpphdl_n1264;
    electrical cpphdl_n1268;
    electrical cpphdl_n1272;
    electrical cpphdl_n1276;
    electrical cpphdl_n1280;
    electrical cpphdl_n1284;
    electrical cpphdl_n1285;
    electrical cpphdl_n1286;
    electrical cpphdl_n1287;
    electrical cpphdl_n1288;
    electrical cpphdl_n1289;
    electrical cpphdl_n1290;
    electrical cpphdl_n1291;
    electrical cpphdl_n1295;
    electrical cpphdl_n1296;
    electrical cpphdl_n1299;
    electrical cpphdl_n1300;
    electrical cpphdl_n1301;
    electrical cpphdl_n1304;
    electrical cpphdl_n1305;
    electrical cpphdl_n1309;
    electrical cpphdl_n1310;
    electrical cpphdl_n1311;
    electrical cpphdl_n1324;
    electrical cpphdl_n1328;
    electrical cpphdl_n1332;
    electrical cpphdl_n1336;
    electrical cpphdl_n1346;
    electrical cpphdl_n1349;
    electrical cpphdl_n1352;
    electrical cpphdl_n1354;
    electrical cpphdl_n1355;
    electrical cpphdl_n1360;
    electrical cpphdl_n1384;
    electrical cpphdl_n1399;
    electrical cpphdl_n1403;
    electrical cpphdl_n1407;
    electrical cpphdl_n1411;
    electrical cpphdl_n1415;
    electrical cpphdl_n1419;
    electrical cpphdl_n1423;
    electrical cpphdl_n1427;
    electrical cpphdl_n1428;
    electrical cpphdl_n1429;
    electrical cpphdl_n1430;
    electrical cpphdl_n1431;
    electrical cpphdl_n1432;
    electrical cpphdl_n1433;
    electrical cpphdl_n1434;
    electrical cpphdl_n1438;
    electrical cpphdl_n1439;
    electrical cpphdl_n1442;
    electrical cpphdl_n1443;
    electrical cpphdl_n1444;
    electrical cpphdl_n1447;
    electrical cpphdl_n1448;
    electrical cpphdl_n1452;
    electrical cpphdl_n1453;
    electrical cpphdl_n1454;
    electrical cpphdl_n1467;
    electrical cpphdl_n1471;
    electrical cpphdl_n1475;
    electrical cpphdl_n1479;
    electrical cpphdl_n1489;
    electrical cpphdl_n1492;
    electrical cpphdl_n1495;
    electrical cpphdl_n1497;
    electrical cpphdl_n1498;
    electrical cpphdl_n1503;
    electrical cpphdl_n1527;
    electrical cpphdl_n1542;
    electrical cpphdl_n1546;
    electrical cpphdl_n1550;
    electrical cpphdl_n1554;
    electrical cpphdl_n1558;
    electrical cpphdl_n1562;
    electrical cpphdl_n1566;
    electrical cpphdl_n1570;
    electrical cpphdl_n1571;
    electrical cpphdl_n1572;
    electrical cpphdl_n1573;
    electrical cpphdl_n1574;
    electrical cpphdl_n1575;
    electrical cpphdl_n1576;
    electrical cpphdl_n1577;
    electrical cpphdl_n1581;
    electrical cpphdl_n1582;
    electrical cpphdl_n1585;
    electrical cpphdl_n1586;
    electrical cpphdl_n1587;
    electrical cpphdl_n1590;
    electrical cpphdl_n1591;
    electrical cpphdl_n1595;
    electrical cpphdl_n1596;
    electrical cpphdl_n1597;
    electrical cpphdl_n1610;
    electrical cpphdl_n1614;
    electrical cpphdl_n1618;
    electrical cpphdl_n1622;
    electrical cpphdl_n1632;
    electrical cpphdl_n1635;
    electrical cpphdl_n1638;
    electrical cpphdl_n1640;
    electrical cpphdl_n1641;
    electrical cpphdl_n1646;
    electrical cpphdl_n1670;
    electrical cpphdl_n1685;
    electrical cpphdl_n1689;
    electrical cpphdl_n1693;
    electrical cpphdl_n1697;
    electrical cpphdl_n1701;
    electrical cpphdl_n1705;
    electrical cpphdl_n1709;
    electrical cpphdl_n1713;
    electrical cpphdl_n1714;
    electrical cpphdl_n1715;
    electrical cpphdl_n1716;
    electrical cpphdl_n1717;
    electrical cpphdl_n1718;
    electrical cpphdl_n1719;
    electrical cpphdl_n1720;
    electrical cpphdl_n1724;
    electrical cpphdl_n1725;
    electrical cpphdl_n1728;
    electrical cpphdl_n1729;
    electrical cpphdl_n1730;
    electrical cpphdl_n1733;
    electrical cpphdl_n1734;
    electrical cpphdl_n1738;
    electrical cpphdl_n1739;
    electrical cpphdl_n1740;
    electrical cpphdl_n1753;
    electrical cpphdl_n1757;
    electrical cpphdl_n1761;
    electrical cpphdl_n1765;
    electrical cpphdl_n1775;
    electrical cpphdl_n1778;
    electrical cpphdl_n1781;
    electrical cpphdl_n1783;
    electrical cpphdl_n1784;
    electrical cpphdl_n1789;
    electrical cpphdl_n1813;
    electrical cpphdl_n1828;
    electrical cpphdl_n1832;
    electrical cpphdl_n1836;
    electrical cpphdl_n1840;
    electrical cpphdl_n1844;
    electrical cpphdl_n1848;
    electrical cpphdl_n1852;
    electrical cpphdl_n1856;
    electrical cpphdl_n1857;
    electrical cpphdl_n1858;
    electrical cpphdl_n1859;
    electrical cpphdl_n1860;
    electrical cpphdl_n1861;
    electrical cpphdl_n1862;
    electrical cpphdl_n1863;
    electrical cpphdl_n1867;
    electrical cpphdl_n1868;
    electrical cpphdl_n1871;
    electrical cpphdl_n1872;
    electrical cpphdl_n1873;
    electrical cpphdl_n1876;
    electrical cpphdl_n1877;
    electrical cpphdl_n1881;
    electrical cpphdl_n1882;
    electrical cpphdl_n1883;
    electrical cpphdl_n1896;
    electrical cpphdl_n1900;
    electrical cpphdl_n1904;
    electrical cpphdl_n1908;
    electrical cpphdl_n1918;
    electrical cpphdl_n1921;
    electrical cpphdl_n1924;
    electrical cpphdl_n1926;
    electrical cpphdl_n1927;
    electrical cpphdl_n1932;
    electrical cpphdl_n1956;
    electrical cpphdl_n1971;
    electrical cpphdl_n1975;
    electrical cpphdl_n1979;
    electrical cpphdl_n1983;
    electrical cpphdl_n1987;
    electrical cpphdl_n1991;
    electrical cpphdl_n1995;
    electrical cpphdl_n1999;
    electrical cpphdl_n2000;
    electrical cpphdl_n2001;
    electrical cpphdl_n2002;
    electrical cpphdl_n2003;
    electrical cpphdl_n2004;
    electrical cpphdl_n2005;
    electrical cpphdl_n2006;
    electrical cpphdl_n2010;
    electrical cpphdl_n2011;
    electrical cpphdl_n2014;
    electrical cpphdl_n2015;
    electrical cpphdl_n2016;
    electrical cpphdl_n2019;
    electrical cpphdl_n2020;
    electrical cpphdl_n2024;
    electrical cpphdl_n2025;
    electrical cpphdl_n2026;
    electrical cpphdl_n2039;
    electrical cpphdl_n2043;
    electrical cpphdl_n2047;
    electrical cpphdl_n2051;
    electrical cpphdl_n2061;
    electrical cpphdl_n2064;
    electrical cpphdl_n2067;
    electrical cpphdl_n2069;
    electrical cpphdl_n2070;
    electrical cpphdl_n2075;
    electrical cpphdl_n2099;
    electrical cpphdl_n2114;
    electrical cpphdl_n2118;
    electrical cpphdl_n2122;
    electrical cpphdl_n2126;
    electrical cpphdl_n2130;
    electrical cpphdl_n2134;
    electrical cpphdl_n2138;
    electrical cpphdl_n2142;
    electrical cpphdl_n2143;
    electrical cpphdl_n2144;
    electrical cpphdl_n2145;
    electrical cpphdl_n2146;
    electrical cpphdl_n2147;
    electrical cpphdl_n2148;
    electrical cpphdl_n2149;
    electrical cpphdl_n2153;
    electrical cpphdl_n2154;
    electrical cpphdl_n2157;
    electrical cpphdl_n2158;
    electrical cpphdl_n2159;
    electrical cpphdl_n2162;
    electrical cpphdl_n2163;
    electrical cpphdl_n2167;
    electrical cpphdl_n2168;
    electrical cpphdl_n2169;
    electrical cpphdl_n2182;
    electrical cpphdl_n2186;
    electrical cpphdl_n2190;
    electrical cpphdl_n2194;
    electrical cpphdl_n2204;
    electrical cpphdl_n2207;
    electrical cpphdl_n2210;
    electrical cpphdl_n2212;
    electrical cpphdl_n2213;
    electrical cpphdl_n2218;
    electrical cpphdl_n2242;
    electrical cpphdl_n2257;
    electrical cpphdl_n2261;
    electrical cpphdl_n2265;
    electrical cpphdl_n2269;
    electrical cpphdl_n2273;
    electrical cpphdl_n2277;
    electrical cpphdl_n2281;
    electrical cpphdl_n2285;
    electrical cpphdl_n2286;
    electrical cpphdl_n2287;
    electrical cpphdl_n2288;
    electrical cpphdl_n2289;
    electrical cpphdl_n2290;
    electrical cpphdl_n2291;
    electrical cpphdl_n2292;
    electrical cpphdl_n2296;
    electrical cpphdl_n2297;
    electrical cpphdl_n2300;
    electrical cpphdl_n2301;
    electrical cpphdl_n2302;
    electrical cpphdl_n2305;
    electrical cpphdl_n2306;
    electrical cpphdl_n2310;
    electrical cpphdl_n2311;
    electrical cpphdl_n2312;
    electrical cpphdl_n2325;
    electrical cpphdl_n2329;
    electrical cpphdl_n2333;
    electrical cpphdl_n2337;
    electrical cpphdl_n2347;
    electrical cpphdl_n2350;
    electrical cpphdl_n2353;
    electrical cpphdl_n2355;
    electrical cpphdl_n2356;
    electrical cpphdl_n2361;
    electrical cpphdl_n2385;
    electrical cpphdl_n2400;
    electrical cpphdl_n2404;
    electrical cpphdl_n2408;
    electrical cpphdl_n2412;
    electrical cpphdl_n2416;
    electrical cpphdl_n2420;
    electrical cpphdl_n2424;
    electrical cpphdl_n2428;
    electrical cpphdl_n2429;
    electrical cpphdl_n2430;
    electrical cpphdl_n2431;
    electrical cpphdl_n2432;
    electrical cpphdl_n2433;
    electrical cpphdl_n2434;
    electrical cpphdl_n2435;
    electrical cpphdl_n2439;
    electrical cpphdl_n2440;
    electrical cpphdl_n2443;
    electrical cpphdl_n2444;
    electrical cpphdl_n2445;
    electrical cpphdl_n2448;
    electrical cpphdl_n2449;
    electrical cpphdl_n2453;
    electrical cpphdl_n2454;
    electrical cpphdl_n2455;
    electrical cpphdl_n2468;
    electrical cpphdl_n2472;
    electrical cpphdl_n2476;
    electrical cpphdl_n2480;
    electrical cpphdl_n2490;
    electrical cpphdl_n2493;
    electrical cpphdl_n2496;
    electrical cpphdl_n2498;
    electrical cpphdl_n2499;
    electrical cpphdl_n2504;
    electrical cpphdl_n2528;
    electrical cpphdl_n2543;
    electrical cpphdl_n2547;
    electrical cpphdl_n2551;
    electrical cpphdl_n2555;
    electrical cpphdl_n2559;
    electrical cpphdl_n2563;
    electrical cpphdl_n2567;
    electrical cpphdl_n2571;
    electrical cpphdl_n2572;
    electrical cpphdl_n2573;
    electrical cpphdl_n2574;
    electrical cpphdl_n2575;
    electrical cpphdl_n2576;
    electrical cpphdl_n2577;
    electrical cpphdl_n2578;
    electrical cpphdl_n2582;
    electrical cpphdl_n2583;
    electrical cpphdl_n2586;
    electrical cpphdl_n2587;
    electrical cpphdl_n2588;
    electrical cpphdl_n2591;
    electrical cpphdl_n2592;
    electrical cpphdl_n2596;
    electrical cpphdl_n2597;
    electrical cpphdl_n2598;
    electrical cpphdl_n2611;
    electrical cpphdl_n2615;
    electrical cpphdl_n2619;
    electrical cpphdl_n2623;
    electrical cpphdl_n2633;
    electrical cpphdl_n2636;
    electrical cpphdl_n2639;
    electrical cpphdl_n2641;
    electrical cpphdl_n2642;
    electrical cpphdl_n2647;
    electrical cpphdl_n2671;
    electrical cpphdl_n2686;
    electrical cpphdl_n2690;
    electrical cpphdl_n2694;
    electrical cpphdl_n2698;
    electrical cpphdl_n2702;
    electrical cpphdl_n2706;
    electrical cpphdl_n2710;
    electrical cpphdl_n2714;
    electrical cpphdl_n2715;
    electrical cpphdl_n2716;
    electrical cpphdl_n2717;
    electrical cpphdl_n2718;
    electrical cpphdl_n2719;
    electrical cpphdl_n2720;
    electrical cpphdl_n2721;
    electrical cpphdl_n2725;
    electrical cpphdl_n2726;
    electrical cpphdl_n2729;
    electrical cpphdl_n2730;
    electrical cpphdl_n2731;
    electrical cpphdl_n2734;
    electrical cpphdl_n2735;
    electrical cpphdl_n2739;
    electrical cpphdl_n2740;
    electrical cpphdl_n2741;
    electrical cpphdl_n2754;
    electrical cpphdl_n2758;
    electrical cpphdl_n2762;
    electrical cpphdl_n2766;
    electrical cpphdl_n2776;
    electrical cpphdl_n2779;
    electrical cpphdl_n2782;
    electrical cpphdl_n2784;
    electrical cpphdl_n2785;
    electrical cpphdl_n2790;
    electrical cpphdl_n2808;
    electrical cpphdl_n2814;
    electrical cpphdl_n2829;
    electrical cpphdl_n2833;
    electrical cpphdl_n2837;
    electrical cpphdl_n2841;
    electrical cpphdl_n2845;
    electrical cpphdl_n2849;
    electrical cpphdl_n2853;
    electrical cpphdl_n2857;
    electrical cpphdl_n2858;
    electrical cpphdl_n2859;
    electrical cpphdl_n2860;
    electrical cpphdl_n2861;
    electrical cpphdl_n2862;
    electrical cpphdl_n2863;
    electrical cpphdl_n2864;
    electrical cpphdl_n2868;
    electrical cpphdl_n2869;
    electrical cpphdl_n2872;
    electrical cpphdl_n2873;
    electrical cpphdl_n2874;
    electrical cpphdl_n2877;
    electrical cpphdl_n2878;
    electrical cpphdl_n2882;
    electrical cpphdl_n2883;
    electrical cpphdl_n2884;
    electrical cpphdl_n2897;
    electrical cpphdl_n2901;
    electrical cpphdl_n2905;
    electrical cpphdl_n2909;
    electrical cpphdl_n2919;
    electrical cpphdl_n2922;
    electrical cpphdl_n2925;
    electrical cpphdl_n2927;
    electrical cpphdl_n2928;
    electrical cpphdl_n2933;
    electrical cpphdl_n2953;
    electrical cpphdl_n2955;
    electrical cpphdl_n2958;
    electrical cpphdl_n2960;
    electrical cpphdl_n2963;
    electrical cpphdl_n2965;
    electrical cpphdl_n2968;
    electrical cpphdl_n2970;
    electrical cpphdl_n2973;
    electrical cpphdl_n2975;
    electrical cpphdl_n2978;
    electrical cpphdl_n2980;
    electrical cpphdl_n2983;
    electrical cpphdl_n2985;
    electrical cpphdl_n2988;
    electrical cpphdl_n2990;
    electrical cpphdl_n2993;
    electrical cpphdl_n2995;
    electrical cpphdl_n2998;
    electrical cpphdl_n3000;
    electrical cpphdl_n3003;
    electrical cpphdl_n3005;
    electrical cpphdl_n3008;
    electrical cpphdl_n3010;
    electrical cpphdl_n3013;
    electrical cpphdl_n3015;
    electrical cpphdl_n3018;
    electrical cpphdl_n3020;
    electrical cpphdl_n3023;
    electrical cpphdl_n3025;
    electrical cpphdl_n3028;
    electrical cpphdl_n3030;

    // Square-law channel, including reverse conduction. This is not a BSIM model.
    analog function real cpphdl_channel;
        input vgs, vds, beta, threshold, polarity;
        real vgs, vds, beta, threshold, polarity;
        real gate, drain, direction, overdrive, current;
        begin
            gate = polarity * vgs;
            drain = polarity * vds;
            direction = 1.0;
            if (drain < 0.0) begin
                gate = gate - drain;
                drain = -drain;
                direction = -1.0;
            end
            overdrive = gate - threshold;
            current = 0.0;
            if (overdrive > 0.0) begin
                if (drain < overdrive)
                    current = beta * (overdrive * drain - drain * drain / 2.0);
                else
                    current = beta * overdrive * overdrive / 2.0;
            end
            cpphdl_channel = polarity * direction * current;
        end
    endfunction

    analog begin
        // device 0, IC IC1, analog/1G/mdi_input_network.hpp:20
        I(P, cpphdl_n367) <+ V(P, cpphdl_n367) / 2000.0;
        // device 1, IC IC1, analog/1G/mdi_input_network.hpp:21
        I(N, cpphdl_n368) <+ V(N, cpphdl_n368) / 2000.0;
        // device 2, IC IC1, analog/1G/mdi_input_network.hpp:22
        I(Vdd, cpphdl_n180) <+ V(Vdd, cpphdl_n180) / 1000.0;
        // device 3, IC IC1, analog/1G/mdi_input_network.hpp:23
        I(cpphdl_n180, Vss) <+ V(cpphdl_n180, Vss) / 1000.0;
        // device 4, IC IC1, analog/1G/mdi_input_network.hpp:24
        I(cpphdl_n180, cpphdl_n367) <+ V(cpphdl_n180, cpphdl_n367) / 330.0;
        // device 5, IC IC1, analog/1G/mdi_input_network.hpp:25
        I(cpphdl_n180, cpphdl_n368) <+ V(cpphdl_n180, cpphdl_n368) / 330.0;
        // device 6, IC IC1, analog/1G/mdi_input_network.hpp:26
        I(cpphdl_n180, Vss) <+ 2e-12 * ddt(V(cpphdl_n180, Vss)); // Bench initial voltage = 0.0 V.
        // device 7, IC IC3, analog/1G/IHPSG13G2/differential_receive_frontend.hpp:24
        I(cpphdl_n367, cpphdl_n368) <+ V(cpphdl_n367, cpphdl_n368) / 100.0;
        // device 8, IC IC4, analog/basic/nmos_resistor_amplifier.hpp:23
        I(Vdd, cpphdl_n380) <+ V(Vdd, cpphdl_n380) / 500.0;
        // device 9, IC IC4, analog/basic/nmos_resistor_amplifier.hpp:24
        I(Vdd, cpphdl_n376) <+ V(Vdd, cpphdl_n376) / 500.0;
        // device 10, IC IC4, analog/basic/nmos_resistor_amplifier.hpp:25
        I(cpphdl_n380, cpphdl_n371) <+ cpphdl_channel(V(cpphdl_n367, cpphdl_n371), V(cpphdl_n380, cpphdl_n371), 0.014999999999999999, 0.69999999999999996, 1.0);
        // device 11, IC IC4, analog/basic/nmos_resistor_amplifier.hpp:26
        I(cpphdl_n376, cpphdl_n372) <+ cpphdl_channel(V(cpphdl_n368, cpphdl_n372), V(cpphdl_n376, cpphdl_n372), 0.014999999999999999, 0.69999999999999996, 1.0);
        // device 12, IC IC4, analog/basic/nmos_resistor_amplifier.hpp:27
        I(cpphdl_n373, cpphdl_n371) <+ V(cpphdl_n373, cpphdl_n371) / 50.0;
        // device 13, IC IC4, analog/basic/nmos_resistor_amplifier.hpp:28
        I(cpphdl_n373, cpphdl_n372) <+ V(cpphdl_n373, cpphdl_n372) / 50.0;
        // device 14, IC IC4, analog/basic/nmos_resistor_amplifier.hpp:29
        I(Vss, cpphdl_n373) <+ V(Vss, cpphdl_n373) / 150.0;
        // device 15, IC IC4, analog/basic/nmos_resistor_amplifier.hpp:30
        I(cpphdl_n380, Vdd) <+ 1e-13 * ddt(V(cpphdl_n380, Vdd)); // Bench initial voltage = 0.0 V.
        // device 16, IC IC4, analog/basic/nmos_resistor_amplifier.hpp:31
        I(cpphdl_n376, Vdd) <+ 1e-13 * ddt(V(cpphdl_n376, Vdd)); // Bench initial voltage = 0.0 V.
        // device 17, IC IC4, analog/basic/nmos_resistor_amplifier.hpp:32
        I(cpphdl_n373, Vss) <+ 4e-14 * ddt(V(cpphdl_n373, Vss)); // Bench initial voltage = 0.0 V.
        // device 18, IC IC4, analog/basic/nmos_resistor_amplifier.hpp:34
        I(cpphdl_n367, cpphdl_n371) <+ 1.4999999999999999e-13 * ddt(V(cpphdl_n367, cpphdl_n371)); // Bench initial voltage = 0.0 V.
        // device 19, IC IC4, analog/basic/nmos_resistor_amplifier.hpp:35
        I(cpphdl_n368, cpphdl_n372) <+ 1.4999999999999999e-13 * ddt(V(cpphdl_n368, cpphdl_n372)); // Bench initial voltage = 0.0 V.
        // device 20, IC IC4, analog/basic/nmos_resistor_amplifier.hpp:36
        I(cpphdl_n367, cpphdl_n380) <+ 2e-14 * ddt(V(cpphdl_n367, cpphdl_n380)); // Bench initial voltage = 0.0 V.
        // device 21, IC IC4, analog/basic/nmos_resistor_amplifier.hpp:37
        I(cpphdl_n368, cpphdl_n376) <+ 2e-14 * ddt(V(cpphdl_n368, cpphdl_n376)); // Bench initial voltage = 0.0 V.
        // device 22, IC IC5, analog/basic/nmos_source_follower.hpp:19
        I(Vdd, cpphdl_n377) <+ cpphdl_channel(V(cpphdl_n376, cpphdl_n377), V(Vdd, cpphdl_n377), 0.10000000000000001, 0.69999999999999996, 1.0);
        // device 23, IC IC5, analog/basic/nmos_source_follower.hpp:20
        I(Vss, cpphdl_n377) <+ V(Vss, cpphdl_n377) / 250.0;
        // device 24, IC IC5, analog/basic/nmos_source_follower.hpp:23
        I(cpphdl_n376, cpphdl_n377) <+ 4e-14 * ddt(V(cpphdl_n376, cpphdl_n377)); // Bench initial voltage = 0.0 V.
        // device 25, IC IC5, analog/basic/nmos_source_follower.hpp:24
        I(cpphdl_n376, Vdd) <+ 1e-14 * ddt(V(cpphdl_n376, Vdd)); // Bench initial voltage = 0.0 V.
        // device 26, IC IC5, analog/basic/nmos_source_follower.hpp:25
        I(cpphdl_n377, Vss) <+ 4e-14 * ddt(V(cpphdl_n377, Vss)); // Bench initial voltage = 0.0 V.
        // device 27, IC IC6, analog/basic/nmos_source_follower.hpp:19
        I(Vdd, cpphdl_n381) <+ cpphdl_channel(V(cpphdl_n380, cpphdl_n381), V(Vdd, cpphdl_n381), 0.10000000000000001, 0.69999999999999996, 1.0);
        // device 28, IC IC6, analog/basic/nmos_source_follower.hpp:20
        I(Vss, cpphdl_n381) <+ V(Vss, cpphdl_n381) / 250.0;
        // device 29, IC IC6, analog/basic/nmos_source_follower.hpp:23
        I(cpphdl_n380, cpphdl_n381) <+ 4e-14 * ddt(V(cpphdl_n380, cpphdl_n381)); // Bench initial voltage = 0.0 V.
        // device 30, IC IC6, analog/basic/nmos_source_follower.hpp:24
        I(cpphdl_n380, Vdd) <+ 1e-14 * ddt(V(cpphdl_n380, Vdd)); // Bench initial voltage = 0.0 V.
        // device 31, IC IC6, analog/basic/nmos_source_follower.hpp:25
        I(cpphdl_n381, Vss) <+ 4e-14 * ddt(V(cpphdl_n381, Vss)); // Bench initial voltage = 0.0 V.
        // device 32, IC IC8, analog/basic/inverter.hpp:11
        I(cpphdl_n416, Vdd) <+ cpphdl_channel(V(SELECT_N0, Vdd), V(cpphdl_n416, Vdd), 0.0030000000000000001, 0.69999999999999996, -1.0);
        // device 33, IC IC8, analog/basic/inverter.hpp:12
        I(cpphdl_n416, Vss) <+ cpphdl_channel(V(SELECT_N0, Vss), V(cpphdl_n416, Vss), 0.0030000000000000001, 0.69999999999999996, 1.0);
        // device 34, IC IC7, analog/1G/IHPSG13G2/differential_receive_gain.hpp:41
        I(cpphdl_n416, Vss) <+ 2e-14 * ddt(V(cpphdl_n416, Vss)); // Bench initial voltage = 0.0 V.
        // device 35, IC IC9, analog/basic/inverter.hpp:11
        I(cpphdl_n420, Vdd) <+ cpphdl_channel(V(SELECT_N1, Vdd), V(cpphdl_n420, Vdd), 0.0030000000000000001, 0.69999999999999996, -1.0);
        // device 36, IC IC9, analog/basic/inverter.hpp:12
        I(cpphdl_n420, Vss) <+ cpphdl_channel(V(SELECT_N1, Vss), V(cpphdl_n420, Vss), 0.0030000000000000001, 0.69999999999999996, 1.0);
        // device 37, IC IC7, analog/1G/IHPSG13G2/differential_receive_gain.hpp:41
        I(cpphdl_n420, Vss) <+ 2e-14 * ddt(V(cpphdl_n420, Vss)); // Bench initial voltage = 0.0 V.
        // device 38, IC IC10, analog/basic/inverter.hpp:11
        I(cpphdl_n424, Vdd) <+ cpphdl_channel(V(SELECT_N2, Vdd), V(cpphdl_n424, Vdd), 0.0030000000000000001, 0.69999999999999996, -1.0);
        // device 39, IC IC10, analog/basic/inverter.hpp:12
        I(cpphdl_n424, Vss) <+ cpphdl_channel(V(SELECT_N2, Vss), V(cpphdl_n424, Vss), 0.0030000000000000001, 0.69999999999999996, 1.0);
        // device 40, IC IC7, analog/1G/IHPSG13G2/differential_receive_gain.hpp:41
        I(cpphdl_n424, Vss) <+ 2e-14 * ddt(V(cpphdl_n424, Vss)); // Bench initial voltage = 0.0 V.
        // device 41, IC IC11, analog/basic/inverter.hpp:11
        I(cpphdl_n428, Vdd) <+ cpphdl_channel(V(SELECT_N3, Vdd), V(cpphdl_n428, Vdd), 0.0030000000000000001, 0.69999999999999996, -1.0);
        // device 42, IC IC11, analog/basic/inverter.hpp:12
        I(cpphdl_n428, Vss) <+ cpphdl_channel(V(SELECT_N3, Vss), V(cpphdl_n428, Vss), 0.0030000000000000001, 0.69999999999999996, 1.0);
        // device 43, IC IC7, analog/1G/IHPSG13G2/differential_receive_gain.hpp:41
        I(cpphdl_n428, Vss) <+ 2e-14 * ddt(V(cpphdl_n428, Vss)); // Bench initial voltage = 0.0 V.
        // device 44, IC IC12, analog/basic/inverter.hpp:11
        I(cpphdl_n432, Vdd) <+ cpphdl_channel(V(SELECT_N4, Vdd), V(cpphdl_n432, Vdd), 0.0030000000000000001, 0.69999999999999996, -1.0);
        // device 45, IC IC12, analog/basic/inverter.hpp:12
        I(cpphdl_n432, Vss) <+ cpphdl_channel(V(SELECT_N4, Vss), V(cpphdl_n432, Vss), 0.0030000000000000001, 0.69999999999999996, 1.0);
        // device 46, IC IC7, analog/1G/IHPSG13G2/differential_receive_gain.hpp:41
        I(cpphdl_n432, Vss) <+ 2e-14 * ddt(V(cpphdl_n432, Vss)); // Bench initial voltage = 0.0 V.
        // device 47, IC IC7, analog/1G/IHPSG13G2/differential_receive_gain.hpp:43
        I(VREF, cpphdl_n405) <+ V(VREF, cpphdl_n405) / 100.0;
        // device 48, IC IC7, analog/1G/IHPSG13G2/differential_receive_gain.hpp:45
        I(cpphdl_n405, cpphdl_n406) <+ V(cpphdl_n405, cpphdl_n406) / 100.0;
        // device 49, IC IC7, analog/1G/IHPSG13G2/differential_receive_gain.hpp:45
        I(cpphdl_n406, cpphdl_n407) <+ V(cpphdl_n406, cpphdl_n407) / 100.0;
        // device 50, IC IC7, analog/1G/IHPSG13G2/differential_receive_gain.hpp:45
        I(cpphdl_n407, cpphdl_n408) <+ V(cpphdl_n407, cpphdl_n408) / 100.0;
        // device 51, IC IC7, analog/1G/IHPSG13G2/differential_receive_gain.hpp:45
        I(cpphdl_n408, cpphdl_n409) <+ V(cpphdl_n408, cpphdl_n409) / 100.0;
        // device 52, IC IC7, analog/1G/IHPSG13G2/differential_receive_gain.hpp:45
        I(cpphdl_n409, cpphdl_n410) <+ V(cpphdl_n409, cpphdl_n410) / 100.0;
        // device 53, IC IC7, analog/1G/IHPSG13G2/differential_receive_gain.hpp:45
        I(cpphdl_n410, cpphdl_n411) <+ V(cpphdl_n410, cpphdl_n411) / 100.0;
        // device 54, IC IC7, analog/1G/IHPSG13G2/differential_receive_gain.hpp:45
        I(cpphdl_n411, cpphdl_n412) <+ V(cpphdl_n411, cpphdl_n412) / 100.0;
        // device 55, IC IC7, analog/1G/IHPSG13G2/differential_receive_gain.hpp:46
        I(cpphdl_n412, cpphdl_n377) <+ V(cpphdl_n412, cpphdl_n377) / 100.0;
        // device 56, IC IC7, analog/1G/IHPSG13G2/differential_receive_gain.hpp:48
        I(cpphdl_n408, cpphdl_n439) <+ cpphdl_channel(V(cpphdl_n416, cpphdl_n439), V(cpphdl_n408, cpphdl_n439), 0.029999999999999999, 0.69999999999999996, 1.0);
        // device 57, IC IC7, analog/1G/IHPSG13G2/differential_receive_gain.hpp:48
        I(cpphdl_n409, cpphdl_n439) <+ cpphdl_channel(V(cpphdl_n420, cpphdl_n439), V(cpphdl_n409, cpphdl_n439), 0.029999999999999999, 0.69999999999999996, 1.0);
        // device 58, IC IC7, analog/1G/IHPSG13G2/differential_receive_gain.hpp:48
        I(cpphdl_n410, cpphdl_n439) <+ cpphdl_channel(V(cpphdl_n424, cpphdl_n439), V(cpphdl_n410, cpphdl_n439), 0.029999999999999999, 0.69999999999999996, 1.0);
        // device 59, IC IC7, analog/1G/IHPSG13G2/differential_receive_gain.hpp:48
        I(cpphdl_n411, cpphdl_n439) <+ cpphdl_channel(V(cpphdl_n428, cpphdl_n439), V(cpphdl_n411, cpphdl_n439), 0.029999999999999999, 0.69999999999999996, 1.0);
        // device 60, IC IC7, analog/1G/IHPSG13G2/differential_receive_gain.hpp:48
        I(cpphdl_n412, cpphdl_n439) <+ cpphdl_channel(V(cpphdl_n432, cpphdl_n439), V(cpphdl_n412, cpphdl_n439), 0.029999999999999999, 0.69999999999999996, 1.0);
        // device 61, IC IC7, analog/1G/IHPSG13G2/differential_receive_gain.hpp:49
        I(cpphdl_n381, cpphdl_n439) <+ V(cpphdl_n381, cpphdl_n439) / 100000.0;
        // device 62, IC IC7, analog/1G/IHPSG13G2/differential_receive_gain.hpp:50
        I(cpphdl_n439, Vss) <+ 5.0000000000000002e-14 * ddt(V(cpphdl_n439, Vss)); // Bench initial voltage = 0.0 V.
        // device 63, IC IC15, analog/basic/resistor_divider.hpp:15
        I(Vdd, cpphdl_n442) <+ V(Vdd, cpphdl_n442) / 15000.0;
        // device 64, IC IC15, analog/basic/resistor_divider.hpp:16
        I(cpphdl_n442, Vss) <+ V(cpphdl_n442, Vss) / 18000.0;
        // device 65, IC IC16, analog/basic/resistor_divider.hpp:15
        I(Vdd, cpphdl_n443) <+ V(Vdd, cpphdl_n443) / 23000.0;
        // device 66, IC IC16, analog/basic/resistor_divider.hpp:16
        I(cpphdl_n443, Vss) <+ V(cpphdl_n443, Vss) / 43000.0;
        // device 67, IC IC7, analog/1G/IHPSG13G2/differential_receive_gain.hpp:61
        I(cpphdl_n442, Vss) <+ 9.9999999999999994e-12 * ddt(V(cpphdl_n442, Vss)); // Bench initial voltage = 0.0 V.
        // device 68, IC IC7, analog/1G/IHPSG13G2/differential_receive_gain.hpp:62
        I(cpphdl_n443, Vss) <+ 9.9999999999999994e-12 * ddt(V(cpphdl_n443, Vss)); // Bench initial voltage = 0.0 V.
        // device 69, IC IC7, analog/1G/IHPSG13G2/differential_receive_gain.hpp:63
        I(Vdd, cpphdl_n444) <+ V(Vdd, cpphdl_n444) / 2500.0;
        // device 70, IC IC7, analog/1G/IHPSG13G2/differential_receive_gain.hpp:64
        I(cpphdl_n444, Vss) <+ cpphdl_channel(V(cpphdl_n444, Vss), V(cpphdl_n444, Vss), 0.029999999999999999, 0.69999999999999996, 1.0);
        // device 71, IC IC7, analog/1G/IHPSG13G2/differential_receive_gain.hpp:65
        I(cpphdl_n444, Vss) <+ 9.9999999999999994e-12 * ddt(V(cpphdl_n444, Vss)); // Bench initial voltage = 0.0 V.
        // device 72, IC IC7, analog/1G/IHPSG13G2/differential_receive_gain.hpp:67
        I(cpphdl_n2808, cpphdl_n397) <+ V(cpphdl_n2808, cpphdl_n397) / 100.0;
        // device 73, IC IC7, analog/1G/IHPSG13G2/differential_receive_gain.hpp:69
        I(cpphdl_n397, cpphdl_n398) <+ V(cpphdl_n397, cpphdl_n398) / 100.0;
        // device 74, IC IC7, analog/1G/IHPSG13G2/differential_receive_gain.hpp:69
        I(cpphdl_n398, cpphdl_n399) <+ V(cpphdl_n398, cpphdl_n399) / 100.0;
        // device 75, IC IC7, analog/1G/IHPSG13G2/differential_receive_gain.hpp:69
        I(cpphdl_n399, cpphdl_n400) <+ V(cpphdl_n399, cpphdl_n400) / 100.0;
        // device 76, IC IC7, analog/1G/IHPSG13G2/differential_receive_gain.hpp:69
        I(cpphdl_n400, cpphdl_n401) <+ V(cpphdl_n400, cpphdl_n401) / 100.0;
        // device 77, IC IC7, analog/1G/IHPSG13G2/differential_receive_gain.hpp:69
        I(cpphdl_n401, cpphdl_n402) <+ V(cpphdl_n401, cpphdl_n402) / 100.0;
        // device 78, IC IC7, analog/1G/IHPSG13G2/differential_receive_gain.hpp:69
        I(cpphdl_n402, cpphdl_n403) <+ V(cpphdl_n402, cpphdl_n403) / 100.0;
        // device 79, IC IC7, analog/1G/IHPSG13G2/differential_receive_gain.hpp:69
        I(cpphdl_n403, cpphdl_n404) <+ V(cpphdl_n403, cpphdl_n404) / 100.0;
        // device 80, IC IC7, analog/1G/IHPSG13G2/differential_receive_gain.hpp:70
        I(cpphdl_n404, cpphdl_n381) <+ V(cpphdl_n404, cpphdl_n381) / 100.0;
        // device 81, IC IC7, analog/1G/IHPSG13G2/differential_receive_gain.hpp:73
        I(cpphdl_n400, cpphdl_n440) <+ cpphdl_channel(V(cpphdl_n416, cpphdl_n440), V(cpphdl_n400, cpphdl_n440), 0.029999999999999999, 0.69999999999999996, 1.0);
        // device 82, IC IC7, analog/1G/IHPSG13G2/differential_receive_gain.hpp:75
        I(cpphdl_n433, cpphdl_n453) <+ cpphdl_channel(V(SELECT_N0, cpphdl_n453), V(cpphdl_n433, cpphdl_n453), 0.02, 0.69999999999999996, -1.0);
        // device 83, IC IC7, analog/1G/IHPSG13G2/differential_receive_gain.hpp:76
        I(cpphdl_n433, Vss) <+ 9.9999999999999998e-13 * ddt(V(cpphdl_n433, Vss)); // Bench initial voltage = 0.0 V.
        // device 84, IC IC7, analog/1G/IHPSG13G2/differential_receive_gain.hpp:73
        I(cpphdl_n401, cpphdl_n440) <+ cpphdl_channel(V(cpphdl_n420, cpphdl_n440), V(cpphdl_n401, cpphdl_n440), 0.029999999999999999, 0.69999999999999996, 1.0);
        // device 85, IC IC7, analog/1G/IHPSG13G2/differential_receive_gain.hpp:75
        I(cpphdl_n434, cpphdl_n453) <+ cpphdl_channel(V(SELECT_N1, cpphdl_n453), V(cpphdl_n434, cpphdl_n453), 0.02, 0.69999999999999996, -1.0);
        // device 86, IC IC7, analog/1G/IHPSG13G2/differential_receive_gain.hpp:76
        I(cpphdl_n434, Vss) <+ 7.5000000000000004e-13 * ddt(V(cpphdl_n434, Vss)); // Bench initial voltage = 0.0 V.
        // device 87, IC IC7, analog/1G/IHPSG13G2/differential_receive_gain.hpp:73
        I(cpphdl_n402, cpphdl_n440) <+ cpphdl_channel(V(cpphdl_n424, cpphdl_n440), V(cpphdl_n402, cpphdl_n440), 0.029999999999999999, 0.69999999999999996, 1.0);
        // device 88, IC IC7, analog/1G/IHPSG13G2/differential_receive_gain.hpp:75
        I(cpphdl_n435, cpphdl_n453) <+ cpphdl_channel(V(SELECT_N2, cpphdl_n453), V(cpphdl_n435, cpphdl_n453), 0.02, 0.69999999999999996, -1.0);
        // device 89, IC IC7, analog/1G/IHPSG13G2/differential_receive_gain.hpp:76
        I(cpphdl_n435, Vss) <+ 4.9999999999999999e-13 * ddt(V(cpphdl_n435, Vss)); // Bench initial voltage = 0.0 V.
        // device 90, IC IC7, analog/1G/IHPSG13G2/differential_receive_gain.hpp:73
        I(cpphdl_n403, cpphdl_n440) <+ cpphdl_channel(V(cpphdl_n428, cpphdl_n440), V(cpphdl_n403, cpphdl_n440), 0.029999999999999999, 0.69999999999999996, 1.0);
        // device 91, IC IC7, analog/1G/IHPSG13G2/differential_receive_gain.hpp:75
        I(cpphdl_n436, cpphdl_n453) <+ cpphdl_channel(V(SELECT_N3, cpphdl_n453), V(cpphdl_n436, cpphdl_n453), 0.02, 0.69999999999999996, -1.0);
        // device 92, IC IC7, analog/1G/IHPSG13G2/differential_receive_gain.hpp:76
        I(cpphdl_n436, Vss) <+ 2.4999999999999999e-13 * ddt(V(cpphdl_n436, Vss)); // Bench initial voltage = 0.0 V.
        // device 93, IC IC7, analog/1G/IHPSG13G2/differential_receive_gain.hpp:73
        I(cpphdl_n404, cpphdl_n440) <+ cpphdl_channel(V(cpphdl_n432, cpphdl_n440), V(cpphdl_n404, cpphdl_n440), 0.029999999999999999, 0.69999999999999996, 1.0);
        // device 94, IC IC13, analog/basic/cascode_ota.hpp:29
        I(cpphdl_n445, cpphdl_n450) <+ cpphdl_channel(V(cpphdl_n439, cpphdl_n450), V(cpphdl_n445, cpphdl_n450), 0.029999999999999999, 0.69999999999999996, 1.0);
        // device 95, IC IC13, analog/basic/cascode_ota.hpp:30
        I(cpphdl_n446, cpphdl_n450) <+ cpphdl_channel(V(cpphdl_n440, cpphdl_n450), V(cpphdl_n446, cpphdl_n450), 0.029999999999999999, 0.69999999999999996, 1.0);
        // device 96, IC IC13, analog/basic/cascode_ota.hpp:31
        I(cpphdl_n447, cpphdl_n445) <+ cpphdl_channel(V(cpphdl_n442, cpphdl_n445), V(cpphdl_n447, cpphdl_n445), 0.059999999999999998, 0.69999999999999996, 1.0);
        // device 97, IC IC13, analog/basic/cascode_ota.hpp:32
        I(cpphdl_n453, cpphdl_n446) <+ cpphdl_channel(V(cpphdl_n442, cpphdl_n446), V(cpphdl_n453, cpphdl_n446), 0.059999999999999998, 0.69999999999999996, 1.0);
        // device 98, IC IC13, analog/basic/cascode_ota.hpp:33
        I(cpphdl_n448, Vdd) <+ cpphdl_channel(V(cpphdl_n447, Vdd), V(cpphdl_n448, Vdd), 0.029999999999999999, 0.69999999999999996, -1.0);
        // device 99, IC IC13, analog/basic/cascode_ota.hpp:34
        I(cpphdl_n449, Vdd) <+ cpphdl_channel(V(cpphdl_n447, Vdd), V(cpphdl_n449, Vdd), 0.029999999999999999, 0.69999999999999996, -1.0);
        // device 100, IC IC13, analog/basic/cascode_ota.hpp:35
        I(cpphdl_n447, cpphdl_n448) <+ cpphdl_channel(V(cpphdl_n443, cpphdl_n448), V(cpphdl_n447, cpphdl_n448), 0.059999999999999998, 0.69999999999999996, -1.0);
        // device 101, IC IC13, analog/basic/cascode_ota.hpp:36
        I(cpphdl_n453, cpphdl_n449) <+ cpphdl_channel(V(cpphdl_n443, cpphdl_n449), V(cpphdl_n453, cpphdl_n449), 0.059999999999999998, 0.69999999999999996, -1.0);
        // device 102, IC IC13, analog/basic/cascode_ota.hpp:37
        I(cpphdl_n450, Vss) <+ cpphdl_channel(V(cpphdl_n444, Vss), V(cpphdl_n450, Vss), 0.059999999999999998, 0.69999999999999996, 1.0);
        // device 103, IC IC13, analog/basic/cascode_ota.hpp:38
        I(cpphdl_n453, Vss) <+ 2.4999999999999999e-13 * ddt(V(cpphdl_n453, Vss)); // Bench initial voltage = 0.0 V.
        // device 104, IC IC13, analog/basic/cascode_ota.hpp:39
        I(cpphdl_n445, Vss) <+ 4e-14 * ddt(V(cpphdl_n445, Vss)); // Bench initial voltage = 0.0 V.
        // device 105, IC IC13, analog/basic/cascode_ota.hpp:40
        I(cpphdl_n446, Vss) <+ 4e-14 * ddt(V(cpphdl_n446, Vss)); // Bench initial voltage = 0.0 V.
        // device 106, IC IC13, analog/basic/cascode_ota.hpp:41
        I(cpphdl_n450, Vss) <+ 4e-14 * ddt(V(cpphdl_n450, Vss)); // Bench initial voltage = 0.0 V.
        // device 107, IC IC13, analog/basic/cascode_ota.hpp:42
        I(cpphdl_n448, Vdd) <+ 4e-14 * ddt(V(cpphdl_n448, Vdd)); // Bench initial voltage = 0.0 V.
        // device 108, IC IC13, analog/basic/cascode_ota.hpp:43
        I(cpphdl_n449, Vdd) <+ 4e-14 * ddt(V(cpphdl_n449, Vdd)); // Bench initial voltage = 0.0 V.
        // device 109, IC IC13, analog/basic/cascode_ota.hpp:44
        I(cpphdl_n447, Vss) <+ 4e-14 * ddt(V(cpphdl_n447, Vss)); // Bench initial voltage = 0.0 V.
        // device 110, IC IC13, analog/basic/cascode_ota.hpp:45
        I(cpphdl_n439, cpphdl_n450) <+ 4e-14 * ddt(V(cpphdl_n439, cpphdl_n450)); // Bench initial voltage = 0.0 V.
        // device 111, IC IC13, analog/basic/cascode_ota.hpp:46
        I(cpphdl_n440, cpphdl_n450) <+ 4e-14 * ddt(V(cpphdl_n440, cpphdl_n450)); // Bench initial voltage = 0.0 V.
        // device 112, IC IC13, analog/basic/cascode_ota.hpp:47
        I(cpphdl_n439, cpphdl_n445) <+ 1e-14 * ddt(V(cpphdl_n439, cpphdl_n445)); // Bench initial voltage = 0.0 V.
        // device 113, IC IC13, analog/basic/cascode_ota.hpp:48
        I(cpphdl_n440, cpphdl_n446) <+ 1e-14 * ddt(V(cpphdl_n440, cpphdl_n446)); // Bench initial voltage = 0.0 V.
        // device 114, IC IC14, analog/basic/nmos_source_follower.hpp:19
        I(Vdd, cpphdl_n2808) <+ cpphdl_channel(V(cpphdl_n453, cpphdl_n2808), V(Vdd, cpphdl_n2808), 0.20000000000000001, 0.69999999999999996, 1.0);
        // device 115, IC IC14, analog/basic/nmos_source_follower.hpp:20
        I(Vss, cpphdl_n2808) <+ V(Vss, cpphdl_n2808) / 500.0;
        // device 116, IC IC14, analog/basic/nmos_source_follower.hpp:23
        I(cpphdl_n453, cpphdl_n2808) <+ 8e-14 * ddt(V(cpphdl_n453, cpphdl_n2808)); // Bench initial voltage = 0.0 V.
        // device 117, IC IC14, analog/basic/nmos_source_follower.hpp:24
        I(cpphdl_n453, Vdd) <+ 2e-14 * ddt(V(cpphdl_n453, Vdd)); // Bench initial voltage = 0.0 V.
        // device 118, IC IC14, analog/basic/nmos_source_follower.hpp:25
        I(cpphdl_n2808, Vss) <+ 8e-14 * ddt(V(cpphdl_n2808, Vss)); // Bench initial voltage = 0.0 V.
        // device 119, IC IC3, analog/1G/IHPSG13G2/differential_receive_frontend.hpp:60
        I(cpphdl_n2808, Vss) <+ 3.0000000000000001e-12 * ddt(V(cpphdl_n2808, Vss)); // Bench initial voltage = 0.0 V.
        // device 120, IC IC20, analog/basic/inverter.hpp:11
        I(cpphdl_n669, Vdd) <+ cpphdl_channel(V(TRACK0, Vdd), V(cpphdl_n669, Vdd), 0.0040000000000000001, 0.69999999999999996, -1.0);
        // device 121, IC IC20, analog/basic/inverter.hpp:12
        I(cpphdl_n669, Vss) <+ cpphdl_channel(V(TRACK0, Vss), V(cpphdl_n669, Vss), 0.0040000000000000001, 0.69999999999999996, 1.0);
        // device 122, IC IC19, analog/basic/mos_track_hold.hpp:31
        I(cpphdl_n669, Vss) <+ 2e-14 * ddt(V(cpphdl_n669, Vss)); // Bench initial voltage = 0.0 V.
        // device 123, IC IC19, analog/basic/mos_track_hold.hpp:32
        I(cpphdl_n2808, cpphdl_n723) <+ cpphdl_channel(V(TRACK0, cpphdl_n723), V(cpphdl_n2808, cpphdl_n723), 0.029999999999999999, 0.69999999999999996, 1.0);
        // device 124, IC IC19, analog/basic/mos_track_hold.hpp:33
        I(cpphdl_n723, cpphdl_n2808) <+ cpphdl_channel(V(cpphdl_n669, cpphdl_n2808), V(cpphdl_n723, cpphdl_n2808), 0.014999999999999999, 0.69999999999999996, -1.0);
        // device 125, IC IC19, analog/basic/mos_track_hold.hpp:37
        I(cpphdl_n723, cpphdl_n723) <+ cpphdl_channel(V(cpphdl_n669, cpphdl_n723), V(cpphdl_n723, cpphdl_n723), 0.016, 0.69999999999999996, 1.0);
        // device 126, IC IC19, analog/basic/mos_track_hold.hpp:38
        I(cpphdl_n723, cpphdl_n723) <+ cpphdl_channel(V(TRACK0, cpphdl_n723), V(cpphdl_n723, cpphdl_n723), 0.0083999999999999995, 0.69999999999999996, -1.0);
        // device 127, IC IC19, analog/basic/mos_track_hold.hpp:39
        I(cpphdl_n723, Vss) <+ 1.5000000000000001e-12 * ddt(V(cpphdl_n723, Vss)); // Bench initial voltage = 0.0 V.
        // device 128, IC IC19, analog/basic/mos_track_hold.hpp:42
        I(TRACK0, cpphdl_n723) <+ 2.0000000000000002e-15 * ddt(V(TRACK0, cpphdl_n723)); // Bench initial voltage = -0.0 V.
        // device 129, IC IC19, analog/basic/mos_track_hold.hpp:43
        I(cpphdl_n669, cpphdl_n723) <+ 2.0000000000000002e-15 * ddt(V(cpphdl_n669, cpphdl_n723)); // Bench initial voltage = 0.0 V.
        // device 130, IC IC19, analog/basic/mos_track_hold.hpp:44
        I(cpphdl_n2808, cpphdl_n723) <+ 1.0000000000000001e-15 * ddt(V(cpphdl_n2808, cpphdl_n723)); // Bench initial voltage = 0.0 V.
        // device 131, IC IC22, analog/basic/inverter.hpp:11
        I(cpphdl_n684, Vdd) <+ cpphdl_channel(V(BIT_N0_0, Vdd), V(cpphdl_n684, Vdd), 0.080000000000000002, 0.69999999999999996, -1.0);
        // device 132, IC IC22, analog/basic/inverter.hpp:12
        I(cpphdl_n684, Vss) <+ cpphdl_channel(V(BIT_N0_0, Vss), V(cpphdl_n684, Vss), 0.080000000000000002, 0.69999999999999996, 1.0);
        // device 133, IC IC21, analog/basic/mos_r2r_dac.hpp:27
        I(cpphdl_n684, Vss) <+ 2.9999999999999998e-15 * ddt(V(cpphdl_n684, Vss)); // Bench initial voltage = 0.0 V.
        // device 134, IC IC21, analog/basic/mos_r2r_dac.hpp:28
        I(cpphdl_n684, cpphdl_n713) <+ V(cpphdl_n684, cpphdl_n713) / 2000.0;
        // device 135, IC IC21, analog/basic/mos_r2r_dac.hpp:29
        I(cpphdl_n713, Vss) <+ 2.9999999999999998e-15 * ddt(V(cpphdl_n713, Vss)); // Bench initial voltage = 0.0 V.
        // device 136, IC IC23, analog/basic/inverter.hpp:11
        I(cpphdl_n688, Vdd) <+ cpphdl_channel(V(BIT_N0_1, Vdd), V(cpphdl_n688, Vdd), 0.080000000000000002, 0.69999999999999996, -1.0);
        // device 137, IC IC23, analog/basic/inverter.hpp:12
        I(cpphdl_n688, Vss) <+ cpphdl_channel(V(BIT_N0_1, Vss), V(cpphdl_n688, Vss), 0.080000000000000002, 0.69999999999999996, 1.0);
        // device 138, IC IC21, analog/basic/mos_r2r_dac.hpp:27
        I(cpphdl_n688, Vss) <+ 2.9999999999999998e-15 * ddt(V(cpphdl_n688, Vss)); // Bench initial voltage = 0.0 V.
        // device 139, IC IC21, analog/basic/mos_r2r_dac.hpp:28
        I(cpphdl_n688, cpphdl_n714) <+ V(cpphdl_n688, cpphdl_n714) / 2000.0;
        // device 140, IC IC21, analog/basic/mos_r2r_dac.hpp:29
        I(cpphdl_n714, Vss) <+ 2.9999999999999998e-15 * ddt(V(cpphdl_n714, Vss)); // Bench initial voltage = 0.0 V.
        // device 141, IC IC21, analog/basic/mos_r2r_dac.hpp:31
        I(cpphdl_n713, cpphdl_n714) <+ V(cpphdl_n713, cpphdl_n714) / 1000.0;
        // device 142, IC IC24, analog/basic/inverter.hpp:11
        I(cpphdl_n692, Vdd) <+ cpphdl_channel(V(BIT_N0_2, Vdd), V(cpphdl_n692, Vdd), 0.080000000000000002, 0.69999999999999996, -1.0);
        // device 143, IC IC24, analog/basic/inverter.hpp:12
        I(cpphdl_n692, Vss) <+ cpphdl_channel(V(BIT_N0_2, Vss), V(cpphdl_n692, Vss), 0.080000000000000002, 0.69999999999999996, 1.0);
        // device 144, IC IC21, analog/basic/mos_r2r_dac.hpp:27
        I(cpphdl_n692, Vss) <+ 2.9999999999999998e-15 * ddt(V(cpphdl_n692, Vss)); // Bench initial voltage = 0.0 V.
        // device 145, IC IC21, analog/basic/mos_r2r_dac.hpp:28
        I(cpphdl_n692, cpphdl_n715) <+ V(cpphdl_n692, cpphdl_n715) / 2000.0;
        // device 146, IC IC21, analog/basic/mos_r2r_dac.hpp:29
        I(cpphdl_n715, Vss) <+ 2.9999999999999998e-15 * ddt(V(cpphdl_n715, Vss)); // Bench initial voltage = 0.0 V.
        // device 147, IC IC21, analog/basic/mos_r2r_dac.hpp:31
        I(cpphdl_n714, cpphdl_n715) <+ V(cpphdl_n714, cpphdl_n715) / 1000.0;
        // device 148, IC IC25, analog/basic/inverter.hpp:11
        I(cpphdl_n696, Vdd) <+ cpphdl_channel(V(BIT_N0_3, Vdd), V(cpphdl_n696, Vdd), 0.080000000000000002, 0.69999999999999996, -1.0);
        // device 149, IC IC25, analog/basic/inverter.hpp:12
        I(cpphdl_n696, Vss) <+ cpphdl_channel(V(BIT_N0_3, Vss), V(cpphdl_n696, Vss), 0.080000000000000002, 0.69999999999999996, 1.0);
        // device 150, IC IC21, analog/basic/mos_r2r_dac.hpp:27
        I(cpphdl_n696, Vss) <+ 2.9999999999999998e-15 * ddt(V(cpphdl_n696, Vss)); // Bench initial voltage = 0.0 V.
        // device 151, IC IC21, analog/basic/mos_r2r_dac.hpp:28
        I(cpphdl_n696, cpphdl_n716) <+ V(cpphdl_n696, cpphdl_n716) / 2000.0;
        // device 152, IC IC21, analog/basic/mos_r2r_dac.hpp:29
        I(cpphdl_n716, Vss) <+ 2.9999999999999998e-15 * ddt(V(cpphdl_n716, Vss)); // Bench initial voltage = 0.0 V.
        // device 153, IC IC21, analog/basic/mos_r2r_dac.hpp:31
        I(cpphdl_n715, cpphdl_n716) <+ V(cpphdl_n715, cpphdl_n716) / 1000.0;
        // device 154, IC IC26, analog/basic/inverter.hpp:11
        I(cpphdl_n700, Vdd) <+ cpphdl_channel(V(BIT_N0_4, Vdd), V(cpphdl_n700, Vdd), 0.080000000000000002, 0.69999999999999996, -1.0);
        // device 155, IC IC26, analog/basic/inverter.hpp:12
        I(cpphdl_n700, Vss) <+ cpphdl_channel(V(BIT_N0_4, Vss), V(cpphdl_n700, Vss), 0.080000000000000002, 0.69999999999999996, 1.0);
        // device 156, IC IC21, analog/basic/mos_r2r_dac.hpp:27
        I(cpphdl_n700, Vss) <+ 2.9999999999999998e-15 * ddt(V(cpphdl_n700, Vss)); // Bench initial voltage = 0.0 V.
        // device 157, IC IC21, analog/basic/mos_r2r_dac.hpp:28
        I(cpphdl_n700, cpphdl_n717) <+ V(cpphdl_n700, cpphdl_n717) / 2000.0;
        // device 158, IC IC21, analog/basic/mos_r2r_dac.hpp:29
        I(cpphdl_n717, Vss) <+ 2.9999999999999998e-15 * ddt(V(cpphdl_n717, Vss)); // Bench initial voltage = 0.0 V.
        // device 159, IC IC21, analog/basic/mos_r2r_dac.hpp:31
        I(cpphdl_n716, cpphdl_n717) <+ V(cpphdl_n716, cpphdl_n717) / 1000.0;
        // device 160, IC IC27, analog/basic/inverter.hpp:11
        I(cpphdl_n704, Vdd) <+ cpphdl_channel(V(BIT_N0_5, Vdd), V(cpphdl_n704, Vdd), 0.080000000000000002, 0.69999999999999996, -1.0);
        // device 161, IC IC27, analog/basic/inverter.hpp:12
        I(cpphdl_n704, Vss) <+ cpphdl_channel(V(BIT_N0_5, Vss), V(cpphdl_n704, Vss), 0.080000000000000002, 0.69999999999999996, 1.0);
        // device 162, IC IC21, analog/basic/mos_r2r_dac.hpp:27
        I(cpphdl_n704, Vss) <+ 2.9999999999999998e-15 * ddt(V(cpphdl_n704, Vss)); // Bench initial voltage = 0.0 V.
        // device 163, IC IC21, analog/basic/mos_r2r_dac.hpp:28
        I(cpphdl_n704, cpphdl_n718) <+ V(cpphdl_n704, cpphdl_n718) / 2000.0;
        // device 164, IC IC21, analog/basic/mos_r2r_dac.hpp:29
        I(cpphdl_n718, Vss) <+ 2.9999999999999998e-15 * ddt(V(cpphdl_n718, Vss)); // Bench initial voltage = 0.0 V.
        // device 165, IC IC21, analog/basic/mos_r2r_dac.hpp:31
        I(cpphdl_n717, cpphdl_n718) <+ V(cpphdl_n717, cpphdl_n718) / 1000.0;
        // device 166, IC IC28, analog/basic/inverter.hpp:11
        I(cpphdl_n708, Vdd) <+ cpphdl_channel(V(BIT_N0_6, Vdd), V(cpphdl_n708, Vdd), 0.080000000000000002, 0.69999999999999996, -1.0);
        // device 167, IC IC28, analog/basic/inverter.hpp:12
        I(cpphdl_n708, Vss) <+ cpphdl_channel(V(BIT_N0_6, Vss), V(cpphdl_n708, Vss), 0.080000000000000002, 0.69999999999999996, 1.0);
        // device 168, IC IC21, analog/basic/mos_r2r_dac.hpp:27
        I(cpphdl_n708, Vss) <+ 2.9999999999999998e-15 * ddt(V(cpphdl_n708, Vss)); // Bench initial voltage = 0.0 V.
        // device 169, IC IC21, analog/basic/mos_r2r_dac.hpp:28
        I(cpphdl_n708, cpphdl_n719) <+ V(cpphdl_n708, cpphdl_n719) / 2000.0;
        // device 170, IC IC21, analog/basic/mos_r2r_dac.hpp:29
        I(cpphdl_n719, Vss) <+ 2.9999999999999998e-15 * ddt(V(cpphdl_n719, Vss)); // Bench initial voltage = 0.0 V.
        // device 171, IC IC21, analog/basic/mos_r2r_dac.hpp:31
        I(cpphdl_n718, cpphdl_n719) <+ V(cpphdl_n718, cpphdl_n719) / 1000.0;
        // device 172, IC IC29, analog/basic/inverter.hpp:11
        I(cpphdl_n712, Vdd) <+ cpphdl_channel(V(BIT_N0_7, Vdd), V(cpphdl_n712, Vdd), 0.080000000000000002, 0.69999999999999996, -1.0);
        // device 173, IC IC29, analog/basic/inverter.hpp:12
        I(cpphdl_n712, Vss) <+ cpphdl_channel(V(BIT_N0_7, Vss), V(cpphdl_n712, Vss), 0.080000000000000002, 0.69999999999999996, 1.0);
        // device 174, IC IC21, analog/basic/mos_r2r_dac.hpp:27
        I(cpphdl_n712, Vss) <+ 2.9999999999999998e-15 * ddt(V(cpphdl_n712, Vss)); // Bench initial voltage = 0.0 V.
        // device 175, IC IC21, analog/basic/mos_r2r_dac.hpp:28
        I(cpphdl_n712, cpphdl_n724) <+ V(cpphdl_n712, cpphdl_n724) / 2000.0;
        // device 176, IC IC21, analog/basic/mos_r2r_dac.hpp:29
        I(cpphdl_n724, Vss) <+ 2.9999999999999998e-15 * ddt(V(cpphdl_n724, Vss)); // Bench initial voltage = 0.0 V.
        // device 177, IC IC21, analog/basic/mos_r2r_dac.hpp:31
        I(cpphdl_n719, cpphdl_n724) <+ V(cpphdl_n719, cpphdl_n724) / 1000.0;
        // device 178, IC IC21, analog/basic/mos_r2r_dac.hpp:33
        I(Vss, cpphdl_n713) <+ V(Vss, cpphdl_n713) / 2000.0;
        // device 179, IC IC30, analog/basic/nmos_resistor_amplifier.hpp:23
        I(Vdd, cpphdl_n733) <+ V(Vdd, cpphdl_n733) / 1000.0;
        // device 180, IC IC30, analog/basic/nmos_resistor_amplifier.hpp:24
        I(Vdd, cpphdl_n732) <+ V(Vdd, cpphdl_n732) / 1000.0;
        // device 181, IC IC30, analog/basic/nmos_resistor_amplifier.hpp:25
        I(cpphdl_n733, cpphdl_n727) <+ cpphdl_channel(V(cpphdl_n723, cpphdl_n727), V(cpphdl_n733, cpphdl_n727), 0.0074999999999999997, 0.69999999999999996, 1.0);
        // device 182, IC IC30, analog/basic/nmos_resistor_amplifier.hpp:26
        I(cpphdl_n732, cpphdl_n728) <+ cpphdl_channel(V(cpphdl_n724, cpphdl_n728), V(cpphdl_n732, cpphdl_n728), 0.0074999999999999997, 0.69999999999999996, 1.0);
        // device 183, IC IC30, analog/basic/nmos_resistor_amplifier.hpp:27
        I(cpphdl_n729, cpphdl_n727) <+ V(cpphdl_n729, cpphdl_n727) / 100.0;
        // device 184, IC IC30, analog/basic/nmos_resistor_amplifier.hpp:28
        I(cpphdl_n729, cpphdl_n728) <+ V(cpphdl_n729, cpphdl_n728) / 100.0;
        // device 185, IC IC30, analog/basic/nmos_resistor_amplifier.hpp:29
        I(Vss, cpphdl_n729) <+ V(Vss, cpphdl_n729) / 300.0;
        // device 186, IC IC30, analog/basic/nmos_resistor_amplifier.hpp:30
        I(cpphdl_n733, Vdd) <+ 2.9999999999999998e-13 * ddt(V(cpphdl_n733, Vdd)); // Bench initial voltage = 0.0 V.
        // device 187, IC IC30, analog/basic/nmos_resistor_amplifier.hpp:31
        I(cpphdl_n732, Vdd) <+ 2.9999999999999998e-13 * ddt(V(cpphdl_n732, Vdd)); // Bench initial voltage = 0.0 V.
        // device 188, IC IC30, analog/basic/nmos_resistor_amplifier.hpp:32
        I(cpphdl_n729, Vss) <+ 4e-14 * ddt(V(cpphdl_n729, Vss)); // Bench initial voltage = 0.0 V.
        // device 189, IC IC30, analog/basic/nmos_resistor_amplifier.hpp:34
        I(cpphdl_n723, cpphdl_n727) <+ 2e-14 * ddt(V(cpphdl_n723, cpphdl_n727)); // Bench initial voltage = 0.0 V.
        // device 190, IC IC30, analog/basic/nmos_resistor_amplifier.hpp:35
        I(cpphdl_n724, cpphdl_n728) <+ 2e-14 * ddt(V(cpphdl_n724, cpphdl_n728)); // Bench initial voltage = 0.0 V.
        // device 191, IC IC30, analog/basic/nmos_resistor_amplifier.hpp:36
        I(cpphdl_n723, cpphdl_n733) <+ 2.9999999999999998e-15 * ddt(V(cpphdl_n723, cpphdl_n733)); // Bench initial voltage = 0.0 V.
        // device 192, IC IC30, analog/basic/nmos_resistor_amplifier.hpp:37
        I(cpphdl_n724, cpphdl_n732) <+ 2.9999999999999998e-15 * ddt(V(cpphdl_n724, cpphdl_n732)); // Bench initial voltage = 0.0 V.
        // device 193, IC IC31, analog/basic/strongarm_comparator.hpp:28
        I(cpphdl_n737, cpphdl_n739) <+ cpphdl_channel(V(cpphdl_n732, cpphdl_n739), V(cpphdl_n737, cpphdl_n739), 0.0080000000000000002, 0.69999999999999996, 1.0);
        // device 194, IC IC31, analog/basic/strongarm_comparator.hpp:29
        I(cpphdl_n738, cpphdl_n739) <+ cpphdl_channel(V(cpphdl_n733, cpphdl_n739), V(cpphdl_n738, cpphdl_n739), 0.0080000000000000002, 0.69999999999999996, 1.0);
        // device 195, IC IC31, analog/basic/strongarm_comparator.hpp:30
        I(cpphdl_n739, Vss) <+ cpphdl_channel(V(EVALUATE, Vss), V(cpphdl_n739, Vss), 0.0080000000000000002, 0.69999999999999996, 1.0);
        // device 196, IC IC31, analog/basic/strongarm_comparator.hpp:33
        I(cpphdl_n752, cpphdl_n737) <+ cpphdl_channel(V(cpphdl_n756, cpphdl_n737), V(cpphdl_n752, cpphdl_n737), 0.0040000000000000001, 0.69999999999999996, 1.0);
        // device 197, IC IC31, analog/basic/strongarm_comparator.hpp:34
        I(cpphdl_n756, cpphdl_n738) <+ cpphdl_channel(V(cpphdl_n752, cpphdl_n738), V(cpphdl_n756, cpphdl_n738), 0.0040000000000000001, 0.69999999999999996, 1.0);
        // device 198, IC IC31, analog/basic/strongarm_comparator.hpp:35
        I(cpphdl_n756, Vdd) <+ cpphdl_channel(V(cpphdl_n752, Vdd), V(cpphdl_n756, Vdd), 0.002, 0.69999999999999996, -1.0);
        // device 199, IC IC31, analog/basic/strongarm_comparator.hpp:36
        I(cpphdl_n752, Vdd) <+ cpphdl_channel(V(cpphdl_n756, Vdd), V(cpphdl_n752, Vdd), 0.002, 0.69999999999999996, -1.0);
        // device 200, IC IC31, analog/basic/strongarm_comparator.hpp:38
        I(cpphdl_n737, Vdd) <+ cpphdl_channel(V(EVALUATE, Vdd), V(cpphdl_n737, Vdd), 0.002, 0.69999999999999996, -1.0);
        // device 201, IC IC31, analog/basic/strongarm_comparator.hpp:39
        I(cpphdl_n738, Vdd) <+ cpphdl_channel(V(EVALUATE, Vdd), V(cpphdl_n738, Vdd), 0.002, 0.69999999999999996, -1.0);
        // device 202, IC IC31, analog/basic/strongarm_comparator.hpp:40
        I(cpphdl_n756, Vdd) <+ cpphdl_channel(V(EVALUATE, Vdd), V(cpphdl_n756, Vdd), 0.002, 0.69999999999999996, -1.0);
        // device 203, IC IC31, analog/basic/strongarm_comparator.hpp:41
        I(cpphdl_n752, Vdd) <+ cpphdl_channel(V(EVALUATE, Vdd), V(cpphdl_n752, Vdd), 0.002, 0.69999999999999996, -1.0);
        // device 204, IC IC31, analog/basic/strongarm_comparator.hpp:42
        I(cpphdl_n737, Vss) <+ 2.9999999999999998e-14 * ddt(V(cpphdl_n737, Vss)); // Bench initial voltage = 0.0 V.
        // device 205, IC IC31, analog/basic/strongarm_comparator.hpp:43
        I(cpphdl_n738, Vss) <+ 2.9999999999999998e-14 * ddt(V(cpphdl_n738, Vss)); // Bench initial voltage = 0.0 V.
        // device 206, IC IC31, analog/basic/strongarm_comparator.hpp:44
        I(cpphdl_n739, Vss) <+ 2.9999999999999998e-14 * ddt(V(cpphdl_n739, Vss)); // Bench initial voltage = 0.0 V.
        // device 207, IC IC31, analog/basic/strongarm_comparator.hpp:45
        I(cpphdl_n756, Vss) <+ 5.0000000000000002e-14 * ddt(V(cpphdl_n756, Vss)); // Bench initial voltage = 0.0 V.
        // device 208, IC IC31, analog/basic/strongarm_comparator.hpp:46
        I(cpphdl_n752, Vss) <+ 5.0000000000000002e-14 * ddt(V(cpphdl_n752, Vss)); // Bench initial voltage = 0.0 V.
        // device 209, IC IC31, analog/basic/strongarm_comparator.hpp:47
        I(cpphdl_n732, cpphdl_n739) <+ 2e-14 * ddt(V(cpphdl_n732, cpphdl_n739)); // Bench initial voltage = 0.0 V.
        // device 210, IC IC31, analog/basic/strongarm_comparator.hpp:48
        I(cpphdl_n733, cpphdl_n739) <+ 2e-14 * ddt(V(cpphdl_n733, cpphdl_n739)); // Bench initial voltage = 0.0 V.
        // device 211, IC IC31, analog/basic/strongarm_comparator.hpp:49
        I(cpphdl_n732, cpphdl_n737) <+ 2.9999999999999998e-15 * ddt(V(cpphdl_n732, cpphdl_n737)); // Bench initial voltage = 0.0 V.
        // device 212, IC IC31, analog/basic/strongarm_comparator.hpp:50
        I(cpphdl_n733, cpphdl_n738) <+ 2.9999999999999998e-15 * ddt(V(cpphdl_n733, cpphdl_n738)); // Bench initial voltage = 0.0 V.
        // device 213, IC IC33, analog/basic/inverter.hpp:11
        I(cpphdl_n760, Vdd) <+ cpphdl_channel(V(cpphdl_n752, Vdd), V(cpphdl_n760, Vdd), 0.001, 0.69999999999999996, -1.0);
        // device 214, IC IC33, analog/basic/inverter.hpp:12
        I(cpphdl_n760, Vss) <+ cpphdl_channel(V(cpphdl_n752, Vss), V(cpphdl_n760, Vss), 0.001, 0.69999999999999996, 1.0);
        // device 215, IC IC35, analog/basic/inverter.hpp:11
        I(cpphdl_n774, Vdd) <+ cpphdl_channel(V(cpphdl_n760, Vdd), V(cpphdl_n774, Vdd), 0.0040000000000000001, 0.69999999999999996, -1.0);
        // device 216, IC IC35, analog/basic/inverter.hpp:12
        I(cpphdl_n774, Vss) <+ cpphdl_channel(V(cpphdl_n760, Vss), V(cpphdl_n774, Vss), 0.0040000000000000001, 0.69999999999999996, 1.0);
        // device 217, IC IC32, analog/basic/buffered_nand_latch.hpp:34
        I(cpphdl_n752, Vss) <+ 2.0000000000000002e-15 * ddt(V(cpphdl_n752, Vss)); // Bench initial voltage = 0.0 V.
        // device 218, IC IC32, analog/basic/buffered_nand_latch.hpp:35
        I(cpphdl_n752, cpphdl_n760) <+ 1.0000000000000001e-15 * ddt(V(cpphdl_n752, cpphdl_n760)); // Bench initial voltage = 0.0 V.
        // device 219, IC IC32, analog/basic/buffered_nand_latch.hpp:36
        I(cpphdl_n760, Vss) <+ 5e-15 * ddt(V(cpphdl_n760, Vss)); // Bench initial voltage = 0.0 V.
        // device 220, IC IC32, analog/basic/buffered_nand_latch.hpp:37
        I(cpphdl_n760, Vss) <+ 8.0000000000000006e-15 * ddt(V(cpphdl_n760, Vss)); // Bench initial voltage = 0.0 V.
        // device 221, IC IC32, analog/basic/buffered_nand_latch.hpp:38
        I(cpphdl_n774, Vss) <+ 1e-14 * ddt(V(cpphdl_n774, Vss)); // Bench initial voltage = 0.0 V.
        // device 222, IC IC34, analog/basic/inverter.hpp:11
        I(cpphdl_n764, Vdd) <+ cpphdl_channel(V(cpphdl_n756, Vdd), V(cpphdl_n764, Vdd), 0.001, 0.69999999999999996, -1.0);
        // device 223, IC IC34, analog/basic/inverter.hpp:12
        I(cpphdl_n764, Vss) <+ cpphdl_channel(V(cpphdl_n756, Vss), V(cpphdl_n764, Vss), 0.001, 0.69999999999999996, 1.0);
        // device 224, IC IC36, analog/basic/inverter.hpp:11
        I(cpphdl_n780, Vdd) <+ cpphdl_channel(V(cpphdl_n764, Vdd), V(cpphdl_n780, Vdd), 0.0040000000000000001, 0.69999999999999996, -1.0);
        // device 225, IC IC36, analog/basic/inverter.hpp:12
        I(cpphdl_n780, Vss) <+ cpphdl_channel(V(cpphdl_n764, Vss), V(cpphdl_n780, Vss), 0.0040000000000000001, 0.69999999999999996, 1.0);
        // device 226, IC IC32, analog/basic/buffered_nand_latch.hpp:34
        I(cpphdl_n756, Vss) <+ 2.0000000000000002e-15 * ddt(V(cpphdl_n756, Vss)); // Bench initial voltage = 0.0 V.
        // device 227, IC IC32, analog/basic/buffered_nand_latch.hpp:35
        I(cpphdl_n756, cpphdl_n764) <+ 1.0000000000000001e-15 * ddt(V(cpphdl_n756, cpphdl_n764)); // Bench initial voltage = 0.0 V.
        // device 228, IC IC32, analog/basic/buffered_nand_latch.hpp:36
        I(cpphdl_n764, Vss) <+ 5e-15 * ddt(V(cpphdl_n764, Vss)); // Bench initial voltage = 0.0 V.
        // device 229, IC IC32, analog/basic/buffered_nand_latch.hpp:37
        I(cpphdl_n764, Vss) <+ 8.0000000000000006e-15 * ddt(V(cpphdl_n764, Vss)); // Bench initial voltage = 0.0 V.
        // device 230, IC IC32, analog/basic/buffered_nand_latch.hpp:38
        I(cpphdl_n780, Vss) <+ 1e-14 * ddt(V(cpphdl_n780, Vss)); // Bench initial voltage = 0.0 V.
        // device 231, IC IC38, analog/basic/cmos_logic.hpp:17
        I(cpphdl_n2953, Vss) <+ 5.0000000000000002e-14 * ddt(V(cpphdl_n2953, Vss)); // Bench initial voltage = 0.0 V.
        // device 232, IC IC38, analog/basic/cmos_logic.hpp:18
        I(cpphdl_n2953, Vdd) <+ cpphdl_channel(V(cpphdl_n774, Vdd), V(cpphdl_n2953, Vdd), 0.01, 0.69999999999999996, -1.0);
        // device 233, IC IC38, analog/basic/cmos_logic.hpp:19
        I(cpphdl_n2953, Vdd) <+ cpphdl_channel(V(cpphdl_n782, Vdd), V(cpphdl_n2953, Vdd), 0.01, 0.69999999999999996, -1.0);
        // device 234, IC IC38, analog/basic/cmos_logic.hpp:20
        I(cpphdl_n2953, cpphdl_n777) <+ cpphdl_channel(V(cpphdl_n774, cpphdl_n777), V(cpphdl_n2953, cpphdl_n777), 0.01, 0.69999999999999996, 1.0);
        // device 235, IC IC38, analog/basic/cmos_logic.hpp:21
        I(cpphdl_n777, Vss) <+ cpphdl_channel(V(cpphdl_n782, Vss), V(cpphdl_n777, Vss), 0.01, 0.69999999999999996, 1.0);
        // device 236, IC IC38, analog/basic/cmos_logic.hpp:27
        I(cpphdl_n777, Vss) <+ 1e-14 * ddt(V(cpphdl_n777, Vss)); // Bench initial voltage = 0.0 V.
        // device 237, IC IC39, analog/basic/cmos_logic.hpp:17
        I(cpphdl_n782, Vss) <+ 5.0000000000000002e-14 * ddt(V(cpphdl_n782, Vss)); // Bench initial voltage = 0.0 V.
        // device 238, IC IC39, analog/basic/cmos_logic.hpp:18
        I(cpphdl_n782, Vdd) <+ cpphdl_channel(V(cpphdl_n780, Vdd), V(cpphdl_n782, Vdd), 0.01, 0.69999999999999996, -1.0);
        // device 239, IC IC39, analog/basic/cmos_logic.hpp:19
        I(cpphdl_n782, Vdd) <+ cpphdl_channel(V(cpphdl_n2953, Vdd), V(cpphdl_n782, Vdd), 0.01, 0.69999999999999996, -1.0);
        // device 240, IC IC39, analog/basic/cmos_logic.hpp:20
        I(cpphdl_n782, cpphdl_n783) <+ cpphdl_channel(V(cpphdl_n780, cpphdl_n783), V(cpphdl_n782, cpphdl_n783), 0.01, 0.69999999999999996, 1.0);
        // device 241, IC IC39, analog/basic/cmos_logic.hpp:21
        I(cpphdl_n783, Vss) <+ cpphdl_channel(V(cpphdl_n2953, Vss), V(cpphdl_n783, Vss), 0.01, 0.69999999999999996, 1.0);
        // device 242, IC IC39, analog/basic/cmos_logic.hpp:27
        I(cpphdl_n783, Vss) <+ 1e-14 * ddt(V(cpphdl_n783, Vss)); // Bench initial voltage = 0.0 V.
        // device 243, IC IC37, analog/basic/nand_latch.hpp:36
        I(cpphdl_n774, Vss) <+ 2.9999999999999998e-15 * ddt(V(cpphdl_n774, Vss)); // Bench initial voltage = 0.0 V.
        // device 244, IC IC37, analog/basic/nand_latch.hpp:37
        I(cpphdl_n780, Vss) <+ 2.9999999999999998e-15 * ddt(V(cpphdl_n780, Vss)); // Bench initial voltage = 0.0 V.
        // device 245, IC IC40, analog/basic/inverter.hpp:11
        I(cpphdl_n788, Vdd) <+ cpphdl_channel(V(CLEAR, Vdd), V(cpphdl_n788, Vdd), 0.01, 0.69999999999999996, -1.0);
        // device 246, IC IC40, analog/basic/inverter.hpp:12
        I(cpphdl_n788, Vss) <+ cpphdl_channel(V(CLEAR, Vss), V(cpphdl_n788, Vss), 0.01, 0.69999999999999996, 1.0);
        // device 247, IC IC37, analog/basic/nand_latch.hpp:58
        I(cpphdl_n788, Vss) <+ 2.9999999999999998e-15 * ddt(V(cpphdl_n788, Vss)); // Bench initial voltage = 0.0 V.
        // device 248, IC IC37, analog/basic/nand_latch.hpp:59
        I(cpphdl_n2953, Vss) <+ cpphdl_channel(V(CLEAR, Vss), V(cpphdl_n2953, Vss), 0.050000000000000003, 0.69999999999999996, 1.0);
        // device 249, IC IC37, analog/basic/nand_latch.hpp:60
        I(cpphdl_n782, Vdd) <+ cpphdl_channel(V(cpphdl_n788, Vdd), V(cpphdl_n782, Vdd), 0.050000000000000003, 0.69999999999999996, -1.0);
        // device 250, IC IC43, analog/basic/inverter.hpp:11
        I(cpphdl_n812, Vdd) <+ cpphdl_channel(V(TRACK1, Vdd), V(cpphdl_n812, Vdd), 0.0040000000000000001, 0.69999999999999996, -1.0);
        // device 251, IC IC43, analog/basic/inverter.hpp:12
        I(cpphdl_n812, Vss) <+ cpphdl_channel(V(TRACK1, Vss), V(cpphdl_n812, Vss), 0.0040000000000000001, 0.69999999999999996, 1.0);
        // device 252, IC IC42, analog/basic/mos_track_hold.hpp:31
        I(cpphdl_n812, Vss) <+ 2e-14 * ddt(V(cpphdl_n812, Vss)); // Bench initial voltage = 0.0 V.
        // device 253, IC IC42, analog/basic/mos_track_hold.hpp:32
        I(cpphdl_n2808, cpphdl_n866) <+ cpphdl_channel(V(TRACK1, cpphdl_n866), V(cpphdl_n2808, cpphdl_n866), 0.029999999999999999, 0.69999999999999996, 1.0);
        // device 254, IC IC42, analog/basic/mos_track_hold.hpp:33
        I(cpphdl_n866, cpphdl_n2808) <+ cpphdl_channel(V(cpphdl_n812, cpphdl_n2808), V(cpphdl_n866, cpphdl_n2808), 0.014999999999999999, 0.69999999999999996, -1.0);
        // device 255, IC IC42, analog/basic/mos_track_hold.hpp:37
        I(cpphdl_n866, cpphdl_n866) <+ cpphdl_channel(V(cpphdl_n812, cpphdl_n866), V(cpphdl_n866, cpphdl_n866), 0.016, 0.69999999999999996, 1.0);
        // device 256, IC IC42, analog/basic/mos_track_hold.hpp:38
        I(cpphdl_n866, cpphdl_n866) <+ cpphdl_channel(V(TRACK1, cpphdl_n866), V(cpphdl_n866, cpphdl_n866), 0.0083999999999999995, 0.69999999999999996, -1.0);
        // device 257, IC IC42, analog/basic/mos_track_hold.hpp:39
        I(cpphdl_n866, Vss) <+ 1.5000000000000001e-12 * ddt(V(cpphdl_n866, Vss)); // Bench initial voltage = 0.0 V.
        // device 258, IC IC42, analog/basic/mos_track_hold.hpp:42
        I(TRACK1, cpphdl_n866) <+ 2.0000000000000002e-15 * ddt(V(TRACK1, cpphdl_n866)); // Bench initial voltage = -0.0 V.
        // device 259, IC IC42, analog/basic/mos_track_hold.hpp:43
        I(cpphdl_n812, cpphdl_n866) <+ 2.0000000000000002e-15 * ddt(V(cpphdl_n812, cpphdl_n866)); // Bench initial voltage = 0.0 V.
        // device 260, IC IC42, analog/basic/mos_track_hold.hpp:44
        I(cpphdl_n2808, cpphdl_n866) <+ 1.0000000000000001e-15 * ddt(V(cpphdl_n2808, cpphdl_n866)); // Bench initial voltage = 0.0 V.
        // device 261, IC IC45, analog/basic/inverter.hpp:11
        I(cpphdl_n827, Vdd) <+ cpphdl_channel(V(BIT_N1_0, Vdd), V(cpphdl_n827, Vdd), 0.080000000000000002, 0.69999999999999996, -1.0);
        // device 262, IC IC45, analog/basic/inverter.hpp:12
        I(cpphdl_n827, Vss) <+ cpphdl_channel(V(BIT_N1_0, Vss), V(cpphdl_n827, Vss), 0.080000000000000002, 0.69999999999999996, 1.0);
        // device 263, IC IC44, analog/basic/mos_r2r_dac.hpp:27
        I(cpphdl_n827, Vss) <+ 2.9999999999999998e-15 * ddt(V(cpphdl_n827, Vss)); // Bench initial voltage = 0.0 V.
        // device 264, IC IC44, analog/basic/mos_r2r_dac.hpp:28
        I(cpphdl_n827, cpphdl_n856) <+ V(cpphdl_n827, cpphdl_n856) / 2000.0;
        // device 265, IC IC44, analog/basic/mos_r2r_dac.hpp:29
        I(cpphdl_n856, Vss) <+ 2.9999999999999998e-15 * ddt(V(cpphdl_n856, Vss)); // Bench initial voltage = 0.0 V.
        // device 266, IC IC46, analog/basic/inverter.hpp:11
        I(cpphdl_n831, Vdd) <+ cpphdl_channel(V(BIT_N1_1, Vdd), V(cpphdl_n831, Vdd), 0.080000000000000002, 0.69999999999999996, -1.0);
        // device 267, IC IC46, analog/basic/inverter.hpp:12
        I(cpphdl_n831, Vss) <+ cpphdl_channel(V(BIT_N1_1, Vss), V(cpphdl_n831, Vss), 0.080000000000000002, 0.69999999999999996, 1.0);
        // device 268, IC IC44, analog/basic/mos_r2r_dac.hpp:27
        I(cpphdl_n831, Vss) <+ 2.9999999999999998e-15 * ddt(V(cpphdl_n831, Vss)); // Bench initial voltage = 0.0 V.
        // device 269, IC IC44, analog/basic/mos_r2r_dac.hpp:28
        I(cpphdl_n831, cpphdl_n857) <+ V(cpphdl_n831, cpphdl_n857) / 2000.0;
        // device 270, IC IC44, analog/basic/mos_r2r_dac.hpp:29
        I(cpphdl_n857, Vss) <+ 2.9999999999999998e-15 * ddt(V(cpphdl_n857, Vss)); // Bench initial voltage = 0.0 V.
        // device 271, IC IC44, analog/basic/mos_r2r_dac.hpp:31
        I(cpphdl_n856, cpphdl_n857) <+ V(cpphdl_n856, cpphdl_n857) / 1000.0;
        // device 272, IC IC47, analog/basic/inverter.hpp:11
        I(cpphdl_n835, Vdd) <+ cpphdl_channel(V(BIT_N1_2, Vdd), V(cpphdl_n835, Vdd), 0.080000000000000002, 0.69999999999999996, -1.0);
        // device 273, IC IC47, analog/basic/inverter.hpp:12
        I(cpphdl_n835, Vss) <+ cpphdl_channel(V(BIT_N1_2, Vss), V(cpphdl_n835, Vss), 0.080000000000000002, 0.69999999999999996, 1.0);
        // device 274, IC IC44, analog/basic/mos_r2r_dac.hpp:27
        I(cpphdl_n835, Vss) <+ 2.9999999999999998e-15 * ddt(V(cpphdl_n835, Vss)); // Bench initial voltage = 0.0 V.
        // device 275, IC IC44, analog/basic/mos_r2r_dac.hpp:28
        I(cpphdl_n835, cpphdl_n858) <+ V(cpphdl_n835, cpphdl_n858) / 2000.0;
        // device 276, IC IC44, analog/basic/mos_r2r_dac.hpp:29
        I(cpphdl_n858, Vss) <+ 2.9999999999999998e-15 * ddt(V(cpphdl_n858, Vss)); // Bench initial voltage = 0.0 V.
        // device 277, IC IC44, analog/basic/mos_r2r_dac.hpp:31
        I(cpphdl_n857, cpphdl_n858) <+ V(cpphdl_n857, cpphdl_n858) / 1000.0;
        // device 278, IC IC48, analog/basic/inverter.hpp:11
        I(cpphdl_n839, Vdd) <+ cpphdl_channel(V(BIT_N1_3, Vdd), V(cpphdl_n839, Vdd), 0.080000000000000002, 0.69999999999999996, -1.0);
        // device 279, IC IC48, analog/basic/inverter.hpp:12
        I(cpphdl_n839, Vss) <+ cpphdl_channel(V(BIT_N1_3, Vss), V(cpphdl_n839, Vss), 0.080000000000000002, 0.69999999999999996, 1.0);
        // device 280, IC IC44, analog/basic/mos_r2r_dac.hpp:27
        I(cpphdl_n839, Vss) <+ 2.9999999999999998e-15 * ddt(V(cpphdl_n839, Vss)); // Bench initial voltage = 0.0 V.
        // device 281, IC IC44, analog/basic/mos_r2r_dac.hpp:28
        I(cpphdl_n839, cpphdl_n859) <+ V(cpphdl_n839, cpphdl_n859) / 2000.0;
        // device 282, IC IC44, analog/basic/mos_r2r_dac.hpp:29
        I(cpphdl_n859, Vss) <+ 2.9999999999999998e-15 * ddt(V(cpphdl_n859, Vss)); // Bench initial voltage = 0.0 V.
        // device 283, IC IC44, analog/basic/mos_r2r_dac.hpp:31
        I(cpphdl_n858, cpphdl_n859) <+ V(cpphdl_n858, cpphdl_n859) / 1000.0;
        // device 284, IC IC49, analog/basic/inverter.hpp:11
        I(cpphdl_n843, Vdd) <+ cpphdl_channel(V(BIT_N1_4, Vdd), V(cpphdl_n843, Vdd), 0.080000000000000002, 0.69999999999999996, -1.0);
        // device 285, IC IC49, analog/basic/inverter.hpp:12
        I(cpphdl_n843, Vss) <+ cpphdl_channel(V(BIT_N1_4, Vss), V(cpphdl_n843, Vss), 0.080000000000000002, 0.69999999999999996, 1.0);
        // device 286, IC IC44, analog/basic/mos_r2r_dac.hpp:27
        I(cpphdl_n843, Vss) <+ 2.9999999999999998e-15 * ddt(V(cpphdl_n843, Vss)); // Bench initial voltage = 0.0 V.
        // device 287, IC IC44, analog/basic/mos_r2r_dac.hpp:28
        I(cpphdl_n843, cpphdl_n860) <+ V(cpphdl_n843, cpphdl_n860) / 2000.0;
        // device 288, IC IC44, analog/basic/mos_r2r_dac.hpp:29
        I(cpphdl_n860, Vss) <+ 2.9999999999999998e-15 * ddt(V(cpphdl_n860, Vss)); // Bench initial voltage = 0.0 V.
        // device 289, IC IC44, analog/basic/mos_r2r_dac.hpp:31
        I(cpphdl_n859, cpphdl_n860) <+ V(cpphdl_n859, cpphdl_n860) / 1000.0;
        // device 290, IC IC50, analog/basic/inverter.hpp:11
        I(cpphdl_n847, Vdd) <+ cpphdl_channel(V(BIT_N1_5, Vdd), V(cpphdl_n847, Vdd), 0.080000000000000002, 0.69999999999999996, -1.0);
        // device 291, IC IC50, analog/basic/inverter.hpp:12
        I(cpphdl_n847, Vss) <+ cpphdl_channel(V(BIT_N1_5, Vss), V(cpphdl_n847, Vss), 0.080000000000000002, 0.69999999999999996, 1.0);
        // device 292, IC IC44, analog/basic/mos_r2r_dac.hpp:27
        I(cpphdl_n847, Vss) <+ 2.9999999999999998e-15 * ddt(V(cpphdl_n847, Vss)); // Bench initial voltage = 0.0 V.
        // device 293, IC IC44, analog/basic/mos_r2r_dac.hpp:28
        I(cpphdl_n847, cpphdl_n861) <+ V(cpphdl_n847, cpphdl_n861) / 2000.0;
        // device 294, IC IC44, analog/basic/mos_r2r_dac.hpp:29
        I(cpphdl_n861, Vss) <+ 2.9999999999999998e-15 * ddt(V(cpphdl_n861, Vss)); // Bench initial voltage = 0.0 V.
        // device 295, IC IC44, analog/basic/mos_r2r_dac.hpp:31
        I(cpphdl_n860, cpphdl_n861) <+ V(cpphdl_n860, cpphdl_n861) / 1000.0;
        // device 296, IC IC51, analog/basic/inverter.hpp:11
        I(cpphdl_n851, Vdd) <+ cpphdl_channel(V(BIT_N1_6, Vdd), V(cpphdl_n851, Vdd), 0.080000000000000002, 0.69999999999999996, -1.0);
        // device 297, IC IC51, analog/basic/inverter.hpp:12
        I(cpphdl_n851, Vss) <+ cpphdl_channel(V(BIT_N1_6, Vss), V(cpphdl_n851, Vss), 0.080000000000000002, 0.69999999999999996, 1.0);
        // device 298, IC IC44, analog/basic/mos_r2r_dac.hpp:27
        I(cpphdl_n851, Vss) <+ 2.9999999999999998e-15 * ddt(V(cpphdl_n851, Vss)); // Bench initial voltage = 0.0 V.
        // device 299, IC IC44, analog/basic/mos_r2r_dac.hpp:28
        I(cpphdl_n851, cpphdl_n862) <+ V(cpphdl_n851, cpphdl_n862) / 2000.0;
        // device 300, IC IC44, analog/basic/mos_r2r_dac.hpp:29
        I(cpphdl_n862, Vss) <+ 2.9999999999999998e-15 * ddt(V(cpphdl_n862, Vss)); // Bench initial voltage = 0.0 V.
        // device 301, IC IC44, analog/basic/mos_r2r_dac.hpp:31
        I(cpphdl_n861, cpphdl_n862) <+ V(cpphdl_n861, cpphdl_n862) / 1000.0;
        // device 302, IC IC52, analog/basic/inverter.hpp:11
        I(cpphdl_n855, Vdd) <+ cpphdl_channel(V(BIT_N1_7, Vdd), V(cpphdl_n855, Vdd), 0.080000000000000002, 0.69999999999999996, -1.0);
        // device 303, IC IC52, analog/basic/inverter.hpp:12
        I(cpphdl_n855, Vss) <+ cpphdl_channel(V(BIT_N1_7, Vss), V(cpphdl_n855, Vss), 0.080000000000000002, 0.69999999999999996, 1.0);
        // device 304, IC IC44, analog/basic/mos_r2r_dac.hpp:27
        I(cpphdl_n855, Vss) <+ 2.9999999999999998e-15 * ddt(V(cpphdl_n855, Vss)); // Bench initial voltage = 0.0 V.
        // device 305, IC IC44, analog/basic/mos_r2r_dac.hpp:28
        I(cpphdl_n855, cpphdl_n867) <+ V(cpphdl_n855, cpphdl_n867) / 2000.0;
        // device 306, IC IC44, analog/basic/mos_r2r_dac.hpp:29
        I(cpphdl_n867, Vss) <+ 2.9999999999999998e-15 * ddt(V(cpphdl_n867, Vss)); // Bench initial voltage = 0.0 V.
        // device 307, IC IC44, analog/basic/mos_r2r_dac.hpp:31
        I(cpphdl_n862, cpphdl_n867) <+ V(cpphdl_n862, cpphdl_n867) / 1000.0;
        // device 308, IC IC44, analog/basic/mos_r2r_dac.hpp:33
        I(Vss, cpphdl_n856) <+ V(Vss, cpphdl_n856) / 2000.0;
        // device 309, IC IC53, analog/basic/nmos_resistor_amplifier.hpp:23
        I(Vdd, cpphdl_n876) <+ V(Vdd, cpphdl_n876) / 1000.0;
        // device 310, IC IC53, analog/basic/nmos_resistor_amplifier.hpp:24
        I(Vdd, cpphdl_n875) <+ V(Vdd, cpphdl_n875) / 1000.0;
        // device 311, IC IC53, analog/basic/nmos_resistor_amplifier.hpp:25
        I(cpphdl_n876, cpphdl_n870) <+ cpphdl_channel(V(cpphdl_n866, cpphdl_n870), V(cpphdl_n876, cpphdl_n870), 0.0074999999999999997, 0.69999999999999996, 1.0);
        // device 312, IC IC53, analog/basic/nmos_resistor_amplifier.hpp:26
        I(cpphdl_n875, cpphdl_n871) <+ cpphdl_channel(V(cpphdl_n867, cpphdl_n871), V(cpphdl_n875, cpphdl_n871), 0.0074999999999999997, 0.69999999999999996, 1.0);
        // device 313, IC IC53, analog/basic/nmos_resistor_amplifier.hpp:27
        I(cpphdl_n872, cpphdl_n870) <+ V(cpphdl_n872, cpphdl_n870) / 100.0;
        // device 314, IC IC53, analog/basic/nmos_resistor_amplifier.hpp:28
        I(cpphdl_n872, cpphdl_n871) <+ V(cpphdl_n872, cpphdl_n871) / 100.0;
        // device 315, IC IC53, analog/basic/nmos_resistor_amplifier.hpp:29
        I(Vss, cpphdl_n872) <+ V(Vss, cpphdl_n872) / 300.0;
        // device 316, IC IC53, analog/basic/nmos_resistor_amplifier.hpp:30
        I(cpphdl_n876, Vdd) <+ 2.9999999999999998e-13 * ddt(V(cpphdl_n876, Vdd)); // Bench initial voltage = 0.0 V.
        // device 317, IC IC53, analog/basic/nmos_resistor_amplifier.hpp:31
        I(cpphdl_n875, Vdd) <+ 2.9999999999999998e-13 * ddt(V(cpphdl_n875, Vdd)); // Bench initial voltage = 0.0 V.
        // device 318, IC IC53, analog/basic/nmos_resistor_amplifier.hpp:32
        I(cpphdl_n872, Vss) <+ 4e-14 * ddt(V(cpphdl_n872, Vss)); // Bench initial voltage = 0.0 V.
        // device 319, IC IC53, analog/basic/nmos_resistor_amplifier.hpp:34
        I(cpphdl_n866, cpphdl_n870) <+ 2e-14 * ddt(V(cpphdl_n866, cpphdl_n870)); // Bench initial voltage = 0.0 V.
        // device 320, IC IC53, analog/basic/nmos_resistor_amplifier.hpp:35
        I(cpphdl_n867, cpphdl_n871) <+ 2e-14 * ddt(V(cpphdl_n867, cpphdl_n871)); // Bench initial voltage = 0.0 V.
        // device 321, IC IC53, analog/basic/nmos_resistor_amplifier.hpp:36
        I(cpphdl_n866, cpphdl_n876) <+ 2.9999999999999998e-15 * ddt(V(cpphdl_n866, cpphdl_n876)); // Bench initial voltage = 0.0 V.
        // device 322, IC IC53, analog/basic/nmos_resistor_amplifier.hpp:37
        I(cpphdl_n867, cpphdl_n875) <+ 2.9999999999999998e-15 * ddt(V(cpphdl_n867, cpphdl_n875)); // Bench initial voltage = 0.0 V.
        // device 323, IC IC54, analog/basic/strongarm_comparator.hpp:28
        I(cpphdl_n880, cpphdl_n882) <+ cpphdl_channel(V(cpphdl_n875, cpphdl_n882), V(cpphdl_n880, cpphdl_n882), 0.0080000000000000002, 0.69999999999999996, 1.0);
        // device 324, IC IC54, analog/basic/strongarm_comparator.hpp:29
        I(cpphdl_n881, cpphdl_n882) <+ cpphdl_channel(V(cpphdl_n876, cpphdl_n882), V(cpphdl_n881, cpphdl_n882), 0.0080000000000000002, 0.69999999999999996, 1.0);
        // device 325, IC IC54, analog/basic/strongarm_comparator.hpp:30
        I(cpphdl_n882, Vss) <+ cpphdl_channel(V(EVALUATE, Vss), V(cpphdl_n882, Vss), 0.0080000000000000002, 0.69999999999999996, 1.0);
        // device 326, IC IC54, analog/basic/strongarm_comparator.hpp:33
        I(cpphdl_n895, cpphdl_n880) <+ cpphdl_channel(V(cpphdl_n899, cpphdl_n880), V(cpphdl_n895, cpphdl_n880), 0.0040000000000000001, 0.69999999999999996, 1.0);
        // device 327, IC IC54, analog/basic/strongarm_comparator.hpp:34
        I(cpphdl_n899, cpphdl_n881) <+ cpphdl_channel(V(cpphdl_n895, cpphdl_n881), V(cpphdl_n899, cpphdl_n881), 0.0040000000000000001, 0.69999999999999996, 1.0);
        // device 328, IC IC54, analog/basic/strongarm_comparator.hpp:35
        I(cpphdl_n899, Vdd) <+ cpphdl_channel(V(cpphdl_n895, Vdd), V(cpphdl_n899, Vdd), 0.002, 0.69999999999999996, -1.0);
        // device 329, IC IC54, analog/basic/strongarm_comparator.hpp:36
        I(cpphdl_n895, Vdd) <+ cpphdl_channel(V(cpphdl_n899, Vdd), V(cpphdl_n895, Vdd), 0.002, 0.69999999999999996, -1.0);
        // device 330, IC IC54, analog/basic/strongarm_comparator.hpp:38
        I(cpphdl_n880, Vdd) <+ cpphdl_channel(V(EVALUATE, Vdd), V(cpphdl_n880, Vdd), 0.002, 0.69999999999999996, -1.0);
        // device 331, IC IC54, analog/basic/strongarm_comparator.hpp:39
        I(cpphdl_n881, Vdd) <+ cpphdl_channel(V(EVALUATE, Vdd), V(cpphdl_n881, Vdd), 0.002, 0.69999999999999996, -1.0);
        // device 332, IC IC54, analog/basic/strongarm_comparator.hpp:40
        I(cpphdl_n899, Vdd) <+ cpphdl_channel(V(EVALUATE, Vdd), V(cpphdl_n899, Vdd), 0.002, 0.69999999999999996, -1.0);
        // device 333, IC IC54, analog/basic/strongarm_comparator.hpp:41
        I(cpphdl_n895, Vdd) <+ cpphdl_channel(V(EVALUATE, Vdd), V(cpphdl_n895, Vdd), 0.002, 0.69999999999999996, -1.0);
        // device 334, IC IC54, analog/basic/strongarm_comparator.hpp:42
        I(cpphdl_n880, Vss) <+ 2.9999999999999998e-14 * ddt(V(cpphdl_n880, Vss)); // Bench initial voltage = 0.0 V.
        // device 335, IC IC54, analog/basic/strongarm_comparator.hpp:43
        I(cpphdl_n881, Vss) <+ 2.9999999999999998e-14 * ddt(V(cpphdl_n881, Vss)); // Bench initial voltage = 0.0 V.
        // device 336, IC IC54, analog/basic/strongarm_comparator.hpp:44
        I(cpphdl_n882, Vss) <+ 2.9999999999999998e-14 * ddt(V(cpphdl_n882, Vss)); // Bench initial voltage = 0.0 V.
        // device 337, IC IC54, analog/basic/strongarm_comparator.hpp:45
        I(cpphdl_n899, Vss) <+ 5.0000000000000002e-14 * ddt(V(cpphdl_n899, Vss)); // Bench initial voltage = 0.0 V.
        // device 338, IC IC54, analog/basic/strongarm_comparator.hpp:46
        I(cpphdl_n895, Vss) <+ 5.0000000000000002e-14 * ddt(V(cpphdl_n895, Vss)); // Bench initial voltage = 0.0 V.
        // device 339, IC IC54, analog/basic/strongarm_comparator.hpp:47
        I(cpphdl_n875, cpphdl_n882) <+ 2e-14 * ddt(V(cpphdl_n875, cpphdl_n882)); // Bench initial voltage = 0.0 V.
        // device 340, IC IC54, analog/basic/strongarm_comparator.hpp:48
        I(cpphdl_n876, cpphdl_n882) <+ 2e-14 * ddt(V(cpphdl_n876, cpphdl_n882)); // Bench initial voltage = 0.0 V.
        // device 341, IC IC54, analog/basic/strongarm_comparator.hpp:49
        I(cpphdl_n875, cpphdl_n880) <+ 2.9999999999999998e-15 * ddt(V(cpphdl_n875, cpphdl_n880)); // Bench initial voltage = 0.0 V.
        // device 342, IC IC54, analog/basic/strongarm_comparator.hpp:50
        I(cpphdl_n876, cpphdl_n881) <+ 2.9999999999999998e-15 * ddt(V(cpphdl_n876, cpphdl_n881)); // Bench initial voltage = 0.0 V.
        // device 343, IC IC56, analog/basic/inverter.hpp:11
        I(cpphdl_n903, Vdd) <+ cpphdl_channel(V(cpphdl_n895, Vdd), V(cpphdl_n903, Vdd), 0.001, 0.69999999999999996, -1.0);
        // device 344, IC IC56, analog/basic/inverter.hpp:12
        I(cpphdl_n903, Vss) <+ cpphdl_channel(V(cpphdl_n895, Vss), V(cpphdl_n903, Vss), 0.001, 0.69999999999999996, 1.0);
        // device 345, IC IC58, analog/basic/inverter.hpp:11
        I(cpphdl_n917, Vdd) <+ cpphdl_channel(V(cpphdl_n903, Vdd), V(cpphdl_n917, Vdd), 0.0040000000000000001, 0.69999999999999996, -1.0);
        // device 346, IC IC58, analog/basic/inverter.hpp:12
        I(cpphdl_n917, Vss) <+ cpphdl_channel(V(cpphdl_n903, Vss), V(cpphdl_n917, Vss), 0.0040000000000000001, 0.69999999999999996, 1.0);
        // device 347, IC IC55, analog/basic/buffered_nand_latch.hpp:34
        I(cpphdl_n895, Vss) <+ 2.0000000000000002e-15 * ddt(V(cpphdl_n895, Vss)); // Bench initial voltage = 0.0 V.
        // device 348, IC IC55, analog/basic/buffered_nand_latch.hpp:35
        I(cpphdl_n895, cpphdl_n903) <+ 1.0000000000000001e-15 * ddt(V(cpphdl_n895, cpphdl_n903)); // Bench initial voltage = 0.0 V.
        // device 349, IC IC55, analog/basic/buffered_nand_latch.hpp:36
        I(cpphdl_n903, Vss) <+ 5e-15 * ddt(V(cpphdl_n903, Vss)); // Bench initial voltage = 0.0 V.
        // device 350, IC IC55, analog/basic/buffered_nand_latch.hpp:37
        I(cpphdl_n903, Vss) <+ 8.0000000000000006e-15 * ddt(V(cpphdl_n903, Vss)); // Bench initial voltage = 0.0 V.
        // device 351, IC IC55, analog/basic/buffered_nand_latch.hpp:38
        I(cpphdl_n917, Vss) <+ 1e-14 * ddt(V(cpphdl_n917, Vss)); // Bench initial voltage = 0.0 V.
        // device 352, IC IC57, analog/basic/inverter.hpp:11
        I(cpphdl_n907, Vdd) <+ cpphdl_channel(V(cpphdl_n899, Vdd), V(cpphdl_n907, Vdd), 0.001, 0.69999999999999996, -1.0);
        // device 353, IC IC57, analog/basic/inverter.hpp:12
        I(cpphdl_n907, Vss) <+ cpphdl_channel(V(cpphdl_n899, Vss), V(cpphdl_n907, Vss), 0.001, 0.69999999999999996, 1.0);
        // device 354, IC IC59, analog/basic/inverter.hpp:11
        I(cpphdl_n923, Vdd) <+ cpphdl_channel(V(cpphdl_n907, Vdd), V(cpphdl_n923, Vdd), 0.0040000000000000001, 0.69999999999999996, -1.0);
        // device 355, IC IC59, analog/basic/inverter.hpp:12
        I(cpphdl_n923, Vss) <+ cpphdl_channel(V(cpphdl_n907, Vss), V(cpphdl_n923, Vss), 0.0040000000000000001, 0.69999999999999996, 1.0);
        // device 356, IC IC55, analog/basic/buffered_nand_latch.hpp:34
        I(cpphdl_n899, Vss) <+ 2.0000000000000002e-15 * ddt(V(cpphdl_n899, Vss)); // Bench initial voltage = 0.0 V.
        // device 357, IC IC55, analog/basic/buffered_nand_latch.hpp:35
        I(cpphdl_n899, cpphdl_n907) <+ 1.0000000000000001e-15 * ddt(V(cpphdl_n899, cpphdl_n907)); // Bench initial voltage = 0.0 V.
        // device 358, IC IC55, analog/basic/buffered_nand_latch.hpp:36
        I(cpphdl_n907, Vss) <+ 5e-15 * ddt(V(cpphdl_n907, Vss)); // Bench initial voltage = 0.0 V.
        // device 359, IC IC55, analog/basic/buffered_nand_latch.hpp:37
        I(cpphdl_n907, Vss) <+ 8.0000000000000006e-15 * ddt(V(cpphdl_n907, Vss)); // Bench initial voltage = 0.0 V.
        // device 360, IC IC55, analog/basic/buffered_nand_latch.hpp:38
        I(cpphdl_n923, Vss) <+ 1e-14 * ddt(V(cpphdl_n923, Vss)); // Bench initial voltage = 0.0 V.
        // device 361, IC IC61, analog/basic/cmos_logic.hpp:17
        I(cpphdl_n2958, Vss) <+ 5.0000000000000002e-14 * ddt(V(cpphdl_n2958, Vss)); // Bench initial voltage = 0.0 V.
        // device 362, IC IC61, analog/basic/cmos_logic.hpp:18
        I(cpphdl_n2958, Vdd) <+ cpphdl_channel(V(cpphdl_n917, Vdd), V(cpphdl_n2958, Vdd), 0.01, 0.69999999999999996, -1.0);
        // device 363, IC IC61, analog/basic/cmos_logic.hpp:19
        I(cpphdl_n2958, Vdd) <+ cpphdl_channel(V(cpphdl_n925, Vdd), V(cpphdl_n2958, Vdd), 0.01, 0.69999999999999996, -1.0);
        // device 364, IC IC61, analog/basic/cmos_logic.hpp:20
        I(cpphdl_n2958, cpphdl_n920) <+ cpphdl_channel(V(cpphdl_n917, cpphdl_n920), V(cpphdl_n2958, cpphdl_n920), 0.01, 0.69999999999999996, 1.0);
        // device 365, IC IC61, analog/basic/cmos_logic.hpp:21
        I(cpphdl_n920, Vss) <+ cpphdl_channel(V(cpphdl_n925, Vss), V(cpphdl_n920, Vss), 0.01, 0.69999999999999996, 1.0);
        // device 366, IC IC61, analog/basic/cmos_logic.hpp:27
        I(cpphdl_n920, Vss) <+ 1e-14 * ddt(V(cpphdl_n920, Vss)); // Bench initial voltage = 0.0 V.
        // device 367, IC IC62, analog/basic/cmos_logic.hpp:17
        I(cpphdl_n925, Vss) <+ 5.0000000000000002e-14 * ddt(V(cpphdl_n925, Vss)); // Bench initial voltage = 0.0 V.
        // device 368, IC IC62, analog/basic/cmos_logic.hpp:18
        I(cpphdl_n925, Vdd) <+ cpphdl_channel(V(cpphdl_n923, Vdd), V(cpphdl_n925, Vdd), 0.01, 0.69999999999999996, -1.0);
        // device 369, IC IC62, analog/basic/cmos_logic.hpp:19
        I(cpphdl_n925, Vdd) <+ cpphdl_channel(V(cpphdl_n2958, Vdd), V(cpphdl_n925, Vdd), 0.01, 0.69999999999999996, -1.0);
        // device 370, IC IC62, analog/basic/cmos_logic.hpp:20
        I(cpphdl_n925, cpphdl_n926) <+ cpphdl_channel(V(cpphdl_n923, cpphdl_n926), V(cpphdl_n925, cpphdl_n926), 0.01, 0.69999999999999996, 1.0);
        // device 371, IC IC62, analog/basic/cmos_logic.hpp:21
        I(cpphdl_n926, Vss) <+ cpphdl_channel(V(cpphdl_n2958, Vss), V(cpphdl_n926, Vss), 0.01, 0.69999999999999996, 1.0);
        // device 372, IC IC62, analog/basic/cmos_logic.hpp:27
        I(cpphdl_n926, Vss) <+ 1e-14 * ddt(V(cpphdl_n926, Vss)); // Bench initial voltage = 0.0 V.
        // device 373, IC IC60, analog/basic/nand_latch.hpp:36
        I(cpphdl_n917, Vss) <+ 2.9999999999999998e-15 * ddt(V(cpphdl_n917, Vss)); // Bench initial voltage = 0.0 V.
        // device 374, IC IC60, analog/basic/nand_latch.hpp:37
        I(cpphdl_n923, Vss) <+ 2.9999999999999998e-15 * ddt(V(cpphdl_n923, Vss)); // Bench initial voltage = 0.0 V.
        // device 375, IC IC63, analog/basic/inverter.hpp:11
        I(cpphdl_n931, Vdd) <+ cpphdl_channel(V(CLEAR, Vdd), V(cpphdl_n931, Vdd), 0.01, 0.69999999999999996, -1.0);
        // device 376, IC IC63, analog/basic/inverter.hpp:12
        I(cpphdl_n931, Vss) <+ cpphdl_channel(V(CLEAR, Vss), V(cpphdl_n931, Vss), 0.01, 0.69999999999999996, 1.0);
        // device 377, IC IC60, analog/basic/nand_latch.hpp:58
        I(cpphdl_n931, Vss) <+ 2.9999999999999998e-15 * ddt(V(cpphdl_n931, Vss)); // Bench initial voltage = 0.0 V.
        // device 378, IC IC60, analog/basic/nand_latch.hpp:59
        I(cpphdl_n2958, Vss) <+ cpphdl_channel(V(CLEAR, Vss), V(cpphdl_n2958, Vss), 0.050000000000000003, 0.69999999999999996, 1.0);
        // device 379, IC IC60, analog/basic/nand_latch.hpp:60
        I(cpphdl_n925, Vdd) <+ cpphdl_channel(V(cpphdl_n931, Vdd), V(cpphdl_n925, Vdd), 0.050000000000000003, 0.69999999999999996, -1.0);
        // device 380, IC IC66, analog/basic/inverter.hpp:11
        I(cpphdl_n955, Vdd) <+ cpphdl_channel(V(TRACK2, Vdd), V(cpphdl_n955, Vdd), 0.0040000000000000001, 0.69999999999999996, -1.0);
        // device 381, IC IC66, analog/basic/inverter.hpp:12
        I(cpphdl_n955, Vss) <+ cpphdl_channel(V(TRACK2, Vss), V(cpphdl_n955, Vss), 0.0040000000000000001, 0.69999999999999996, 1.0);
        // device 382, IC IC65, analog/basic/mos_track_hold.hpp:31
        I(cpphdl_n955, Vss) <+ 2e-14 * ddt(V(cpphdl_n955, Vss)); // Bench initial voltage = 0.0 V.
        // device 383, IC IC65, analog/basic/mos_track_hold.hpp:32
        I(cpphdl_n2808, cpphdl_n1009) <+ cpphdl_channel(V(TRACK2, cpphdl_n1009), V(cpphdl_n2808, cpphdl_n1009), 0.029999999999999999, 0.69999999999999996, 1.0);
        // device 384, IC IC65, analog/basic/mos_track_hold.hpp:33
        I(cpphdl_n1009, cpphdl_n2808) <+ cpphdl_channel(V(cpphdl_n955, cpphdl_n2808), V(cpphdl_n1009, cpphdl_n2808), 0.014999999999999999, 0.69999999999999996, -1.0);
        // device 385, IC IC65, analog/basic/mos_track_hold.hpp:37
        I(cpphdl_n1009, cpphdl_n1009) <+ cpphdl_channel(V(cpphdl_n955, cpphdl_n1009), V(cpphdl_n1009, cpphdl_n1009), 0.016, 0.69999999999999996, 1.0);
        // device 386, IC IC65, analog/basic/mos_track_hold.hpp:38
        I(cpphdl_n1009, cpphdl_n1009) <+ cpphdl_channel(V(TRACK2, cpphdl_n1009), V(cpphdl_n1009, cpphdl_n1009), 0.0083999999999999995, 0.69999999999999996, -1.0);
        // device 387, IC IC65, analog/basic/mos_track_hold.hpp:39
        I(cpphdl_n1009, Vss) <+ 1.5000000000000001e-12 * ddt(V(cpphdl_n1009, Vss)); // Bench initial voltage = 0.0 V.
        // device 388, IC IC65, analog/basic/mos_track_hold.hpp:42
        I(TRACK2, cpphdl_n1009) <+ 2.0000000000000002e-15 * ddt(V(TRACK2, cpphdl_n1009)); // Bench initial voltage = -0.0 V.
        // device 389, IC IC65, analog/basic/mos_track_hold.hpp:43
        I(cpphdl_n955, cpphdl_n1009) <+ 2.0000000000000002e-15 * ddt(V(cpphdl_n955, cpphdl_n1009)); // Bench initial voltage = 0.0 V.
        // device 390, IC IC65, analog/basic/mos_track_hold.hpp:44
        I(cpphdl_n2808, cpphdl_n1009) <+ 1.0000000000000001e-15 * ddt(V(cpphdl_n2808, cpphdl_n1009)); // Bench initial voltage = 0.0 V.
        // device 391, IC IC68, analog/basic/inverter.hpp:11
        I(cpphdl_n970, Vdd) <+ cpphdl_channel(V(BIT_N2_0, Vdd), V(cpphdl_n970, Vdd), 0.080000000000000002, 0.69999999999999996, -1.0);
        // device 392, IC IC68, analog/basic/inverter.hpp:12
        I(cpphdl_n970, Vss) <+ cpphdl_channel(V(BIT_N2_0, Vss), V(cpphdl_n970, Vss), 0.080000000000000002, 0.69999999999999996, 1.0);
        // device 393, IC IC67, analog/basic/mos_r2r_dac.hpp:27
        I(cpphdl_n970, Vss) <+ 2.9999999999999998e-15 * ddt(V(cpphdl_n970, Vss)); // Bench initial voltage = 0.0 V.
        // device 394, IC IC67, analog/basic/mos_r2r_dac.hpp:28
        I(cpphdl_n970, cpphdl_n999) <+ V(cpphdl_n970, cpphdl_n999) / 2000.0;
        // device 395, IC IC67, analog/basic/mos_r2r_dac.hpp:29
        I(cpphdl_n999, Vss) <+ 2.9999999999999998e-15 * ddt(V(cpphdl_n999, Vss)); // Bench initial voltage = 0.0 V.
        // device 396, IC IC69, analog/basic/inverter.hpp:11
        I(cpphdl_n974, Vdd) <+ cpphdl_channel(V(BIT_N2_1, Vdd), V(cpphdl_n974, Vdd), 0.080000000000000002, 0.69999999999999996, -1.0);
        // device 397, IC IC69, analog/basic/inverter.hpp:12
        I(cpphdl_n974, Vss) <+ cpphdl_channel(V(BIT_N2_1, Vss), V(cpphdl_n974, Vss), 0.080000000000000002, 0.69999999999999996, 1.0);
        // device 398, IC IC67, analog/basic/mos_r2r_dac.hpp:27
        I(cpphdl_n974, Vss) <+ 2.9999999999999998e-15 * ddt(V(cpphdl_n974, Vss)); // Bench initial voltage = 0.0 V.
        // device 399, IC IC67, analog/basic/mos_r2r_dac.hpp:28
        I(cpphdl_n974, cpphdl_n1000) <+ V(cpphdl_n974, cpphdl_n1000) / 2000.0;
        // device 400, IC IC67, analog/basic/mos_r2r_dac.hpp:29
        I(cpphdl_n1000, Vss) <+ 2.9999999999999998e-15 * ddt(V(cpphdl_n1000, Vss)); // Bench initial voltage = 0.0 V.
        // device 401, IC IC67, analog/basic/mos_r2r_dac.hpp:31
        I(cpphdl_n999, cpphdl_n1000) <+ V(cpphdl_n999, cpphdl_n1000) / 1000.0;
        // device 402, IC IC70, analog/basic/inverter.hpp:11
        I(cpphdl_n978, Vdd) <+ cpphdl_channel(V(BIT_N2_2, Vdd), V(cpphdl_n978, Vdd), 0.080000000000000002, 0.69999999999999996, -1.0);
        // device 403, IC IC70, analog/basic/inverter.hpp:12
        I(cpphdl_n978, Vss) <+ cpphdl_channel(V(BIT_N2_2, Vss), V(cpphdl_n978, Vss), 0.080000000000000002, 0.69999999999999996, 1.0);
        // device 404, IC IC67, analog/basic/mos_r2r_dac.hpp:27
        I(cpphdl_n978, Vss) <+ 2.9999999999999998e-15 * ddt(V(cpphdl_n978, Vss)); // Bench initial voltage = 0.0 V.
        // device 405, IC IC67, analog/basic/mos_r2r_dac.hpp:28
        I(cpphdl_n978, cpphdl_n1001) <+ V(cpphdl_n978, cpphdl_n1001) / 2000.0;
        // device 406, IC IC67, analog/basic/mos_r2r_dac.hpp:29
        I(cpphdl_n1001, Vss) <+ 2.9999999999999998e-15 * ddt(V(cpphdl_n1001, Vss)); // Bench initial voltage = 0.0 V.
        // device 407, IC IC67, analog/basic/mos_r2r_dac.hpp:31
        I(cpphdl_n1000, cpphdl_n1001) <+ V(cpphdl_n1000, cpphdl_n1001) / 1000.0;
        // device 408, IC IC71, analog/basic/inverter.hpp:11
        I(cpphdl_n982, Vdd) <+ cpphdl_channel(V(BIT_N2_3, Vdd), V(cpphdl_n982, Vdd), 0.080000000000000002, 0.69999999999999996, -1.0);
        // device 409, IC IC71, analog/basic/inverter.hpp:12
        I(cpphdl_n982, Vss) <+ cpphdl_channel(V(BIT_N2_3, Vss), V(cpphdl_n982, Vss), 0.080000000000000002, 0.69999999999999996, 1.0);
        // device 410, IC IC67, analog/basic/mos_r2r_dac.hpp:27
        I(cpphdl_n982, Vss) <+ 2.9999999999999998e-15 * ddt(V(cpphdl_n982, Vss)); // Bench initial voltage = 0.0 V.
        // device 411, IC IC67, analog/basic/mos_r2r_dac.hpp:28
        I(cpphdl_n982, cpphdl_n1002) <+ V(cpphdl_n982, cpphdl_n1002) / 2000.0;
        // device 412, IC IC67, analog/basic/mos_r2r_dac.hpp:29
        I(cpphdl_n1002, Vss) <+ 2.9999999999999998e-15 * ddt(V(cpphdl_n1002, Vss)); // Bench initial voltage = 0.0 V.
        // device 413, IC IC67, analog/basic/mos_r2r_dac.hpp:31
        I(cpphdl_n1001, cpphdl_n1002) <+ V(cpphdl_n1001, cpphdl_n1002) / 1000.0;
        // device 414, IC IC72, analog/basic/inverter.hpp:11
        I(cpphdl_n986, Vdd) <+ cpphdl_channel(V(BIT_N2_4, Vdd), V(cpphdl_n986, Vdd), 0.080000000000000002, 0.69999999999999996, -1.0);
        // device 415, IC IC72, analog/basic/inverter.hpp:12
        I(cpphdl_n986, Vss) <+ cpphdl_channel(V(BIT_N2_4, Vss), V(cpphdl_n986, Vss), 0.080000000000000002, 0.69999999999999996, 1.0);
        // device 416, IC IC67, analog/basic/mos_r2r_dac.hpp:27
        I(cpphdl_n986, Vss) <+ 2.9999999999999998e-15 * ddt(V(cpphdl_n986, Vss)); // Bench initial voltage = 0.0 V.
        // device 417, IC IC67, analog/basic/mos_r2r_dac.hpp:28
        I(cpphdl_n986, cpphdl_n1003) <+ V(cpphdl_n986, cpphdl_n1003) / 2000.0;
        // device 418, IC IC67, analog/basic/mos_r2r_dac.hpp:29
        I(cpphdl_n1003, Vss) <+ 2.9999999999999998e-15 * ddt(V(cpphdl_n1003, Vss)); // Bench initial voltage = 0.0 V.
        // device 419, IC IC67, analog/basic/mos_r2r_dac.hpp:31
        I(cpphdl_n1002, cpphdl_n1003) <+ V(cpphdl_n1002, cpphdl_n1003) / 1000.0;
        // device 420, IC IC73, analog/basic/inverter.hpp:11
        I(cpphdl_n990, Vdd) <+ cpphdl_channel(V(BIT_N2_5, Vdd), V(cpphdl_n990, Vdd), 0.080000000000000002, 0.69999999999999996, -1.0);
        // device 421, IC IC73, analog/basic/inverter.hpp:12
        I(cpphdl_n990, Vss) <+ cpphdl_channel(V(BIT_N2_5, Vss), V(cpphdl_n990, Vss), 0.080000000000000002, 0.69999999999999996, 1.0);
        // device 422, IC IC67, analog/basic/mos_r2r_dac.hpp:27
        I(cpphdl_n990, Vss) <+ 2.9999999999999998e-15 * ddt(V(cpphdl_n990, Vss)); // Bench initial voltage = 0.0 V.
        // device 423, IC IC67, analog/basic/mos_r2r_dac.hpp:28
        I(cpphdl_n990, cpphdl_n1004) <+ V(cpphdl_n990, cpphdl_n1004) / 2000.0;
        // device 424, IC IC67, analog/basic/mos_r2r_dac.hpp:29
        I(cpphdl_n1004, Vss) <+ 2.9999999999999998e-15 * ddt(V(cpphdl_n1004, Vss)); // Bench initial voltage = 0.0 V.
        // device 425, IC IC67, analog/basic/mos_r2r_dac.hpp:31
        I(cpphdl_n1003, cpphdl_n1004) <+ V(cpphdl_n1003, cpphdl_n1004) / 1000.0;
        // device 426, IC IC74, analog/basic/inverter.hpp:11
        I(cpphdl_n994, Vdd) <+ cpphdl_channel(V(BIT_N2_6, Vdd), V(cpphdl_n994, Vdd), 0.080000000000000002, 0.69999999999999996, -1.0);
        // device 427, IC IC74, analog/basic/inverter.hpp:12
        I(cpphdl_n994, Vss) <+ cpphdl_channel(V(BIT_N2_6, Vss), V(cpphdl_n994, Vss), 0.080000000000000002, 0.69999999999999996, 1.0);
        // device 428, IC IC67, analog/basic/mos_r2r_dac.hpp:27
        I(cpphdl_n994, Vss) <+ 2.9999999999999998e-15 * ddt(V(cpphdl_n994, Vss)); // Bench initial voltage = 0.0 V.
        // device 429, IC IC67, analog/basic/mos_r2r_dac.hpp:28
        I(cpphdl_n994, cpphdl_n1005) <+ V(cpphdl_n994, cpphdl_n1005) / 2000.0;
        // device 430, IC IC67, analog/basic/mos_r2r_dac.hpp:29
        I(cpphdl_n1005, Vss) <+ 2.9999999999999998e-15 * ddt(V(cpphdl_n1005, Vss)); // Bench initial voltage = 0.0 V.
        // device 431, IC IC67, analog/basic/mos_r2r_dac.hpp:31
        I(cpphdl_n1004, cpphdl_n1005) <+ V(cpphdl_n1004, cpphdl_n1005) / 1000.0;
        // device 432, IC IC75, analog/basic/inverter.hpp:11
        I(cpphdl_n998, Vdd) <+ cpphdl_channel(V(BIT_N2_7, Vdd), V(cpphdl_n998, Vdd), 0.080000000000000002, 0.69999999999999996, -1.0);
        // device 433, IC IC75, analog/basic/inverter.hpp:12
        I(cpphdl_n998, Vss) <+ cpphdl_channel(V(BIT_N2_7, Vss), V(cpphdl_n998, Vss), 0.080000000000000002, 0.69999999999999996, 1.0);
        // device 434, IC IC67, analog/basic/mos_r2r_dac.hpp:27
        I(cpphdl_n998, Vss) <+ 2.9999999999999998e-15 * ddt(V(cpphdl_n998, Vss)); // Bench initial voltage = 0.0 V.
        // device 435, IC IC67, analog/basic/mos_r2r_dac.hpp:28
        I(cpphdl_n998, cpphdl_n1010) <+ V(cpphdl_n998, cpphdl_n1010) / 2000.0;
        // device 436, IC IC67, analog/basic/mos_r2r_dac.hpp:29
        I(cpphdl_n1010, Vss) <+ 2.9999999999999998e-15 * ddt(V(cpphdl_n1010, Vss)); // Bench initial voltage = 0.0 V.
        // device 437, IC IC67, analog/basic/mos_r2r_dac.hpp:31
        I(cpphdl_n1005, cpphdl_n1010) <+ V(cpphdl_n1005, cpphdl_n1010) / 1000.0;
        // device 438, IC IC67, analog/basic/mos_r2r_dac.hpp:33
        I(Vss, cpphdl_n999) <+ V(Vss, cpphdl_n999) / 2000.0;
        // device 439, IC IC76, analog/basic/nmos_resistor_amplifier.hpp:23
        I(Vdd, cpphdl_n1019) <+ V(Vdd, cpphdl_n1019) / 1000.0;
        // device 440, IC IC76, analog/basic/nmos_resistor_amplifier.hpp:24
        I(Vdd, cpphdl_n1018) <+ V(Vdd, cpphdl_n1018) / 1000.0;
        // device 441, IC IC76, analog/basic/nmos_resistor_amplifier.hpp:25
        I(cpphdl_n1019, cpphdl_n1013) <+ cpphdl_channel(V(cpphdl_n1009, cpphdl_n1013), V(cpphdl_n1019, cpphdl_n1013), 0.0074999999999999997, 0.69999999999999996, 1.0);
        // device 442, IC IC76, analog/basic/nmos_resistor_amplifier.hpp:26
        I(cpphdl_n1018, cpphdl_n1014) <+ cpphdl_channel(V(cpphdl_n1010, cpphdl_n1014), V(cpphdl_n1018, cpphdl_n1014), 0.0074999999999999997, 0.69999999999999996, 1.0);
        // device 443, IC IC76, analog/basic/nmos_resistor_amplifier.hpp:27
        I(cpphdl_n1015, cpphdl_n1013) <+ V(cpphdl_n1015, cpphdl_n1013) / 100.0;
        // device 444, IC IC76, analog/basic/nmos_resistor_amplifier.hpp:28
        I(cpphdl_n1015, cpphdl_n1014) <+ V(cpphdl_n1015, cpphdl_n1014) / 100.0;
        // device 445, IC IC76, analog/basic/nmos_resistor_amplifier.hpp:29
        I(Vss, cpphdl_n1015) <+ V(Vss, cpphdl_n1015) / 300.0;
        // device 446, IC IC76, analog/basic/nmos_resistor_amplifier.hpp:30
        I(cpphdl_n1019, Vdd) <+ 2.9999999999999998e-13 * ddt(V(cpphdl_n1019, Vdd)); // Bench initial voltage = 0.0 V.
        // device 447, IC IC76, analog/basic/nmos_resistor_amplifier.hpp:31
        I(cpphdl_n1018, Vdd) <+ 2.9999999999999998e-13 * ddt(V(cpphdl_n1018, Vdd)); // Bench initial voltage = 0.0 V.
        // device 448, IC IC76, analog/basic/nmos_resistor_amplifier.hpp:32
        I(cpphdl_n1015, Vss) <+ 4e-14 * ddt(V(cpphdl_n1015, Vss)); // Bench initial voltage = 0.0 V.
        // device 449, IC IC76, analog/basic/nmos_resistor_amplifier.hpp:34
        I(cpphdl_n1009, cpphdl_n1013) <+ 2e-14 * ddt(V(cpphdl_n1009, cpphdl_n1013)); // Bench initial voltage = 0.0 V.
        // device 450, IC IC76, analog/basic/nmos_resistor_amplifier.hpp:35
        I(cpphdl_n1010, cpphdl_n1014) <+ 2e-14 * ddt(V(cpphdl_n1010, cpphdl_n1014)); // Bench initial voltage = 0.0 V.
        // device 451, IC IC76, analog/basic/nmos_resistor_amplifier.hpp:36
        I(cpphdl_n1009, cpphdl_n1019) <+ 2.9999999999999998e-15 * ddt(V(cpphdl_n1009, cpphdl_n1019)); // Bench initial voltage = 0.0 V.
        // device 452, IC IC76, analog/basic/nmos_resistor_amplifier.hpp:37
        I(cpphdl_n1010, cpphdl_n1018) <+ 2.9999999999999998e-15 * ddt(V(cpphdl_n1010, cpphdl_n1018)); // Bench initial voltage = 0.0 V.
        // device 453, IC IC77, analog/basic/strongarm_comparator.hpp:28
        I(cpphdl_n1023, cpphdl_n1025) <+ cpphdl_channel(V(cpphdl_n1018, cpphdl_n1025), V(cpphdl_n1023, cpphdl_n1025), 0.0080000000000000002, 0.69999999999999996, 1.0);
        // device 454, IC IC77, analog/basic/strongarm_comparator.hpp:29
        I(cpphdl_n1024, cpphdl_n1025) <+ cpphdl_channel(V(cpphdl_n1019, cpphdl_n1025), V(cpphdl_n1024, cpphdl_n1025), 0.0080000000000000002, 0.69999999999999996, 1.0);
        // device 455, IC IC77, analog/basic/strongarm_comparator.hpp:30
        I(cpphdl_n1025, Vss) <+ cpphdl_channel(V(EVALUATE, Vss), V(cpphdl_n1025, Vss), 0.0080000000000000002, 0.69999999999999996, 1.0);
        // device 456, IC IC77, analog/basic/strongarm_comparator.hpp:33
        I(cpphdl_n1038, cpphdl_n1023) <+ cpphdl_channel(V(cpphdl_n1042, cpphdl_n1023), V(cpphdl_n1038, cpphdl_n1023), 0.0040000000000000001, 0.69999999999999996, 1.0);
        // device 457, IC IC77, analog/basic/strongarm_comparator.hpp:34
        I(cpphdl_n1042, cpphdl_n1024) <+ cpphdl_channel(V(cpphdl_n1038, cpphdl_n1024), V(cpphdl_n1042, cpphdl_n1024), 0.0040000000000000001, 0.69999999999999996, 1.0);
        // device 458, IC IC77, analog/basic/strongarm_comparator.hpp:35
        I(cpphdl_n1042, Vdd) <+ cpphdl_channel(V(cpphdl_n1038, Vdd), V(cpphdl_n1042, Vdd), 0.002, 0.69999999999999996, -1.0);
        // device 459, IC IC77, analog/basic/strongarm_comparator.hpp:36
        I(cpphdl_n1038, Vdd) <+ cpphdl_channel(V(cpphdl_n1042, Vdd), V(cpphdl_n1038, Vdd), 0.002, 0.69999999999999996, -1.0);
        // device 460, IC IC77, analog/basic/strongarm_comparator.hpp:38
        I(cpphdl_n1023, Vdd) <+ cpphdl_channel(V(EVALUATE, Vdd), V(cpphdl_n1023, Vdd), 0.002, 0.69999999999999996, -1.0);
        // device 461, IC IC77, analog/basic/strongarm_comparator.hpp:39
        I(cpphdl_n1024, Vdd) <+ cpphdl_channel(V(EVALUATE, Vdd), V(cpphdl_n1024, Vdd), 0.002, 0.69999999999999996, -1.0);
        // device 462, IC IC77, analog/basic/strongarm_comparator.hpp:40
        I(cpphdl_n1042, Vdd) <+ cpphdl_channel(V(EVALUATE, Vdd), V(cpphdl_n1042, Vdd), 0.002, 0.69999999999999996, -1.0);
        // device 463, IC IC77, analog/basic/strongarm_comparator.hpp:41
        I(cpphdl_n1038, Vdd) <+ cpphdl_channel(V(EVALUATE, Vdd), V(cpphdl_n1038, Vdd), 0.002, 0.69999999999999996, -1.0);
        // device 464, IC IC77, analog/basic/strongarm_comparator.hpp:42
        I(cpphdl_n1023, Vss) <+ 2.9999999999999998e-14 * ddt(V(cpphdl_n1023, Vss)); // Bench initial voltage = 0.0 V.
        // device 465, IC IC77, analog/basic/strongarm_comparator.hpp:43
        I(cpphdl_n1024, Vss) <+ 2.9999999999999998e-14 * ddt(V(cpphdl_n1024, Vss)); // Bench initial voltage = 0.0 V.
        // device 466, IC IC77, analog/basic/strongarm_comparator.hpp:44
        I(cpphdl_n1025, Vss) <+ 2.9999999999999998e-14 * ddt(V(cpphdl_n1025, Vss)); // Bench initial voltage = 0.0 V.
        // device 467, IC IC77, analog/basic/strongarm_comparator.hpp:45
        I(cpphdl_n1042, Vss) <+ 5.0000000000000002e-14 * ddt(V(cpphdl_n1042, Vss)); // Bench initial voltage = 0.0 V.
        // device 468, IC IC77, analog/basic/strongarm_comparator.hpp:46
        I(cpphdl_n1038, Vss) <+ 5.0000000000000002e-14 * ddt(V(cpphdl_n1038, Vss)); // Bench initial voltage = 0.0 V.
        // device 469, IC IC77, analog/basic/strongarm_comparator.hpp:47
        I(cpphdl_n1018, cpphdl_n1025) <+ 2e-14 * ddt(V(cpphdl_n1018, cpphdl_n1025)); // Bench initial voltage = 0.0 V.
        // device 470, IC IC77, analog/basic/strongarm_comparator.hpp:48
        I(cpphdl_n1019, cpphdl_n1025) <+ 2e-14 * ddt(V(cpphdl_n1019, cpphdl_n1025)); // Bench initial voltage = 0.0 V.
        // device 471, IC IC77, analog/basic/strongarm_comparator.hpp:49
        I(cpphdl_n1018, cpphdl_n1023) <+ 2.9999999999999998e-15 * ddt(V(cpphdl_n1018, cpphdl_n1023)); // Bench initial voltage = 0.0 V.
        // device 472, IC IC77, analog/basic/strongarm_comparator.hpp:50
        I(cpphdl_n1019, cpphdl_n1024) <+ 2.9999999999999998e-15 * ddt(V(cpphdl_n1019, cpphdl_n1024)); // Bench initial voltage = 0.0 V.
        // device 473, IC IC79, analog/basic/inverter.hpp:11
        I(cpphdl_n1046, Vdd) <+ cpphdl_channel(V(cpphdl_n1038, Vdd), V(cpphdl_n1046, Vdd), 0.001, 0.69999999999999996, -1.0);
        // device 474, IC IC79, analog/basic/inverter.hpp:12
        I(cpphdl_n1046, Vss) <+ cpphdl_channel(V(cpphdl_n1038, Vss), V(cpphdl_n1046, Vss), 0.001, 0.69999999999999996, 1.0);
        // device 475, IC IC81, analog/basic/inverter.hpp:11
        I(cpphdl_n1060, Vdd) <+ cpphdl_channel(V(cpphdl_n1046, Vdd), V(cpphdl_n1060, Vdd), 0.0040000000000000001, 0.69999999999999996, -1.0);
        // device 476, IC IC81, analog/basic/inverter.hpp:12
        I(cpphdl_n1060, Vss) <+ cpphdl_channel(V(cpphdl_n1046, Vss), V(cpphdl_n1060, Vss), 0.0040000000000000001, 0.69999999999999996, 1.0);
        // device 477, IC IC78, analog/basic/buffered_nand_latch.hpp:34
        I(cpphdl_n1038, Vss) <+ 2.0000000000000002e-15 * ddt(V(cpphdl_n1038, Vss)); // Bench initial voltage = 0.0 V.
        // device 478, IC IC78, analog/basic/buffered_nand_latch.hpp:35
        I(cpphdl_n1038, cpphdl_n1046) <+ 1.0000000000000001e-15 * ddt(V(cpphdl_n1038, cpphdl_n1046)); // Bench initial voltage = 0.0 V.
        // device 479, IC IC78, analog/basic/buffered_nand_latch.hpp:36
        I(cpphdl_n1046, Vss) <+ 5e-15 * ddt(V(cpphdl_n1046, Vss)); // Bench initial voltage = 0.0 V.
        // device 480, IC IC78, analog/basic/buffered_nand_latch.hpp:37
        I(cpphdl_n1046, Vss) <+ 8.0000000000000006e-15 * ddt(V(cpphdl_n1046, Vss)); // Bench initial voltage = 0.0 V.
        // device 481, IC IC78, analog/basic/buffered_nand_latch.hpp:38
        I(cpphdl_n1060, Vss) <+ 1e-14 * ddt(V(cpphdl_n1060, Vss)); // Bench initial voltage = 0.0 V.
        // device 482, IC IC80, analog/basic/inverter.hpp:11
        I(cpphdl_n1050, Vdd) <+ cpphdl_channel(V(cpphdl_n1042, Vdd), V(cpphdl_n1050, Vdd), 0.001, 0.69999999999999996, -1.0);
        // device 483, IC IC80, analog/basic/inverter.hpp:12
        I(cpphdl_n1050, Vss) <+ cpphdl_channel(V(cpphdl_n1042, Vss), V(cpphdl_n1050, Vss), 0.001, 0.69999999999999996, 1.0);
        // device 484, IC IC82, analog/basic/inverter.hpp:11
        I(cpphdl_n1066, Vdd) <+ cpphdl_channel(V(cpphdl_n1050, Vdd), V(cpphdl_n1066, Vdd), 0.0040000000000000001, 0.69999999999999996, -1.0);
        // device 485, IC IC82, analog/basic/inverter.hpp:12
        I(cpphdl_n1066, Vss) <+ cpphdl_channel(V(cpphdl_n1050, Vss), V(cpphdl_n1066, Vss), 0.0040000000000000001, 0.69999999999999996, 1.0);
        // device 486, IC IC78, analog/basic/buffered_nand_latch.hpp:34
        I(cpphdl_n1042, Vss) <+ 2.0000000000000002e-15 * ddt(V(cpphdl_n1042, Vss)); // Bench initial voltage = 0.0 V.
        // device 487, IC IC78, analog/basic/buffered_nand_latch.hpp:35
        I(cpphdl_n1042, cpphdl_n1050) <+ 1.0000000000000001e-15 * ddt(V(cpphdl_n1042, cpphdl_n1050)); // Bench initial voltage = 0.0 V.
        // device 488, IC IC78, analog/basic/buffered_nand_latch.hpp:36
        I(cpphdl_n1050, Vss) <+ 5e-15 * ddt(V(cpphdl_n1050, Vss)); // Bench initial voltage = 0.0 V.
        // device 489, IC IC78, analog/basic/buffered_nand_latch.hpp:37
        I(cpphdl_n1050, Vss) <+ 8.0000000000000006e-15 * ddt(V(cpphdl_n1050, Vss)); // Bench initial voltage = 0.0 V.
        // device 490, IC IC78, analog/basic/buffered_nand_latch.hpp:38
        I(cpphdl_n1066, Vss) <+ 1e-14 * ddt(V(cpphdl_n1066, Vss)); // Bench initial voltage = 0.0 V.
        // device 491, IC IC84, analog/basic/cmos_logic.hpp:17
        I(cpphdl_n2963, Vss) <+ 5.0000000000000002e-14 * ddt(V(cpphdl_n2963, Vss)); // Bench initial voltage = 0.0 V.
        // device 492, IC IC84, analog/basic/cmos_logic.hpp:18
        I(cpphdl_n2963, Vdd) <+ cpphdl_channel(V(cpphdl_n1060, Vdd), V(cpphdl_n2963, Vdd), 0.01, 0.69999999999999996, -1.0);
        // device 493, IC IC84, analog/basic/cmos_logic.hpp:19
        I(cpphdl_n2963, Vdd) <+ cpphdl_channel(V(cpphdl_n1068, Vdd), V(cpphdl_n2963, Vdd), 0.01, 0.69999999999999996, -1.0);
        // device 494, IC IC84, analog/basic/cmos_logic.hpp:20
        I(cpphdl_n2963, cpphdl_n1063) <+ cpphdl_channel(V(cpphdl_n1060, cpphdl_n1063), V(cpphdl_n2963, cpphdl_n1063), 0.01, 0.69999999999999996, 1.0);
        // device 495, IC IC84, analog/basic/cmos_logic.hpp:21
        I(cpphdl_n1063, Vss) <+ cpphdl_channel(V(cpphdl_n1068, Vss), V(cpphdl_n1063, Vss), 0.01, 0.69999999999999996, 1.0);
        // device 496, IC IC84, analog/basic/cmos_logic.hpp:27
        I(cpphdl_n1063, Vss) <+ 1e-14 * ddt(V(cpphdl_n1063, Vss)); // Bench initial voltage = 0.0 V.
        // device 497, IC IC85, analog/basic/cmos_logic.hpp:17
        I(cpphdl_n1068, Vss) <+ 5.0000000000000002e-14 * ddt(V(cpphdl_n1068, Vss)); // Bench initial voltage = 0.0 V.
        // device 498, IC IC85, analog/basic/cmos_logic.hpp:18
        I(cpphdl_n1068, Vdd) <+ cpphdl_channel(V(cpphdl_n1066, Vdd), V(cpphdl_n1068, Vdd), 0.01, 0.69999999999999996, -1.0);
        // device 499, IC IC85, analog/basic/cmos_logic.hpp:19
        I(cpphdl_n1068, Vdd) <+ cpphdl_channel(V(cpphdl_n2963, Vdd), V(cpphdl_n1068, Vdd), 0.01, 0.69999999999999996, -1.0);
        // device 500, IC IC85, analog/basic/cmos_logic.hpp:20
        I(cpphdl_n1068, cpphdl_n1069) <+ cpphdl_channel(V(cpphdl_n1066, cpphdl_n1069), V(cpphdl_n1068, cpphdl_n1069), 0.01, 0.69999999999999996, 1.0);
        // device 501, IC IC85, analog/basic/cmos_logic.hpp:21
        I(cpphdl_n1069, Vss) <+ cpphdl_channel(V(cpphdl_n2963, Vss), V(cpphdl_n1069, Vss), 0.01, 0.69999999999999996, 1.0);
        // device 502, IC IC85, analog/basic/cmos_logic.hpp:27
        I(cpphdl_n1069, Vss) <+ 1e-14 * ddt(V(cpphdl_n1069, Vss)); // Bench initial voltage = 0.0 V.
        // device 503, IC IC83, analog/basic/nand_latch.hpp:36
        I(cpphdl_n1060, Vss) <+ 2.9999999999999998e-15 * ddt(V(cpphdl_n1060, Vss)); // Bench initial voltage = 0.0 V.
        // device 504, IC IC83, analog/basic/nand_latch.hpp:37
        I(cpphdl_n1066, Vss) <+ 2.9999999999999998e-15 * ddt(V(cpphdl_n1066, Vss)); // Bench initial voltage = 0.0 V.
        // device 505, IC IC86, analog/basic/inverter.hpp:11
        I(cpphdl_n1074, Vdd) <+ cpphdl_channel(V(CLEAR, Vdd), V(cpphdl_n1074, Vdd), 0.01, 0.69999999999999996, -1.0);
        // device 506, IC IC86, analog/basic/inverter.hpp:12
        I(cpphdl_n1074, Vss) <+ cpphdl_channel(V(CLEAR, Vss), V(cpphdl_n1074, Vss), 0.01, 0.69999999999999996, 1.0);
        // device 507, IC IC83, analog/basic/nand_latch.hpp:58
        I(cpphdl_n1074, Vss) <+ 2.9999999999999998e-15 * ddt(V(cpphdl_n1074, Vss)); // Bench initial voltage = 0.0 V.
        // device 508, IC IC83, analog/basic/nand_latch.hpp:59
        I(cpphdl_n2963, Vss) <+ cpphdl_channel(V(CLEAR, Vss), V(cpphdl_n2963, Vss), 0.050000000000000003, 0.69999999999999996, 1.0);
        // device 509, IC IC83, analog/basic/nand_latch.hpp:60
        I(cpphdl_n1068, Vdd) <+ cpphdl_channel(V(cpphdl_n1074, Vdd), V(cpphdl_n1068, Vdd), 0.050000000000000003, 0.69999999999999996, -1.0);
        // device 510, IC IC89, analog/basic/inverter.hpp:11
        I(cpphdl_n1098, Vdd) <+ cpphdl_channel(V(TRACK3, Vdd), V(cpphdl_n1098, Vdd), 0.0040000000000000001, 0.69999999999999996, -1.0);
        // device 511, IC IC89, analog/basic/inverter.hpp:12
        I(cpphdl_n1098, Vss) <+ cpphdl_channel(V(TRACK3, Vss), V(cpphdl_n1098, Vss), 0.0040000000000000001, 0.69999999999999996, 1.0);
        // device 512, IC IC88, analog/basic/mos_track_hold.hpp:31
        I(cpphdl_n1098, Vss) <+ 2e-14 * ddt(V(cpphdl_n1098, Vss)); // Bench initial voltage = 0.0 V.
        // device 513, IC IC88, analog/basic/mos_track_hold.hpp:32
        I(cpphdl_n2808, cpphdl_n1152) <+ cpphdl_channel(V(TRACK3, cpphdl_n1152), V(cpphdl_n2808, cpphdl_n1152), 0.029999999999999999, 0.69999999999999996, 1.0);
        // device 514, IC IC88, analog/basic/mos_track_hold.hpp:33
        I(cpphdl_n1152, cpphdl_n2808) <+ cpphdl_channel(V(cpphdl_n1098, cpphdl_n2808), V(cpphdl_n1152, cpphdl_n2808), 0.014999999999999999, 0.69999999999999996, -1.0);
        // device 515, IC IC88, analog/basic/mos_track_hold.hpp:37
        I(cpphdl_n1152, cpphdl_n1152) <+ cpphdl_channel(V(cpphdl_n1098, cpphdl_n1152), V(cpphdl_n1152, cpphdl_n1152), 0.016, 0.69999999999999996, 1.0);
        // device 516, IC IC88, analog/basic/mos_track_hold.hpp:38
        I(cpphdl_n1152, cpphdl_n1152) <+ cpphdl_channel(V(TRACK3, cpphdl_n1152), V(cpphdl_n1152, cpphdl_n1152), 0.0083999999999999995, 0.69999999999999996, -1.0);
        // device 517, IC IC88, analog/basic/mos_track_hold.hpp:39
        I(cpphdl_n1152, Vss) <+ 1.5000000000000001e-12 * ddt(V(cpphdl_n1152, Vss)); // Bench initial voltage = 0.0 V.
        // device 518, IC IC88, analog/basic/mos_track_hold.hpp:42
        I(TRACK3, cpphdl_n1152) <+ 2.0000000000000002e-15 * ddt(V(TRACK3, cpphdl_n1152)); // Bench initial voltage = -0.0 V.
        // device 519, IC IC88, analog/basic/mos_track_hold.hpp:43
        I(cpphdl_n1098, cpphdl_n1152) <+ 2.0000000000000002e-15 * ddt(V(cpphdl_n1098, cpphdl_n1152)); // Bench initial voltage = 0.0 V.
        // device 520, IC IC88, analog/basic/mos_track_hold.hpp:44
        I(cpphdl_n2808, cpphdl_n1152) <+ 1.0000000000000001e-15 * ddt(V(cpphdl_n2808, cpphdl_n1152)); // Bench initial voltage = 0.0 V.
        // device 521, IC IC91, analog/basic/inverter.hpp:11
        I(cpphdl_n1113, Vdd) <+ cpphdl_channel(V(BIT_N3_0, Vdd), V(cpphdl_n1113, Vdd), 0.080000000000000002, 0.69999999999999996, -1.0);
        // device 522, IC IC91, analog/basic/inverter.hpp:12
        I(cpphdl_n1113, Vss) <+ cpphdl_channel(V(BIT_N3_0, Vss), V(cpphdl_n1113, Vss), 0.080000000000000002, 0.69999999999999996, 1.0);
        // device 523, IC IC90, analog/basic/mos_r2r_dac.hpp:27
        I(cpphdl_n1113, Vss) <+ 2.9999999999999998e-15 * ddt(V(cpphdl_n1113, Vss)); // Bench initial voltage = 0.0 V.
        // device 524, IC IC90, analog/basic/mos_r2r_dac.hpp:28
        I(cpphdl_n1113, cpphdl_n1142) <+ V(cpphdl_n1113, cpphdl_n1142) / 2000.0;
        // device 525, IC IC90, analog/basic/mos_r2r_dac.hpp:29
        I(cpphdl_n1142, Vss) <+ 2.9999999999999998e-15 * ddt(V(cpphdl_n1142, Vss)); // Bench initial voltage = 0.0 V.
        // device 526, IC IC92, analog/basic/inverter.hpp:11
        I(cpphdl_n1117, Vdd) <+ cpphdl_channel(V(BIT_N3_1, Vdd), V(cpphdl_n1117, Vdd), 0.080000000000000002, 0.69999999999999996, -1.0);
        // device 527, IC IC92, analog/basic/inverter.hpp:12
        I(cpphdl_n1117, Vss) <+ cpphdl_channel(V(BIT_N3_1, Vss), V(cpphdl_n1117, Vss), 0.080000000000000002, 0.69999999999999996, 1.0);
        // device 528, IC IC90, analog/basic/mos_r2r_dac.hpp:27
        I(cpphdl_n1117, Vss) <+ 2.9999999999999998e-15 * ddt(V(cpphdl_n1117, Vss)); // Bench initial voltage = 0.0 V.
        // device 529, IC IC90, analog/basic/mos_r2r_dac.hpp:28
        I(cpphdl_n1117, cpphdl_n1143) <+ V(cpphdl_n1117, cpphdl_n1143) / 2000.0;
        // device 530, IC IC90, analog/basic/mos_r2r_dac.hpp:29
        I(cpphdl_n1143, Vss) <+ 2.9999999999999998e-15 * ddt(V(cpphdl_n1143, Vss)); // Bench initial voltage = 0.0 V.
        // device 531, IC IC90, analog/basic/mos_r2r_dac.hpp:31
        I(cpphdl_n1142, cpphdl_n1143) <+ V(cpphdl_n1142, cpphdl_n1143) / 1000.0;
        // device 532, IC IC93, analog/basic/inverter.hpp:11
        I(cpphdl_n1121, Vdd) <+ cpphdl_channel(V(BIT_N3_2, Vdd), V(cpphdl_n1121, Vdd), 0.080000000000000002, 0.69999999999999996, -1.0);
        // device 533, IC IC93, analog/basic/inverter.hpp:12
        I(cpphdl_n1121, Vss) <+ cpphdl_channel(V(BIT_N3_2, Vss), V(cpphdl_n1121, Vss), 0.080000000000000002, 0.69999999999999996, 1.0);
        // device 534, IC IC90, analog/basic/mos_r2r_dac.hpp:27
        I(cpphdl_n1121, Vss) <+ 2.9999999999999998e-15 * ddt(V(cpphdl_n1121, Vss)); // Bench initial voltage = 0.0 V.
        // device 535, IC IC90, analog/basic/mos_r2r_dac.hpp:28
        I(cpphdl_n1121, cpphdl_n1144) <+ V(cpphdl_n1121, cpphdl_n1144) / 2000.0;
        // device 536, IC IC90, analog/basic/mos_r2r_dac.hpp:29
        I(cpphdl_n1144, Vss) <+ 2.9999999999999998e-15 * ddt(V(cpphdl_n1144, Vss)); // Bench initial voltage = 0.0 V.
        // device 537, IC IC90, analog/basic/mos_r2r_dac.hpp:31
        I(cpphdl_n1143, cpphdl_n1144) <+ V(cpphdl_n1143, cpphdl_n1144) / 1000.0;
        // device 538, IC IC94, analog/basic/inverter.hpp:11
        I(cpphdl_n1125, Vdd) <+ cpphdl_channel(V(BIT_N3_3, Vdd), V(cpphdl_n1125, Vdd), 0.080000000000000002, 0.69999999999999996, -1.0);
        // device 539, IC IC94, analog/basic/inverter.hpp:12
        I(cpphdl_n1125, Vss) <+ cpphdl_channel(V(BIT_N3_3, Vss), V(cpphdl_n1125, Vss), 0.080000000000000002, 0.69999999999999996, 1.0);
        // device 540, IC IC90, analog/basic/mos_r2r_dac.hpp:27
        I(cpphdl_n1125, Vss) <+ 2.9999999999999998e-15 * ddt(V(cpphdl_n1125, Vss)); // Bench initial voltage = 0.0 V.
        // device 541, IC IC90, analog/basic/mos_r2r_dac.hpp:28
        I(cpphdl_n1125, cpphdl_n1145) <+ V(cpphdl_n1125, cpphdl_n1145) / 2000.0;
        // device 542, IC IC90, analog/basic/mos_r2r_dac.hpp:29
        I(cpphdl_n1145, Vss) <+ 2.9999999999999998e-15 * ddt(V(cpphdl_n1145, Vss)); // Bench initial voltage = 0.0 V.
        // device 543, IC IC90, analog/basic/mos_r2r_dac.hpp:31
        I(cpphdl_n1144, cpphdl_n1145) <+ V(cpphdl_n1144, cpphdl_n1145) / 1000.0;
        // device 544, IC IC95, analog/basic/inverter.hpp:11
        I(cpphdl_n1129, Vdd) <+ cpphdl_channel(V(BIT_N3_4, Vdd), V(cpphdl_n1129, Vdd), 0.080000000000000002, 0.69999999999999996, -1.0);
        // device 545, IC IC95, analog/basic/inverter.hpp:12
        I(cpphdl_n1129, Vss) <+ cpphdl_channel(V(BIT_N3_4, Vss), V(cpphdl_n1129, Vss), 0.080000000000000002, 0.69999999999999996, 1.0);
        // device 546, IC IC90, analog/basic/mos_r2r_dac.hpp:27
        I(cpphdl_n1129, Vss) <+ 2.9999999999999998e-15 * ddt(V(cpphdl_n1129, Vss)); // Bench initial voltage = 0.0 V.
        // device 547, IC IC90, analog/basic/mos_r2r_dac.hpp:28
        I(cpphdl_n1129, cpphdl_n1146) <+ V(cpphdl_n1129, cpphdl_n1146) / 2000.0;
        // device 548, IC IC90, analog/basic/mos_r2r_dac.hpp:29
        I(cpphdl_n1146, Vss) <+ 2.9999999999999998e-15 * ddt(V(cpphdl_n1146, Vss)); // Bench initial voltage = 0.0 V.
        // device 549, IC IC90, analog/basic/mos_r2r_dac.hpp:31
        I(cpphdl_n1145, cpphdl_n1146) <+ V(cpphdl_n1145, cpphdl_n1146) / 1000.0;
        // device 550, IC IC96, analog/basic/inverter.hpp:11
        I(cpphdl_n1133, Vdd) <+ cpphdl_channel(V(BIT_N3_5, Vdd), V(cpphdl_n1133, Vdd), 0.080000000000000002, 0.69999999999999996, -1.0);
        // device 551, IC IC96, analog/basic/inverter.hpp:12
        I(cpphdl_n1133, Vss) <+ cpphdl_channel(V(BIT_N3_5, Vss), V(cpphdl_n1133, Vss), 0.080000000000000002, 0.69999999999999996, 1.0);
        // device 552, IC IC90, analog/basic/mos_r2r_dac.hpp:27
        I(cpphdl_n1133, Vss) <+ 2.9999999999999998e-15 * ddt(V(cpphdl_n1133, Vss)); // Bench initial voltage = 0.0 V.
        // device 553, IC IC90, analog/basic/mos_r2r_dac.hpp:28
        I(cpphdl_n1133, cpphdl_n1147) <+ V(cpphdl_n1133, cpphdl_n1147) / 2000.0;
        // device 554, IC IC90, analog/basic/mos_r2r_dac.hpp:29
        I(cpphdl_n1147, Vss) <+ 2.9999999999999998e-15 * ddt(V(cpphdl_n1147, Vss)); // Bench initial voltage = 0.0 V.
        // device 555, IC IC90, analog/basic/mos_r2r_dac.hpp:31
        I(cpphdl_n1146, cpphdl_n1147) <+ V(cpphdl_n1146, cpphdl_n1147) / 1000.0;
        // device 556, IC IC97, analog/basic/inverter.hpp:11
        I(cpphdl_n1137, Vdd) <+ cpphdl_channel(V(BIT_N3_6, Vdd), V(cpphdl_n1137, Vdd), 0.080000000000000002, 0.69999999999999996, -1.0);
        // device 557, IC IC97, analog/basic/inverter.hpp:12
        I(cpphdl_n1137, Vss) <+ cpphdl_channel(V(BIT_N3_6, Vss), V(cpphdl_n1137, Vss), 0.080000000000000002, 0.69999999999999996, 1.0);
        // device 558, IC IC90, analog/basic/mos_r2r_dac.hpp:27
        I(cpphdl_n1137, Vss) <+ 2.9999999999999998e-15 * ddt(V(cpphdl_n1137, Vss)); // Bench initial voltage = 0.0 V.
        // device 559, IC IC90, analog/basic/mos_r2r_dac.hpp:28
        I(cpphdl_n1137, cpphdl_n1148) <+ V(cpphdl_n1137, cpphdl_n1148) / 2000.0;
        // device 560, IC IC90, analog/basic/mos_r2r_dac.hpp:29
        I(cpphdl_n1148, Vss) <+ 2.9999999999999998e-15 * ddt(V(cpphdl_n1148, Vss)); // Bench initial voltage = 0.0 V.
        // device 561, IC IC90, analog/basic/mos_r2r_dac.hpp:31
        I(cpphdl_n1147, cpphdl_n1148) <+ V(cpphdl_n1147, cpphdl_n1148) / 1000.0;
        // device 562, IC IC98, analog/basic/inverter.hpp:11
        I(cpphdl_n1141, Vdd) <+ cpphdl_channel(V(BIT_N3_7, Vdd), V(cpphdl_n1141, Vdd), 0.080000000000000002, 0.69999999999999996, -1.0);
        // device 563, IC IC98, analog/basic/inverter.hpp:12
        I(cpphdl_n1141, Vss) <+ cpphdl_channel(V(BIT_N3_7, Vss), V(cpphdl_n1141, Vss), 0.080000000000000002, 0.69999999999999996, 1.0);
        // device 564, IC IC90, analog/basic/mos_r2r_dac.hpp:27
        I(cpphdl_n1141, Vss) <+ 2.9999999999999998e-15 * ddt(V(cpphdl_n1141, Vss)); // Bench initial voltage = 0.0 V.
        // device 565, IC IC90, analog/basic/mos_r2r_dac.hpp:28
        I(cpphdl_n1141, cpphdl_n1153) <+ V(cpphdl_n1141, cpphdl_n1153) / 2000.0;
        // device 566, IC IC90, analog/basic/mos_r2r_dac.hpp:29
        I(cpphdl_n1153, Vss) <+ 2.9999999999999998e-15 * ddt(V(cpphdl_n1153, Vss)); // Bench initial voltage = 0.0 V.
        // device 567, IC IC90, analog/basic/mos_r2r_dac.hpp:31
        I(cpphdl_n1148, cpphdl_n1153) <+ V(cpphdl_n1148, cpphdl_n1153) / 1000.0;
        // device 568, IC IC90, analog/basic/mos_r2r_dac.hpp:33
        I(Vss, cpphdl_n1142) <+ V(Vss, cpphdl_n1142) / 2000.0;
        // device 569, IC IC99, analog/basic/nmos_resistor_amplifier.hpp:23
        I(Vdd, cpphdl_n1162) <+ V(Vdd, cpphdl_n1162) / 1000.0;
        // device 570, IC IC99, analog/basic/nmos_resistor_amplifier.hpp:24
        I(Vdd, cpphdl_n1161) <+ V(Vdd, cpphdl_n1161) / 1000.0;
        // device 571, IC IC99, analog/basic/nmos_resistor_amplifier.hpp:25
        I(cpphdl_n1162, cpphdl_n1156) <+ cpphdl_channel(V(cpphdl_n1152, cpphdl_n1156), V(cpphdl_n1162, cpphdl_n1156), 0.0074999999999999997, 0.69999999999999996, 1.0);
        // device 572, IC IC99, analog/basic/nmos_resistor_amplifier.hpp:26
        I(cpphdl_n1161, cpphdl_n1157) <+ cpphdl_channel(V(cpphdl_n1153, cpphdl_n1157), V(cpphdl_n1161, cpphdl_n1157), 0.0074999999999999997, 0.69999999999999996, 1.0);
        // device 573, IC IC99, analog/basic/nmos_resistor_amplifier.hpp:27
        I(cpphdl_n1158, cpphdl_n1156) <+ V(cpphdl_n1158, cpphdl_n1156) / 100.0;
        // device 574, IC IC99, analog/basic/nmos_resistor_amplifier.hpp:28
        I(cpphdl_n1158, cpphdl_n1157) <+ V(cpphdl_n1158, cpphdl_n1157) / 100.0;
        // device 575, IC IC99, analog/basic/nmos_resistor_amplifier.hpp:29
        I(Vss, cpphdl_n1158) <+ V(Vss, cpphdl_n1158) / 300.0;
        // device 576, IC IC99, analog/basic/nmos_resistor_amplifier.hpp:30
        I(cpphdl_n1162, Vdd) <+ 2.9999999999999998e-13 * ddt(V(cpphdl_n1162, Vdd)); // Bench initial voltage = 0.0 V.
        // device 577, IC IC99, analog/basic/nmos_resistor_amplifier.hpp:31
        I(cpphdl_n1161, Vdd) <+ 2.9999999999999998e-13 * ddt(V(cpphdl_n1161, Vdd)); // Bench initial voltage = 0.0 V.
        // device 578, IC IC99, analog/basic/nmos_resistor_amplifier.hpp:32
        I(cpphdl_n1158, Vss) <+ 4e-14 * ddt(V(cpphdl_n1158, Vss)); // Bench initial voltage = 0.0 V.
        // device 579, IC IC99, analog/basic/nmos_resistor_amplifier.hpp:34
        I(cpphdl_n1152, cpphdl_n1156) <+ 2e-14 * ddt(V(cpphdl_n1152, cpphdl_n1156)); // Bench initial voltage = 0.0 V.
        // device 580, IC IC99, analog/basic/nmos_resistor_amplifier.hpp:35
        I(cpphdl_n1153, cpphdl_n1157) <+ 2e-14 * ddt(V(cpphdl_n1153, cpphdl_n1157)); // Bench initial voltage = 0.0 V.
        // device 581, IC IC99, analog/basic/nmos_resistor_amplifier.hpp:36
        I(cpphdl_n1152, cpphdl_n1162) <+ 2.9999999999999998e-15 * ddt(V(cpphdl_n1152, cpphdl_n1162)); // Bench initial voltage = 0.0 V.
        // device 582, IC IC99, analog/basic/nmos_resistor_amplifier.hpp:37
        I(cpphdl_n1153, cpphdl_n1161) <+ 2.9999999999999998e-15 * ddt(V(cpphdl_n1153, cpphdl_n1161)); // Bench initial voltage = 0.0 V.
        // device 583, IC IC100, analog/basic/strongarm_comparator.hpp:28
        I(cpphdl_n1166, cpphdl_n1168) <+ cpphdl_channel(V(cpphdl_n1161, cpphdl_n1168), V(cpphdl_n1166, cpphdl_n1168), 0.0080000000000000002, 0.69999999999999996, 1.0);
        // device 584, IC IC100, analog/basic/strongarm_comparator.hpp:29
        I(cpphdl_n1167, cpphdl_n1168) <+ cpphdl_channel(V(cpphdl_n1162, cpphdl_n1168), V(cpphdl_n1167, cpphdl_n1168), 0.0080000000000000002, 0.69999999999999996, 1.0);
        // device 585, IC IC100, analog/basic/strongarm_comparator.hpp:30
        I(cpphdl_n1168, Vss) <+ cpphdl_channel(V(EVALUATE, Vss), V(cpphdl_n1168, Vss), 0.0080000000000000002, 0.69999999999999996, 1.0);
        // device 586, IC IC100, analog/basic/strongarm_comparator.hpp:33
        I(cpphdl_n1181, cpphdl_n1166) <+ cpphdl_channel(V(cpphdl_n1185, cpphdl_n1166), V(cpphdl_n1181, cpphdl_n1166), 0.0040000000000000001, 0.69999999999999996, 1.0);
        // device 587, IC IC100, analog/basic/strongarm_comparator.hpp:34
        I(cpphdl_n1185, cpphdl_n1167) <+ cpphdl_channel(V(cpphdl_n1181, cpphdl_n1167), V(cpphdl_n1185, cpphdl_n1167), 0.0040000000000000001, 0.69999999999999996, 1.0);
        // device 588, IC IC100, analog/basic/strongarm_comparator.hpp:35
        I(cpphdl_n1185, Vdd) <+ cpphdl_channel(V(cpphdl_n1181, Vdd), V(cpphdl_n1185, Vdd), 0.002, 0.69999999999999996, -1.0);
        // device 589, IC IC100, analog/basic/strongarm_comparator.hpp:36
        I(cpphdl_n1181, Vdd) <+ cpphdl_channel(V(cpphdl_n1185, Vdd), V(cpphdl_n1181, Vdd), 0.002, 0.69999999999999996, -1.0);
        // device 590, IC IC100, analog/basic/strongarm_comparator.hpp:38
        I(cpphdl_n1166, Vdd) <+ cpphdl_channel(V(EVALUATE, Vdd), V(cpphdl_n1166, Vdd), 0.002, 0.69999999999999996, -1.0);
        // device 591, IC IC100, analog/basic/strongarm_comparator.hpp:39
        I(cpphdl_n1167, Vdd) <+ cpphdl_channel(V(EVALUATE, Vdd), V(cpphdl_n1167, Vdd), 0.002, 0.69999999999999996, -1.0);
        // device 592, IC IC100, analog/basic/strongarm_comparator.hpp:40
        I(cpphdl_n1185, Vdd) <+ cpphdl_channel(V(EVALUATE, Vdd), V(cpphdl_n1185, Vdd), 0.002, 0.69999999999999996, -1.0);
        // device 593, IC IC100, analog/basic/strongarm_comparator.hpp:41
        I(cpphdl_n1181, Vdd) <+ cpphdl_channel(V(EVALUATE, Vdd), V(cpphdl_n1181, Vdd), 0.002, 0.69999999999999996, -1.0);
        // device 594, IC IC100, analog/basic/strongarm_comparator.hpp:42
        I(cpphdl_n1166, Vss) <+ 2.9999999999999998e-14 * ddt(V(cpphdl_n1166, Vss)); // Bench initial voltage = 0.0 V.
        // device 595, IC IC100, analog/basic/strongarm_comparator.hpp:43
        I(cpphdl_n1167, Vss) <+ 2.9999999999999998e-14 * ddt(V(cpphdl_n1167, Vss)); // Bench initial voltage = 0.0 V.
        // device 596, IC IC100, analog/basic/strongarm_comparator.hpp:44
        I(cpphdl_n1168, Vss) <+ 2.9999999999999998e-14 * ddt(V(cpphdl_n1168, Vss)); // Bench initial voltage = 0.0 V.
        // device 597, IC IC100, analog/basic/strongarm_comparator.hpp:45
        I(cpphdl_n1185, Vss) <+ 5.0000000000000002e-14 * ddt(V(cpphdl_n1185, Vss)); // Bench initial voltage = 0.0 V.
        // device 598, IC IC100, analog/basic/strongarm_comparator.hpp:46
        I(cpphdl_n1181, Vss) <+ 5.0000000000000002e-14 * ddt(V(cpphdl_n1181, Vss)); // Bench initial voltage = 0.0 V.
        // device 599, IC IC100, analog/basic/strongarm_comparator.hpp:47
        I(cpphdl_n1161, cpphdl_n1168) <+ 2e-14 * ddt(V(cpphdl_n1161, cpphdl_n1168)); // Bench initial voltage = 0.0 V.
        // device 600, IC IC100, analog/basic/strongarm_comparator.hpp:48
        I(cpphdl_n1162, cpphdl_n1168) <+ 2e-14 * ddt(V(cpphdl_n1162, cpphdl_n1168)); // Bench initial voltage = 0.0 V.
        // device 601, IC IC100, analog/basic/strongarm_comparator.hpp:49
        I(cpphdl_n1161, cpphdl_n1166) <+ 2.9999999999999998e-15 * ddt(V(cpphdl_n1161, cpphdl_n1166)); // Bench initial voltage = 0.0 V.
        // device 602, IC IC100, analog/basic/strongarm_comparator.hpp:50
        I(cpphdl_n1162, cpphdl_n1167) <+ 2.9999999999999998e-15 * ddt(V(cpphdl_n1162, cpphdl_n1167)); // Bench initial voltage = 0.0 V.
        // device 603, IC IC102, analog/basic/inverter.hpp:11
        I(cpphdl_n1189, Vdd) <+ cpphdl_channel(V(cpphdl_n1181, Vdd), V(cpphdl_n1189, Vdd), 0.001, 0.69999999999999996, -1.0);
        // device 604, IC IC102, analog/basic/inverter.hpp:12
        I(cpphdl_n1189, Vss) <+ cpphdl_channel(V(cpphdl_n1181, Vss), V(cpphdl_n1189, Vss), 0.001, 0.69999999999999996, 1.0);
        // device 605, IC IC104, analog/basic/inverter.hpp:11
        I(cpphdl_n1203, Vdd) <+ cpphdl_channel(V(cpphdl_n1189, Vdd), V(cpphdl_n1203, Vdd), 0.0040000000000000001, 0.69999999999999996, -1.0);
        // device 606, IC IC104, analog/basic/inverter.hpp:12
        I(cpphdl_n1203, Vss) <+ cpphdl_channel(V(cpphdl_n1189, Vss), V(cpphdl_n1203, Vss), 0.0040000000000000001, 0.69999999999999996, 1.0);
        // device 607, IC IC101, analog/basic/buffered_nand_latch.hpp:34
        I(cpphdl_n1181, Vss) <+ 2.0000000000000002e-15 * ddt(V(cpphdl_n1181, Vss)); // Bench initial voltage = 0.0 V.
        // device 608, IC IC101, analog/basic/buffered_nand_latch.hpp:35
        I(cpphdl_n1181, cpphdl_n1189) <+ 1.0000000000000001e-15 * ddt(V(cpphdl_n1181, cpphdl_n1189)); // Bench initial voltage = 0.0 V.
        // device 609, IC IC101, analog/basic/buffered_nand_latch.hpp:36
        I(cpphdl_n1189, Vss) <+ 5e-15 * ddt(V(cpphdl_n1189, Vss)); // Bench initial voltage = 0.0 V.
        // device 610, IC IC101, analog/basic/buffered_nand_latch.hpp:37
        I(cpphdl_n1189, Vss) <+ 8.0000000000000006e-15 * ddt(V(cpphdl_n1189, Vss)); // Bench initial voltage = 0.0 V.
        // device 611, IC IC101, analog/basic/buffered_nand_latch.hpp:38
        I(cpphdl_n1203, Vss) <+ 1e-14 * ddt(V(cpphdl_n1203, Vss)); // Bench initial voltage = 0.0 V.
        // device 612, IC IC103, analog/basic/inverter.hpp:11
        I(cpphdl_n1193, Vdd) <+ cpphdl_channel(V(cpphdl_n1185, Vdd), V(cpphdl_n1193, Vdd), 0.001, 0.69999999999999996, -1.0);
        // device 613, IC IC103, analog/basic/inverter.hpp:12
        I(cpphdl_n1193, Vss) <+ cpphdl_channel(V(cpphdl_n1185, Vss), V(cpphdl_n1193, Vss), 0.001, 0.69999999999999996, 1.0);
        // device 614, IC IC105, analog/basic/inverter.hpp:11
        I(cpphdl_n1209, Vdd) <+ cpphdl_channel(V(cpphdl_n1193, Vdd), V(cpphdl_n1209, Vdd), 0.0040000000000000001, 0.69999999999999996, -1.0);
        // device 615, IC IC105, analog/basic/inverter.hpp:12
        I(cpphdl_n1209, Vss) <+ cpphdl_channel(V(cpphdl_n1193, Vss), V(cpphdl_n1209, Vss), 0.0040000000000000001, 0.69999999999999996, 1.0);
        // device 616, IC IC101, analog/basic/buffered_nand_latch.hpp:34
        I(cpphdl_n1185, Vss) <+ 2.0000000000000002e-15 * ddt(V(cpphdl_n1185, Vss)); // Bench initial voltage = 0.0 V.
        // device 617, IC IC101, analog/basic/buffered_nand_latch.hpp:35
        I(cpphdl_n1185, cpphdl_n1193) <+ 1.0000000000000001e-15 * ddt(V(cpphdl_n1185, cpphdl_n1193)); // Bench initial voltage = 0.0 V.
        // device 618, IC IC101, analog/basic/buffered_nand_latch.hpp:36
        I(cpphdl_n1193, Vss) <+ 5e-15 * ddt(V(cpphdl_n1193, Vss)); // Bench initial voltage = 0.0 V.
        // device 619, IC IC101, analog/basic/buffered_nand_latch.hpp:37
        I(cpphdl_n1193, Vss) <+ 8.0000000000000006e-15 * ddt(V(cpphdl_n1193, Vss)); // Bench initial voltage = 0.0 V.
        // device 620, IC IC101, analog/basic/buffered_nand_latch.hpp:38
        I(cpphdl_n1209, Vss) <+ 1e-14 * ddt(V(cpphdl_n1209, Vss)); // Bench initial voltage = 0.0 V.
        // device 621, IC IC107, analog/basic/cmos_logic.hpp:17
        I(cpphdl_n2968, Vss) <+ 5.0000000000000002e-14 * ddt(V(cpphdl_n2968, Vss)); // Bench initial voltage = 0.0 V.
        // device 622, IC IC107, analog/basic/cmos_logic.hpp:18
        I(cpphdl_n2968, Vdd) <+ cpphdl_channel(V(cpphdl_n1203, Vdd), V(cpphdl_n2968, Vdd), 0.01, 0.69999999999999996, -1.0);
        // device 623, IC IC107, analog/basic/cmos_logic.hpp:19
        I(cpphdl_n2968, Vdd) <+ cpphdl_channel(V(cpphdl_n1211, Vdd), V(cpphdl_n2968, Vdd), 0.01, 0.69999999999999996, -1.0);
        // device 624, IC IC107, analog/basic/cmos_logic.hpp:20
        I(cpphdl_n2968, cpphdl_n1206) <+ cpphdl_channel(V(cpphdl_n1203, cpphdl_n1206), V(cpphdl_n2968, cpphdl_n1206), 0.01, 0.69999999999999996, 1.0);
        // device 625, IC IC107, analog/basic/cmos_logic.hpp:21
        I(cpphdl_n1206, Vss) <+ cpphdl_channel(V(cpphdl_n1211, Vss), V(cpphdl_n1206, Vss), 0.01, 0.69999999999999996, 1.0);
        // device 626, IC IC107, analog/basic/cmos_logic.hpp:27
        I(cpphdl_n1206, Vss) <+ 1e-14 * ddt(V(cpphdl_n1206, Vss)); // Bench initial voltage = 0.0 V.
        // device 627, IC IC108, analog/basic/cmos_logic.hpp:17
        I(cpphdl_n1211, Vss) <+ 5.0000000000000002e-14 * ddt(V(cpphdl_n1211, Vss)); // Bench initial voltage = 0.0 V.
        // device 628, IC IC108, analog/basic/cmos_logic.hpp:18
        I(cpphdl_n1211, Vdd) <+ cpphdl_channel(V(cpphdl_n1209, Vdd), V(cpphdl_n1211, Vdd), 0.01, 0.69999999999999996, -1.0);
        // device 629, IC IC108, analog/basic/cmos_logic.hpp:19
        I(cpphdl_n1211, Vdd) <+ cpphdl_channel(V(cpphdl_n2968, Vdd), V(cpphdl_n1211, Vdd), 0.01, 0.69999999999999996, -1.0);
        // device 630, IC IC108, analog/basic/cmos_logic.hpp:20
        I(cpphdl_n1211, cpphdl_n1212) <+ cpphdl_channel(V(cpphdl_n1209, cpphdl_n1212), V(cpphdl_n1211, cpphdl_n1212), 0.01, 0.69999999999999996, 1.0);
        // device 631, IC IC108, analog/basic/cmos_logic.hpp:21
        I(cpphdl_n1212, Vss) <+ cpphdl_channel(V(cpphdl_n2968, Vss), V(cpphdl_n1212, Vss), 0.01, 0.69999999999999996, 1.0);
        // device 632, IC IC108, analog/basic/cmos_logic.hpp:27
        I(cpphdl_n1212, Vss) <+ 1e-14 * ddt(V(cpphdl_n1212, Vss)); // Bench initial voltage = 0.0 V.
        // device 633, IC IC106, analog/basic/nand_latch.hpp:36
        I(cpphdl_n1203, Vss) <+ 2.9999999999999998e-15 * ddt(V(cpphdl_n1203, Vss)); // Bench initial voltage = 0.0 V.
        // device 634, IC IC106, analog/basic/nand_latch.hpp:37
        I(cpphdl_n1209, Vss) <+ 2.9999999999999998e-15 * ddt(V(cpphdl_n1209, Vss)); // Bench initial voltage = 0.0 V.
        // device 635, IC IC109, analog/basic/inverter.hpp:11
        I(cpphdl_n1217, Vdd) <+ cpphdl_channel(V(CLEAR, Vdd), V(cpphdl_n1217, Vdd), 0.01, 0.69999999999999996, -1.0);
        // device 636, IC IC109, analog/basic/inverter.hpp:12
        I(cpphdl_n1217, Vss) <+ cpphdl_channel(V(CLEAR, Vss), V(cpphdl_n1217, Vss), 0.01, 0.69999999999999996, 1.0);
        // device 637, IC IC106, analog/basic/nand_latch.hpp:58
        I(cpphdl_n1217, Vss) <+ 2.9999999999999998e-15 * ddt(V(cpphdl_n1217, Vss)); // Bench initial voltage = 0.0 V.
        // device 638, IC IC106, analog/basic/nand_latch.hpp:59
        I(cpphdl_n2968, Vss) <+ cpphdl_channel(V(CLEAR, Vss), V(cpphdl_n2968, Vss), 0.050000000000000003, 0.69999999999999996, 1.0);
        // device 639, IC IC106, analog/basic/nand_latch.hpp:60
        I(cpphdl_n1211, Vdd) <+ cpphdl_channel(V(cpphdl_n1217, Vdd), V(cpphdl_n1211, Vdd), 0.050000000000000003, 0.69999999999999996, -1.0);
        // device 640, IC IC112, analog/basic/inverter.hpp:11
        I(cpphdl_n1241, Vdd) <+ cpphdl_channel(V(TRACK4, Vdd), V(cpphdl_n1241, Vdd), 0.0040000000000000001, 0.69999999999999996, -1.0);
        // device 641, IC IC112, analog/basic/inverter.hpp:12
        I(cpphdl_n1241, Vss) <+ cpphdl_channel(V(TRACK4, Vss), V(cpphdl_n1241, Vss), 0.0040000000000000001, 0.69999999999999996, 1.0);
        // device 642, IC IC111, analog/basic/mos_track_hold.hpp:31
        I(cpphdl_n1241, Vss) <+ 2e-14 * ddt(V(cpphdl_n1241, Vss)); // Bench initial voltage = 0.0 V.
        // device 643, IC IC111, analog/basic/mos_track_hold.hpp:32
        I(cpphdl_n2808, cpphdl_n1295) <+ cpphdl_channel(V(TRACK4, cpphdl_n1295), V(cpphdl_n2808, cpphdl_n1295), 0.029999999999999999, 0.69999999999999996, 1.0);
        // device 644, IC IC111, analog/basic/mos_track_hold.hpp:33
        I(cpphdl_n1295, cpphdl_n2808) <+ cpphdl_channel(V(cpphdl_n1241, cpphdl_n2808), V(cpphdl_n1295, cpphdl_n2808), 0.014999999999999999, 0.69999999999999996, -1.0);
        // device 645, IC IC111, analog/basic/mos_track_hold.hpp:37
        I(cpphdl_n1295, cpphdl_n1295) <+ cpphdl_channel(V(cpphdl_n1241, cpphdl_n1295), V(cpphdl_n1295, cpphdl_n1295), 0.016, 0.69999999999999996, 1.0);
        // device 646, IC IC111, analog/basic/mos_track_hold.hpp:38
        I(cpphdl_n1295, cpphdl_n1295) <+ cpphdl_channel(V(TRACK4, cpphdl_n1295), V(cpphdl_n1295, cpphdl_n1295), 0.0083999999999999995, 0.69999999999999996, -1.0);
        // device 647, IC IC111, analog/basic/mos_track_hold.hpp:39
        I(cpphdl_n1295, Vss) <+ 1.5000000000000001e-12 * ddt(V(cpphdl_n1295, Vss)); // Bench initial voltage = 0.0 V.
        // device 648, IC IC111, analog/basic/mos_track_hold.hpp:42
        I(TRACK4, cpphdl_n1295) <+ 2.0000000000000002e-15 * ddt(V(TRACK4, cpphdl_n1295)); // Bench initial voltage = -0.0 V.
        // device 649, IC IC111, analog/basic/mos_track_hold.hpp:43
        I(cpphdl_n1241, cpphdl_n1295) <+ 2.0000000000000002e-15 * ddt(V(cpphdl_n1241, cpphdl_n1295)); // Bench initial voltage = 0.0 V.
        // device 650, IC IC111, analog/basic/mos_track_hold.hpp:44
        I(cpphdl_n2808, cpphdl_n1295) <+ 1.0000000000000001e-15 * ddt(V(cpphdl_n2808, cpphdl_n1295)); // Bench initial voltage = 0.0 V.
        // device 651, IC IC114, analog/basic/inverter.hpp:11
        I(cpphdl_n1256, Vdd) <+ cpphdl_channel(V(BIT_N4_0, Vdd), V(cpphdl_n1256, Vdd), 0.080000000000000002, 0.69999999999999996, -1.0);
        // device 652, IC IC114, analog/basic/inverter.hpp:12
        I(cpphdl_n1256, Vss) <+ cpphdl_channel(V(BIT_N4_0, Vss), V(cpphdl_n1256, Vss), 0.080000000000000002, 0.69999999999999996, 1.0);
        // device 653, IC IC113, analog/basic/mos_r2r_dac.hpp:27
        I(cpphdl_n1256, Vss) <+ 2.9999999999999998e-15 * ddt(V(cpphdl_n1256, Vss)); // Bench initial voltage = 0.0 V.
        // device 654, IC IC113, analog/basic/mos_r2r_dac.hpp:28
        I(cpphdl_n1256, cpphdl_n1285) <+ V(cpphdl_n1256, cpphdl_n1285) / 2000.0;
        // device 655, IC IC113, analog/basic/mos_r2r_dac.hpp:29
        I(cpphdl_n1285, Vss) <+ 2.9999999999999998e-15 * ddt(V(cpphdl_n1285, Vss)); // Bench initial voltage = 0.0 V.
        // device 656, IC IC115, analog/basic/inverter.hpp:11
        I(cpphdl_n1260, Vdd) <+ cpphdl_channel(V(BIT_N4_1, Vdd), V(cpphdl_n1260, Vdd), 0.080000000000000002, 0.69999999999999996, -1.0);
        // device 657, IC IC115, analog/basic/inverter.hpp:12
        I(cpphdl_n1260, Vss) <+ cpphdl_channel(V(BIT_N4_1, Vss), V(cpphdl_n1260, Vss), 0.080000000000000002, 0.69999999999999996, 1.0);
        // device 658, IC IC113, analog/basic/mos_r2r_dac.hpp:27
        I(cpphdl_n1260, Vss) <+ 2.9999999999999998e-15 * ddt(V(cpphdl_n1260, Vss)); // Bench initial voltage = 0.0 V.
        // device 659, IC IC113, analog/basic/mos_r2r_dac.hpp:28
        I(cpphdl_n1260, cpphdl_n1286) <+ V(cpphdl_n1260, cpphdl_n1286) / 2000.0;
        // device 660, IC IC113, analog/basic/mos_r2r_dac.hpp:29
        I(cpphdl_n1286, Vss) <+ 2.9999999999999998e-15 * ddt(V(cpphdl_n1286, Vss)); // Bench initial voltage = 0.0 V.
        // device 661, IC IC113, analog/basic/mos_r2r_dac.hpp:31
        I(cpphdl_n1285, cpphdl_n1286) <+ V(cpphdl_n1285, cpphdl_n1286) / 1000.0;
        // device 662, IC IC116, analog/basic/inverter.hpp:11
        I(cpphdl_n1264, Vdd) <+ cpphdl_channel(V(BIT_N4_2, Vdd), V(cpphdl_n1264, Vdd), 0.080000000000000002, 0.69999999999999996, -1.0);
        // device 663, IC IC116, analog/basic/inverter.hpp:12
        I(cpphdl_n1264, Vss) <+ cpphdl_channel(V(BIT_N4_2, Vss), V(cpphdl_n1264, Vss), 0.080000000000000002, 0.69999999999999996, 1.0);
        // device 664, IC IC113, analog/basic/mos_r2r_dac.hpp:27
        I(cpphdl_n1264, Vss) <+ 2.9999999999999998e-15 * ddt(V(cpphdl_n1264, Vss)); // Bench initial voltage = 0.0 V.
        // device 665, IC IC113, analog/basic/mos_r2r_dac.hpp:28
        I(cpphdl_n1264, cpphdl_n1287) <+ V(cpphdl_n1264, cpphdl_n1287) / 2000.0;
        // device 666, IC IC113, analog/basic/mos_r2r_dac.hpp:29
        I(cpphdl_n1287, Vss) <+ 2.9999999999999998e-15 * ddt(V(cpphdl_n1287, Vss)); // Bench initial voltage = 0.0 V.
        // device 667, IC IC113, analog/basic/mos_r2r_dac.hpp:31
        I(cpphdl_n1286, cpphdl_n1287) <+ V(cpphdl_n1286, cpphdl_n1287) / 1000.0;
        // device 668, IC IC117, analog/basic/inverter.hpp:11
        I(cpphdl_n1268, Vdd) <+ cpphdl_channel(V(BIT_N4_3, Vdd), V(cpphdl_n1268, Vdd), 0.080000000000000002, 0.69999999999999996, -1.0);
        // device 669, IC IC117, analog/basic/inverter.hpp:12
        I(cpphdl_n1268, Vss) <+ cpphdl_channel(V(BIT_N4_3, Vss), V(cpphdl_n1268, Vss), 0.080000000000000002, 0.69999999999999996, 1.0);
        // device 670, IC IC113, analog/basic/mos_r2r_dac.hpp:27
        I(cpphdl_n1268, Vss) <+ 2.9999999999999998e-15 * ddt(V(cpphdl_n1268, Vss)); // Bench initial voltage = 0.0 V.
        // device 671, IC IC113, analog/basic/mos_r2r_dac.hpp:28
        I(cpphdl_n1268, cpphdl_n1288) <+ V(cpphdl_n1268, cpphdl_n1288) / 2000.0;
        // device 672, IC IC113, analog/basic/mos_r2r_dac.hpp:29
        I(cpphdl_n1288, Vss) <+ 2.9999999999999998e-15 * ddt(V(cpphdl_n1288, Vss)); // Bench initial voltage = 0.0 V.
        // device 673, IC IC113, analog/basic/mos_r2r_dac.hpp:31
        I(cpphdl_n1287, cpphdl_n1288) <+ V(cpphdl_n1287, cpphdl_n1288) / 1000.0;
        // device 674, IC IC118, analog/basic/inverter.hpp:11
        I(cpphdl_n1272, Vdd) <+ cpphdl_channel(V(BIT_N4_4, Vdd), V(cpphdl_n1272, Vdd), 0.080000000000000002, 0.69999999999999996, -1.0);
        // device 675, IC IC118, analog/basic/inverter.hpp:12
        I(cpphdl_n1272, Vss) <+ cpphdl_channel(V(BIT_N4_4, Vss), V(cpphdl_n1272, Vss), 0.080000000000000002, 0.69999999999999996, 1.0);
        // device 676, IC IC113, analog/basic/mos_r2r_dac.hpp:27
        I(cpphdl_n1272, Vss) <+ 2.9999999999999998e-15 * ddt(V(cpphdl_n1272, Vss)); // Bench initial voltage = 0.0 V.
        // device 677, IC IC113, analog/basic/mos_r2r_dac.hpp:28
        I(cpphdl_n1272, cpphdl_n1289) <+ V(cpphdl_n1272, cpphdl_n1289) / 2000.0;
        // device 678, IC IC113, analog/basic/mos_r2r_dac.hpp:29
        I(cpphdl_n1289, Vss) <+ 2.9999999999999998e-15 * ddt(V(cpphdl_n1289, Vss)); // Bench initial voltage = 0.0 V.
        // device 679, IC IC113, analog/basic/mos_r2r_dac.hpp:31
        I(cpphdl_n1288, cpphdl_n1289) <+ V(cpphdl_n1288, cpphdl_n1289) / 1000.0;
        // device 680, IC IC119, analog/basic/inverter.hpp:11
        I(cpphdl_n1276, Vdd) <+ cpphdl_channel(V(BIT_N4_5, Vdd), V(cpphdl_n1276, Vdd), 0.080000000000000002, 0.69999999999999996, -1.0);
        // device 681, IC IC119, analog/basic/inverter.hpp:12
        I(cpphdl_n1276, Vss) <+ cpphdl_channel(V(BIT_N4_5, Vss), V(cpphdl_n1276, Vss), 0.080000000000000002, 0.69999999999999996, 1.0);
        // device 682, IC IC113, analog/basic/mos_r2r_dac.hpp:27
        I(cpphdl_n1276, Vss) <+ 2.9999999999999998e-15 * ddt(V(cpphdl_n1276, Vss)); // Bench initial voltage = 0.0 V.
        // device 683, IC IC113, analog/basic/mos_r2r_dac.hpp:28
        I(cpphdl_n1276, cpphdl_n1290) <+ V(cpphdl_n1276, cpphdl_n1290) / 2000.0;
        // device 684, IC IC113, analog/basic/mos_r2r_dac.hpp:29
        I(cpphdl_n1290, Vss) <+ 2.9999999999999998e-15 * ddt(V(cpphdl_n1290, Vss)); // Bench initial voltage = 0.0 V.
        // device 685, IC IC113, analog/basic/mos_r2r_dac.hpp:31
        I(cpphdl_n1289, cpphdl_n1290) <+ V(cpphdl_n1289, cpphdl_n1290) / 1000.0;
        // device 686, IC IC120, analog/basic/inverter.hpp:11
        I(cpphdl_n1280, Vdd) <+ cpphdl_channel(V(BIT_N4_6, Vdd), V(cpphdl_n1280, Vdd), 0.080000000000000002, 0.69999999999999996, -1.0);
        // device 687, IC IC120, analog/basic/inverter.hpp:12
        I(cpphdl_n1280, Vss) <+ cpphdl_channel(V(BIT_N4_6, Vss), V(cpphdl_n1280, Vss), 0.080000000000000002, 0.69999999999999996, 1.0);
        // device 688, IC IC113, analog/basic/mos_r2r_dac.hpp:27
        I(cpphdl_n1280, Vss) <+ 2.9999999999999998e-15 * ddt(V(cpphdl_n1280, Vss)); // Bench initial voltage = 0.0 V.
        // device 689, IC IC113, analog/basic/mos_r2r_dac.hpp:28
        I(cpphdl_n1280, cpphdl_n1291) <+ V(cpphdl_n1280, cpphdl_n1291) / 2000.0;
        // device 690, IC IC113, analog/basic/mos_r2r_dac.hpp:29
        I(cpphdl_n1291, Vss) <+ 2.9999999999999998e-15 * ddt(V(cpphdl_n1291, Vss)); // Bench initial voltage = 0.0 V.
        // device 691, IC IC113, analog/basic/mos_r2r_dac.hpp:31
        I(cpphdl_n1290, cpphdl_n1291) <+ V(cpphdl_n1290, cpphdl_n1291) / 1000.0;
        // device 692, IC IC121, analog/basic/inverter.hpp:11
        I(cpphdl_n1284, Vdd) <+ cpphdl_channel(V(BIT_N4_7, Vdd), V(cpphdl_n1284, Vdd), 0.080000000000000002, 0.69999999999999996, -1.0);
        // device 693, IC IC121, analog/basic/inverter.hpp:12
        I(cpphdl_n1284, Vss) <+ cpphdl_channel(V(BIT_N4_7, Vss), V(cpphdl_n1284, Vss), 0.080000000000000002, 0.69999999999999996, 1.0);
        // device 694, IC IC113, analog/basic/mos_r2r_dac.hpp:27
        I(cpphdl_n1284, Vss) <+ 2.9999999999999998e-15 * ddt(V(cpphdl_n1284, Vss)); // Bench initial voltage = 0.0 V.
        // device 695, IC IC113, analog/basic/mos_r2r_dac.hpp:28
        I(cpphdl_n1284, cpphdl_n1296) <+ V(cpphdl_n1284, cpphdl_n1296) / 2000.0;
        // device 696, IC IC113, analog/basic/mos_r2r_dac.hpp:29
        I(cpphdl_n1296, Vss) <+ 2.9999999999999998e-15 * ddt(V(cpphdl_n1296, Vss)); // Bench initial voltage = 0.0 V.
        // device 697, IC IC113, analog/basic/mos_r2r_dac.hpp:31
        I(cpphdl_n1291, cpphdl_n1296) <+ V(cpphdl_n1291, cpphdl_n1296) / 1000.0;
        // device 698, IC IC113, analog/basic/mos_r2r_dac.hpp:33
        I(Vss, cpphdl_n1285) <+ V(Vss, cpphdl_n1285) / 2000.0;
        // device 699, IC IC122, analog/basic/nmos_resistor_amplifier.hpp:23
        I(Vdd, cpphdl_n1305) <+ V(Vdd, cpphdl_n1305) / 1000.0;
        // device 700, IC IC122, analog/basic/nmos_resistor_amplifier.hpp:24
        I(Vdd, cpphdl_n1304) <+ V(Vdd, cpphdl_n1304) / 1000.0;
        // device 701, IC IC122, analog/basic/nmos_resistor_amplifier.hpp:25
        I(cpphdl_n1305, cpphdl_n1299) <+ cpphdl_channel(V(cpphdl_n1295, cpphdl_n1299), V(cpphdl_n1305, cpphdl_n1299), 0.0074999999999999997, 0.69999999999999996, 1.0);
        // device 702, IC IC122, analog/basic/nmos_resistor_amplifier.hpp:26
        I(cpphdl_n1304, cpphdl_n1300) <+ cpphdl_channel(V(cpphdl_n1296, cpphdl_n1300), V(cpphdl_n1304, cpphdl_n1300), 0.0074999999999999997, 0.69999999999999996, 1.0);
        // device 703, IC IC122, analog/basic/nmos_resistor_amplifier.hpp:27
        I(cpphdl_n1301, cpphdl_n1299) <+ V(cpphdl_n1301, cpphdl_n1299) / 100.0;
        // device 704, IC IC122, analog/basic/nmos_resistor_amplifier.hpp:28
        I(cpphdl_n1301, cpphdl_n1300) <+ V(cpphdl_n1301, cpphdl_n1300) / 100.0;
        // device 705, IC IC122, analog/basic/nmos_resistor_amplifier.hpp:29
        I(Vss, cpphdl_n1301) <+ V(Vss, cpphdl_n1301) / 300.0;
        // device 706, IC IC122, analog/basic/nmos_resistor_amplifier.hpp:30
        I(cpphdl_n1305, Vdd) <+ 2.9999999999999998e-13 * ddt(V(cpphdl_n1305, Vdd)); // Bench initial voltage = 0.0 V.
        // device 707, IC IC122, analog/basic/nmos_resistor_amplifier.hpp:31
        I(cpphdl_n1304, Vdd) <+ 2.9999999999999998e-13 * ddt(V(cpphdl_n1304, Vdd)); // Bench initial voltage = 0.0 V.
        // device 708, IC IC122, analog/basic/nmos_resistor_amplifier.hpp:32
        I(cpphdl_n1301, Vss) <+ 4e-14 * ddt(V(cpphdl_n1301, Vss)); // Bench initial voltage = 0.0 V.
        // device 709, IC IC122, analog/basic/nmos_resistor_amplifier.hpp:34
        I(cpphdl_n1295, cpphdl_n1299) <+ 2e-14 * ddt(V(cpphdl_n1295, cpphdl_n1299)); // Bench initial voltage = 0.0 V.
        // device 710, IC IC122, analog/basic/nmos_resistor_amplifier.hpp:35
        I(cpphdl_n1296, cpphdl_n1300) <+ 2e-14 * ddt(V(cpphdl_n1296, cpphdl_n1300)); // Bench initial voltage = 0.0 V.
        // device 711, IC IC122, analog/basic/nmos_resistor_amplifier.hpp:36
        I(cpphdl_n1295, cpphdl_n1305) <+ 2.9999999999999998e-15 * ddt(V(cpphdl_n1295, cpphdl_n1305)); // Bench initial voltage = 0.0 V.
        // device 712, IC IC122, analog/basic/nmos_resistor_amplifier.hpp:37
        I(cpphdl_n1296, cpphdl_n1304) <+ 2.9999999999999998e-15 * ddt(V(cpphdl_n1296, cpphdl_n1304)); // Bench initial voltage = 0.0 V.
        // device 713, IC IC123, analog/basic/strongarm_comparator.hpp:28
        I(cpphdl_n1309, cpphdl_n1311) <+ cpphdl_channel(V(cpphdl_n1304, cpphdl_n1311), V(cpphdl_n1309, cpphdl_n1311), 0.0080000000000000002, 0.69999999999999996, 1.0);
        // device 714, IC IC123, analog/basic/strongarm_comparator.hpp:29
        I(cpphdl_n1310, cpphdl_n1311) <+ cpphdl_channel(V(cpphdl_n1305, cpphdl_n1311), V(cpphdl_n1310, cpphdl_n1311), 0.0080000000000000002, 0.69999999999999996, 1.0);
        // device 715, IC IC123, analog/basic/strongarm_comparator.hpp:30
        I(cpphdl_n1311, Vss) <+ cpphdl_channel(V(EVALUATE, Vss), V(cpphdl_n1311, Vss), 0.0080000000000000002, 0.69999999999999996, 1.0);
        // device 716, IC IC123, analog/basic/strongarm_comparator.hpp:33
        I(cpphdl_n1324, cpphdl_n1309) <+ cpphdl_channel(V(cpphdl_n1328, cpphdl_n1309), V(cpphdl_n1324, cpphdl_n1309), 0.0040000000000000001, 0.69999999999999996, 1.0);
        // device 717, IC IC123, analog/basic/strongarm_comparator.hpp:34
        I(cpphdl_n1328, cpphdl_n1310) <+ cpphdl_channel(V(cpphdl_n1324, cpphdl_n1310), V(cpphdl_n1328, cpphdl_n1310), 0.0040000000000000001, 0.69999999999999996, 1.0);
        // device 718, IC IC123, analog/basic/strongarm_comparator.hpp:35
        I(cpphdl_n1328, Vdd) <+ cpphdl_channel(V(cpphdl_n1324, Vdd), V(cpphdl_n1328, Vdd), 0.002, 0.69999999999999996, -1.0);
        // device 719, IC IC123, analog/basic/strongarm_comparator.hpp:36
        I(cpphdl_n1324, Vdd) <+ cpphdl_channel(V(cpphdl_n1328, Vdd), V(cpphdl_n1324, Vdd), 0.002, 0.69999999999999996, -1.0);
        // device 720, IC IC123, analog/basic/strongarm_comparator.hpp:38
        I(cpphdl_n1309, Vdd) <+ cpphdl_channel(V(EVALUATE, Vdd), V(cpphdl_n1309, Vdd), 0.002, 0.69999999999999996, -1.0);
        // device 721, IC IC123, analog/basic/strongarm_comparator.hpp:39
        I(cpphdl_n1310, Vdd) <+ cpphdl_channel(V(EVALUATE, Vdd), V(cpphdl_n1310, Vdd), 0.002, 0.69999999999999996, -1.0);
        // device 722, IC IC123, analog/basic/strongarm_comparator.hpp:40
        I(cpphdl_n1328, Vdd) <+ cpphdl_channel(V(EVALUATE, Vdd), V(cpphdl_n1328, Vdd), 0.002, 0.69999999999999996, -1.0);
        // device 723, IC IC123, analog/basic/strongarm_comparator.hpp:41
        I(cpphdl_n1324, Vdd) <+ cpphdl_channel(V(EVALUATE, Vdd), V(cpphdl_n1324, Vdd), 0.002, 0.69999999999999996, -1.0);
        // device 724, IC IC123, analog/basic/strongarm_comparator.hpp:42
        I(cpphdl_n1309, Vss) <+ 2.9999999999999998e-14 * ddt(V(cpphdl_n1309, Vss)); // Bench initial voltage = 0.0 V.
        // device 725, IC IC123, analog/basic/strongarm_comparator.hpp:43
        I(cpphdl_n1310, Vss) <+ 2.9999999999999998e-14 * ddt(V(cpphdl_n1310, Vss)); // Bench initial voltage = 0.0 V.
        // device 726, IC IC123, analog/basic/strongarm_comparator.hpp:44
        I(cpphdl_n1311, Vss) <+ 2.9999999999999998e-14 * ddt(V(cpphdl_n1311, Vss)); // Bench initial voltage = 0.0 V.
        // device 727, IC IC123, analog/basic/strongarm_comparator.hpp:45
        I(cpphdl_n1328, Vss) <+ 5.0000000000000002e-14 * ddt(V(cpphdl_n1328, Vss)); // Bench initial voltage = 0.0 V.
        // device 728, IC IC123, analog/basic/strongarm_comparator.hpp:46
        I(cpphdl_n1324, Vss) <+ 5.0000000000000002e-14 * ddt(V(cpphdl_n1324, Vss)); // Bench initial voltage = 0.0 V.
        // device 729, IC IC123, analog/basic/strongarm_comparator.hpp:47
        I(cpphdl_n1304, cpphdl_n1311) <+ 2e-14 * ddt(V(cpphdl_n1304, cpphdl_n1311)); // Bench initial voltage = 0.0 V.
        // device 730, IC IC123, analog/basic/strongarm_comparator.hpp:48
        I(cpphdl_n1305, cpphdl_n1311) <+ 2e-14 * ddt(V(cpphdl_n1305, cpphdl_n1311)); // Bench initial voltage = 0.0 V.
        // device 731, IC IC123, analog/basic/strongarm_comparator.hpp:49
        I(cpphdl_n1304, cpphdl_n1309) <+ 2.9999999999999998e-15 * ddt(V(cpphdl_n1304, cpphdl_n1309)); // Bench initial voltage = 0.0 V.
        // device 732, IC IC123, analog/basic/strongarm_comparator.hpp:50
        I(cpphdl_n1305, cpphdl_n1310) <+ 2.9999999999999998e-15 * ddt(V(cpphdl_n1305, cpphdl_n1310)); // Bench initial voltage = 0.0 V.
        // device 733, IC IC125, analog/basic/inverter.hpp:11
        I(cpphdl_n1332, Vdd) <+ cpphdl_channel(V(cpphdl_n1324, Vdd), V(cpphdl_n1332, Vdd), 0.001, 0.69999999999999996, -1.0);
        // device 734, IC IC125, analog/basic/inverter.hpp:12
        I(cpphdl_n1332, Vss) <+ cpphdl_channel(V(cpphdl_n1324, Vss), V(cpphdl_n1332, Vss), 0.001, 0.69999999999999996, 1.0);
        // device 735, IC IC127, analog/basic/inverter.hpp:11
        I(cpphdl_n1346, Vdd) <+ cpphdl_channel(V(cpphdl_n1332, Vdd), V(cpphdl_n1346, Vdd), 0.0040000000000000001, 0.69999999999999996, -1.0);
        // device 736, IC IC127, analog/basic/inverter.hpp:12
        I(cpphdl_n1346, Vss) <+ cpphdl_channel(V(cpphdl_n1332, Vss), V(cpphdl_n1346, Vss), 0.0040000000000000001, 0.69999999999999996, 1.0);
        // device 737, IC IC124, analog/basic/buffered_nand_latch.hpp:34
        I(cpphdl_n1324, Vss) <+ 2.0000000000000002e-15 * ddt(V(cpphdl_n1324, Vss)); // Bench initial voltage = 0.0 V.
        // device 738, IC IC124, analog/basic/buffered_nand_latch.hpp:35
        I(cpphdl_n1324, cpphdl_n1332) <+ 1.0000000000000001e-15 * ddt(V(cpphdl_n1324, cpphdl_n1332)); // Bench initial voltage = 0.0 V.
        // device 739, IC IC124, analog/basic/buffered_nand_latch.hpp:36
        I(cpphdl_n1332, Vss) <+ 5e-15 * ddt(V(cpphdl_n1332, Vss)); // Bench initial voltage = 0.0 V.
        // device 740, IC IC124, analog/basic/buffered_nand_latch.hpp:37
        I(cpphdl_n1332, Vss) <+ 8.0000000000000006e-15 * ddt(V(cpphdl_n1332, Vss)); // Bench initial voltage = 0.0 V.
        // device 741, IC IC124, analog/basic/buffered_nand_latch.hpp:38
        I(cpphdl_n1346, Vss) <+ 1e-14 * ddt(V(cpphdl_n1346, Vss)); // Bench initial voltage = 0.0 V.
        // device 742, IC IC126, analog/basic/inverter.hpp:11
        I(cpphdl_n1336, Vdd) <+ cpphdl_channel(V(cpphdl_n1328, Vdd), V(cpphdl_n1336, Vdd), 0.001, 0.69999999999999996, -1.0);
        // device 743, IC IC126, analog/basic/inverter.hpp:12
        I(cpphdl_n1336, Vss) <+ cpphdl_channel(V(cpphdl_n1328, Vss), V(cpphdl_n1336, Vss), 0.001, 0.69999999999999996, 1.0);
        // device 744, IC IC128, analog/basic/inverter.hpp:11
        I(cpphdl_n1352, Vdd) <+ cpphdl_channel(V(cpphdl_n1336, Vdd), V(cpphdl_n1352, Vdd), 0.0040000000000000001, 0.69999999999999996, -1.0);
        // device 745, IC IC128, analog/basic/inverter.hpp:12
        I(cpphdl_n1352, Vss) <+ cpphdl_channel(V(cpphdl_n1336, Vss), V(cpphdl_n1352, Vss), 0.0040000000000000001, 0.69999999999999996, 1.0);
        // device 746, IC IC124, analog/basic/buffered_nand_latch.hpp:34
        I(cpphdl_n1328, Vss) <+ 2.0000000000000002e-15 * ddt(V(cpphdl_n1328, Vss)); // Bench initial voltage = 0.0 V.
        // device 747, IC IC124, analog/basic/buffered_nand_latch.hpp:35
        I(cpphdl_n1328, cpphdl_n1336) <+ 1.0000000000000001e-15 * ddt(V(cpphdl_n1328, cpphdl_n1336)); // Bench initial voltage = 0.0 V.
        // device 748, IC IC124, analog/basic/buffered_nand_latch.hpp:36
        I(cpphdl_n1336, Vss) <+ 5e-15 * ddt(V(cpphdl_n1336, Vss)); // Bench initial voltage = 0.0 V.
        // device 749, IC IC124, analog/basic/buffered_nand_latch.hpp:37
        I(cpphdl_n1336, Vss) <+ 8.0000000000000006e-15 * ddt(V(cpphdl_n1336, Vss)); // Bench initial voltage = 0.0 V.
        // device 750, IC IC124, analog/basic/buffered_nand_latch.hpp:38
        I(cpphdl_n1352, Vss) <+ 1e-14 * ddt(V(cpphdl_n1352, Vss)); // Bench initial voltage = 0.0 V.
        // device 751, IC IC130, analog/basic/cmos_logic.hpp:17
        I(cpphdl_n2973, Vss) <+ 5.0000000000000002e-14 * ddt(V(cpphdl_n2973, Vss)); // Bench initial voltage = 0.0 V.
        // device 752, IC IC130, analog/basic/cmos_logic.hpp:18
        I(cpphdl_n2973, Vdd) <+ cpphdl_channel(V(cpphdl_n1346, Vdd), V(cpphdl_n2973, Vdd), 0.01, 0.69999999999999996, -1.0);
        // device 753, IC IC130, analog/basic/cmos_logic.hpp:19
        I(cpphdl_n2973, Vdd) <+ cpphdl_channel(V(cpphdl_n1354, Vdd), V(cpphdl_n2973, Vdd), 0.01, 0.69999999999999996, -1.0);
        // device 754, IC IC130, analog/basic/cmos_logic.hpp:20
        I(cpphdl_n2973, cpphdl_n1349) <+ cpphdl_channel(V(cpphdl_n1346, cpphdl_n1349), V(cpphdl_n2973, cpphdl_n1349), 0.01, 0.69999999999999996, 1.0);
        // device 755, IC IC130, analog/basic/cmos_logic.hpp:21
        I(cpphdl_n1349, Vss) <+ cpphdl_channel(V(cpphdl_n1354, Vss), V(cpphdl_n1349, Vss), 0.01, 0.69999999999999996, 1.0);
        // device 756, IC IC130, analog/basic/cmos_logic.hpp:27
        I(cpphdl_n1349, Vss) <+ 1e-14 * ddt(V(cpphdl_n1349, Vss)); // Bench initial voltage = 0.0 V.
        // device 757, IC IC131, analog/basic/cmos_logic.hpp:17
        I(cpphdl_n1354, Vss) <+ 5.0000000000000002e-14 * ddt(V(cpphdl_n1354, Vss)); // Bench initial voltage = 0.0 V.
        // device 758, IC IC131, analog/basic/cmos_logic.hpp:18
        I(cpphdl_n1354, Vdd) <+ cpphdl_channel(V(cpphdl_n1352, Vdd), V(cpphdl_n1354, Vdd), 0.01, 0.69999999999999996, -1.0);
        // device 759, IC IC131, analog/basic/cmos_logic.hpp:19
        I(cpphdl_n1354, Vdd) <+ cpphdl_channel(V(cpphdl_n2973, Vdd), V(cpphdl_n1354, Vdd), 0.01, 0.69999999999999996, -1.0);
        // device 760, IC IC131, analog/basic/cmos_logic.hpp:20
        I(cpphdl_n1354, cpphdl_n1355) <+ cpphdl_channel(V(cpphdl_n1352, cpphdl_n1355), V(cpphdl_n1354, cpphdl_n1355), 0.01, 0.69999999999999996, 1.0);
        // device 761, IC IC131, analog/basic/cmos_logic.hpp:21
        I(cpphdl_n1355, Vss) <+ cpphdl_channel(V(cpphdl_n2973, Vss), V(cpphdl_n1355, Vss), 0.01, 0.69999999999999996, 1.0);
        // device 762, IC IC131, analog/basic/cmos_logic.hpp:27
        I(cpphdl_n1355, Vss) <+ 1e-14 * ddt(V(cpphdl_n1355, Vss)); // Bench initial voltage = 0.0 V.
        // device 763, IC IC129, analog/basic/nand_latch.hpp:36
        I(cpphdl_n1346, Vss) <+ 2.9999999999999998e-15 * ddt(V(cpphdl_n1346, Vss)); // Bench initial voltage = 0.0 V.
        // device 764, IC IC129, analog/basic/nand_latch.hpp:37
        I(cpphdl_n1352, Vss) <+ 2.9999999999999998e-15 * ddt(V(cpphdl_n1352, Vss)); // Bench initial voltage = 0.0 V.
        // device 765, IC IC132, analog/basic/inverter.hpp:11
        I(cpphdl_n1360, Vdd) <+ cpphdl_channel(V(CLEAR, Vdd), V(cpphdl_n1360, Vdd), 0.01, 0.69999999999999996, -1.0);
        // device 766, IC IC132, analog/basic/inverter.hpp:12
        I(cpphdl_n1360, Vss) <+ cpphdl_channel(V(CLEAR, Vss), V(cpphdl_n1360, Vss), 0.01, 0.69999999999999996, 1.0);
        // device 767, IC IC129, analog/basic/nand_latch.hpp:58
        I(cpphdl_n1360, Vss) <+ 2.9999999999999998e-15 * ddt(V(cpphdl_n1360, Vss)); // Bench initial voltage = 0.0 V.
        // device 768, IC IC129, analog/basic/nand_latch.hpp:59
        I(cpphdl_n2973, Vss) <+ cpphdl_channel(V(CLEAR, Vss), V(cpphdl_n2973, Vss), 0.050000000000000003, 0.69999999999999996, 1.0);
        // device 769, IC IC129, analog/basic/nand_latch.hpp:60
        I(cpphdl_n1354, Vdd) <+ cpphdl_channel(V(cpphdl_n1360, Vdd), V(cpphdl_n1354, Vdd), 0.050000000000000003, 0.69999999999999996, -1.0);
        // device 770, IC IC135, analog/basic/inverter.hpp:11
        I(cpphdl_n1384, Vdd) <+ cpphdl_channel(V(TRACK5, Vdd), V(cpphdl_n1384, Vdd), 0.0040000000000000001, 0.69999999999999996, -1.0);
        // device 771, IC IC135, analog/basic/inverter.hpp:12
        I(cpphdl_n1384, Vss) <+ cpphdl_channel(V(TRACK5, Vss), V(cpphdl_n1384, Vss), 0.0040000000000000001, 0.69999999999999996, 1.0);
        // device 772, IC IC134, analog/basic/mos_track_hold.hpp:31
        I(cpphdl_n1384, Vss) <+ 2e-14 * ddt(V(cpphdl_n1384, Vss)); // Bench initial voltage = 0.0 V.
        // device 773, IC IC134, analog/basic/mos_track_hold.hpp:32
        I(cpphdl_n2808, cpphdl_n1438) <+ cpphdl_channel(V(TRACK5, cpphdl_n1438), V(cpphdl_n2808, cpphdl_n1438), 0.029999999999999999, 0.69999999999999996, 1.0);
        // device 774, IC IC134, analog/basic/mos_track_hold.hpp:33
        I(cpphdl_n1438, cpphdl_n2808) <+ cpphdl_channel(V(cpphdl_n1384, cpphdl_n2808), V(cpphdl_n1438, cpphdl_n2808), 0.014999999999999999, 0.69999999999999996, -1.0);
        // device 775, IC IC134, analog/basic/mos_track_hold.hpp:37
        I(cpphdl_n1438, cpphdl_n1438) <+ cpphdl_channel(V(cpphdl_n1384, cpphdl_n1438), V(cpphdl_n1438, cpphdl_n1438), 0.016, 0.69999999999999996, 1.0);
        // device 776, IC IC134, analog/basic/mos_track_hold.hpp:38
        I(cpphdl_n1438, cpphdl_n1438) <+ cpphdl_channel(V(TRACK5, cpphdl_n1438), V(cpphdl_n1438, cpphdl_n1438), 0.0083999999999999995, 0.69999999999999996, -1.0);
        // device 777, IC IC134, analog/basic/mos_track_hold.hpp:39
        I(cpphdl_n1438, Vss) <+ 1.5000000000000001e-12 * ddt(V(cpphdl_n1438, Vss)); // Bench initial voltage = 0.0 V.
        // device 778, IC IC134, analog/basic/mos_track_hold.hpp:42
        I(TRACK5, cpphdl_n1438) <+ 2.0000000000000002e-15 * ddt(V(TRACK5, cpphdl_n1438)); // Bench initial voltage = -0.0 V.
        // device 779, IC IC134, analog/basic/mos_track_hold.hpp:43
        I(cpphdl_n1384, cpphdl_n1438) <+ 2.0000000000000002e-15 * ddt(V(cpphdl_n1384, cpphdl_n1438)); // Bench initial voltage = 0.0 V.
        // device 780, IC IC134, analog/basic/mos_track_hold.hpp:44
        I(cpphdl_n2808, cpphdl_n1438) <+ 1.0000000000000001e-15 * ddt(V(cpphdl_n2808, cpphdl_n1438)); // Bench initial voltage = 0.0 V.
        // device 781, IC IC137, analog/basic/inverter.hpp:11
        I(cpphdl_n1399, Vdd) <+ cpphdl_channel(V(BIT_N5_0, Vdd), V(cpphdl_n1399, Vdd), 0.080000000000000002, 0.69999999999999996, -1.0);
        // device 782, IC IC137, analog/basic/inverter.hpp:12
        I(cpphdl_n1399, Vss) <+ cpphdl_channel(V(BIT_N5_0, Vss), V(cpphdl_n1399, Vss), 0.080000000000000002, 0.69999999999999996, 1.0);
        // device 783, IC IC136, analog/basic/mos_r2r_dac.hpp:27
        I(cpphdl_n1399, Vss) <+ 2.9999999999999998e-15 * ddt(V(cpphdl_n1399, Vss)); // Bench initial voltage = 0.0 V.
        // device 784, IC IC136, analog/basic/mos_r2r_dac.hpp:28
        I(cpphdl_n1399, cpphdl_n1428) <+ V(cpphdl_n1399, cpphdl_n1428) / 2000.0;
        // device 785, IC IC136, analog/basic/mos_r2r_dac.hpp:29
        I(cpphdl_n1428, Vss) <+ 2.9999999999999998e-15 * ddt(V(cpphdl_n1428, Vss)); // Bench initial voltage = 0.0 V.
        // device 786, IC IC138, analog/basic/inverter.hpp:11
        I(cpphdl_n1403, Vdd) <+ cpphdl_channel(V(BIT_N5_1, Vdd), V(cpphdl_n1403, Vdd), 0.080000000000000002, 0.69999999999999996, -1.0);
        // device 787, IC IC138, analog/basic/inverter.hpp:12
        I(cpphdl_n1403, Vss) <+ cpphdl_channel(V(BIT_N5_1, Vss), V(cpphdl_n1403, Vss), 0.080000000000000002, 0.69999999999999996, 1.0);
        // device 788, IC IC136, analog/basic/mos_r2r_dac.hpp:27
        I(cpphdl_n1403, Vss) <+ 2.9999999999999998e-15 * ddt(V(cpphdl_n1403, Vss)); // Bench initial voltage = 0.0 V.
        // device 789, IC IC136, analog/basic/mos_r2r_dac.hpp:28
        I(cpphdl_n1403, cpphdl_n1429) <+ V(cpphdl_n1403, cpphdl_n1429) / 2000.0;
        // device 790, IC IC136, analog/basic/mos_r2r_dac.hpp:29
        I(cpphdl_n1429, Vss) <+ 2.9999999999999998e-15 * ddt(V(cpphdl_n1429, Vss)); // Bench initial voltage = 0.0 V.
        // device 791, IC IC136, analog/basic/mos_r2r_dac.hpp:31
        I(cpphdl_n1428, cpphdl_n1429) <+ V(cpphdl_n1428, cpphdl_n1429) / 1000.0;
        // device 792, IC IC139, analog/basic/inverter.hpp:11
        I(cpphdl_n1407, Vdd) <+ cpphdl_channel(V(BIT_N5_2, Vdd), V(cpphdl_n1407, Vdd), 0.080000000000000002, 0.69999999999999996, -1.0);
        // device 793, IC IC139, analog/basic/inverter.hpp:12
        I(cpphdl_n1407, Vss) <+ cpphdl_channel(V(BIT_N5_2, Vss), V(cpphdl_n1407, Vss), 0.080000000000000002, 0.69999999999999996, 1.0);
        // device 794, IC IC136, analog/basic/mos_r2r_dac.hpp:27
        I(cpphdl_n1407, Vss) <+ 2.9999999999999998e-15 * ddt(V(cpphdl_n1407, Vss)); // Bench initial voltage = 0.0 V.
        // device 795, IC IC136, analog/basic/mos_r2r_dac.hpp:28
        I(cpphdl_n1407, cpphdl_n1430) <+ V(cpphdl_n1407, cpphdl_n1430) / 2000.0;
        // device 796, IC IC136, analog/basic/mos_r2r_dac.hpp:29
        I(cpphdl_n1430, Vss) <+ 2.9999999999999998e-15 * ddt(V(cpphdl_n1430, Vss)); // Bench initial voltage = 0.0 V.
        // device 797, IC IC136, analog/basic/mos_r2r_dac.hpp:31
        I(cpphdl_n1429, cpphdl_n1430) <+ V(cpphdl_n1429, cpphdl_n1430) / 1000.0;
        // device 798, IC IC140, analog/basic/inverter.hpp:11
        I(cpphdl_n1411, Vdd) <+ cpphdl_channel(V(BIT_N5_3, Vdd), V(cpphdl_n1411, Vdd), 0.080000000000000002, 0.69999999999999996, -1.0);
        // device 799, IC IC140, analog/basic/inverter.hpp:12
        I(cpphdl_n1411, Vss) <+ cpphdl_channel(V(BIT_N5_3, Vss), V(cpphdl_n1411, Vss), 0.080000000000000002, 0.69999999999999996, 1.0);
        // device 800, IC IC136, analog/basic/mos_r2r_dac.hpp:27
        I(cpphdl_n1411, Vss) <+ 2.9999999999999998e-15 * ddt(V(cpphdl_n1411, Vss)); // Bench initial voltage = 0.0 V.
        // device 801, IC IC136, analog/basic/mos_r2r_dac.hpp:28
        I(cpphdl_n1411, cpphdl_n1431) <+ V(cpphdl_n1411, cpphdl_n1431) / 2000.0;
        // device 802, IC IC136, analog/basic/mos_r2r_dac.hpp:29
        I(cpphdl_n1431, Vss) <+ 2.9999999999999998e-15 * ddt(V(cpphdl_n1431, Vss)); // Bench initial voltage = 0.0 V.
        // device 803, IC IC136, analog/basic/mos_r2r_dac.hpp:31
        I(cpphdl_n1430, cpphdl_n1431) <+ V(cpphdl_n1430, cpphdl_n1431) / 1000.0;
        // device 804, IC IC141, analog/basic/inverter.hpp:11
        I(cpphdl_n1415, Vdd) <+ cpphdl_channel(V(BIT_N5_4, Vdd), V(cpphdl_n1415, Vdd), 0.080000000000000002, 0.69999999999999996, -1.0);
        // device 805, IC IC141, analog/basic/inverter.hpp:12
        I(cpphdl_n1415, Vss) <+ cpphdl_channel(V(BIT_N5_4, Vss), V(cpphdl_n1415, Vss), 0.080000000000000002, 0.69999999999999996, 1.0);
        // device 806, IC IC136, analog/basic/mos_r2r_dac.hpp:27
        I(cpphdl_n1415, Vss) <+ 2.9999999999999998e-15 * ddt(V(cpphdl_n1415, Vss)); // Bench initial voltage = 0.0 V.
        // device 807, IC IC136, analog/basic/mos_r2r_dac.hpp:28
        I(cpphdl_n1415, cpphdl_n1432) <+ V(cpphdl_n1415, cpphdl_n1432) / 2000.0;
        // device 808, IC IC136, analog/basic/mos_r2r_dac.hpp:29
        I(cpphdl_n1432, Vss) <+ 2.9999999999999998e-15 * ddt(V(cpphdl_n1432, Vss)); // Bench initial voltage = 0.0 V.
        // device 809, IC IC136, analog/basic/mos_r2r_dac.hpp:31
        I(cpphdl_n1431, cpphdl_n1432) <+ V(cpphdl_n1431, cpphdl_n1432) / 1000.0;
        // device 810, IC IC142, analog/basic/inverter.hpp:11
        I(cpphdl_n1419, Vdd) <+ cpphdl_channel(V(BIT_N5_5, Vdd), V(cpphdl_n1419, Vdd), 0.080000000000000002, 0.69999999999999996, -1.0);
        // device 811, IC IC142, analog/basic/inverter.hpp:12
        I(cpphdl_n1419, Vss) <+ cpphdl_channel(V(BIT_N5_5, Vss), V(cpphdl_n1419, Vss), 0.080000000000000002, 0.69999999999999996, 1.0);
        // device 812, IC IC136, analog/basic/mos_r2r_dac.hpp:27
        I(cpphdl_n1419, Vss) <+ 2.9999999999999998e-15 * ddt(V(cpphdl_n1419, Vss)); // Bench initial voltage = 0.0 V.
        // device 813, IC IC136, analog/basic/mos_r2r_dac.hpp:28
        I(cpphdl_n1419, cpphdl_n1433) <+ V(cpphdl_n1419, cpphdl_n1433) / 2000.0;
        // device 814, IC IC136, analog/basic/mos_r2r_dac.hpp:29
        I(cpphdl_n1433, Vss) <+ 2.9999999999999998e-15 * ddt(V(cpphdl_n1433, Vss)); // Bench initial voltage = 0.0 V.
        // device 815, IC IC136, analog/basic/mos_r2r_dac.hpp:31
        I(cpphdl_n1432, cpphdl_n1433) <+ V(cpphdl_n1432, cpphdl_n1433) / 1000.0;
        // device 816, IC IC143, analog/basic/inverter.hpp:11
        I(cpphdl_n1423, Vdd) <+ cpphdl_channel(V(BIT_N5_6, Vdd), V(cpphdl_n1423, Vdd), 0.080000000000000002, 0.69999999999999996, -1.0);
        // device 817, IC IC143, analog/basic/inverter.hpp:12
        I(cpphdl_n1423, Vss) <+ cpphdl_channel(V(BIT_N5_6, Vss), V(cpphdl_n1423, Vss), 0.080000000000000002, 0.69999999999999996, 1.0);
        // device 818, IC IC136, analog/basic/mos_r2r_dac.hpp:27
        I(cpphdl_n1423, Vss) <+ 2.9999999999999998e-15 * ddt(V(cpphdl_n1423, Vss)); // Bench initial voltage = 0.0 V.
        // device 819, IC IC136, analog/basic/mos_r2r_dac.hpp:28
        I(cpphdl_n1423, cpphdl_n1434) <+ V(cpphdl_n1423, cpphdl_n1434) / 2000.0;
        // device 820, IC IC136, analog/basic/mos_r2r_dac.hpp:29
        I(cpphdl_n1434, Vss) <+ 2.9999999999999998e-15 * ddt(V(cpphdl_n1434, Vss)); // Bench initial voltage = 0.0 V.
        // device 821, IC IC136, analog/basic/mos_r2r_dac.hpp:31
        I(cpphdl_n1433, cpphdl_n1434) <+ V(cpphdl_n1433, cpphdl_n1434) / 1000.0;
        // device 822, IC IC144, analog/basic/inverter.hpp:11
        I(cpphdl_n1427, Vdd) <+ cpphdl_channel(V(BIT_N5_7, Vdd), V(cpphdl_n1427, Vdd), 0.080000000000000002, 0.69999999999999996, -1.0);
        // device 823, IC IC144, analog/basic/inverter.hpp:12
        I(cpphdl_n1427, Vss) <+ cpphdl_channel(V(BIT_N5_7, Vss), V(cpphdl_n1427, Vss), 0.080000000000000002, 0.69999999999999996, 1.0);
        // device 824, IC IC136, analog/basic/mos_r2r_dac.hpp:27
        I(cpphdl_n1427, Vss) <+ 2.9999999999999998e-15 * ddt(V(cpphdl_n1427, Vss)); // Bench initial voltage = 0.0 V.
        // device 825, IC IC136, analog/basic/mos_r2r_dac.hpp:28
        I(cpphdl_n1427, cpphdl_n1439) <+ V(cpphdl_n1427, cpphdl_n1439) / 2000.0;
        // device 826, IC IC136, analog/basic/mos_r2r_dac.hpp:29
        I(cpphdl_n1439, Vss) <+ 2.9999999999999998e-15 * ddt(V(cpphdl_n1439, Vss)); // Bench initial voltage = 0.0 V.
        // device 827, IC IC136, analog/basic/mos_r2r_dac.hpp:31
        I(cpphdl_n1434, cpphdl_n1439) <+ V(cpphdl_n1434, cpphdl_n1439) / 1000.0;
        // device 828, IC IC136, analog/basic/mos_r2r_dac.hpp:33
        I(Vss, cpphdl_n1428) <+ V(Vss, cpphdl_n1428) / 2000.0;
        // device 829, IC IC145, analog/basic/nmos_resistor_amplifier.hpp:23
        I(Vdd, cpphdl_n1448) <+ V(Vdd, cpphdl_n1448) / 1000.0;
        // device 830, IC IC145, analog/basic/nmos_resistor_amplifier.hpp:24
        I(Vdd, cpphdl_n1447) <+ V(Vdd, cpphdl_n1447) / 1000.0;
        // device 831, IC IC145, analog/basic/nmos_resistor_amplifier.hpp:25
        I(cpphdl_n1448, cpphdl_n1442) <+ cpphdl_channel(V(cpphdl_n1438, cpphdl_n1442), V(cpphdl_n1448, cpphdl_n1442), 0.0074999999999999997, 0.69999999999999996, 1.0);
        // device 832, IC IC145, analog/basic/nmos_resistor_amplifier.hpp:26
        I(cpphdl_n1447, cpphdl_n1443) <+ cpphdl_channel(V(cpphdl_n1439, cpphdl_n1443), V(cpphdl_n1447, cpphdl_n1443), 0.0074999999999999997, 0.69999999999999996, 1.0);
        // device 833, IC IC145, analog/basic/nmos_resistor_amplifier.hpp:27
        I(cpphdl_n1444, cpphdl_n1442) <+ V(cpphdl_n1444, cpphdl_n1442) / 100.0;
        // device 834, IC IC145, analog/basic/nmos_resistor_amplifier.hpp:28
        I(cpphdl_n1444, cpphdl_n1443) <+ V(cpphdl_n1444, cpphdl_n1443) / 100.0;
        // device 835, IC IC145, analog/basic/nmos_resistor_amplifier.hpp:29
        I(Vss, cpphdl_n1444) <+ V(Vss, cpphdl_n1444) / 300.0;
        // device 836, IC IC145, analog/basic/nmos_resistor_amplifier.hpp:30
        I(cpphdl_n1448, Vdd) <+ 2.9999999999999998e-13 * ddt(V(cpphdl_n1448, Vdd)); // Bench initial voltage = 0.0 V.
        // device 837, IC IC145, analog/basic/nmos_resistor_amplifier.hpp:31
        I(cpphdl_n1447, Vdd) <+ 2.9999999999999998e-13 * ddt(V(cpphdl_n1447, Vdd)); // Bench initial voltage = 0.0 V.
        // device 838, IC IC145, analog/basic/nmos_resistor_amplifier.hpp:32
        I(cpphdl_n1444, Vss) <+ 4e-14 * ddt(V(cpphdl_n1444, Vss)); // Bench initial voltage = 0.0 V.
        // device 839, IC IC145, analog/basic/nmos_resistor_amplifier.hpp:34
        I(cpphdl_n1438, cpphdl_n1442) <+ 2e-14 * ddt(V(cpphdl_n1438, cpphdl_n1442)); // Bench initial voltage = 0.0 V.
        // device 840, IC IC145, analog/basic/nmos_resistor_amplifier.hpp:35
        I(cpphdl_n1439, cpphdl_n1443) <+ 2e-14 * ddt(V(cpphdl_n1439, cpphdl_n1443)); // Bench initial voltage = 0.0 V.
        // device 841, IC IC145, analog/basic/nmos_resistor_amplifier.hpp:36
        I(cpphdl_n1438, cpphdl_n1448) <+ 2.9999999999999998e-15 * ddt(V(cpphdl_n1438, cpphdl_n1448)); // Bench initial voltage = 0.0 V.
        // device 842, IC IC145, analog/basic/nmos_resistor_amplifier.hpp:37
        I(cpphdl_n1439, cpphdl_n1447) <+ 2.9999999999999998e-15 * ddt(V(cpphdl_n1439, cpphdl_n1447)); // Bench initial voltage = 0.0 V.
        // device 843, IC IC146, analog/basic/strongarm_comparator.hpp:28
        I(cpphdl_n1452, cpphdl_n1454) <+ cpphdl_channel(V(cpphdl_n1447, cpphdl_n1454), V(cpphdl_n1452, cpphdl_n1454), 0.0080000000000000002, 0.69999999999999996, 1.0);
        // device 844, IC IC146, analog/basic/strongarm_comparator.hpp:29
        I(cpphdl_n1453, cpphdl_n1454) <+ cpphdl_channel(V(cpphdl_n1448, cpphdl_n1454), V(cpphdl_n1453, cpphdl_n1454), 0.0080000000000000002, 0.69999999999999996, 1.0);
        // device 845, IC IC146, analog/basic/strongarm_comparator.hpp:30
        I(cpphdl_n1454, Vss) <+ cpphdl_channel(V(EVALUATE, Vss), V(cpphdl_n1454, Vss), 0.0080000000000000002, 0.69999999999999996, 1.0);
        // device 846, IC IC146, analog/basic/strongarm_comparator.hpp:33
        I(cpphdl_n1467, cpphdl_n1452) <+ cpphdl_channel(V(cpphdl_n1471, cpphdl_n1452), V(cpphdl_n1467, cpphdl_n1452), 0.0040000000000000001, 0.69999999999999996, 1.0);
        // device 847, IC IC146, analog/basic/strongarm_comparator.hpp:34
        I(cpphdl_n1471, cpphdl_n1453) <+ cpphdl_channel(V(cpphdl_n1467, cpphdl_n1453), V(cpphdl_n1471, cpphdl_n1453), 0.0040000000000000001, 0.69999999999999996, 1.0);
        // device 848, IC IC146, analog/basic/strongarm_comparator.hpp:35
        I(cpphdl_n1471, Vdd) <+ cpphdl_channel(V(cpphdl_n1467, Vdd), V(cpphdl_n1471, Vdd), 0.002, 0.69999999999999996, -1.0);
        // device 849, IC IC146, analog/basic/strongarm_comparator.hpp:36
        I(cpphdl_n1467, Vdd) <+ cpphdl_channel(V(cpphdl_n1471, Vdd), V(cpphdl_n1467, Vdd), 0.002, 0.69999999999999996, -1.0);
        // device 850, IC IC146, analog/basic/strongarm_comparator.hpp:38
        I(cpphdl_n1452, Vdd) <+ cpphdl_channel(V(EVALUATE, Vdd), V(cpphdl_n1452, Vdd), 0.002, 0.69999999999999996, -1.0);
        // device 851, IC IC146, analog/basic/strongarm_comparator.hpp:39
        I(cpphdl_n1453, Vdd) <+ cpphdl_channel(V(EVALUATE, Vdd), V(cpphdl_n1453, Vdd), 0.002, 0.69999999999999996, -1.0);
        // device 852, IC IC146, analog/basic/strongarm_comparator.hpp:40
        I(cpphdl_n1471, Vdd) <+ cpphdl_channel(V(EVALUATE, Vdd), V(cpphdl_n1471, Vdd), 0.002, 0.69999999999999996, -1.0);
        // device 853, IC IC146, analog/basic/strongarm_comparator.hpp:41
        I(cpphdl_n1467, Vdd) <+ cpphdl_channel(V(EVALUATE, Vdd), V(cpphdl_n1467, Vdd), 0.002, 0.69999999999999996, -1.0);
        // device 854, IC IC146, analog/basic/strongarm_comparator.hpp:42
        I(cpphdl_n1452, Vss) <+ 2.9999999999999998e-14 * ddt(V(cpphdl_n1452, Vss)); // Bench initial voltage = 0.0 V.
        // device 855, IC IC146, analog/basic/strongarm_comparator.hpp:43
        I(cpphdl_n1453, Vss) <+ 2.9999999999999998e-14 * ddt(V(cpphdl_n1453, Vss)); // Bench initial voltage = 0.0 V.
        // device 856, IC IC146, analog/basic/strongarm_comparator.hpp:44
        I(cpphdl_n1454, Vss) <+ 2.9999999999999998e-14 * ddt(V(cpphdl_n1454, Vss)); // Bench initial voltage = 0.0 V.
        // device 857, IC IC146, analog/basic/strongarm_comparator.hpp:45
        I(cpphdl_n1471, Vss) <+ 5.0000000000000002e-14 * ddt(V(cpphdl_n1471, Vss)); // Bench initial voltage = 0.0 V.
        // device 858, IC IC146, analog/basic/strongarm_comparator.hpp:46
        I(cpphdl_n1467, Vss) <+ 5.0000000000000002e-14 * ddt(V(cpphdl_n1467, Vss)); // Bench initial voltage = 0.0 V.
        // device 859, IC IC146, analog/basic/strongarm_comparator.hpp:47
        I(cpphdl_n1447, cpphdl_n1454) <+ 2e-14 * ddt(V(cpphdl_n1447, cpphdl_n1454)); // Bench initial voltage = 0.0 V.
        // device 860, IC IC146, analog/basic/strongarm_comparator.hpp:48
        I(cpphdl_n1448, cpphdl_n1454) <+ 2e-14 * ddt(V(cpphdl_n1448, cpphdl_n1454)); // Bench initial voltage = 0.0 V.
        // device 861, IC IC146, analog/basic/strongarm_comparator.hpp:49
        I(cpphdl_n1447, cpphdl_n1452) <+ 2.9999999999999998e-15 * ddt(V(cpphdl_n1447, cpphdl_n1452)); // Bench initial voltage = 0.0 V.
        // device 862, IC IC146, analog/basic/strongarm_comparator.hpp:50
        I(cpphdl_n1448, cpphdl_n1453) <+ 2.9999999999999998e-15 * ddt(V(cpphdl_n1448, cpphdl_n1453)); // Bench initial voltage = 0.0 V.
        // device 863, IC IC148, analog/basic/inverter.hpp:11
        I(cpphdl_n1475, Vdd) <+ cpphdl_channel(V(cpphdl_n1467, Vdd), V(cpphdl_n1475, Vdd), 0.001, 0.69999999999999996, -1.0);
        // device 864, IC IC148, analog/basic/inverter.hpp:12
        I(cpphdl_n1475, Vss) <+ cpphdl_channel(V(cpphdl_n1467, Vss), V(cpphdl_n1475, Vss), 0.001, 0.69999999999999996, 1.0);
        // device 865, IC IC150, analog/basic/inverter.hpp:11
        I(cpphdl_n1489, Vdd) <+ cpphdl_channel(V(cpphdl_n1475, Vdd), V(cpphdl_n1489, Vdd), 0.0040000000000000001, 0.69999999999999996, -1.0);
        // device 866, IC IC150, analog/basic/inverter.hpp:12
        I(cpphdl_n1489, Vss) <+ cpphdl_channel(V(cpphdl_n1475, Vss), V(cpphdl_n1489, Vss), 0.0040000000000000001, 0.69999999999999996, 1.0);
        // device 867, IC IC147, analog/basic/buffered_nand_latch.hpp:34
        I(cpphdl_n1467, Vss) <+ 2.0000000000000002e-15 * ddt(V(cpphdl_n1467, Vss)); // Bench initial voltage = 0.0 V.
        // device 868, IC IC147, analog/basic/buffered_nand_latch.hpp:35
        I(cpphdl_n1467, cpphdl_n1475) <+ 1.0000000000000001e-15 * ddt(V(cpphdl_n1467, cpphdl_n1475)); // Bench initial voltage = 0.0 V.
        // device 869, IC IC147, analog/basic/buffered_nand_latch.hpp:36
        I(cpphdl_n1475, Vss) <+ 5e-15 * ddt(V(cpphdl_n1475, Vss)); // Bench initial voltage = 0.0 V.
        // device 870, IC IC147, analog/basic/buffered_nand_latch.hpp:37
        I(cpphdl_n1475, Vss) <+ 8.0000000000000006e-15 * ddt(V(cpphdl_n1475, Vss)); // Bench initial voltage = 0.0 V.
        // device 871, IC IC147, analog/basic/buffered_nand_latch.hpp:38
        I(cpphdl_n1489, Vss) <+ 1e-14 * ddt(V(cpphdl_n1489, Vss)); // Bench initial voltage = 0.0 V.
        // device 872, IC IC149, analog/basic/inverter.hpp:11
        I(cpphdl_n1479, Vdd) <+ cpphdl_channel(V(cpphdl_n1471, Vdd), V(cpphdl_n1479, Vdd), 0.001, 0.69999999999999996, -1.0);
        // device 873, IC IC149, analog/basic/inverter.hpp:12
        I(cpphdl_n1479, Vss) <+ cpphdl_channel(V(cpphdl_n1471, Vss), V(cpphdl_n1479, Vss), 0.001, 0.69999999999999996, 1.0);
        // device 874, IC IC151, analog/basic/inverter.hpp:11
        I(cpphdl_n1495, Vdd) <+ cpphdl_channel(V(cpphdl_n1479, Vdd), V(cpphdl_n1495, Vdd), 0.0040000000000000001, 0.69999999999999996, -1.0);
        // device 875, IC IC151, analog/basic/inverter.hpp:12
        I(cpphdl_n1495, Vss) <+ cpphdl_channel(V(cpphdl_n1479, Vss), V(cpphdl_n1495, Vss), 0.0040000000000000001, 0.69999999999999996, 1.0);
        // device 876, IC IC147, analog/basic/buffered_nand_latch.hpp:34
        I(cpphdl_n1471, Vss) <+ 2.0000000000000002e-15 * ddt(V(cpphdl_n1471, Vss)); // Bench initial voltage = 0.0 V.
        // device 877, IC IC147, analog/basic/buffered_nand_latch.hpp:35
        I(cpphdl_n1471, cpphdl_n1479) <+ 1.0000000000000001e-15 * ddt(V(cpphdl_n1471, cpphdl_n1479)); // Bench initial voltage = 0.0 V.
        // device 878, IC IC147, analog/basic/buffered_nand_latch.hpp:36
        I(cpphdl_n1479, Vss) <+ 5e-15 * ddt(V(cpphdl_n1479, Vss)); // Bench initial voltage = 0.0 V.
        // device 879, IC IC147, analog/basic/buffered_nand_latch.hpp:37
        I(cpphdl_n1479, Vss) <+ 8.0000000000000006e-15 * ddt(V(cpphdl_n1479, Vss)); // Bench initial voltage = 0.0 V.
        // device 880, IC IC147, analog/basic/buffered_nand_latch.hpp:38
        I(cpphdl_n1495, Vss) <+ 1e-14 * ddt(V(cpphdl_n1495, Vss)); // Bench initial voltage = 0.0 V.
        // device 881, IC IC153, analog/basic/cmos_logic.hpp:17
        I(cpphdl_n2978, Vss) <+ 5.0000000000000002e-14 * ddt(V(cpphdl_n2978, Vss)); // Bench initial voltage = 0.0 V.
        // device 882, IC IC153, analog/basic/cmos_logic.hpp:18
        I(cpphdl_n2978, Vdd) <+ cpphdl_channel(V(cpphdl_n1489, Vdd), V(cpphdl_n2978, Vdd), 0.01, 0.69999999999999996, -1.0);
        // device 883, IC IC153, analog/basic/cmos_logic.hpp:19
        I(cpphdl_n2978, Vdd) <+ cpphdl_channel(V(cpphdl_n1497, Vdd), V(cpphdl_n2978, Vdd), 0.01, 0.69999999999999996, -1.0);
        // device 884, IC IC153, analog/basic/cmos_logic.hpp:20
        I(cpphdl_n2978, cpphdl_n1492) <+ cpphdl_channel(V(cpphdl_n1489, cpphdl_n1492), V(cpphdl_n2978, cpphdl_n1492), 0.01, 0.69999999999999996, 1.0);
        // device 885, IC IC153, analog/basic/cmos_logic.hpp:21
        I(cpphdl_n1492, Vss) <+ cpphdl_channel(V(cpphdl_n1497, Vss), V(cpphdl_n1492, Vss), 0.01, 0.69999999999999996, 1.0);
        // device 886, IC IC153, analog/basic/cmos_logic.hpp:27
        I(cpphdl_n1492, Vss) <+ 1e-14 * ddt(V(cpphdl_n1492, Vss)); // Bench initial voltage = 0.0 V.
        // device 887, IC IC154, analog/basic/cmos_logic.hpp:17
        I(cpphdl_n1497, Vss) <+ 5.0000000000000002e-14 * ddt(V(cpphdl_n1497, Vss)); // Bench initial voltage = 0.0 V.
        // device 888, IC IC154, analog/basic/cmos_logic.hpp:18
        I(cpphdl_n1497, Vdd) <+ cpphdl_channel(V(cpphdl_n1495, Vdd), V(cpphdl_n1497, Vdd), 0.01, 0.69999999999999996, -1.0);
        // device 889, IC IC154, analog/basic/cmos_logic.hpp:19
        I(cpphdl_n1497, Vdd) <+ cpphdl_channel(V(cpphdl_n2978, Vdd), V(cpphdl_n1497, Vdd), 0.01, 0.69999999999999996, -1.0);
        // device 890, IC IC154, analog/basic/cmos_logic.hpp:20
        I(cpphdl_n1497, cpphdl_n1498) <+ cpphdl_channel(V(cpphdl_n1495, cpphdl_n1498), V(cpphdl_n1497, cpphdl_n1498), 0.01, 0.69999999999999996, 1.0);
        // device 891, IC IC154, analog/basic/cmos_logic.hpp:21
        I(cpphdl_n1498, Vss) <+ cpphdl_channel(V(cpphdl_n2978, Vss), V(cpphdl_n1498, Vss), 0.01, 0.69999999999999996, 1.0);
        // device 892, IC IC154, analog/basic/cmos_logic.hpp:27
        I(cpphdl_n1498, Vss) <+ 1e-14 * ddt(V(cpphdl_n1498, Vss)); // Bench initial voltage = 0.0 V.
        // device 893, IC IC152, analog/basic/nand_latch.hpp:36
        I(cpphdl_n1489, Vss) <+ 2.9999999999999998e-15 * ddt(V(cpphdl_n1489, Vss)); // Bench initial voltage = 0.0 V.
        // device 894, IC IC152, analog/basic/nand_latch.hpp:37
        I(cpphdl_n1495, Vss) <+ 2.9999999999999998e-15 * ddt(V(cpphdl_n1495, Vss)); // Bench initial voltage = 0.0 V.
        // device 895, IC IC155, analog/basic/inverter.hpp:11
        I(cpphdl_n1503, Vdd) <+ cpphdl_channel(V(CLEAR, Vdd), V(cpphdl_n1503, Vdd), 0.01, 0.69999999999999996, -1.0);
        // device 896, IC IC155, analog/basic/inverter.hpp:12
        I(cpphdl_n1503, Vss) <+ cpphdl_channel(V(CLEAR, Vss), V(cpphdl_n1503, Vss), 0.01, 0.69999999999999996, 1.0);
        // device 897, IC IC152, analog/basic/nand_latch.hpp:58
        I(cpphdl_n1503, Vss) <+ 2.9999999999999998e-15 * ddt(V(cpphdl_n1503, Vss)); // Bench initial voltage = 0.0 V.
        // device 898, IC IC152, analog/basic/nand_latch.hpp:59
        I(cpphdl_n2978, Vss) <+ cpphdl_channel(V(CLEAR, Vss), V(cpphdl_n2978, Vss), 0.050000000000000003, 0.69999999999999996, 1.0);
        // device 899, IC IC152, analog/basic/nand_latch.hpp:60
        I(cpphdl_n1497, Vdd) <+ cpphdl_channel(V(cpphdl_n1503, Vdd), V(cpphdl_n1497, Vdd), 0.050000000000000003, 0.69999999999999996, -1.0);
        // device 900, IC IC158, analog/basic/inverter.hpp:11
        I(cpphdl_n1527, Vdd) <+ cpphdl_channel(V(TRACK6, Vdd), V(cpphdl_n1527, Vdd), 0.0040000000000000001, 0.69999999999999996, -1.0);
        // device 901, IC IC158, analog/basic/inverter.hpp:12
        I(cpphdl_n1527, Vss) <+ cpphdl_channel(V(TRACK6, Vss), V(cpphdl_n1527, Vss), 0.0040000000000000001, 0.69999999999999996, 1.0);
        // device 902, IC IC157, analog/basic/mos_track_hold.hpp:31
        I(cpphdl_n1527, Vss) <+ 2e-14 * ddt(V(cpphdl_n1527, Vss)); // Bench initial voltage = 0.0 V.
        // device 903, IC IC157, analog/basic/mos_track_hold.hpp:32
        I(cpphdl_n2808, cpphdl_n1581) <+ cpphdl_channel(V(TRACK6, cpphdl_n1581), V(cpphdl_n2808, cpphdl_n1581), 0.029999999999999999, 0.69999999999999996, 1.0);
        // device 904, IC IC157, analog/basic/mos_track_hold.hpp:33
        I(cpphdl_n1581, cpphdl_n2808) <+ cpphdl_channel(V(cpphdl_n1527, cpphdl_n2808), V(cpphdl_n1581, cpphdl_n2808), 0.014999999999999999, 0.69999999999999996, -1.0);
        // device 905, IC IC157, analog/basic/mos_track_hold.hpp:37
        I(cpphdl_n1581, cpphdl_n1581) <+ cpphdl_channel(V(cpphdl_n1527, cpphdl_n1581), V(cpphdl_n1581, cpphdl_n1581), 0.016, 0.69999999999999996, 1.0);
        // device 906, IC IC157, analog/basic/mos_track_hold.hpp:38
        I(cpphdl_n1581, cpphdl_n1581) <+ cpphdl_channel(V(TRACK6, cpphdl_n1581), V(cpphdl_n1581, cpphdl_n1581), 0.0083999999999999995, 0.69999999999999996, -1.0);
        // device 907, IC IC157, analog/basic/mos_track_hold.hpp:39
        I(cpphdl_n1581, Vss) <+ 1.5000000000000001e-12 * ddt(V(cpphdl_n1581, Vss)); // Bench initial voltage = 0.0 V.
        // device 908, IC IC157, analog/basic/mos_track_hold.hpp:42
        I(TRACK6, cpphdl_n1581) <+ 2.0000000000000002e-15 * ddt(V(TRACK6, cpphdl_n1581)); // Bench initial voltage = -0.0 V.
        // device 909, IC IC157, analog/basic/mos_track_hold.hpp:43
        I(cpphdl_n1527, cpphdl_n1581) <+ 2.0000000000000002e-15 * ddt(V(cpphdl_n1527, cpphdl_n1581)); // Bench initial voltage = 0.0 V.
        // device 910, IC IC157, analog/basic/mos_track_hold.hpp:44
        I(cpphdl_n2808, cpphdl_n1581) <+ 1.0000000000000001e-15 * ddt(V(cpphdl_n2808, cpphdl_n1581)); // Bench initial voltage = 0.0 V.
        // device 911, IC IC160, analog/basic/inverter.hpp:11
        I(cpphdl_n1542, Vdd) <+ cpphdl_channel(V(BIT_N6_0, Vdd), V(cpphdl_n1542, Vdd), 0.080000000000000002, 0.69999999999999996, -1.0);
        // device 912, IC IC160, analog/basic/inverter.hpp:12
        I(cpphdl_n1542, Vss) <+ cpphdl_channel(V(BIT_N6_0, Vss), V(cpphdl_n1542, Vss), 0.080000000000000002, 0.69999999999999996, 1.0);
        // device 913, IC IC159, analog/basic/mos_r2r_dac.hpp:27
        I(cpphdl_n1542, Vss) <+ 2.9999999999999998e-15 * ddt(V(cpphdl_n1542, Vss)); // Bench initial voltage = 0.0 V.
        // device 914, IC IC159, analog/basic/mos_r2r_dac.hpp:28
        I(cpphdl_n1542, cpphdl_n1571) <+ V(cpphdl_n1542, cpphdl_n1571) / 2000.0;
        // device 915, IC IC159, analog/basic/mos_r2r_dac.hpp:29
        I(cpphdl_n1571, Vss) <+ 2.9999999999999998e-15 * ddt(V(cpphdl_n1571, Vss)); // Bench initial voltage = 0.0 V.
        // device 916, IC IC161, analog/basic/inverter.hpp:11
        I(cpphdl_n1546, Vdd) <+ cpphdl_channel(V(BIT_N6_1, Vdd), V(cpphdl_n1546, Vdd), 0.080000000000000002, 0.69999999999999996, -1.0);
        // device 917, IC IC161, analog/basic/inverter.hpp:12
        I(cpphdl_n1546, Vss) <+ cpphdl_channel(V(BIT_N6_1, Vss), V(cpphdl_n1546, Vss), 0.080000000000000002, 0.69999999999999996, 1.0);
        // device 918, IC IC159, analog/basic/mos_r2r_dac.hpp:27
        I(cpphdl_n1546, Vss) <+ 2.9999999999999998e-15 * ddt(V(cpphdl_n1546, Vss)); // Bench initial voltage = 0.0 V.
        // device 919, IC IC159, analog/basic/mos_r2r_dac.hpp:28
        I(cpphdl_n1546, cpphdl_n1572) <+ V(cpphdl_n1546, cpphdl_n1572) / 2000.0;
        // device 920, IC IC159, analog/basic/mos_r2r_dac.hpp:29
        I(cpphdl_n1572, Vss) <+ 2.9999999999999998e-15 * ddt(V(cpphdl_n1572, Vss)); // Bench initial voltage = 0.0 V.
        // device 921, IC IC159, analog/basic/mos_r2r_dac.hpp:31
        I(cpphdl_n1571, cpphdl_n1572) <+ V(cpphdl_n1571, cpphdl_n1572) / 1000.0;
        // device 922, IC IC162, analog/basic/inverter.hpp:11
        I(cpphdl_n1550, Vdd) <+ cpphdl_channel(V(BIT_N6_2, Vdd), V(cpphdl_n1550, Vdd), 0.080000000000000002, 0.69999999999999996, -1.0);
        // device 923, IC IC162, analog/basic/inverter.hpp:12
        I(cpphdl_n1550, Vss) <+ cpphdl_channel(V(BIT_N6_2, Vss), V(cpphdl_n1550, Vss), 0.080000000000000002, 0.69999999999999996, 1.0);
        // device 924, IC IC159, analog/basic/mos_r2r_dac.hpp:27
        I(cpphdl_n1550, Vss) <+ 2.9999999999999998e-15 * ddt(V(cpphdl_n1550, Vss)); // Bench initial voltage = 0.0 V.
        // device 925, IC IC159, analog/basic/mos_r2r_dac.hpp:28
        I(cpphdl_n1550, cpphdl_n1573) <+ V(cpphdl_n1550, cpphdl_n1573) / 2000.0;
        // device 926, IC IC159, analog/basic/mos_r2r_dac.hpp:29
        I(cpphdl_n1573, Vss) <+ 2.9999999999999998e-15 * ddt(V(cpphdl_n1573, Vss)); // Bench initial voltage = 0.0 V.
        // device 927, IC IC159, analog/basic/mos_r2r_dac.hpp:31
        I(cpphdl_n1572, cpphdl_n1573) <+ V(cpphdl_n1572, cpphdl_n1573) / 1000.0;
        // device 928, IC IC163, analog/basic/inverter.hpp:11
        I(cpphdl_n1554, Vdd) <+ cpphdl_channel(V(BIT_N6_3, Vdd), V(cpphdl_n1554, Vdd), 0.080000000000000002, 0.69999999999999996, -1.0);
        // device 929, IC IC163, analog/basic/inverter.hpp:12
        I(cpphdl_n1554, Vss) <+ cpphdl_channel(V(BIT_N6_3, Vss), V(cpphdl_n1554, Vss), 0.080000000000000002, 0.69999999999999996, 1.0);
        // device 930, IC IC159, analog/basic/mos_r2r_dac.hpp:27
        I(cpphdl_n1554, Vss) <+ 2.9999999999999998e-15 * ddt(V(cpphdl_n1554, Vss)); // Bench initial voltage = 0.0 V.
        // device 931, IC IC159, analog/basic/mos_r2r_dac.hpp:28
        I(cpphdl_n1554, cpphdl_n1574) <+ V(cpphdl_n1554, cpphdl_n1574) / 2000.0;
        // device 932, IC IC159, analog/basic/mos_r2r_dac.hpp:29
        I(cpphdl_n1574, Vss) <+ 2.9999999999999998e-15 * ddt(V(cpphdl_n1574, Vss)); // Bench initial voltage = 0.0 V.
        // device 933, IC IC159, analog/basic/mos_r2r_dac.hpp:31
        I(cpphdl_n1573, cpphdl_n1574) <+ V(cpphdl_n1573, cpphdl_n1574) / 1000.0;
        // device 934, IC IC164, analog/basic/inverter.hpp:11
        I(cpphdl_n1558, Vdd) <+ cpphdl_channel(V(BIT_N6_4, Vdd), V(cpphdl_n1558, Vdd), 0.080000000000000002, 0.69999999999999996, -1.0);
        // device 935, IC IC164, analog/basic/inverter.hpp:12
        I(cpphdl_n1558, Vss) <+ cpphdl_channel(V(BIT_N6_4, Vss), V(cpphdl_n1558, Vss), 0.080000000000000002, 0.69999999999999996, 1.0);
        // device 936, IC IC159, analog/basic/mos_r2r_dac.hpp:27
        I(cpphdl_n1558, Vss) <+ 2.9999999999999998e-15 * ddt(V(cpphdl_n1558, Vss)); // Bench initial voltage = 0.0 V.
        // device 937, IC IC159, analog/basic/mos_r2r_dac.hpp:28
        I(cpphdl_n1558, cpphdl_n1575) <+ V(cpphdl_n1558, cpphdl_n1575) / 2000.0;
        // device 938, IC IC159, analog/basic/mos_r2r_dac.hpp:29
        I(cpphdl_n1575, Vss) <+ 2.9999999999999998e-15 * ddt(V(cpphdl_n1575, Vss)); // Bench initial voltage = 0.0 V.
        // device 939, IC IC159, analog/basic/mos_r2r_dac.hpp:31
        I(cpphdl_n1574, cpphdl_n1575) <+ V(cpphdl_n1574, cpphdl_n1575) / 1000.0;
        // device 940, IC IC165, analog/basic/inverter.hpp:11
        I(cpphdl_n1562, Vdd) <+ cpphdl_channel(V(BIT_N6_5, Vdd), V(cpphdl_n1562, Vdd), 0.080000000000000002, 0.69999999999999996, -1.0);
        // device 941, IC IC165, analog/basic/inverter.hpp:12
        I(cpphdl_n1562, Vss) <+ cpphdl_channel(V(BIT_N6_5, Vss), V(cpphdl_n1562, Vss), 0.080000000000000002, 0.69999999999999996, 1.0);
        // device 942, IC IC159, analog/basic/mos_r2r_dac.hpp:27
        I(cpphdl_n1562, Vss) <+ 2.9999999999999998e-15 * ddt(V(cpphdl_n1562, Vss)); // Bench initial voltage = 0.0 V.
        // device 943, IC IC159, analog/basic/mos_r2r_dac.hpp:28
        I(cpphdl_n1562, cpphdl_n1576) <+ V(cpphdl_n1562, cpphdl_n1576) / 2000.0;
        // device 944, IC IC159, analog/basic/mos_r2r_dac.hpp:29
        I(cpphdl_n1576, Vss) <+ 2.9999999999999998e-15 * ddt(V(cpphdl_n1576, Vss)); // Bench initial voltage = 0.0 V.
        // device 945, IC IC159, analog/basic/mos_r2r_dac.hpp:31
        I(cpphdl_n1575, cpphdl_n1576) <+ V(cpphdl_n1575, cpphdl_n1576) / 1000.0;
        // device 946, IC IC166, analog/basic/inverter.hpp:11
        I(cpphdl_n1566, Vdd) <+ cpphdl_channel(V(BIT_N6_6, Vdd), V(cpphdl_n1566, Vdd), 0.080000000000000002, 0.69999999999999996, -1.0);
        // device 947, IC IC166, analog/basic/inverter.hpp:12
        I(cpphdl_n1566, Vss) <+ cpphdl_channel(V(BIT_N6_6, Vss), V(cpphdl_n1566, Vss), 0.080000000000000002, 0.69999999999999996, 1.0);
        // device 948, IC IC159, analog/basic/mos_r2r_dac.hpp:27
        I(cpphdl_n1566, Vss) <+ 2.9999999999999998e-15 * ddt(V(cpphdl_n1566, Vss)); // Bench initial voltage = 0.0 V.
        // device 949, IC IC159, analog/basic/mos_r2r_dac.hpp:28
        I(cpphdl_n1566, cpphdl_n1577) <+ V(cpphdl_n1566, cpphdl_n1577) / 2000.0;
        // device 950, IC IC159, analog/basic/mos_r2r_dac.hpp:29
        I(cpphdl_n1577, Vss) <+ 2.9999999999999998e-15 * ddt(V(cpphdl_n1577, Vss)); // Bench initial voltage = 0.0 V.
        // device 951, IC IC159, analog/basic/mos_r2r_dac.hpp:31
        I(cpphdl_n1576, cpphdl_n1577) <+ V(cpphdl_n1576, cpphdl_n1577) / 1000.0;
        // device 952, IC IC167, analog/basic/inverter.hpp:11
        I(cpphdl_n1570, Vdd) <+ cpphdl_channel(V(BIT_N6_7, Vdd), V(cpphdl_n1570, Vdd), 0.080000000000000002, 0.69999999999999996, -1.0);
        // device 953, IC IC167, analog/basic/inverter.hpp:12
        I(cpphdl_n1570, Vss) <+ cpphdl_channel(V(BIT_N6_7, Vss), V(cpphdl_n1570, Vss), 0.080000000000000002, 0.69999999999999996, 1.0);
        // device 954, IC IC159, analog/basic/mos_r2r_dac.hpp:27
        I(cpphdl_n1570, Vss) <+ 2.9999999999999998e-15 * ddt(V(cpphdl_n1570, Vss)); // Bench initial voltage = 0.0 V.
        // device 955, IC IC159, analog/basic/mos_r2r_dac.hpp:28
        I(cpphdl_n1570, cpphdl_n1582) <+ V(cpphdl_n1570, cpphdl_n1582) / 2000.0;
        // device 956, IC IC159, analog/basic/mos_r2r_dac.hpp:29
        I(cpphdl_n1582, Vss) <+ 2.9999999999999998e-15 * ddt(V(cpphdl_n1582, Vss)); // Bench initial voltage = 0.0 V.
        // device 957, IC IC159, analog/basic/mos_r2r_dac.hpp:31
        I(cpphdl_n1577, cpphdl_n1582) <+ V(cpphdl_n1577, cpphdl_n1582) / 1000.0;
        // device 958, IC IC159, analog/basic/mos_r2r_dac.hpp:33
        I(Vss, cpphdl_n1571) <+ V(Vss, cpphdl_n1571) / 2000.0;
        // device 959, IC IC168, analog/basic/nmos_resistor_amplifier.hpp:23
        I(Vdd, cpphdl_n1591) <+ V(Vdd, cpphdl_n1591) / 1000.0;
        // device 960, IC IC168, analog/basic/nmos_resistor_amplifier.hpp:24
        I(Vdd, cpphdl_n1590) <+ V(Vdd, cpphdl_n1590) / 1000.0;
        // device 961, IC IC168, analog/basic/nmos_resistor_amplifier.hpp:25
        I(cpphdl_n1591, cpphdl_n1585) <+ cpphdl_channel(V(cpphdl_n1581, cpphdl_n1585), V(cpphdl_n1591, cpphdl_n1585), 0.0074999999999999997, 0.69999999999999996, 1.0);
        // device 962, IC IC168, analog/basic/nmos_resistor_amplifier.hpp:26
        I(cpphdl_n1590, cpphdl_n1586) <+ cpphdl_channel(V(cpphdl_n1582, cpphdl_n1586), V(cpphdl_n1590, cpphdl_n1586), 0.0074999999999999997, 0.69999999999999996, 1.0);
        // device 963, IC IC168, analog/basic/nmos_resistor_amplifier.hpp:27
        I(cpphdl_n1587, cpphdl_n1585) <+ V(cpphdl_n1587, cpphdl_n1585) / 100.0;
        // device 964, IC IC168, analog/basic/nmos_resistor_amplifier.hpp:28
        I(cpphdl_n1587, cpphdl_n1586) <+ V(cpphdl_n1587, cpphdl_n1586) / 100.0;
        // device 965, IC IC168, analog/basic/nmos_resistor_amplifier.hpp:29
        I(Vss, cpphdl_n1587) <+ V(Vss, cpphdl_n1587) / 300.0;
        // device 966, IC IC168, analog/basic/nmos_resistor_amplifier.hpp:30
        I(cpphdl_n1591, Vdd) <+ 2.9999999999999998e-13 * ddt(V(cpphdl_n1591, Vdd)); // Bench initial voltage = 0.0 V.
        // device 967, IC IC168, analog/basic/nmos_resistor_amplifier.hpp:31
        I(cpphdl_n1590, Vdd) <+ 2.9999999999999998e-13 * ddt(V(cpphdl_n1590, Vdd)); // Bench initial voltage = 0.0 V.
        // device 968, IC IC168, analog/basic/nmos_resistor_amplifier.hpp:32
        I(cpphdl_n1587, Vss) <+ 4e-14 * ddt(V(cpphdl_n1587, Vss)); // Bench initial voltage = 0.0 V.
        // device 969, IC IC168, analog/basic/nmos_resistor_amplifier.hpp:34
        I(cpphdl_n1581, cpphdl_n1585) <+ 2e-14 * ddt(V(cpphdl_n1581, cpphdl_n1585)); // Bench initial voltage = 0.0 V.
        // device 970, IC IC168, analog/basic/nmos_resistor_amplifier.hpp:35
        I(cpphdl_n1582, cpphdl_n1586) <+ 2e-14 * ddt(V(cpphdl_n1582, cpphdl_n1586)); // Bench initial voltage = 0.0 V.
        // device 971, IC IC168, analog/basic/nmos_resistor_amplifier.hpp:36
        I(cpphdl_n1581, cpphdl_n1591) <+ 2.9999999999999998e-15 * ddt(V(cpphdl_n1581, cpphdl_n1591)); // Bench initial voltage = 0.0 V.
        // device 972, IC IC168, analog/basic/nmos_resistor_amplifier.hpp:37
        I(cpphdl_n1582, cpphdl_n1590) <+ 2.9999999999999998e-15 * ddt(V(cpphdl_n1582, cpphdl_n1590)); // Bench initial voltage = 0.0 V.
        // device 973, IC IC169, analog/basic/strongarm_comparator.hpp:28
        I(cpphdl_n1595, cpphdl_n1597) <+ cpphdl_channel(V(cpphdl_n1590, cpphdl_n1597), V(cpphdl_n1595, cpphdl_n1597), 0.0080000000000000002, 0.69999999999999996, 1.0);
        // device 974, IC IC169, analog/basic/strongarm_comparator.hpp:29
        I(cpphdl_n1596, cpphdl_n1597) <+ cpphdl_channel(V(cpphdl_n1591, cpphdl_n1597), V(cpphdl_n1596, cpphdl_n1597), 0.0080000000000000002, 0.69999999999999996, 1.0);
        // device 975, IC IC169, analog/basic/strongarm_comparator.hpp:30
        I(cpphdl_n1597, Vss) <+ cpphdl_channel(V(EVALUATE, Vss), V(cpphdl_n1597, Vss), 0.0080000000000000002, 0.69999999999999996, 1.0);
        // device 976, IC IC169, analog/basic/strongarm_comparator.hpp:33
        I(cpphdl_n1610, cpphdl_n1595) <+ cpphdl_channel(V(cpphdl_n1614, cpphdl_n1595), V(cpphdl_n1610, cpphdl_n1595), 0.0040000000000000001, 0.69999999999999996, 1.0);
        // device 977, IC IC169, analog/basic/strongarm_comparator.hpp:34
        I(cpphdl_n1614, cpphdl_n1596) <+ cpphdl_channel(V(cpphdl_n1610, cpphdl_n1596), V(cpphdl_n1614, cpphdl_n1596), 0.0040000000000000001, 0.69999999999999996, 1.0);
        // device 978, IC IC169, analog/basic/strongarm_comparator.hpp:35
        I(cpphdl_n1614, Vdd) <+ cpphdl_channel(V(cpphdl_n1610, Vdd), V(cpphdl_n1614, Vdd), 0.002, 0.69999999999999996, -1.0);
        // device 979, IC IC169, analog/basic/strongarm_comparator.hpp:36
        I(cpphdl_n1610, Vdd) <+ cpphdl_channel(V(cpphdl_n1614, Vdd), V(cpphdl_n1610, Vdd), 0.002, 0.69999999999999996, -1.0);
        // device 980, IC IC169, analog/basic/strongarm_comparator.hpp:38
        I(cpphdl_n1595, Vdd) <+ cpphdl_channel(V(EVALUATE, Vdd), V(cpphdl_n1595, Vdd), 0.002, 0.69999999999999996, -1.0);
        // device 981, IC IC169, analog/basic/strongarm_comparator.hpp:39
        I(cpphdl_n1596, Vdd) <+ cpphdl_channel(V(EVALUATE, Vdd), V(cpphdl_n1596, Vdd), 0.002, 0.69999999999999996, -1.0);
        // device 982, IC IC169, analog/basic/strongarm_comparator.hpp:40
        I(cpphdl_n1614, Vdd) <+ cpphdl_channel(V(EVALUATE, Vdd), V(cpphdl_n1614, Vdd), 0.002, 0.69999999999999996, -1.0);
        // device 983, IC IC169, analog/basic/strongarm_comparator.hpp:41
        I(cpphdl_n1610, Vdd) <+ cpphdl_channel(V(EVALUATE, Vdd), V(cpphdl_n1610, Vdd), 0.002, 0.69999999999999996, -1.0);
        // device 984, IC IC169, analog/basic/strongarm_comparator.hpp:42
        I(cpphdl_n1595, Vss) <+ 2.9999999999999998e-14 * ddt(V(cpphdl_n1595, Vss)); // Bench initial voltage = 0.0 V.
        // device 985, IC IC169, analog/basic/strongarm_comparator.hpp:43
        I(cpphdl_n1596, Vss) <+ 2.9999999999999998e-14 * ddt(V(cpphdl_n1596, Vss)); // Bench initial voltage = 0.0 V.
        // device 986, IC IC169, analog/basic/strongarm_comparator.hpp:44
        I(cpphdl_n1597, Vss) <+ 2.9999999999999998e-14 * ddt(V(cpphdl_n1597, Vss)); // Bench initial voltage = 0.0 V.
        // device 987, IC IC169, analog/basic/strongarm_comparator.hpp:45
        I(cpphdl_n1614, Vss) <+ 5.0000000000000002e-14 * ddt(V(cpphdl_n1614, Vss)); // Bench initial voltage = 0.0 V.
        // device 988, IC IC169, analog/basic/strongarm_comparator.hpp:46
        I(cpphdl_n1610, Vss) <+ 5.0000000000000002e-14 * ddt(V(cpphdl_n1610, Vss)); // Bench initial voltage = 0.0 V.
        // device 989, IC IC169, analog/basic/strongarm_comparator.hpp:47
        I(cpphdl_n1590, cpphdl_n1597) <+ 2e-14 * ddt(V(cpphdl_n1590, cpphdl_n1597)); // Bench initial voltage = 0.0 V.
        // device 990, IC IC169, analog/basic/strongarm_comparator.hpp:48
        I(cpphdl_n1591, cpphdl_n1597) <+ 2e-14 * ddt(V(cpphdl_n1591, cpphdl_n1597)); // Bench initial voltage = 0.0 V.
        // device 991, IC IC169, analog/basic/strongarm_comparator.hpp:49
        I(cpphdl_n1590, cpphdl_n1595) <+ 2.9999999999999998e-15 * ddt(V(cpphdl_n1590, cpphdl_n1595)); // Bench initial voltage = 0.0 V.
        // device 992, IC IC169, analog/basic/strongarm_comparator.hpp:50
        I(cpphdl_n1591, cpphdl_n1596) <+ 2.9999999999999998e-15 * ddt(V(cpphdl_n1591, cpphdl_n1596)); // Bench initial voltage = 0.0 V.
        // device 993, IC IC171, analog/basic/inverter.hpp:11
        I(cpphdl_n1618, Vdd) <+ cpphdl_channel(V(cpphdl_n1610, Vdd), V(cpphdl_n1618, Vdd), 0.001, 0.69999999999999996, -1.0);
        // device 994, IC IC171, analog/basic/inverter.hpp:12
        I(cpphdl_n1618, Vss) <+ cpphdl_channel(V(cpphdl_n1610, Vss), V(cpphdl_n1618, Vss), 0.001, 0.69999999999999996, 1.0);
        // device 995, IC IC173, analog/basic/inverter.hpp:11
        I(cpphdl_n1632, Vdd) <+ cpphdl_channel(V(cpphdl_n1618, Vdd), V(cpphdl_n1632, Vdd), 0.0040000000000000001, 0.69999999999999996, -1.0);
        // device 996, IC IC173, analog/basic/inverter.hpp:12
        I(cpphdl_n1632, Vss) <+ cpphdl_channel(V(cpphdl_n1618, Vss), V(cpphdl_n1632, Vss), 0.0040000000000000001, 0.69999999999999996, 1.0);
        // device 997, IC IC170, analog/basic/buffered_nand_latch.hpp:34
        I(cpphdl_n1610, Vss) <+ 2.0000000000000002e-15 * ddt(V(cpphdl_n1610, Vss)); // Bench initial voltage = 0.0 V.
        // device 998, IC IC170, analog/basic/buffered_nand_latch.hpp:35
        I(cpphdl_n1610, cpphdl_n1618) <+ 1.0000000000000001e-15 * ddt(V(cpphdl_n1610, cpphdl_n1618)); // Bench initial voltage = 0.0 V.
        // device 999, IC IC170, analog/basic/buffered_nand_latch.hpp:36
        I(cpphdl_n1618, Vss) <+ 5e-15 * ddt(V(cpphdl_n1618, Vss)); // Bench initial voltage = 0.0 V.
        // device 1000, IC IC170, analog/basic/buffered_nand_latch.hpp:37
        I(cpphdl_n1618, Vss) <+ 8.0000000000000006e-15 * ddt(V(cpphdl_n1618, Vss)); // Bench initial voltage = 0.0 V.
        // device 1001, IC IC170, analog/basic/buffered_nand_latch.hpp:38
        I(cpphdl_n1632, Vss) <+ 1e-14 * ddt(V(cpphdl_n1632, Vss)); // Bench initial voltage = 0.0 V.
        // device 1002, IC IC172, analog/basic/inverter.hpp:11
        I(cpphdl_n1622, Vdd) <+ cpphdl_channel(V(cpphdl_n1614, Vdd), V(cpphdl_n1622, Vdd), 0.001, 0.69999999999999996, -1.0);
        // device 1003, IC IC172, analog/basic/inverter.hpp:12
        I(cpphdl_n1622, Vss) <+ cpphdl_channel(V(cpphdl_n1614, Vss), V(cpphdl_n1622, Vss), 0.001, 0.69999999999999996, 1.0);
        // device 1004, IC IC174, analog/basic/inverter.hpp:11
        I(cpphdl_n1638, Vdd) <+ cpphdl_channel(V(cpphdl_n1622, Vdd), V(cpphdl_n1638, Vdd), 0.0040000000000000001, 0.69999999999999996, -1.0);
        // device 1005, IC IC174, analog/basic/inverter.hpp:12
        I(cpphdl_n1638, Vss) <+ cpphdl_channel(V(cpphdl_n1622, Vss), V(cpphdl_n1638, Vss), 0.0040000000000000001, 0.69999999999999996, 1.0);
        // device 1006, IC IC170, analog/basic/buffered_nand_latch.hpp:34
        I(cpphdl_n1614, Vss) <+ 2.0000000000000002e-15 * ddt(V(cpphdl_n1614, Vss)); // Bench initial voltage = 0.0 V.
        // device 1007, IC IC170, analog/basic/buffered_nand_latch.hpp:35
        I(cpphdl_n1614, cpphdl_n1622) <+ 1.0000000000000001e-15 * ddt(V(cpphdl_n1614, cpphdl_n1622)); // Bench initial voltage = 0.0 V.
        // device 1008, IC IC170, analog/basic/buffered_nand_latch.hpp:36
        I(cpphdl_n1622, Vss) <+ 5e-15 * ddt(V(cpphdl_n1622, Vss)); // Bench initial voltage = 0.0 V.
        // device 1009, IC IC170, analog/basic/buffered_nand_latch.hpp:37
        I(cpphdl_n1622, Vss) <+ 8.0000000000000006e-15 * ddt(V(cpphdl_n1622, Vss)); // Bench initial voltage = 0.0 V.
        // device 1010, IC IC170, analog/basic/buffered_nand_latch.hpp:38
        I(cpphdl_n1638, Vss) <+ 1e-14 * ddt(V(cpphdl_n1638, Vss)); // Bench initial voltage = 0.0 V.
        // device 1011, IC IC176, analog/basic/cmos_logic.hpp:17
        I(cpphdl_n2983, Vss) <+ 5.0000000000000002e-14 * ddt(V(cpphdl_n2983, Vss)); // Bench initial voltage = 0.0 V.
        // device 1012, IC IC176, analog/basic/cmos_logic.hpp:18
        I(cpphdl_n2983, Vdd) <+ cpphdl_channel(V(cpphdl_n1632, Vdd), V(cpphdl_n2983, Vdd), 0.01, 0.69999999999999996, -1.0);
        // device 1013, IC IC176, analog/basic/cmos_logic.hpp:19
        I(cpphdl_n2983, Vdd) <+ cpphdl_channel(V(cpphdl_n1640, Vdd), V(cpphdl_n2983, Vdd), 0.01, 0.69999999999999996, -1.0);
        // device 1014, IC IC176, analog/basic/cmos_logic.hpp:20
        I(cpphdl_n2983, cpphdl_n1635) <+ cpphdl_channel(V(cpphdl_n1632, cpphdl_n1635), V(cpphdl_n2983, cpphdl_n1635), 0.01, 0.69999999999999996, 1.0);
        // device 1015, IC IC176, analog/basic/cmos_logic.hpp:21
        I(cpphdl_n1635, Vss) <+ cpphdl_channel(V(cpphdl_n1640, Vss), V(cpphdl_n1635, Vss), 0.01, 0.69999999999999996, 1.0);
        // device 1016, IC IC176, analog/basic/cmos_logic.hpp:27
        I(cpphdl_n1635, Vss) <+ 1e-14 * ddt(V(cpphdl_n1635, Vss)); // Bench initial voltage = 0.0 V.
        // device 1017, IC IC177, analog/basic/cmos_logic.hpp:17
        I(cpphdl_n1640, Vss) <+ 5.0000000000000002e-14 * ddt(V(cpphdl_n1640, Vss)); // Bench initial voltage = 0.0 V.
        // device 1018, IC IC177, analog/basic/cmos_logic.hpp:18
        I(cpphdl_n1640, Vdd) <+ cpphdl_channel(V(cpphdl_n1638, Vdd), V(cpphdl_n1640, Vdd), 0.01, 0.69999999999999996, -1.0);
        // device 1019, IC IC177, analog/basic/cmos_logic.hpp:19
        I(cpphdl_n1640, Vdd) <+ cpphdl_channel(V(cpphdl_n2983, Vdd), V(cpphdl_n1640, Vdd), 0.01, 0.69999999999999996, -1.0);
        // device 1020, IC IC177, analog/basic/cmos_logic.hpp:20
        I(cpphdl_n1640, cpphdl_n1641) <+ cpphdl_channel(V(cpphdl_n1638, cpphdl_n1641), V(cpphdl_n1640, cpphdl_n1641), 0.01, 0.69999999999999996, 1.0);
        // device 1021, IC IC177, analog/basic/cmos_logic.hpp:21
        I(cpphdl_n1641, Vss) <+ cpphdl_channel(V(cpphdl_n2983, Vss), V(cpphdl_n1641, Vss), 0.01, 0.69999999999999996, 1.0);
        // device 1022, IC IC177, analog/basic/cmos_logic.hpp:27
        I(cpphdl_n1641, Vss) <+ 1e-14 * ddt(V(cpphdl_n1641, Vss)); // Bench initial voltage = 0.0 V.
        // device 1023, IC IC175, analog/basic/nand_latch.hpp:36
        I(cpphdl_n1632, Vss) <+ 2.9999999999999998e-15 * ddt(V(cpphdl_n1632, Vss)); // Bench initial voltage = 0.0 V.
        // device 1024, IC IC175, analog/basic/nand_latch.hpp:37
        I(cpphdl_n1638, Vss) <+ 2.9999999999999998e-15 * ddt(V(cpphdl_n1638, Vss)); // Bench initial voltage = 0.0 V.
        // device 1025, IC IC178, analog/basic/inverter.hpp:11
        I(cpphdl_n1646, Vdd) <+ cpphdl_channel(V(CLEAR, Vdd), V(cpphdl_n1646, Vdd), 0.01, 0.69999999999999996, -1.0);
        // device 1026, IC IC178, analog/basic/inverter.hpp:12
        I(cpphdl_n1646, Vss) <+ cpphdl_channel(V(CLEAR, Vss), V(cpphdl_n1646, Vss), 0.01, 0.69999999999999996, 1.0);
        // device 1027, IC IC175, analog/basic/nand_latch.hpp:58
        I(cpphdl_n1646, Vss) <+ 2.9999999999999998e-15 * ddt(V(cpphdl_n1646, Vss)); // Bench initial voltage = 0.0 V.
        // device 1028, IC IC175, analog/basic/nand_latch.hpp:59
        I(cpphdl_n2983, Vss) <+ cpphdl_channel(V(CLEAR, Vss), V(cpphdl_n2983, Vss), 0.050000000000000003, 0.69999999999999996, 1.0);
        // device 1029, IC IC175, analog/basic/nand_latch.hpp:60
        I(cpphdl_n1640, Vdd) <+ cpphdl_channel(V(cpphdl_n1646, Vdd), V(cpphdl_n1640, Vdd), 0.050000000000000003, 0.69999999999999996, -1.0);
        // device 1030, IC IC181, analog/basic/inverter.hpp:11
        I(cpphdl_n1670, Vdd) <+ cpphdl_channel(V(TRACK7, Vdd), V(cpphdl_n1670, Vdd), 0.0040000000000000001, 0.69999999999999996, -1.0);
        // device 1031, IC IC181, analog/basic/inverter.hpp:12
        I(cpphdl_n1670, Vss) <+ cpphdl_channel(V(TRACK7, Vss), V(cpphdl_n1670, Vss), 0.0040000000000000001, 0.69999999999999996, 1.0);
        // device 1032, IC IC180, analog/basic/mos_track_hold.hpp:31
        I(cpphdl_n1670, Vss) <+ 2e-14 * ddt(V(cpphdl_n1670, Vss)); // Bench initial voltage = 0.0 V.
        // device 1033, IC IC180, analog/basic/mos_track_hold.hpp:32
        I(cpphdl_n2808, cpphdl_n1724) <+ cpphdl_channel(V(TRACK7, cpphdl_n1724), V(cpphdl_n2808, cpphdl_n1724), 0.029999999999999999, 0.69999999999999996, 1.0);
        // device 1034, IC IC180, analog/basic/mos_track_hold.hpp:33
        I(cpphdl_n1724, cpphdl_n2808) <+ cpphdl_channel(V(cpphdl_n1670, cpphdl_n2808), V(cpphdl_n1724, cpphdl_n2808), 0.014999999999999999, 0.69999999999999996, -1.0);
        // device 1035, IC IC180, analog/basic/mos_track_hold.hpp:37
        I(cpphdl_n1724, cpphdl_n1724) <+ cpphdl_channel(V(cpphdl_n1670, cpphdl_n1724), V(cpphdl_n1724, cpphdl_n1724), 0.016, 0.69999999999999996, 1.0);
        // device 1036, IC IC180, analog/basic/mos_track_hold.hpp:38
        I(cpphdl_n1724, cpphdl_n1724) <+ cpphdl_channel(V(TRACK7, cpphdl_n1724), V(cpphdl_n1724, cpphdl_n1724), 0.0083999999999999995, 0.69999999999999996, -1.0);
        // device 1037, IC IC180, analog/basic/mos_track_hold.hpp:39
        I(cpphdl_n1724, Vss) <+ 1.5000000000000001e-12 * ddt(V(cpphdl_n1724, Vss)); // Bench initial voltage = 0.0 V.
        // device 1038, IC IC180, analog/basic/mos_track_hold.hpp:42
        I(TRACK7, cpphdl_n1724) <+ 2.0000000000000002e-15 * ddt(V(TRACK7, cpphdl_n1724)); // Bench initial voltage = -0.0 V.
        // device 1039, IC IC180, analog/basic/mos_track_hold.hpp:43
        I(cpphdl_n1670, cpphdl_n1724) <+ 2.0000000000000002e-15 * ddt(V(cpphdl_n1670, cpphdl_n1724)); // Bench initial voltage = 0.0 V.
        // device 1040, IC IC180, analog/basic/mos_track_hold.hpp:44
        I(cpphdl_n2808, cpphdl_n1724) <+ 1.0000000000000001e-15 * ddt(V(cpphdl_n2808, cpphdl_n1724)); // Bench initial voltage = 0.0 V.
        // device 1041, IC IC183, analog/basic/inverter.hpp:11
        I(cpphdl_n1685, Vdd) <+ cpphdl_channel(V(BIT_N7_0, Vdd), V(cpphdl_n1685, Vdd), 0.080000000000000002, 0.69999999999999996, -1.0);
        // device 1042, IC IC183, analog/basic/inverter.hpp:12
        I(cpphdl_n1685, Vss) <+ cpphdl_channel(V(BIT_N7_0, Vss), V(cpphdl_n1685, Vss), 0.080000000000000002, 0.69999999999999996, 1.0);
        // device 1043, IC IC182, analog/basic/mos_r2r_dac.hpp:27
        I(cpphdl_n1685, Vss) <+ 2.9999999999999998e-15 * ddt(V(cpphdl_n1685, Vss)); // Bench initial voltage = 0.0 V.
        // device 1044, IC IC182, analog/basic/mos_r2r_dac.hpp:28
        I(cpphdl_n1685, cpphdl_n1714) <+ V(cpphdl_n1685, cpphdl_n1714) / 2000.0;
        // device 1045, IC IC182, analog/basic/mos_r2r_dac.hpp:29
        I(cpphdl_n1714, Vss) <+ 2.9999999999999998e-15 * ddt(V(cpphdl_n1714, Vss)); // Bench initial voltage = 0.0 V.
        // device 1046, IC IC184, analog/basic/inverter.hpp:11
        I(cpphdl_n1689, Vdd) <+ cpphdl_channel(V(BIT_N7_1, Vdd), V(cpphdl_n1689, Vdd), 0.080000000000000002, 0.69999999999999996, -1.0);
        // device 1047, IC IC184, analog/basic/inverter.hpp:12
        I(cpphdl_n1689, Vss) <+ cpphdl_channel(V(BIT_N7_1, Vss), V(cpphdl_n1689, Vss), 0.080000000000000002, 0.69999999999999996, 1.0);
        // device 1048, IC IC182, analog/basic/mos_r2r_dac.hpp:27
        I(cpphdl_n1689, Vss) <+ 2.9999999999999998e-15 * ddt(V(cpphdl_n1689, Vss)); // Bench initial voltage = 0.0 V.
        // device 1049, IC IC182, analog/basic/mos_r2r_dac.hpp:28
        I(cpphdl_n1689, cpphdl_n1715) <+ V(cpphdl_n1689, cpphdl_n1715) / 2000.0;
        // device 1050, IC IC182, analog/basic/mos_r2r_dac.hpp:29
        I(cpphdl_n1715, Vss) <+ 2.9999999999999998e-15 * ddt(V(cpphdl_n1715, Vss)); // Bench initial voltage = 0.0 V.
        // device 1051, IC IC182, analog/basic/mos_r2r_dac.hpp:31
        I(cpphdl_n1714, cpphdl_n1715) <+ V(cpphdl_n1714, cpphdl_n1715) / 1000.0;
        // device 1052, IC IC185, analog/basic/inverter.hpp:11
        I(cpphdl_n1693, Vdd) <+ cpphdl_channel(V(BIT_N7_2, Vdd), V(cpphdl_n1693, Vdd), 0.080000000000000002, 0.69999999999999996, -1.0);
        // device 1053, IC IC185, analog/basic/inverter.hpp:12
        I(cpphdl_n1693, Vss) <+ cpphdl_channel(V(BIT_N7_2, Vss), V(cpphdl_n1693, Vss), 0.080000000000000002, 0.69999999999999996, 1.0);
        // device 1054, IC IC182, analog/basic/mos_r2r_dac.hpp:27
        I(cpphdl_n1693, Vss) <+ 2.9999999999999998e-15 * ddt(V(cpphdl_n1693, Vss)); // Bench initial voltage = 0.0 V.
        // device 1055, IC IC182, analog/basic/mos_r2r_dac.hpp:28
        I(cpphdl_n1693, cpphdl_n1716) <+ V(cpphdl_n1693, cpphdl_n1716) / 2000.0;
        // device 1056, IC IC182, analog/basic/mos_r2r_dac.hpp:29
        I(cpphdl_n1716, Vss) <+ 2.9999999999999998e-15 * ddt(V(cpphdl_n1716, Vss)); // Bench initial voltage = 0.0 V.
        // device 1057, IC IC182, analog/basic/mos_r2r_dac.hpp:31
        I(cpphdl_n1715, cpphdl_n1716) <+ V(cpphdl_n1715, cpphdl_n1716) / 1000.0;
        // device 1058, IC IC186, analog/basic/inverter.hpp:11
        I(cpphdl_n1697, Vdd) <+ cpphdl_channel(V(BIT_N7_3, Vdd), V(cpphdl_n1697, Vdd), 0.080000000000000002, 0.69999999999999996, -1.0);
        // device 1059, IC IC186, analog/basic/inverter.hpp:12
        I(cpphdl_n1697, Vss) <+ cpphdl_channel(V(BIT_N7_3, Vss), V(cpphdl_n1697, Vss), 0.080000000000000002, 0.69999999999999996, 1.0);
        // device 1060, IC IC182, analog/basic/mos_r2r_dac.hpp:27
        I(cpphdl_n1697, Vss) <+ 2.9999999999999998e-15 * ddt(V(cpphdl_n1697, Vss)); // Bench initial voltage = 0.0 V.
        // device 1061, IC IC182, analog/basic/mos_r2r_dac.hpp:28
        I(cpphdl_n1697, cpphdl_n1717) <+ V(cpphdl_n1697, cpphdl_n1717) / 2000.0;
        // device 1062, IC IC182, analog/basic/mos_r2r_dac.hpp:29
        I(cpphdl_n1717, Vss) <+ 2.9999999999999998e-15 * ddt(V(cpphdl_n1717, Vss)); // Bench initial voltage = 0.0 V.
        // device 1063, IC IC182, analog/basic/mos_r2r_dac.hpp:31
        I(cpphdl_n1716, cpphdl_n1717) <+ V(cpphdl_n1716, cpphdl_n1717) / 1000.0;
        // device 1064, IC IC187, analog/basic/inverter.hpp:11
        I(cpphdl_n1701, Vdd) <+ cpphdl_channel(V(BIT_N7_4, Vdd), V(cpphdl_n1701, Vdd), 0.080000000000000002, 0.69999999999999996, -1.0);
        // device 1065, IC IC187, analog/basic/inverter.hpp:12
        I(cpphdl_n1701, Vss) <+ cpphdl_channel(V(BIT_N7_4, Vss), V(cpphdl_n1701, Vss), 0.080000000000000002, 0.69999999999999996, 1.0);
        // device 1066, IC IC182, analog/basic/mos_r2r_dac.hpp:27
        I(cpphdl_n1701, Vss) <+ 2.9999999999999998e-15 * ddt(V(cpphdl_n1701, Vss)); // Bench initial voltage = 0.0 V.
        // device 1067, IC IC182, analog/basic/mos_r2r_dac.hpp:28
        I(cpphdl_n1701, cpphdl_n1718) <+ V(cpphdl_n1701, cpphdl_n1718) / 2000.0;
        // device 1068, IC IC182, analog/basic/mos_r2r_dac.hpp:29
        I(cpphdl_n1718, Vss) <+ 2.9999999999999998e-15 * ddt(V(cpphdl_n1718, Vss)); // Bench initial voltage = 0.0 V.
        // device 1069, IC IC182, analog/basic/mos_r2r_dac.hpp:31
        I(cpphdl_n1717, cpphdl_n1718) <+ V(cpphdl_n1717, cpphdl_n1718) / 1000.0;
        // device 1070, IC IC188, analog/basic/inverter.hpp:11
        I(cpphdl_n1705, Vdd) <+ cpphdl_channel(V(BIT_N7_5, Vdd), V(cpphdl_n1705, Vdd), 0.080000000000000002, 0.69999999999999996, -1.0);
        // device 1071, IC IC188, analog/basic/inverter.hpp:12
        I(cpphdl_n1705, Vss) <+ cpphdl_channel(V(BIT_N7_5, Vss), V(cpphdl_n1705, Vss), 0.080000000000000002, 0.69999999999999996, 1.0);
        // device 1072, IC IC182, analog/basic/mos_r2r_dac.hpp:27
        I(cpphdl_n1705, Vss) <+ 2.9999999999999998e-15 * ddt(V(cpphdl_n1705, Vss)); // Bench initial voltage = 0.0 V.
        // device 1073, IC IC182, analog/basic/mos_r2r_dac.hpp:28
        I(cpphdl_n1705, cpphdl_n1719) <+ V(cpphdl_n1705, cpphdl_n1719) / 2000.0;
        // device 1074, IC IC182, analog/basic/mos_r2r_dac.hpp:29
        I(cpphdl_n1719, Vss) <+ 2.9999999999999998e-15 * ddt(V(cpphdl_n1719, Vss)); // Bench initial voltage = 0.0 V.
        // device 1075, IC IC182, analog/basic/mos_r2r_dac.hpp:31
        I(cpphdl_n1718, cpphdl_n1719) <+ V(cpphdl_n1718, cpphdl_n1719) / 1000.0;
        // device 1076, IC IC189, analog/basic/inverter.hpp:11
        I(cpphdl_n1709, Vdd) <+ cpphdl_channel(V(BIT_N7_6, Vdd), V(cpphdl_n1709, Vdd), 0.080000000000000002, 0.69999999999999996, -1.0);
        // device 1077, IC IC189, analog/basic/inverter.hpp:12
        I(cpphdl_n1709, Vss) <+ cpphdl_channel(V(BIT_N7_6, Vss), V(cpphdl_n1709, Vss), 0.080000000000000002, 0.69999999999999996, 1.0);
        // device 1078, IC IC182, analog/basic/mos_r2r_dac.hpp:27
        I(cpphdl_n1709, Vss) <+ 2.9999999999999998e-15 * ddt(V(cpphdl_n1709, Vss)); // Bench initial voltage = 0.0 V.
        // device 1079, IC IC182, analog/basic/mos_r2r_dac.hpp:28
        I(cpphdl_n1709, cpphdl_n1720) <+ V(cpphdl_n1709, cpphdl_n1720) / 2000.0;
        // device 1080, IC IC182, analog/basic/mos_r2r_dac.hpp:29
        I(cpphdl_n1720, Vss) <+ 2.9999999999999998e-15 * ddt(V(cpphdl_n1720, Vss)); // Bench initial voltage = 0.0 V.
        // device 1081, IC IC182, analog/basic/mos_r2r_dac.hpp:31
        I(cpphdl_n1719, cpphdl_n1720) <+ V(cpphdl_n1719, cpphdl_n1720) / 1000.0;
        // device 1082, IC IC190, analog/basic/inverter.hpp:11
        I(cpphdl_n1713, Vdd) <+ cpphdl_channel(V(BIT_N7_7, Vdd), V(cpphdl_n1713, Vdd), 0.080000000000000002, 0.69999999999999996, -1.0);
        // device 1083, IC IC190, analog/basic/inverter.hpp:12
        I(cpphdl_n1713, Vss) <+ cpphdl_channel(V(BIT_N7_7, Vss), V(cpphdl_n1713, Vss), 0.080000000000000002, 0.69999999999999996, 1.0);
        // device 1084, IC IC182, analog/basic/mos_r2r_dac.hpp:27
        I(cpphdl_n1713, Vss) <+ 2.9999999999999998e-15 * ddt(V(cpphdl_n1713, Vss)); // Bench initial voltage = 0.0 V.
        // device 1085, IC IC182, analog/basic/mos_r2r_dac.hpp:28
        I(cpphdl_n1713, cpphdl_n1725) <+ V(cpphdl_n1713, cpphdl_n1725) / 2000.0;
        // device 1086, IC IC182, analog/basic/mos_r2r_dac.hpp:29
        I(cpphdl_n1725, Vss) <+ 2.9999999999999998e-15 * ddt(V(cpphdl_n1725, Vss)); // Bench initial voltage = 0.0 V.
        // device 1087, IC IC182, analog/basic/mos_r2r_dac.hpp:31
        I(cpphdl_n1720, cpphdl_n1725) <+ V(cpphdl_n1720, cpphdl_n1725) / 1000.0;
        // device 1088, IC IC182, analog/basic/mos_r2r_dac.hpp:33
        I(Vss, cpphdl_n1714) <+ V(Vss, cpphdl_n1714) / 2000.0;
        // device 1089, IC IC191, analog/basic/nmos_resistor_amplifier.hpp:23
        I(Vdd, cpphdl_n1734) <+ V(Vdd, cpphdl_n1734) / 1000.0;
        // device 1090, IC IC191, analog/basic/nmos_resistor_amplifier.hpp:24
        I(Vdd, cpphdl_n1733) <+ V(Vdd, cpphdl_n1733) / 1000.0;
        // device 1091, IC IC191, analog/basic/nmos_resistor_amplifier.hpp:25
        I(cpphdl_n1734, cpphdl_n1728) <+ cpphdl_channel(V(cpphdl_n1724, cpphdl_n1728), V(cpphdl_n1734, cpphdl_n1728), 0.0074999999999999997, 0.69999999999999996, 1.0);
        // device 1092, IC IC191, analog/basic/nmos_resistor_amplifier.hpp:26
        I(cpphdl_n1733, cpphdl_n1729) <+ cpphdl_channel(V(cpphdl_n1725, cpphdl_n1729), V(cpphdl_n1733, cpphdl_n1729), 0.0074999999999999997, 0.69999999999999996, 1.0);
        // device 1093, IC IC191, analog/basic/nmos_resistor_amplifier.hpp:27
        I(cpphdl_n1730, cpphdl_n1728) <+ V(cpphdl_n1730, cpphdl_n1728) / 100.0;
        // device 1094, IC IC191, analog/basic/nmos_resistor_amplifier.hpp:28
        I(cpphdl_n1730, cpphdl_n1729) <+ V(cpphdl_n1730, cpphdl_n1729) / 100.0;
        // device 1095, IC IC191, analog/basic/nmos_resistor_amplifier.hpp:29
        I(Vss, cpphdl_n1730) <+ V(Vss, cpphdl_n1730) / 300.0;
        // device 1096, IC IC191, analog/basic/nmos_resistor_amplifier.hpp:30
        I(cpphdl_n1734, Vdd) <+ 2.9999999999999998e-13 * ddt(V(cpphdl_n1734, Vdd)); // Bench initial voltage = 0.0 V.
        // device 1097, IC IC191, analog/basic/nmos_resistor_amplifier.hpp:31
        I(cpphdl_n1733, Vdd) <+ 2.9999999999999998e-13 * ddt(V(cpphdl_n1733, Vdd)); // Bench initial voltage = 0.0 V.
        // device 1098, IC IC191, analog/basic/nmos_resistor_amplifier.hpp:32
        I(cpphdl_n1730, Vss) <+ 4e-14 * ddt(V(cpphdl_n1730, Vss)); // Bench initial voltage = 0.0 V.
        // device 1099, IC IC191, analog/basic/nmos_resistor_amplifier.hpp:34
        I(cpphdl_n1724, cpphdl_n1728) <+ 2e-14 * ddt(V(cpphdl_n1724, cpphdl_n1728)); // Bench initial voltage = 0.0 V.
        // device 1100, IC IC191, analog/basic/nmos_resistor_amplifier.hpp:35
        I(cpphdl_n1725, cpphdl_n1729) <+ 2e-14 * ddt(V(cpphdl_n1725, cpphdl_n1729)); // Bench initial voltage = 0.0 V.
        // device 1101, IC IC191, analog/basic/nmos_resistor_amplifier.hpp:36
        I(cpphdl_n1724, cpphdl_n1734) <+ 2.9999999999999998e-15 * ddt(V(cpphdl_n1724, cpphdl_n1734)); // Bench initial voltage = 0.0 V.
        // device 1102, IC IC191, analog/basic/nmos_resistor_amplifier.hpp:37
        I(cpphdl_n1725, cpphdl_n1733) <+ 2.9999999999999998e-15 * ddt(V(cpphdl_n1725, cpphdl_n1733)); // Bench initial voltage = 0.0 V.
        // device 1103, IC IC192, analog/basic/strongarm_comparator.hpp:28
        I(cpphdl_n1738, cpphdl_n1740) <+ cpphdl_channel(V(cpphdl_n1733, cpphdl_n1740), V(cpphdl_n1738, cpphdl_n1740), 0.0080000000000000002, 0.69999999999999996, 1.0);
        // device 1104, IC IC192, analog/basic/strongarm_comparator.hpp:29
        I(cpphdl_n1739, cpphdl_n1740) <+ cpphdl_channel(V(cpphdl_n1734, cpphdl_n1740), V(cpphdl_n1739, cpphdl_n1740), 0.0080000000000000002, 0.69999999999999996, 1.0);
        // device 1105, IC IC192, analog/basic/strongarm_comparator.hpp:30
        I(cpphdl_n1740, Vss) <+ cpphdl_channel(V(EVALUATE, Vss), V(cpphdl_n1740, Vss), 0.0080000000000000002, 0.69999999999999996, 1.0);
        // device 1106, IC IC192, analog/basic/strongarm_comparator.hpp:33
        I(cpphdl_n1753, cpphdl_n1738) <+ cpphdl_channel(V(cpphdl_n1757, cpphdl_n1738), V(cpphdl_n1753, cpphdl_n1738), 0.0040000000000000001, 0.69999999999999996, 1.0);
        // device 1107, IC IC192, analog/basic/strongarm_comparator.hpp:34
        I(cpphdl_n1757, cpphdl_n1739) <+ cpphdl_channel(V(cpphdl_n1753, cpphdl_n1739), V(cpphdl_n1757, cpphdl_n1739), 0.0040000000000000001, 0.69999999999999996, 1.0);
        // device 1108, IC IC192, analog/basic/strongarm_comparator.hpp:35
        I(cpphdl_n1757, Vdd) <+ cpphdl_channel(V(cpphdl_n1753, Vdd), V(cpphdl_n1757, Vdd), 0.002, 0.69999999999999996, -1.0);
        // device 1109, IC IC192, analog/basic/strongarm_comparator.hpp:36
        I(cpphdl_n1753, Vdd) <+ cpphdl_channel(V(cpphdl_n1757, Vdd), V(cpphdl_n1753, Vdd), 0.002, 0.69999999999999996, -1.0);
        // device 1110, IC IC192, analog/basic/strongarm_comparator.hpp:38
        I(cpphdl_n1738, Vdd) <+ cpphdl_channel(V(EVALUATE, Vdd), V(cpphdl_n1738, Vdd), 0.002, 0.69999999999999996, -1.0);
        // device 1111, IC IC192, analog/basic/strongarm_comparator.hpp:39
        I(cpphdl_n1739, Vdd) <+ cpphdl_channel(V(EVALUATE, Vdd), V(cpphdl_n1739, Vdd), 0.002, 0.69999999999999996, -1.0);
        // device 1112, IC IC192, analog/basic/strongarm_comparator.hpp:40
        I(cpphdl_n1757, Vdd) <+ cpphdl_channel(V(EVALUATE, Vdd), V(cpphdl_n1757, Vdd), 0.002, 0.69999999999999996, -1.0);
        // device 1113, IC IC192, analog/basic/strongarm_comparator.hpp:41
        I(cpphdl_n1753, Vdd) <+ cpphdl_channel(V(EVALUATE, Vdd), V(cpphdl_n1753, Vdd), 0.002, 0.69999999999999996, -1.0);
        // device 1114, IC IC192, analog/basic/strongarm_comparator.hpp:42
        I(cpphdl_n1738, Vss) <+ 2.9999999999999998e-14 * ddt(V(cpphdl_n1738, Vss)); // Bench initial voltage = 0.0 V.
        // device 1115, IC IC192, analog/basic/strongarm_comparator.hpp:43
        I(cpphdl_n1739, Vss) <+ 2.9999999999999998e-14 * ddt(V(cpphdl_n1739, Vss)); // Bench initial voltage = 0.0 V.
        // device 1116, IC IC192, analog/basic/strongarm_comparator.hpp:44
        I(cpphdl_n1740, Vss) <+ 2.9999999999999998e-14 * ddt(V(cpphdl_n1740, Vss)); // Bench initial voltage = 0.0 V.
        // device 1117, IC IC192, analog/basic/strongarm_comparator.hpp:45
        I(cpphdl_n1757, Vss) <+ 5.0000000000000002e-14 * ddt(V(cpphdl_n1757, Vss)); // Bench initial voltage = 0.0 V.
        // device 1118, IC IC192, analog/basic/strongarm_comparator.hpp:46
        I(cpphdl_n1753, Vss) <+ 5.0000000000000002e-14 * ddt(V(cpphdl_n1753, Vss)); // Bench initial voltage = 0.0 V.
        // device 1119, IC IC192, analog/basic/strongarm_comparator.hpp:47
        I(cpphdl_n1733, cpphdl_n1740) <+ 2e-14 * ddt(V(cpphdl_n1733, cpphdl_n1740)); // Bench initial voltage = 0.0 V.
        // device 1120, IC IC192, analog/basic/strongarm_comparator.hpp:48
        I(cpphdl_n1734, cpphdl_n1740) <+ 2e-14 * ddt(V(cpphdl_n1734, cpphdl_n1740)); // Bench initial voltage = 0.0 V.
        // device 1121, IC IC192, analog/basic/strongarm_comparator.hpp:49
        I(cpphdl_n1733, cpphdl_n1738) <+ 2.9999999999999998e-15 * ddt(V(cpphdl_n1733, cpphdl_n1738)); // Bench initial voltage = 0.0 V.
        // device 1122, IC IC192, analog/basic/strongarm_comparator.hpp:50
        I(cpphdl_n1734, cpphdl_n1739) <+ 2.9999999999999998e-15 * ddt(V(cpphdl_n1734, cpphdl_n1739)); // Bench initial voltage = 0.0 V.
        // device 1123, IC IC194, analog/basic/inverter.hpp:11
        I(cpphdl_n1761, Vdd) <+ cpphdl_channel(V(cpphdl_n1753, Vdd), V(cpphdl_n1761, Vdd), 0.001, 0.69999999999999996, -1.0);
        // device 1124, IC IC194, analog/basic/inverter.hpp:12
        I(cpphdl_n1761, Vss) <+ cpphdl_channel(V(cpphdl_n1753, Vss), V(cpphdl_n1761, Vss), 0.001, 0.69999999999999996, 1.0);
        // device 1125, IC IC196, analog/basic/inverter.hpp:11
        I(cpphdl_n1775, Vdd) <+ cpphdl_channel(V(cpphdl_n1761, Vdd), V(cpphdl_n1775, Vdd), 0.0040000000000000001, 0.69999999999999996, -1.0);
        // device 1126, IC IC196, analog/basic/inverter.hpp:12
        I(cpphdl_n1775, Vss) <+ cpphdl_channel(V(cpphdl_n1761, Vss), V(cpphdl_n1775, Vss), 0.0040000000000000001, 0.69999999999999996, 1.0);
        // device 1127, IC IC193, analog/basic/buffered_nand_latch.hpp:34
        I(cpphdl_n1753, Vss) <+ 2.0000000000000002e-15 * ddt(V(cpphdl_n1753, Vss)); // Bench initial voltage = 0.0 V.
        // device 1128, IC IC193, analog/basic/buffered_nand_latch.hpp:35
        I(cpphdl_n1753, cpphdl_n1761) <+ 1.0000000000000001e-15 * ddt(V(cpphdl_n1753, cpphdl_n1761)); // Bench initial voltage = 0.0 V.
        // device 1129, IC IC193, analog/basic/buffered_nand_latch.hpp:36
        I(cpphdl_n1761, Vss) <+ 5e-15 * ddt(V(cpphdl_n1761, Vss)); // Bench initial voltage = 0.0 V.
        // device 1130, IC IC193, analog/basic/buffered_nand_latch.hpp:37
        I(cpphdl_n1761, Vss) <+ 8.0000000000000006e-15 * ddt(V(cpphdl_n1761, Vss)); // Bench initial voltage = 0.0 V.
        // device 1131, IC IC193, analog/basic/buffered_nand_latch.hpp:38
        I(cpphdl_n1775, Vss) <+ 1e-14 * ddt(V(cpphdl_n1775, Vss)); // Bench initial voltage = 0.0 V.
        // device 1132, IC IC195, analog/basic/inverter.hpp:11
        I(cpphdl_n1765, Vdd) <+ cpphdl_channel(V(cpphdl_n1757, Vdd), V(cpphdl_n1765, Vdd), 0.001, 0.69999999999999996, -1.0);
        // device 1133, IC IC195, analog/basic/inverter.hpp:12
        I(cpphdl_n1765, Vss) <+ cpphdl_channel(V(cpphdl_n1757, Vss), V(cpphdl_n1765, Vss), 0.001, 0.69999999999999996, 1.0);
        // device 1134, IC IC197, analog/basic/inverter.hpp:11
        I(cpphdl_n1781, Vdd) <+ cpphdl_channel(V(cpphdl_n1765, Vdd), V(cpphdl_n1781, Vdd), 0.0040000000000000001, 0.69999999999999996, -1.0);
        // device 1135, IC IC197, analog/basic/inverter.hpp:12
        I(cpphdl_n1781, Vss) <+ cpphdl_channel(V(cpphdl_n1765, Vss), V(cpphdl_n1781, Vss), 0.0040000000000000001, 0.69999999999999996, 1.0);
        // device 1136, IC IC193, analog/basic/buffered_nand_latch.hpp:34
        I(cpphdl_n1757, Vss) <+ 2.0000000000000002e-15 * ddt(V(cpphdl_n1757, Vss)); // Bench initial voltage = 0.0 V.
        // device 1137, IC IC193, analog/basic/buffered_nand_latch.hpp:35
        I(cpphdl_n1757, cpphdl_n1765) <+ 1.0000000000000001e-15 * ddt(V(cpphdl_n1757, cpphdl_n1765)); // Bench initial voltage = 0.0 V.
        // device 1138, IC IC193, analog/basic/buffered_nand_latch.hpp:36
        I(cpphdl_n1765, Vss) <+ 5e-15 * ddt(V(cpphdl_n1765, Vss)); // Bench initial voltage = 0.0 V.
        // device 1139, IC IC193, analog/basic/buffered_nand_latch.hpp:37
        I(cpphdl_n1765, Vss) <+ 8.0000000000000006e-15 * ddt(V(cpphdl_n1765, Vss)); // Bench initial voltage = 0.0 V.
        // device 1140, IC IC193, analog/basic/buffered_nand_latch.hpp:38
        I(cpphdl_n1781, Vss) <+ 1e-14 * ddt(V(cpphdl_n1781, Vss)); // Bench initial voltage = 0.0 V.
        // device 1141, IC IC199, analog/basic/cmos_logic.hpp:17
        I(cpphdl_n2988, Vss) <+ 5.0000000000000002e-14 * ddt(V(cpphdl_n2988, Vss)); // Bench initial voltage = 0.0 V.
        // device 1142, IC IC199, analog/basic/cmos_logic.hpp:18
        I(cpphdl_n2988, Vdd) <+ cpphdl_channel(V(cpphdl_n1775, Vdd), V(cpphdl_n2988, Vdd), 0.01, 0.69999999999999996, -1.0);
        // device 1143, IC IC199, analog/basic/cmos_logic.hpp:19
        I(cpphdl_n2988, Vdd) <+ cpphdl_channel(V(cpphdl_n1783, Vdd), V(cpphdl_n2988, Vdd), 0.01, 0.69999999999999996, -1.0);
        // device 1144, IC IC199, analog/basic/cmos_logic.hpp:20
        I(cpphdl_n2988, cpphdl_n1778) <+ cpphdl_channel(V(cpphdl_n1775, cpphdl_n1778), V(cpphdl_n2988, cpphdl_n1778), 0.01, 0.69999999999999996, 1.0);
        // device 1145, IC IC199, analog/basic/cmos_logic.hpp:21
        I(cpphdl_n1778, Vss) <+ cpphdl_channel(V(cpphdl_n1783, Vss), V(cpphdl_n1778, Vss), 0.01, 0.69999999999999996, 1.0);
        // device 1146, IC IC199, analog/basic/cmos_logic.hpp:27
        I(cpphdl_n1778, Vss) <+ 1e-14 * ddt(V(cpphdl_n1778, Vss)); // Bench initial voltage = 0.0 V.
        // device 1147, IC IC200, analog/basic/cmos_logic.hpp:17
        I(cpphdl_n1783, Vss) <+ 5.0000000000000002e-14 * ddt(V(cpphdl_n1783, Vss)); // Bench initial voltage = 0.0 V.
        // device 1148, IC IC200, analog/basic/cmos_logic.hpp:18
        I(cpphdl_n1783, Vdd) <+ cpphdl_channel(V(cpphdl_n1781, Vdd), V(cpphdl_n1783, Vdd), 0.01, 0.69999999999999996, -1.0);
        // device 1149, IC IC200, analog/basic/cmos_logic.hpp:19
        I(cpphdl_n1783, Vdd) <+ cpphdl_channel(V(cpphdl_n2988, Vdd), V(cpphdl_n1783, Vdd), 0.01, 0.69999999999999996, -1.0);
        // device 1150, IC IC200, analog/basic/cmos_logic.hpp:20
        I(cpphdl_n1783, cpphdl_n1784) <+ cpphdl_channel(V(cpphdl_n1781, cpphdl_n1784), V(cpphdl_n1783, cpphdl_n1784), 0.01, 0.69999999999999996, 1.0);
        // device 1151, IC IC200, analog/basic/cmos_logic.hpp:21
        I(cpphdl_n1784, Vss) <+ cpphdl_channel(V(cpphdl_n2988, Vss), V(cpphdl_n1784, Vss), 0.01, 0.69999999999999996, 1.0);
        // device 1152, IC IC200, analog/basic/cmos_logic.hpp:27
        I(cpphdl_n1784, Vss) <+ 1e-14 * ddt(V(cpphdl_n1784, Vss)); // Bench initial voltage = 0.0 V.
        // device 1153, IC IC198, analog/basic/nand_latch.hpp:36
        I(cpphdl_n1775, Vss) <+ 2.9999999999999998e-15 * ddt(V(cpphdl_n1775, Vss)); // Bench initial voltage = 0.0 V.
        // device 1154, IC IC198, analog/basic/nand_latch.hpp:37
        I(cpphdl_n1781, Vss) <+ 2.9999999999999998e-15 * ddt(V(cpphdl_n1781, Vss)); // Bench initial voltage = 0.0 V.
        // device 1155, IC IC201, analog/basic/inverter.hpp:11
        I(cpphdl_n1789, Vdd) <+ cpphdl_channel(V(CLEAR, Vdd), V(cpphdl_n1789, Vdd), 0.01, 0.69999999999999996, -1.0);
        // device 1156, IC IC201, analog/basic/inverter.hpp:12
        I(cpphdl_n1789, Vss) <+ cpphdl_channel(V(CLEAR, Vss), V(cpphdl_n1789, Vss), 0.01, 0.69999999999999996, 1.0);
        // device 1157, IC IC198, analog/basic/nand_latch.hpp:58
        I(cpphdl_n1789, Vss) <+ 2.9999999999999998e-15 * ddt(V(cpphdl_n1789, Vss)); // Bench initial voltage = 0.0 V.
        // device 1158, IC IC198, analog/basic/nand_latch.hpp:59
        I(cpphdl_n2988, Vss) <+ cpphdl_channel(V(CLEAR, Vss), V(cpphdl_n2988, Vss), 0.050000000000000003, 0.69999999999999996, 1.0);
        // device 1159, IC IC198, analog/basic/nand_latch.hpp:60
        I(cpphdl_n1783, Vdd) <+ cpphdl_channel(V(cpphdl_n1789, Vdd), V(cpphdl_n1783, Vdd), 0.050000000000000003, 0.69999999999999996, -1.0);
        // device 1160, IC IC204, analog/basic/inverter.hpp:11
        I(cpphdl_n1813, Vdd) <+ cpphdl_channel(V(TRACK8, Vdd), V(cpphdl_n1813, Vdd), 0.0040000000000000001, 0.69999999999999996, -1.0);
        // device 1161, IC IC204, analog/basic/inverter.hpp:12
        I(cpphdl_n1813, Vss) <+ cpphdl_channel(V(TRACK8, Vss), V(cpphdl_n1813, Vss), 0.0040000000000000001, 0.69999999999999996, 1.0);
        // device 1162, IC IC203, analog/basic/mos_track_hold.hpp:31
        I(cpphdl_n1813, Vss) <+ 2e-14 * ddt(V(cpphdl_n1813, Vss)); // Bench initial voltage = 0.0 V.
        // device 1163, IC IC203, analog/basic/mos_track_hold.hpp:32
        I(cpphdl_n2808, cpphdl_n1867) <+ cpphdl_channel(V(TRACK8, cpphdl_n1867), V(cpphdl_n2808, cpphdl_n1867), 0.029999999999999999, 0.69999999999999996, 1.0);
        // device 1164, IC IC203, analog/basic/mos_track_hold.hpp:33
        I(cpphdl_n1867, cpphdl_n2808) <+ cpphdl_channel(V(cpphdl_n1813, cpphdl_n2808), V(cpphdl_n1867, cpphdl_n2808), 0.014999999999999999, 0.69999999999999996, -1.0);
        // device 1165, IC IC203, analog/basic/mos_track_hold.hpp:37
        I(cpphdl_n1867, cpphdl_n1867) <+ cpphdl_channel(V(cpphdl_n1813, cpphdl_n1867), V(cpphdl_n1867, cpphdl_n1867), 0.016, 0.69999999999999996, 1.0);
        // device 1166, IC IC203, analog/basic/mos_track_hold.hpp:38
        I(cpphdl_n1867, cpphdl_n1867) <+ cpphdl_channel(V(TRACK8, cpphdl_n1867), V(cpphdl_n1867, cpphdl_n1867), 0.0083999999999999995, 0.69999999999999996, -1.0);
        // device 1167, IC IC203, analog/basic/mos_track_hold.hpp:39
        I(cpphdl_n1867, Vss) <+ 1.5000000000000001e-12 * ddt(V(cpphdl_n1867, Vss)); // Bench initial voltage = 0.0 V.
        // device 1168, IC IC203, analog/basic/mos_track_hold.hpp:42
        I(TRACK8, cpphdl_n1867) <+ 2.0000000000000002e-15 * ddt(V(TRACK8, cpphdl_n1867)); // Bench initial voltage = -0.0 V.
        // device 1169, IC IC203, analog/basic/mos_track_hold.hpp:43
        I(cpphdl_n1813, cpphdl_n1867) <+ 2.0000000000000002e-15 * ddt(V(cpphdl_n1813, cpphdl_n1867)); // Bench initial voltage = 0.0 V.
        // device 1170, IC IC203, analog/basic/mos_track_hold.hpp:44
        I(cpphdl_n2808, cpphdl_n1867) <+ 1.0000000000000001e-15 * ddt(V(cpphdl_n2808, cpphdl_n1867)); // Bench initial voltage = 0.0 V.
        // device 1171, IC IC206, analog/basic/inverter.hpp:11
        I(cpphdl_n1828, Vdd) <+ cpphdl_channel(V(BIT_N8_0, Vdd), V(cpphdl_n1828, Vdd), 0.080000000000000002, 0.69999999999999996, -1.0);
        // device 1172, IC IC206, analog/basic/inverter.hpp:12
        I(cpphdl_n1828, Vss) <+ cpphdl_channel(V(BIT_N8_0, Vss), V(cpphdl_n1828, Vss), 0.080000000000000002, 0.69999999999999996, 1.0);
        // device 1173, IC IC205, analog/basic/mos_r2r_dac.hpp:27
        I(cpphdl_n1828, Vss) <+ 2.9999999999999998e-15 * ddt(V(cpphdl_n1828, Vss)); // Bench initial voltage = 0.0 V.
        // device 1174, IC IC205, analog/basic/mos_r2r_dac.hpp:28
        I(cpphdl_n1828, cpphdl_n1857) <+ V(cpphdl_n1828, cpphdl_n1857) / 2000.0;
        // device 1175, IC IC205, analog/basic/mos_r2r_dac.hpp:29
        I(cpphdl_n1857, Vss) <+ 2.9999999999999998e-15 * ddt(V(cpphdl_n1857, Vss)); // Bench initial voltage = 0.0 V.
        // device 1176, IC IC207, analog/basic/inverter.hpp:11
        I(cpphdl_n1832, Vdd) <+ cpphdl_channel(V(BIT_N8_1, Vdd), V(cpphdl_n1832, Vdd), 0.080000000000000002, 0.69999999999999996, -1.0);
        // device 1177, IC IC207, analog/basic/inverter.hpp:12
        I(cpphdl_n1832, Vss) <+ cpphdl_channel(V(BIT_N8_1, Vss), V(cpphdl_n1832, Vss), 0.080000000000000002, 0.69999999999999996, 1.0);
        // device 1178, IC IC205, analog/basic/mos_r2r_dac.hpp:27
        I(cpphdl_n1832, Vss) <+ 2.9999999999999998e-15 * ddt(V(cpphdl_n1832, Vss)); // Bench initial voltage = 0.0 V.
        // device 1179, IC IC205, analog/basic/mos_r2r_dac.hpp:28
        I(cpphdl_n1832, cpphdl_n1858) <+ V(cpphdl_n1832, cpphdl_n1858) / 2000.0;
        // device 1180, IC IC205, analog/basic/mos_r2r_dac.hpp:29
        I(cpphdl_n1858, Vss) <+ 2.9999999999999998e-15 * ddt(V(cpphdl_n1858, Vss)); // Bench initial voltage = 0.0 V.
        // device 1181, IC IC205, analog/basic/mos_r2r_dac.hpp:31
        I(cpphdl_n1857, cpphdl_n1858) <+ V(cpphdl_n1857, cpphdl_n1858) / 1000.0;
        // device 1182, IC IC208, analog/basic/inverter.hpp:11
        I(cpphdl_n1836, Vdd) <+ cpphdl_channel(V(BIT_N8_2, Vdd), V(cpphdl_n1836, Vdd), 0.080000000000000002, 0.69999999999999996, -1.0);
        // device 1183, IC IC208, analog/basic/inverter.hpp:12
        I(cpphdl_n1836, Vss) <+ cpphdl_channel(V(BIT_N8_2, Vss), V(cpphdl_n1836, Vss), 0.080000000000000002, 0.69999999999999996, 1.0);
        // device 1184, IC IC205, analog/basic/mos_r2r_dac.hpp:27
        I(cpphdl_n1836, Vss) <+ 2.9999999999999998e-15 * ddt(V(cpphdl_n1836, Vss)); // Bench initial voltage = 0.0 V.
        // device 1185, IC IC205, analog/basic/mos_r2r_dac.hpp:28
        I(cpphdl_n1836, cpphdl_n1859) <+ V(cpphdl_n1836, cpphdl_n1859) / 2000.0;
        // device 1186, IC IC205, analog/basic/mos_r2r_dac.hpp:29
        I(cpphdl_n1859, Vss) <+ 2.9999999999999998e-15 * ddt(V(cpphdl_n1859, Vss)); // Bench initial voltage = 0.0 V.
        // device 1187, IC IC205, analog/basic/mos_r2r_dac.hpp:31
        I(cpphdl_n1858, cpphdl_n1859) <+ V(cpphdl_n1858, cpphdl_n1859) / 1000.0;
        // device 1188, IC IC209, analog/basic/inverter.hpp:11
        I(cpphdl_n1840, Vdd) <+ cpphdl_channel(V(BIT_N8_3, Vdd), V(cpphdl_n1840, Vdd), 0.080000000000000002, 0.69999999999999996, -1.0);
        // device 1189, IC IC209, analog/basic/inverter.hpp:12
        I(cpphdl_n1840, Vss) <+ cpphdl_channel(V(BIT_N8_3, Vss), V(cpphdl_n1840, Vss), 0.080000000000000002, 0.69999999999999996, 1.0);
        // device 1190, IC IC205, analog/basic/mos_r2r_dac.hpp:27
        I(cpphdl_n1840, Vss) <+ 2.9999999999999998e-15 * ddt(V(cpphdl_n1840, Vss)); // Bench initial voltage = 0.0 V.
        // device 1191, IC IC205, analog/basic/mos_r2r_dac.hpp:28
        I(cpphdl_n1840, cpphdl_n1860) <+ V(cpphdl_n1840, cpphdl_n1860) / 2000.0;
        // device 1192, IC IC205, analog/basic/mos_r2r_dac.hpp:29
        I(cpphdl_n1860, Vss) <+ 2.9999999999999998e-15 * ddt(V(cpphdl_n1860, Vss)); // Bench initial voltage = 0.0 V.
        // device 1193, IC IC205, analog/basic/mos_r2r_dac.hpp:31
        I(cpphdl_n1859, cpphdl_n1860) <+ V(cpphdl_n1859, cpphdl_n1860) / 1000.0;
        // device 1194, IC IC210, analog/basic/inverter.hpp:11
        I(cpphdl_n1844, Vdd) <+ cpphdl_channel(V(BIT_N8_4, Vdd), V(cpphdl_n1844, Vdd), 0.080000000000000002, 0.69999999999999996, -1.0);
        // device 1195, IC IC210, analog/basic/inverter.hpp:12
        I(cpphdl_n1844, Vss) <+ cpphdl_channel(V(BIT_N8_4, Vss), V(cpphdl_n1844, Vss), 0.080000000000000002, 0.69999999999999996, 1.0);
        // device 1196, IC IC205, analog/basic/mos_r2r_dac.hpp:27
        I(cpphdl_n1844, Vss) <+ 2.9999999999999998e-15 * ddt(V(cpphdl_n1844, Vss)); // Bench initial voltage = 0.0 V.
        // device 1197, IC IC205, analog/basic/mos_r2r_dac.hpp:28
        I(cpphdl_n1844, cpphdl_n1861) <+ V(cpphdl_n1844, cpphdl_n1861) / 2000.0;
        // device 1198, IC IC205, analog/basic/mos_r2r_dac.hpp:29
        I(cpphdl_n1861, Vss) <+ 2.9999999999999998e-15 * ddt(V(cpphdl_n1861, Vss)); // Bench initial voltage = 0.0 V.
        // device 1199, IC IC205, analog/basic/mos_r2r_dac.hpp:31
        I(cpphdl_n1860, cpphdl_n1861) <+ V(cpphdl_n1860, cpphdl_n1861) / 1000.0;
        // device 1200, IC IC211, analog/basic/inverter.hpp:11
        I(cpphdl_n1848, Vdd) <+ cpphdl_channel(V(BIT_N8_5, Vdd), V(cpphdl_n1848, Vdd), 0.080000000000000002, 0.69999999999999996, -1.0);
        // device 1201, IC IC211, analog/basic/inverter.hpp:12
        I(cpphdl_n1848, Vss) <+ cpphdl_channel(V(BIT_N8_5, Vss), V(cpphdl_n1848, Vss), 0.080000000000000002, 0.69999999999999996, 1.0);
        // device 1202, IC IC205, analog/basic/mos_r2r_dac.hpp:27
        I(cpphdl_n1848, Vss) <+ 2.9999999999999998e-15 * ddt(V(cpphdl_n1848, Vss)); // Bench initial voltage = 0.0 V.
        // device 1203, IC IC205, analog/basic/mos_r2r_dac.hpp:28
        I(cpphdl_n1848, cpphdl_n1862) <+ V(cpphdl_n1848, cpphdl_n1862) / 2000.0;
        // device 1204, IC IC205, analog/basic/mos_r2r_dac.hpp:29
        I(cpphdl_n1862, Vss) <+ 2.9999999999999998e-15 * ddt(V(cpphdl_n1862, Vss)); // Bench initial voltage = 0.0 V.
        // device 1205, IC IC205, analog/basic/mos_r2r_dac.hpp:31
        I(cpphdl_n1861, cpphdl_n1862) <+ V(cpphdl_n1861, cpphdl_n1862) / 1000.0;
        // device 1206, IC IC212, analog/basic/inverter.hpp:11
        I(cpphdl_n1852, Vdd) <+ cpphdl_channel(V(BIT_N8_6, Vdd), V(cpphdl_n1852, Vdd), 0.080000000000000002, 0.69999999999999996, -1.0);
        // device 1207, IC IC212, analog/basic/inverter.hpp:12
        I(cpphdl_n1852, Vss) <+ cpphdl_channel(V(BIT_N8_6, Vss), V(cpphdl_n1852, Vss), 0.080000000000000002, 0.69999999999999996, 1.0);
        // device 1208, IC IC205, analog/basic/mos_r2r_dac.hpp:27
        I(cpphdl_n1852, Vss) <+ 2.9999999999999998e-15 * ddt(V(cpphdl_n1852, Vss)); // Bench initial voltage = 0.0 V.
        // device 1209, IC IC205, analog/basic/mos_r2r_dac.hpp:28
        I(cpphdl_n1852, cpphdl_n1863) <+ V(cpphdl_n1852, cpphdl_n1863) / 2000.0;
        // device 1210, IC IC205, analog/basic/mos_r2r_dac.hpp:29
        I(cpphdl_n1863, Vss) <+ 2.9999999999999998e-15 * ddt(V(cpphdl_n1863, Vss)); // Bench initial voltage = 0.0 V.
        // device 1211, IC IC205, analog/basic/mos_r2r_dac.hpp:31
        I(cpphdl_n1862, cpphdl_n1863) <+ V(cpphdl_n1862, cpphdl_n1863) / 1000.0;
        // device 1212, IC IC213, analog/basic/inverter.hpp:11
        I(cpphdl_n1856, Vdd) <+ cpphdl_channel(V(BIT_N8_7, Vdd), V(cpphdl_n1856, Vdd), 0.080000000000000002, 0.69999999999999996, -1.0);
        // device 1213, IC IC213, analog/basic/inverter.hpp:12
        I(cpphdl_n1856, Vss) <+ cpphdl_channel(V(BIT_N8_7, Vss), V(cpphdl_n1856, Vss), 0.080000000000000002, 0.69999999999999996, 1.0);
        // device 1214, IC IC205, analog/basic/mos_r2r_dac.hpp:27
        I(cpphdl_n1856, Vss) <+ 2.9999999999999998e-15 * ddt(V(cpphdl_n1856, Vss)); // Bench initial voltage = 0.0 V.
        // device 1215, IC IC205, analog/basic/mos_r2r_dac.hpp:28
        I(cpphdl_n1856, cpphdl_n1868) <+ V(cpphdl_n1856, cpphdl_n1868) / 2000.0;
        // device 1216, IC IC205, analog/basic/mos_r2r_dac.hpp:29
        I(cpphdl_n1868, Vss) <+ 2.9999999999999998e-15 * ddt(V(cpphdl_n1868, Vss)); // Bench initial voltage = 0.0 V.
        // device 1217, IC IC205, analog/basic/mos_r2r_dac.hpp:31
        I(cpphdl_n1863, cpphdl_n1868) <+ V(cpphdl_n1863, cpphdl_n1868) / 1000.0;
        // device 1218, IC IC205, analog/basic/mos_r2r_dac.hpp:33
        I(Vss, cpphdl_n1857) <+ V(Vss, cpphdl_n1857) / 2000.0;
        // device 1219, IC IC214, analog/basic/nmos_resistor_amplifier.hpp:23
        I(Vdd, cpphdl_n1877) <+ V(Vdd, cpphdl_n1877) / 1000.0;
        // device 1220, IC IC214, analog/basic/nmos_resistor_amplifier.hpp:24
        I(Vdd, cpphdl_n1876) <+ V(Vdd, cpphdl_n1876) / 1000.0;
        // device 1221, IC IC214, analog/basic/nmos_resistor_amplifier.hpp:25
        I(cpphdl_n1877, cpphdl_n1871) <+ cpphdl_channel(V(cpphdl_n1867, cpphdl_n1871), V(cpphdl_n1877, cpphdl_n1871), 0.0074999999999999997, 0.69999999999999996, 1.0);
        // device 1222, IC IC214, analog/basic/nmos_resistor_amplifier.hpp:26
        I(cpphdl_n1876, cpphdl_n1872) <+ cpphdl_channel(V(cpphdl_n1868, cpphdl_n1872), V(cpphdl_n1876, cpphdl_n1872), 0.0074999999999999997, 0.69999999999999996, 1.0);
        // device 1223, IC IC214, analog/basic/nmos_resistor_amplifier.hpp:27
        I(cpphdl_n1873, cpphdl_n1871) <+ V(cpphdl_n1873, cpphdl_n1871) / 100.0;
        // device 1224, IC IC214, analog/basic/nmos_resistor_amplifier.hpp:28
        I(cpphdl_n1873, cpphdl_n1872) <+ V(cpphdl_n1873, cpphdl_n1872) / 100.0;
        // device 1225, IC IC214, analog/basic/nmos_resistor_amplifier.hpp:29
        I(Vss, cpphdl_n1873) <+ V(Vss, cpphdl_n1873) / 300.0;
        // device 1226, IC IC214, analog/basic/nmos_resistor_amplifier.hpp:30
        I(cpphdl_n1877, Vdd) <+ 2.9999999999999998e-13 * ddt(V(cpphdl_n1877, Vdd)); // Bench initial voltage = 0.0 V.
        // device 1227, IC IC214, analog/basic/nmos_resistor_amplifier.hpp:31
        I(cpphdl_n1876, Vdd) <+ 2.9999999999999998e-13 * ddt(V(cpphdl_n1876, Vdd)); // Bench initial voltage = 0.0 V.
        // device 1228, IC IC214, analog/basic/nmos_resistor_amplifier.hpp:32
        I(cpphdl_n1873, Vss) <+ 4e-14 * ddt(V(cpphdl_n1873, Vss)); // Bench initial voltage = 0.0 V.
        // device 1229, IC IC214, analog/basic/nmos_resistor_amplifier.hpp:34
        I(cpphdl_n1867, cpphdl_n1871) <+ 2e-14 * ddt(V(cpphdl_n1867, cpphdl_n1871)); // Bench initial voltage = 0.0 V.
        // device 1230, IC IC214, analog/basic/nmos_resistor_amplifier.hpp:35
        I(cpphdl_n1868, cpphdl_n1872) <+ 2e-14 * ddt(V(cpphdl_n1868, cpphdl_n1872)); // Bench initial voltage = 0.0 V.
        // device 1231, IC IC214, analog/basic/nmos_resistor_amplifier.hpp:36
        I(cpphdl_n1867, cpphdl_n1877) <+ 2.9999999999999998e-15 * ddt(V(cpphdl_n1867, cpphdl_n1877)); // Bench initial voltage = 0.0 V.
        // device 1232, IC IC214, analog/basic/nmos_resistor_amplifier.hpp:37
        I(cpphdl_n1868, cpphdl_n1876) <+ 2.9999999999999998e-15 * ddt(V(cpphdl_n1868, cpphdl_n1876)); // Bench initial voltage = 0.0 V.
        // device 1233, IC IC215, analog/basic/strongarm_comparator.hpp:28
        I(cpphdl_n1881, cpphdl_n1883) <+ cpphdl_channel(V(cpphdl_n1876, cpphdl_n1883), V(cpphdl_n1881, cpphdl_n1883), 0.0080000000000000002, 0.69999999999999996, 1.0);
        // device 1234, IC IC215, analog/basic/strongarm_comparator.hpp:29
        I(cpphdl_n1882, cpphdl_n1883) <+ cpphdl_channel(V(cpphdl_n1877, cpphdl_n1883), V(cpphdl_n1882, cpphdl_n1883), 0.0080000000000000002, 0.69999999999999996, 1.0);
        // device 1235, IC IC215, analog/basic/strongarm_comparator.hpp:30
        I(cpphdl_n1883, Vss) <+ cpphdl_channel(V(EVALUATE, Vss), V(cpphdl_n1883, Vss), 0.0080000000000000002, 0.69999999999999996, 1.0);
        // device 1236, IC IC215, analog/basic/strongarm_comparator.hpp:33
        I(cpphdl_n1896, cpphdl_n1881) <+ cpphdl_channel(V(cpphdl_n1900, cpphdl_n1881), V(cpphdl_n1896, cpphdl_n1881), 0.0040000000000000001, 0.69999999999999996, 1.0);
        // device 1237, IC IC215, analog/basic/strongarm_comparator.hpp:34
        I(cpphdl_n1900, cpphdl_n1882) <+ cpphdl_channel(V(cpphdl_n1896, cpphdl_n1882), V(cpphdl_n1900, cpphdl_n1882), 0.0040000000000000001, 0.69999999999999996, 1.0);
        // device 1238, IC IC215, analog/basic/strongarm_comparator.hpp:35
        I(cpphdl_n1900, Vdd) <+ cpphdl_channel(V(cpphdl_n1896, Vdd), V(cpphdl_n1900, Vdd), 0.002, 0.69999999999999996, -1.0);
        // device 1239, IC IC215, analog/basic/strongarm_comparator.hpp:36
        I(cpphdl_n1896, Vdd) <+ cpphdl_channel(V(cpphdl_n1900, Vdd), V(cpphdl_n1896, Vdd), 0.002, 0.69999999999999996, -1.0);
        // device 1240, IC IC215, analog/basic/strongarm_comparator.hpp:38
        I(cpphdl_n1881, Vdd) <+ cpphdl_channel(V(EVALUATE, Vdd), V(cpphdl_n1881, Vdd), 0.002, 0.69999999999999996, -1.0);
        // device 1241, IC IC215, analog/basic/strongarm_comparator.hpp:39
        I(cpphdl_n1882, Vdd) <+ cpphdl_channel(V(EVALUATE, Vdd), V(cpphdl_n1882, Vdd), 0.002, 0.69999999999999996, -1.0);
        // device 1242, IC IC215, analog/basic/strongarm_comparator.hpp:40
        I(cpphdl_n1900, Vdd) <+ cpphdl_channel(V(EVALUATE, Vdd), V(cpphdl_n1900, Vdd), 0.002, 0.69999999999999996, -1.0);
        // device 1243, IC IC215, analog/basic/strongarm_comparator.hpp:41
        I(cpphdl_n1896, Vdd) <+ cpphdl_channel(V(EVALUATE, Vdd), V(cpphdl_n1896, Vdd), 0.002, 0.69999999999999996, -1.0);
        // device 1244, IC IC215, analog/basic/strongarm_comparator.hpp:42
        I(cpphdl_n1881, Vss) <+ 2.9999999999999998e-14 * ddt(V(cpphdl_n1881, Vss)); // Bench initial voltage = 0.0 V.
        // device 1245, IC IC215, analog/basic/strongarm_comparator.hpp:43
        I(cpphdl_n1882, Vss) <+ 2.9999999999999998e-14 * ddt(V(cpphdl_n1882, Vss)); // Bench initial voltage = 0.0 V.
        // device 1246, IC IC215, analog/basic/strongarm_comparator.hpp:44
        I(cpphdl_n1883, Vss) <+ 2.9999999999999998e-14 * ddt(V(cpphdl_n1883, Vss)); // Bench initial voltage = 0.0 V.
        // device 1247, IC IC215, analog/basic/strongarm_comparator.hpp:45
        I(cpphdl_n1900, Vss) <+ 5.0000000000000002e-14 * ddt(V(cpphdl_n1900, Vss)); // Bench initial voltage = 0.0 V.
        // device 1248, IC IC215, analog/basic/strongarm_comparator.hpp:46
        I(cpphdl_n1896, Vss) <+ 5.0000000000000002e-14 * ddt(V(cpphdl_n1896, Vss)); // Bench initial voltage = 0.0 V.
        // device 1249, IC IC215, analog/basic/strongarm_comparator.hpp:47
        I(cpphdl_n1876, cpphdl_n1883) <+ 2e-14 * ddt(V(cpphdl_n1876, cpphdl_n1883)); // Bench initial voltage = 0.0 V.
        // device 1250, IC IC215, analog/basic/strongarm_comparator.hpp:48
        I(cpphdl_n1877, cpphdl_n1883) <+ 2e-14 * ddt(V(cpphdl_n1877, cpphdl_n1883)); // Bench initial voltage = 0.0 V.
        // device 1251, IC IC215, analog/basic/strongarm_comparator.hpp:49
        I(cpphdl_n1876, cpphdl_n1881) <+ 2.9999999999999998e-15 * ddt(V(cpphdl_n1876, cpphdl_n1881)); // Bench initial voltage = 0.0 V.
        // device 1252, IC IC215, analog/basic/strongarm_comparator.hpp:50
        I(cpphdl_n1877, cpphdl_n1882) <+ 2.9999999999999998e-15 * ddt(V(cpphdl_n1877, cpphdl_n1882)); // Bench initial voltage = 0.0 V.
        // device 1253, IC IC217, analog/basic/inverter.hpp:11
        I(cpphdl_n1904, Vdd) <+ cpphdl_channel(V(cpphdl_n1896, Vdd), V(cpphdl_n1904, Vdd), 0.001, 0.69999999999999996, -1.0);
        // device 1254, IC IC217, analog/basic/inverter.hpp:12
        I(cpphdl_n1904, Vss) <+ cpphdl_channel(V(cpphdl_n1896, Vss), V(cpphdl_n1904, Vss), 0.001, 0.69999999999999996, 1.0);
        // device 1255, IC IC219, analog/basic/inverter.hpp:11
        I(cpphdl_n1918, Vdd) <+ cpphdl_channel(V(cpphdl_n1904, Vdd), V(cpphdl_n1918, Vdd), 0.0040000000000000001, 0.69999999999999996, -1.0);
        // device 1256, IC IC219, analog/basic/inverter.hpp:12
        I(cpphdl_n1918, Vss) <+ cpphdl_channel(V(cpphdl_n1904, Vss), V(cpphdl_n1918, Vss), 0.0040000000000000001, 0.69999999999999996, 1.0);
        // device 1257, IC IC216, analog/basic/buffered_nand_latch.hpp:34
        I(cpphdl_n1896, Vss) <+ 2.0000000000000002e-15 * ddt(V(cpphdl_n1896, Vss)); // Bench initial voltage = 0.0 V.
        // device 1258, IC IC216, analog/basic/buffered_nand_latch.hpp:35
        I(cpphdl_n1896, cpphdl_n1904) <+ 1.0000000000000001e-15 * ddt(V(cpphdl_n1896, cpphdl_n1904)); // Bench initial voltage = 0.0 V.
        // device 1259, IC IC216, analog/basic/buffered_nand_latch.hpp:36
        I(cpphdl_n1904, Vss) <+ 5e-15 * ddt(V(cpphdl_n1904, Vss)); // Bench initial voltage = 0.0 V.
        // device 1260, IC IC216, analog/basic/buffered_nand_latch.hpp:37
        I(cpphdl_n1904, Vss) <+ 8.0000000000000006e-15 * ddt(V(cpphdl_n1904, Vss)); // Bench initial voltage = 0.0 V.
        // device 1261, IC IC216, analog/basic/buffered_nand_latch.hpp:38
        I(cpphdl_n1918, Vss) <+ 1e-14 * ddt(V(cpphdl_n1918, Vss)); // Bench initial voltage = 0.0 V.
        // device 1262, IC IC218, analog/basic/inverter.hpp:11
        I(cpphdl_n1908, Vdd) <+ cpphdl_channel(V(cpphdl_n1900, Vdd), V(cpphdl_n1908, Vdd), 0.001, 0.69999999999999996, -1.0);
        // device 1263, IC IC218, analog/basic/inverter.hpp:12
        I(cpphdl_n1908, Vss) <+ cpphdl_channel(V(cpphdl_n1900, Vss), V(cpphdl_n1908, Vss), 0.001, 0.69999999999999996, 1.0);
        // device 1264, IC IC220, analog/basic/inverter.hpp:11
        I(cpphdl_n1924, Vdd) <+ cpphdl_channel(V(cpphdl_n1908, Vdd), V(cpphdl_n1924, Vdd), 0.0040000000000000001, 0.69999999999999996, -1.0);
        // device 1265, IC IC220, analog/basic/inverter.hpp:12
        I(cpphdl_n1924, Vss) <+ cpphdl_channel(V(cpphdl_n1908, Vss), V(cpphdl_n1924, Vss), 0.0040000000000000001, 0.69999999999999996, 1.0);
        // device 1266, IC IC216, analog/basic/buffered_nand_latch.hpp:34
        I(cpphdl_n1900, Vss) <+ 2.0000000000000002e-15 * ddt(V(cpphdl_n1900, Vss)); // Bench initial voltage = 0.0 V.
        // device 1267, IC IC216, analog/basic/buffered_nand_latch.hpp:35
        I(cpphdl_n1900, cpphdl_n1908) <+ 1.0000000000000001e-15 * ddt(V(cpphdl_n1900, cpphdl_n1908)); // Bench initial voltage = 0.0 V.
        // device 1268, IC IC216, analog/basic/buffered_nand_latch.hpp:36
        I(cpphdl_n1908, Vss) <+ 5e-15 * ddt(V(cpphdl_n1908, Vss)); // Bench initial voltage = 0.0 V.
        // device 1269, IC IC216, analog/basic/buffered_nand_latch.hpp:37
        I(cpphdl_n1908, Vss) <+ 8.0000000000000006e-15 * ddt(V(cpphdl_n1908, Vss)); // Bench initial voltage = 0.0 V.
        // device 1270, IC IC216, analog/basic/buffered_nand_latch.hpp:38
        I(cpphdl_n1924, Vss) <+ 1e-14 * ddt(V(cpphdl_n1924, Vss)); // Bench initial voltage = 0.0 V.
        // device 1271, IC IC222, analog/basic/cmos_logic.hpp:17
        I(cpphdl_n2993, Vss) <+ 5.0000000000000002e-14 * ddt(V(cpphdl_n2993, Vss)); // Bench initial voltage = 0.0 V.
        // device 1272, IC IC222, analog/basic/cmos_logic.hpp:18
        I(cpphdl_n2993, Vdd) <+ cpphdl_channel(V(cpphdl_n1918, Vdd), V(cpphdl_n2993, Vdd), 0.01, 0.69999999999999996, -1.0);
        // device 1273, IC IC222, analog/basic/cmos_logic.hpp:19
        I(cpphdl_n2993, Vdd) <+ cpphdl_channel(V(cpphdl_n1926, Vdd), V(cpphdl_n2993, Vdd), 0.01, 0.69999999999999996, -1.0);
        // device 1274, IC IC222, analog/basic/cmos_logic.hpp:20
        I(cpphdl_n2993, cpphdl_n1921) <+ cpphdl_channel(V(cpphdl_n1918, cpphdl_n1921), V(cpphdl_n2993, cpphdl_n1921), 0.01, 0.69999999999999996, 1.0);
        // device 1275, IC IC222, analog/basic/cmos_logic.hpp:21
        I(cpphdl_n1921, Vss) <+ cpphdl_channel(V(cpphdl_n1926, Vss), V(cpphdl_n1921, Vss), 0.01, 0.69999999999999996, 1.0);
        // device 1276, IC IC222, analog/basic/cmos_logic.hpp:27
        I(cpphdl_n1921, Vss) <+ 1e-14 * ddt(V(cpphdl_n1921, Vss)); // Bench initial voltage = 0.0 V.
        // device 1277, IC IC223, analog/basic/cmos_logic.hpp:17
        I(cpphdl_n1926, Vss) <+ 5.0000000000000002e-14 * ddt(V(cpphdl_n1926, Vss)); // Bench initial voltage = 0.0 V.
        // device 1278, IC IC223, analog/basic/cmos_logic.hpp:18
        I(cpphdl_n1926, Vdd) <+ cpphdl_channel(V(cpphdl_n1924, Vdd), V(cpphdl_n1926, Vdd), 0.01, 0.69999999999999996, -1.0);
        // device 1279, IC IC223, analog/basic/cmos_logic.hpp:19
        I(cpphdl_n1926, Vdd) <+ cpphdl_channel(V(cpphdl_n2993, Vdd), V(cpphdl_n1926, Vdd), 0.01, 0.69999999999999996, -1.0);
        // device 1280, IC IC223, analog/basic/cmos_logic.hpp:20
        I(cpphdl_n1926, cpphdl_n1927) <+ cpphdl_channel(V(cpphdl_n1924, cpphdl_n1927), V(cpphdl_n1926, cpphdl_n1927), 0.01, 0.69999999999999996, 1.0);
        // device 1281, IC IC223, analog/basic/cmos_logic.hpp:21
        I(cpphdl_n1927, Vss) <+ cpphdl_channel(V(cpphdl_n2993, Vss), V(cpphdl_n1927, Vss), 0.01, 0.69999999999999996, 1.0);
        // device 1282, IC IC223, analog/basic/cmos_logic.hpp:27
        I(cpphdl_n1927, Vss) <+ 1e-14 * ddt(V(cpphdl_n1927, Vss)); // Bench initial voltage = 0.0 V.
        // device 1283, IC IC221, analog/basic/nand_latch.hpp:36
        I(cpphdl_n1918, Vss) <+ 2.9999999999999998e-15 * ddt(V(cpphdl_n1918, Vss)); // Bench initial voltage = 0.0 V.
        // device 1284, IC IC221, analog/basic/nand_latch.hpp:37
        I(cpphdl_n1924, Vss) <+ 2.9999999999999998e-15 * ddt(V(cpphdl_n1924, Vss)); // Bench initial voltage = 0.0 V.
        // device 1285, IC IC224, analog/basic/inverter.hpp:11
        I(cpphdl_n1932, Vdd) <+ cpphdl_channel(V(CLEAR, Vdd), V(cpphdl_n1932, Vdd), 0.01, 0.69999999999999996, -1.0);
        // device 1286, IC IC224, analog/basic/inverter.hpp:12
        I(cpphdl_n1932, Vss) <+ cpphdl_channel(V(CLEAR, Vss), V(cpphdl_n1932, Vss), 0.01, 0.69999999999999996, 1.0);
        // device 1287, IC IC221, analog/basic/nand_latch.hpp:58
        I(cpphdl_n1932, Vss) <+ 2.9999999999999998e-15 * ddt(V(cpphdl_n1932, Vss)); // Bench initial voltage = 0.0 V.
        // device 1288, IC IC221, analog/basic/nand_latch.hpp:59
        I(cpphdl_n2993, Vss) <+ cpphdl_channel(V(CLEAR, Vss), V(cpphdl_n2993, Vss), 0.050000000000000003, 0.69999999999999996, 1.0);
        // device 1289, IC IC221, analog/basic/nand_latch.hpp:60
        I(cpphdl_n1926, Vdd) <+ cpphdl_channel(V(cpphdl_n1932, Vdd), V(cpphdl_n1926, Vdd), 0.050000000000000003, 0.69999999999999996, -1.0);
        // device 1290, IC IC227, analog/basic/inverter.hpp:11
        I(cpphdl_n1956, Vdd) <+ cpphdl_channel(V(TRACK9, Vdd), V(cpphdl_n1956, Vdd), 0.0040000000000000001, 0.69999999999999996, -1.0);
        // device 1291, IC IC227, analog/basic/inverter.hpp:12
        I(cpphdl_n1956, Vss) <+ cpphdl_channel(V(TRACK9, Vss), V(cpphdl_n1956, Vss), 0.0040000000000000001, 0.69999999999999996, 1.0);
        // device 1292, IC IC226, analog/basic/mos_track_hold.hpp:31
        I(cpphdl_n1956, Vss) <+ 2e-14 * ddt(V(cpphdl_n1956, Vss)); // Bench initial voltage = 0.0 V.
        // device 1293, IC IC226, analog/basic/mos_track_hold.hpp:32
        I(cpphdl_n2808, cpphdl_n2010) <+ cpphdl_channel(V(TRACK9, cpphdl_n2010), V(cpphdl_n2808, cpphdl_n2010), 0.029999999999999999, 0.69999999999999996, 1.0);
        // device 1294, IC IC226, analog/basic/mos_track_hold.hpp:33
        I(cpphdl_n2010, cpphdl_n2808) <+ cpphdl_channel(V(cpphdl_n1956, cpphdl_n2808), V(cpphdl_n2010, cpphdl_n2808), 0.014999999999999999, 0.69999999999999996, -1.0);
        // device 1295, IC IC226, analog/basic/mos_track_hold.hpp:37
        I(cpphdl_n2010, cpphdl_n2010) <+ cpphdl_channel(V(cpphdl_n1956, cpphdl_n2010), V(cpphdl_n2010, cpphdl_n2010), 0.016, 0.69999999999999996, 1.0);
        // device 1296, IC IC226, analog/basic/mos_track_hold.hpp:38
        I(cpphdl_n2010, cpphdl_n2010) <+ cpphdl_channel(V(TRACK9, cpphdl_n2010), V(cpphdl_n2010, cpphdl_n2010), 0.0083999999999999995, 0.69999999999999996, -1.0);
        // device 1297, IC IC226, analog/basic/mos_track_hold.hpp:39
        I(cpphdl_n2010, Vss) <+ 1.5000000000000001e-12 * ddt(V(cpphdl_n2010, Vss)); // Bench initial voltage = 0.0 V.
        // device 1298, IC IC226, analog/basic/mos_track_hold.hpp:42
        I(TRACK9, cpphdl_n2010) <+ 2.0000000000000002e-15 * ddt(V(TRACK9, cpphdl_n2010)); // Bench initial voltage = -0.0 V.
        // device 1299, IC IC226, analog/basic/mos_track_hold.hpp:43
        I(cpphdl_n1956, cpphdl_n2010) <+ 2.0000000000000002e-15 * ddt(V(cpphdl_n1956, cpphdl_n2010)); // Bench initial voltage = 0.0 V.
        // device 1300, IC IC226, analog/basic/mos_track_hold.hpp:44
        I(cpphdl_n2808, cpphdl_n2010) <+ 1.0000000000000001e-15 * ddt(V(cpphdl_n2808, cpphdl_n2010)); // Bench initial voltage = 0.0 V.
        // device 1301, IC IC229, analog/basic/inverter.hpp:11
        I(cpphdl_n1971, Vdd) <+ cpphdl_channel(V(BIT_N9_0, Vdd), V(cpphdl_n1971, Vdd), 0.080000000000000002, 0.69999999999999996, -1.0);
        // device 1302, IC IC229, analog/basic/inverter.hpp:12
        I(cpphdl_n1971, Vss) <+ cpphdl_channel(V(BIT_N9_0, Vss), V(cpphdl_n1971, Vss), 0.080000000000000002, 0.69999999999999996, 1.0);
        // device 1303, IC IC228, analog/basic/mos_r2r_dac.hpp:27
        I(cpphdl_n1971, Vss) <+ 2.9999999999999998e-15 * ddt(V(cpphdl_n1971, Vss)); // Bench initial voltage = 0.0 V.
        // device 1304, IC IC228, analog/basic/mos_r2r_dac.hpp:28
        I(cpphdl_n1971, cpphdl_n2000) <+ V(cpphdl_n1971, cpphdl_n2000) / 2000.0;
        // device 1305, IC IC228, analog/basic/mos_r2r_dac.hpp:29
        I(cpphdl_n2000, Vss) <+ 2.9999999999999998e-15 * ddt(V(cpphdl_n2000, Vss)); // Bench initial voltage = 0.0 V.
        // device 1306, IC IC230, analog/basic/inverter.hpp:11
        I(cpphdl_n1975, Vdd) <+ cpphdl_channel(V(BIT_N9_1, Vdd), V(cpphdl_n1975, Vdd), 0.080000000000000002, 0.69999999999999996, -1.0);
        // device 1307, IC IC230, analog/basic/inverter.hpp:12
        I(cpphdl_n1975, Vss) <+ cpphdl_channel(V(BIT_N9_1, Vss), V(cpphdl_n1975, Vss), 0.080000000000000002, 0.69999999999999996, 1.0);
        // device 1308, IC IC228, analog/basic/mos_r2r_dac.hpp:27
        I(cpphdl_n1975, Vss) <+ 2.9999999999999998e-15 * ddt(V(cpphdl_n1975, Vss)); // Bench initial voltage = 0.0 V.
        // device 1309, IC IC228, analog/basic/mos_r2r_dac.hpp:28
        I(cpphdl_n1975, cpphdl_n2001) <+ V(cpphdl_n1975, cpphdl_n2001) / 2000.0;
        // device 1310, IC IC228, analog/basic/mos_r2r_dac.hpp:29
        I(cpphdl_n2001, Vss) <+ 2.9999999999999998e-15 * ddt(V(cpphdl_n2001, Vss)); // Bench initial voltage = 0.0 V.
        // device 1311, IC IC228, analog/basic/mos_r2r_dac.hpp:31
        I(cpphdl_n2000, cpphdl_n2001) <+ V(cpphdl_n2000, cpphdl_n2001) / 1000.0;
        // device 1312, IC IC231, analog/basic/inverter.hpp:11
        I(cpphdl_n1979, Vdd) <+ cpphdl_channel(V(BIT_N9_2, Vdd), V(cpphdl_n1979, Vdd), 0.080000000000000002, 0.69999999999999996, -1.0);
        // device 1313, IC IC231, analog/basic/inverter.hpp:12
        I(cpphdl_n1979, Vss) <+ cpphdl_channel(V(BIT_N9_2, Vss), V(cpphdl_n1979, Vss), 0.080000000000000002, 0.69999999999999996, 1.0);
        // device 1314, IC IC228, analog/basic/mos_r2r_dac.hpp:27
        I(cpphdl_n1979, Vss) <+ 2.9999999999999998e-15 * ddt(V(cpphdl_n1979, Vss)); // Bench initial voltage = 0.0 V.
        // device 1315, IC IC228, analog/basic/mos_r2r_dac.hpp:28
        I(cpphdl_n1979, cpphdl_n2002) <+ V(cpphdl_n1979, cpphdl_n2002) / 2000.0;
        // device 1316, IC IC228, analog/basic/mos_r2r_dac.hpp:29
        I(cpphdl_n2002, Vss) <+ 2.9999999999999998e-15 * ddt(V(cpphdl_n2002, Vss)); // Bench initial voltage = 0.0 V.
        // device 1317, IC IC228, analog/basic/mos_r2r_dac.hpp:31
        I(cpphdl_n2001, cpphdl_n2002) <+ V(cpphdl_n2001, cpphdl_n2002) / 1000.0;
        // device 1318, IC IC232, analog/basic/inverter.hpp:11
        I(cpphdl_n1983, Vdd) <+ cpphdl_channel(V(BIT_N9_3, Vdd), V(cpphdl_n1983, Vdd), 0.080000000000000002, 0.69999999999999996, -1.0);
        // device 1319, IC IC232, analog/basic/inverter.hpp:12
        I(cpphdl_n1983, Vss) <+ cpphdl_channel(V(BIT_N9_3, Vss), V(cpphdl_n1983, Vss), 0.080000000000000002, 0.69999999999999996, 1.0);
        // device 1320, IC IC228, analog/basic/mos_r2r_dac.hpp:27
        I(cpphdl_n1983, Vss) <+ 2.9999999999999998e-15 * ddt(V(cpphdl_n1983, Vss)); // Bench initial voltage = 0.0 V.
        // device 1321, IC IC228, analog/basic/mos_r2r_dac.hpp:28
        I(cpphdl_n1983, cpphdl_n2003) <+ V(cpphdl_n1983, cpphdl_n2003) / 2000.0;
        // device 1322, IC IC228, analog/basic/mos_r2r_dac.hpp:29
        I(cpphdl_n2003, Vss) <+ 2.9999999999999998e-15 * ddt(V(cpphdl_n2003, Vss)); // Bench initial voltage = 0.0 V.
        // device 1323, IC IC228, analog/basic/mos_r2r_dac.hpp:31
        I(cpphdl_n2002, cpphdl_n2003) <+ V(cpphdl_n2002, cpphdl_n2003) / 1000.0;
        // device 1324, IC IC233, analog/basic/inverter.hpp:11
        I(cpphdl_n1987, Vdd) <+ cpphdl_channel(V(BIT_N9_4, Vdd), V(cpphdl_n1987, Vdd), 0.080000000000000002, 0.69999999999999996, -1.0);
        // device 1325, IC IC233, analog/basic/inverter.hpp:12
        I(cpphdl_n1987, Vss) <+ cpphdl_channel(V(BIT_N9_4, Vss), V(cpphdl_n1987, Vss), 0.080000000000000002, 0.69999999999999996, 1.0);
        // device 1326, IC IC228, analog/basic/mos_r2r_dac.hpp:27
        I(cpphdl_n1987, Vss) <+ 2.9999999999999998e-15 * ddt(V(cpphdl_n1987, Vss)); // Bench initial voltage = 0.0 V.
        // device 1327, IC IC228, analog/basic/mos_r2r_dac.hpp:28
        I(cpphdl_n1987, cpphdl_n2004) <+ V(cpphdl_n1987, cpphdl_n2004) / 2000.0;
        // device 1328, IC IC228, analog/basic/mos_r2r_dac.hpp:29
        I(cpphdl_n2004, Vss) <+ 2.9999999999999998e-15 * ddt(V(cpphdl_n2004, Vss)); // Bench initial voltage = 0.0 V.
        // device 1329, IC IC228, analog/basic/mos_r2r_dac.hpp:31
        I(cpphdl_n2003, cpphdl_n2004) <+ V(cpphdl_n2003, cpphdl_n2004) / 1000.0;
        // device 1330, IC IC234, analog/basic/inverter.hpp:11
        I(cpphdl_n1991, Vdd) <+ cpphdl_channel(V(BIT_N9_5, Vdd), V(cpphdl_n1991, Vdd), 0.080000000000000002, 0.69999999999999996, -1.0);
        // device 1331, IC IC234, analog/basic/inverter.hpp:12
        I(cpphdl_n1991, Vss) <+ cpphdl_channel(V(BIT_N9_5, Vss), V(cpphdl_n1991, Vss), 0.080000000000000002, 0.69999999999999996, 1.0);
        // device 1332, IC IC228, analog/basic/mos_r2r_dac.hpp:27
        I(cpphdl_n1991, Vss) <+ 2.9999999999999998e-15 * ddt(V(cpphdl_n1991, Vss)); // Bench initial voltage = 0.0 V.
        // device 1333, IC IC228, analog/basic/mos_r2r_dac.hpp:28
        I(cpphdl_n1991, cpphdl_n2005) <+ V(cpphdl_n1991, cpphdl_n2005) / 2000.0;
        // device 1334, IC IC228, analog/basic/mos_r2r_dac.hpp:29
        I(cpphdl_n2005, Vss) <+ 2.9999999999999998e-15 * ddt(V(cpphdl_n2005, Vss)); // Bench initial voltage = 0.0 V.
        // device 1335, IC IC228, analog/basic/mos_r2r_dac.hpp:31
        I(cpphdl_n2004, cpphdl_n2005) <+ V(cpphdl_n2004, cpphdl_n2005) / 1000.0;
        // device 1336, IC IC235, analog/basic/inverter.hpp:11
        I(cpphdl_n1995, Vdd) <+ cpphdl_channel(V(BIT_N9_6, Vdd), V(cpphdl_n1995, Vdd), 0.080000000000000002, 0.69999999999999996, -1.0);
        // device 1337, IC IC235, analog/basic/inverter.hpp:12
        I(cpphdl_n1995, Vss) <+ cpphdl_channel(V(BIT_N9_6, Vss), V(cpphdl_n1995, Vss), 0.080000000000000002, 0.69999999999999996, 1.0);
        // device 1338, IC IC228, analog/basic/mos_r2r_dac.hpp:27
        I(cpphdl_n1995, Vss) <+ 2.9999999999999998e-15 * ddt(V(cpphdl_n1995, Vss)); // Bench initial voltage = 0.0 V.
        // device 1339, IC IC228, analog/basic/mos_r2r_dac.hpp:28
        I(cpphdl_n1995, cpphdl_n2006) <+ V(cpphdl_n1995, cpphdl_n2006) / 2000.0;
        // device 1340, IC IC228, analog/basic/mos_r2r_dac.hpp:29
        I(cpphdl_n2006, Vss) <+ 2.9999999999999998e-15 * ddt(V(cpphdl_n2006, Vss)); // Bench initial voltage = 0.0 V.
        // device 1341, IC IC228, analog/basic/mos_r2r_dac.hpp:31
        I(cpphdl_n2005, cpphdl_n2006) <+ V(cpphdl_n2005, cpphdl_n2006) / 1000.0;
        // device 1342, IC IC236, analog/basic/inverter.hpp:11
        I(cpphdl_n1999, Vdd) <+ cpphdl_channel(V(BIT_N9_7, Vdd), V(cpphdl_n1999, Vdd), 0.080000000000000002, 0.69999999999999996, -1.0);
        // device 1343, IC IC236, analog/basic/inverter.hpp:12
        I(cpphdl_n1999, Vss) <+ cpphdl_channel(V(BIT_N9_7, Vss), V(cpphdl_n1999, Vss), 0.080000000000000002, 0.69999999999999996, 1.0);
        // device 1344, IC IC228, analog/basic/mos_r2r_dac.hpp:27
        I(cpphdl_n1999, Vss) <+ 2.9999999999999998e-15 * ddt(V(cpphdl_n1999, Vss)); // Bench initial voltage = 0.0 V.
        // device 1345, IC IC228, analog/basic/mos_r2r_dac.hpp:28
        I(cpphdl_n1999, cpphdl_n2011) <+ V(cpphdl_n1999, cpphdl_n2011) / 2000.0;
        // device 1346, IC IC228, analog/basic/mos_r2r_dac.hpp:29
        I(cpphdl_n2011, Vss) <+ 2.9999999999999998e-15 * ddt(V(cpphdl_n2011, Vss)); // Bench initial voltage = 0.0 V.
        // device 1347, IC IC228, analog/basic/mos_r2r_dac.hpp:31
        I(cpphdl_n2006, cpphdl_n2011) <+ V(cpphdl_n2006, cpphdl_n2011) / 1000.0;
        // device 1348, IC IC228, analog/basic/mos_r2r_dac.hpp:33
        I(Vss, cpphdl_n2000) <+ V(Vss, cpphdl_n2000) / 2000.0;
        // device 1349, IC IC237, analog/basic/nmos_resistor_amplifier.hpp:23
        I(Vdd, cpphdl_n2020) <+ V(Vdd, cpphdl_n2020) / 1000.0;
        // device 1350, IC IC237, analog/basic/nmos_resistor_amplifier.hpp:24
        I(Vdd, cpphdl_n2019) <+ V(Vdd, cpphdl_n2019) / 1000.0;
        // device 1351, IC IC237, analog/basic/nmos_resistor_amplifier.hpp:25
        I(cpphdl_n2020, cpphdl_n2014) <+ cpphdl_channel(V(cpphdl_n2010, cpphdl_n2014), V(cpphdl_n2020, cpphdl_n2014), 0.0074999999999999997, 0.69999999999999996, 1.0);
        // device 1352, IC IC237, analog/basic/nmos_resistor_amplifier.hpp:26
        I(cpphdl_n2019, cpphdl_n2015) <+ cpphdl_channel(V(cpphdl_n2011, cpphdl_n2015), V(cpphdl_n2019, cpphdl_n2015), 0.0074999999999999997, 0.69999999999999996, 1.0);
        // device 1353, IC IC237, analog/basic/nmos_resistor_amplifier.hpp:27
        I(cpphdl_n2016, cpphdl_n2014) <+ V(cpphdl_n2016, cpphdl_n2014) / 100.0;
        // device 1354, IC IC237, analog/basic/nmos_resistor_amplifier.hpp:28
        I(cpphdl_n2016, cpphdl_n2015) <+ V(cpphdl_n2016, cpphdl_n2015) / 100.0;
        // device 1355, IC IC237, analog/basic/nmos_resistor_amplifier.hpp:29
        I(Vss, cpphdl_n2016) <+ V(Vss, cpphdl_n2016) / 300.0;
        // device 1356, IC IC237, analog/basic/nmos_resistor_amplifier.hpp:30
        I(cpphdl_n2020, Vdd) <+ 2.9999999999999998e-13 * ddt(V(cpphdl_n2020, Vdd)); // Bench initial voltage = 0.0 V.
        // device 1357, IC IC237, analog/basic/nmos_resistor_amplifier.hpp:31
        I(cpphdl_n2019, Vdd) <+ 2.9999999999999998e-13 * ddt(V(cpphdl_n2019, Vdd)); // Bench initial voltage = 0.0 V.
        // device 1358, IC IC237, analog/basic/nmos_resistor_amplifier.hpp:32
        I(cpphdl_n2016, Vss) <+ 4e-14 * ddt(V(cpphdl_n2016, Vss)); // Bench initial voltage = 0.0 V.
        // device 1359, IC IC237, analog/basic/nmos_resistor_amplifier.hpp:34
        I(cpphdl_n2010, cpphdl_n2014) <+ 2e-14 * ddt(V(cpphdl_n2010, cpphdl_n2014)); // Bench initial voltage = 0.0 V.
        // device 1360, IC IC237, analog/basic/nmos_resistor_amplifier.hpp:35
        I(cpphdl_n2011, cpphdl_n2015) <+ 2e-14 * ddt(V(cpphdl_n2011, cpphdl_n2015)); // Bench initial voltage = 0.0 V.
        // device 1361, IC IC237, analog/basic/nmos_resistor_amplifier.hpp:36
        I(cpphdl_n2010, cpphdl_n2020) <+ 2.9999999999999998e-15 * ddt(V(cpphdl_n2010, cpphdl_n2020)); // Bench initial voltage = 0.0 V.
        // device 1362, IC IC237, analog/basic/nmos_resistor_amplifier.hpp:37
        I(cpphdl_n2011, cpphdl_n2019) <+ 2.9999999999999998e-15 * ddt(V(cpphdl_n2011, cpphdl_n2019)); // Bench initial voltage = 0.0 V.
        // device 1363, IC IC238, analog/basic/strongarm_comparator.hpp:28
        I(cpphdl_n2024, cpphdl_n2026) <+ cpphdl_channel(V(cpphdl_n2019, cpphdl_n2026), V(cpphdl_n2024, cpphdl_n2026), 0.0080000000000000002, 0.69999999999999996, 1.0);
        // device 1364, IC IC238, analog/basic/strongarm_comparator.hpp:29
        I(cpphdl_n2025, cpphdl_n2026) <+ cpphdl_channel(V(cpphdl_n2020, cpphdl_n2026), V(cpphdl_n2025, cpphdl_n2026), 0.0080000000000000002, 0.69999999999999996, 1.0);
        // device 1365, IC IC238, analog/basic/strongarm_comparator.hpp:30
        I(cpphdl_n2026, Vss) <+ cpphdl_channel(V(EVALUATE, Vss), V(cpphdl_n2026, Vss), 0.0080000000000000002, 0.69999999999999996, 1.0);
        // device 1366, IC IC238, analog/basic/strongarm_comparator.hpp:33
        I(cpphdl_n2039, cpphdl_n2024) <+ cpphdl_channel(V(cpphdl_n2043, cpphdl_n2024), V(cpphdl_n2039, cpphdl_n2024), 0.0040000000000000001, 0.69999999999999996, 1.0);
        // device 1367, IC IC238, analog/basic/strongarm_comparator.hpp:34
        I(cpphdl_n2043, cpphdl_n2025) <+ cpphdl_channel(V(cpphdl_n2039, cpphdl_n2025), V(cpphdl_n2043, cpphdl_n2025), 0.0040000000000000001, 0.69999999999999996, 1.0);
        // device 1368, IC IC238, analog/basic/strongarm_comparator.hpp:35
        I(cpphdl_n2043, Vdd) <+ cpphdl_channel(V(cpphdl_n2039, Vdd), V(cpphdl_n2043, Vdd), 0.002, 0.69999999999999996, -1.0);
        // device 1369, IC IC238, analog/basic/strongarm_comparator.hpp:36
        I(cpphdl_n2039, Vdd) <+ cpphdl_channel(V(cpphdl_n2043, Vdd), V(cpphdl_n2039, Vdd), 0.002, 0.69999999999999996, -1.0);
        // device 1370, IC IC238, analog/basic/strongarm_comparator.hpp:38
        I(cpphdl_n2024, Vdd) <+ cpphdl_channel(V(EVALUATE, Vdd), V(cpphdl_n2024, Vdd), 0.002, 0.69999999999999996, -1.0);
        // device 1371, IC IC238, analog/basic/strongarm_comparator.hpp:39
        I(cpphdl_n2025, Vdd) <+ cpphdl_channel(V(EVALUATE, Vdd), V(cpphdl_n2025, Vdd), 0.002, 0.69999999999999996, -1.0);
        // device 1372, IC IC238, analog/basic/strongarm_comparator.hpp:40
        I(cpphdl_n2043, Vdd) <+ cpphdl_channel(V(EVALUATE, Vdd), V(cpphdl_n2043, Vdd), 0.002, 0.69999999999999996, -1.0);
        // device 1373, IC IC238, analog/basic/strongarm_comparator.hpp:41
        I(cpphdl_n2039, Vdd) <+ cpphdl_channel(V(EVALUATE, Vdd), V(cpphdl_n2039, Vdd), 0.002, 0.69999999999999996, -1.0);
        // device 1374, IC IC238, analog/basic/strongarm_comparator.hpp:42
        I(cpphdl_n2024, Vss) <+ 2.9999999999999998e-14 * ddt(V(cpphdl_n2024, Vss)); // Bench initial voltage = 0.0 V.
        // device 1375, IC IC238, analog/basic/strongarm_comparator.hpp:43
        I(cpphdl_n2025, Vss) <+ 2.9999999999999998e-14 * ddt(V(cpphdl_n2025, Vss)); // Bench initial voltage = 0.0 V.
        // device 1376, IC IC238, analog/basic/strongarm_comparator.hpp:44
        I(cpphdl_n2026, Vss) <+ 2.9999999999999998e-14 * ddt(V(cpphdl_n2026, Vss)); // Bench initial voltage = 0.0 V.
        // device 1377, IC IC238, analog/basic/strongarm_comparator.hpp:45
        I(cpphdl_n2043, Vss) <+ 5.0000000000000002e-14 * ddt(V(cpphdl_n2043, Vss)); // Bench initial voltage = 0.0 V.
        // device 1378, IC IC238, analog/basic/strongarm_comparator.hpp:46
        I(cpphdl_n2039, Vss) <+ 5.0000000000000002e-14 * ddt(V(cpphdl_n2039, Vss)); // Bench initial voltage = 0.0 V.
        // device 1379, IC IC238, analog/basic/strongarm_comparator.hpp:47
        I(cpphdl_n2019, cpphdl_n2026) <+ 2e-14 * ddt(V(cpphdl_n2019, cpphdl_n2026)); // Bench initial voltage = 0.0 V.
        // device 1380, IC IC238, analog/basic/strongarm_comparator.hpp:48
        I(cpphdl_n2020, cpphdl_n2026) <+ 2e-14 * ddt(V(cpphdl_n2020, cpphdl_n2026)); // Bench initial voltage = 0.0 V.
        // device 1381, IC IC238, analog/basic/strongarm_comparator.hpp:49
        I(cpphdl_n2019, cpphdl_n2024) <+ 2.9999999999999998e-15 * ddt(V(cpphdl_n2019, cpphdl_n2024)); // Bench initial voltage = 0.0 V.
        // device 1382, IC IC238, analog/basic/strongarm_comparator.hpp:50
        I(cpphdl_n2020, cpphdl_n2025) <+ 2.9999999999999998e-15 * ddt(V(cpphdl_n2020, cpphdl_n2025)); // Bench initial voltage = 0.0 V.
        // device 1383, IC IC240, analog/basic/inverter.hpp:11
        I(cpphdl_n2047, Vdd) <+ cpphdl_channel(V(cpphdl_n2039, Vdd), V(cpphdl_n2047, Vdd), 0.001, 0.69999999999999996, -1.0);
        // device 1384, IC IC240, analog/basic/inverter.hpp:12
        I(cpphdl_n2047, Vss) <+ cpphdl_channel(V(cpphdl_n2039, Vss), V(cpphdl_n2047, Vss), 0.001, 0.69999999999999996, 1.0);
        // device 1385, IC IC242, analog/basic/inverter.hpp:11
        I(cpphdl_n2061, Vdd) <+ cpphdl_channel(V(cpphdl_n2047, Vdd), V(cpphdl_n2061, Vdd), 0.0040000000000000001, 0.69999999999999996, -1.0);
        // device 1386, IC IC242, analog/basic/inverter.hpp:12
        I(cpphdl_n2061, Vss) <+ cpphdl_channel(V(cpphdl_n2047, Vss), V(cpphdl_n2061, Vss), 0.0040000000000000001, 0.69999999999999996, 1.0);
        // device 1387, IC IC239, analog/basic/buffered_nand_latch.hpp:34
        I(cpphdl_n2039, Vss) <+ 2.0000000000000002e-15 * ddt(V(cpphdl_n2039, Vss)); // Bench initial voltage = 0.0 V.
        // device 1388, IC IC239, analog/basic/buffered_nand_latch.hpp:35
        I(cpphdl_n2039, cpphdl_n2047) <+ 1.0000000000000001e-15 * ddt(V(cpphdl_n2039, cpphdl_n2047)); // Bench initial voltage = 0.0 V.
        // device 1389, IC IC239, analog/basic/buffered_nand_latch.hpp:36
        I(cpphdl_n2047, Vss) <+ 5e-15 * ddt(V(cpphdl_n2047, Vss)); // Bench initial voltage = 0.0 V.
        // device 1390, IC IC239, analog/basic/buffered_nand_latch.hpp:37
        I(cpphdl_n2047, Vss) <+ 8.0000000000000006e-15 * ddt(V(cpphdl_n2047, Vss)); // Bench initial voltage = 0.0 V.
        // device 1391, IC IC239, analog/basic/buffered_nand_latch.hpp:38
        I(cpphdl_n2061, Vss) <+ 1e-14 * ddt(V(cpphdl_n2061, Vss)); // Bench initial voltage = 0.0 V.
        // device 1392, IC IC241, analog/basic/inverter.hpp:11
        I(cpphdl_n2051, Vdd) <+ cpphdl_channel(V(cpphdl_n2043, Vdd), V(cpphdl_n2051, Vdd), 0.001, 0.69999999999999996, -1.0);
        // device 1393, IC IC241, analog/basic/inverter.hpp:12
        I(cpphdl_n2051, Vss) <+ cpphdl_channel(V(cpphdl_n2043, Vss), V(cpphdl_n2051, Vss), 0.001, 0.69999999999999996, 1.0);
        // device 1394, IC IC243, analog/basic/inverter.hpp:11
        I(cpphdl_n2067, Vdd) <+ cpphdl_channel(V(cpphdl_n2051, Vdd), V(cpphdl_n2067, Vdd), 0.0040000000000000001, 0.69999999999999996, -1.0);
        // device 1395, IC IC243, analog/basic/inverter.hpp:12
        I(cpphdl_n2067, Vss) <+ cpphdl_channel(V(cpphdl_n2051, Vss), V(cpphdl_n2067, Vss), 0.0040000000000000001, 0.69999999999999996, 1.0);
        // device 1396, IC IC239, analog/basic/buffered_nand_latch.hpp:34
        I(cpphdl_n2043, Vss) <+ 2.0000000000000002e-15 * ddt(V(cpphdl_n2043, Vss)); // Bench initial voltage = 0.0 V.
        // device 1397, IC IC239, analog/basic/buffered_nand_latch.hpp:35
        I(cpphdl_n2043, cpphdl_n2051) <+ 1.0000000000000001e-15 * ddt(V(cpphdl_n2043, cpphdl_n2051)); // Bench initial voltage = 0.0 V.
        // device 1398, IC IC239, analog/basic/buffered_nand_latch.hpp:36
        I(cpphdl_n2051, Vss) <+ 5e-15 * ddt(V(cpphdl_n2051, Vss)); // Bench initial voltage = 0.0 V.
        // device 1399, IC IC239, analog/basic/buffered_nand_latch.hpp:37
        I(cpphdl_n2051, Vss) <+ 8.0000000000000006e-15 * ddt(V(cpphdl_n2051, Vss)); // Bench initial voltage = 0.0 V.
        // device 1400, IC IC239, analog/basic/buffered_nand_latch.hpp:38
        I(cpphdl_n2067, Vss) <+ 1e-14 * ddt(V(cpphdl_n2067, Vss)); // Bench initial voltage = 0.0 V.
        // device 1401, IC IC245, analog/basic/cmos_logic.hpp:17
        I(cpphdl_n2998, Vss) <+ 5.0000000000000002e-14 * ddt(V(cpphdl_n2998, Vss)); // Bench initial voltage = 0.0 V.
        // device 1402, IC IC245, analog/basic/cmos_logic.hpp:18
        I(cpphdl_n2998, Vdd) <+ cpphdl_channel(V(cpphdl_n2061, Vdd), V(cpphdl_n2998, Vdd), 0.01, 0.69999999999999996, -1.0);
        // device 1403, IC IC245, analog/basic/cmos_logic.hpp:19
        I(cpphdl_n2998, Vdd) <+ cpphdl_channel(V(cpphdl_n2069, Vdd), V(cpphdl_n2998, Vdd), 0.01, 0.69999999999999996, -1.0);
        // device 1404, IC IC245, analog/basic/cmos_logic.hpp:20
        I(cpphdl_n2998, cpphdl_n2064) <+ cpphdl_channel(V(cpphdl_n2061, cpphdl_n2064), V(cpphdl_n2998, cpphdl_n2064), 0.01, 0.69999999999999996, 1.0);
        // device 1405, IC IC245, analog/basic/cmos_logic.hpp:21
        I(cpphdl_n2064, Vss) <+ cpphdl_channel(V(cpphdl_n2069, Vss), V(cpphdl_n2064, Vss), 0.01, 0.69999999999999996, 1.0);
        // device 1406, IC IC245, analog/basic/cmos_logic.hpp:27
        I(cpphdl_n2064, Vss) <+ 1e-14 * ddt(V(cpphdl_n2064, Vss)); // Bench initial voltage = 0.0 V.
        // device 1407, IC IC246, analog/basic/cmos_logic.hpp:17
        I(cpphdl_n2069, Vss) <+ 5.0000000000000002e-14 * ddt(V(cpphdl_n2069, Vss)); // Bench initial voltage = 0.0 V.
        // device 1408, IC IC246, analog/basic/cmos_logic.hpp:18
        I(cpphdl_n2069, Vdd) <+ cpphdl_channel(V(cpphdl_n2067, Vdd), V(cpphdl_n2069, Vdd), 0.01, 0.69999999999999996, -1.0);
        // device 1409, IC IC246, analog/basic/cmos_logic.hpp:19
        I(cpphdl_n2069, Vdd) <+ cpphdl_channel(V(cpphdl_n2998, Vdd), V(cpphdl_n2069, Vdd), 0.01, 0.69999999999999996, -1.0);
        // device 1410, IC IC246, analog/basic/cmos_logic.hpp:20
        I(cpphdl_n2069, cpphdl_n2070) <+ cpphdl_channel(V(cpphdl_n2067, cpphdl_n2070), V(cpphdl_n2069, cpphdl_n2070), 0.01, 0.69999999999999996, 1.0);
        // device 1411, IC IC246, analog/basic/cmos_logic.hpp:21
        I(cpphdl_n2070, Vss) <+ cpphdl_channel(V(cpphdl_n2998, Vss), V(cpphdl_n2070, Vss), 0.01, 0.69999999999999996, 1.0);
        // device 1412, IC IC246, analog/basic/cmos_logic.hpp:27
        I(cpphdl_n2070, Vss) <+ 1e-14 * ddt(V(cpphdl_n2070, Vss)); // Bench initial voltage = 0.0 V.
        // device 1413, IC IC244, analog/basic/nand_latch.hpp:36
        I(cpphdl_n2061, Vss) <+ 2.9999999999999998e-15 * ddt(V(cpphdl_n2061, Vss)); // Bench initial voltage = 0.0 V.
        // device 1414, IC IC244, analog/basic/nand_latch.hpp:37
        I(cpphdl_n2067, Vss) <+ 2.9999999999999998e-15 * ddt(V(cpphdl_n2067, Vss)); // Bench initial voltage = 0.0 V.
        // device 1415, IC IC247, analog/basic/inverter.hpp:11
        I(cpphdl_n2075, Vdd) <+ cpphdl_channel(V(CLEAR, Vdd), V(cpphdl_n2075, Vdd), 0.01, 0.69999999999999996, -1.0);
        // device 1416, IC IC247, analog/basic/inverter.hpp:12
        I(cpphdl_n2075, Vss) <+ cpphdl_channel(V(CLEAR, Vss), V(cpphdl_n2075, Vss), 0.01, 0.69999999999999996, 1.0);
        // device 1417, IC IC244, analog/basic/nand_latch.hpp:58
        I(cpphdl_n2075, Vss) <+ 2.9999999999999998e-15 * ddt(V(cpphdl_n2075, Vss)); // Bench initial voltage = 0.0 V.
        // device 1418, IC IC244, analog/basic/nand_latch.hpp:59
        I(cpphdl_n2998, Vss) <+ cpphdl_channel(V(CLEAR, Vss), V(cpphdl_n2998, Vss), 0.050000000000000003, 0.69999999999999996, 1.0);
        // device 1419, IC IC244, analog/basic/nand_latch.hpp:60
        I(cpphdl_n2069, Vdd) <+ cpphdl_channel(V(cpphdl_n2075, Vdd), V(cpphdl_n2069, Vdd), 0.050000000000000003, 0.69999999999999996, -1.0);
        // device 1420, IC IC250, analog/basic/inverter.hpp:11
        I(cpphdl_n2099, Vdd) <+ cpphdl_channel(V(TRACK10, Vdd), V(cpphdl_n2099, Vdd), 0.0040000000000000001, 0.69999999999999996, -1.0);
        // device 1421, IC IC250, analog/basic/inverter.hpp:12
        I(cpphdl_n2099, Vss) <+ cpphdl_channel(V(TRACK10, Vss), V(cpphdl_n2099, Vss), 0.0040000000000000001, 0.69999999999999996, 1.0);
        // device 1422, IC IC249, analog/basic/mos_track_hold.hpp:31
        I(cpphdl_n2099, Vss) <+ 2e-14 * ddt(V(cpphdl_n2099, Vss)); // Bench initial voltage = 0.0 V.
        // device 1423, IC IC249, analog/basic/mos_track_hold.hpp:32
        I(cpphdl_n2808, cpphdl_n2153) <+ cpphdl_channel(V(TRACK10, cpphdl_n2153), V(cpphdl_n2808, cpphdl_n2153), 0.029999999999999999, 0.69999999999999996, 1.0);
        // device 1424, IC IC249, analog/basic/mos_track_hold.hpp:33
        I(cpphdl_n2153, cpphdl_n2808) <+ cpphdl_channel(V(cpphdl_n2099, cpphdl_n2808), V(cpphdl_n2153, cpphdl_n2808), 0.014999999999999999, 0.69999999999999996, -1.0);
        // device 1425, IC IC249, analog/basic/mos_track_hold.hpp:37
        I(cpphdl_n2153, cpphdl_n2153) <+ cpphdl_channel(V(cpphdl_n2099, cpphdl_n2153), V(cpphdl_n2153, cpphdl_n2153), 0.016, 0.69999999999999996, 1.0);
        // device 1426, IC IC249, analog/basic/mos_track_hold.hpp:38
        I(cpphdl_n2153, cpphdl_n2153) <+ cpphdl_channel(V(TRACK10, cpphdl_n2153), V(cpphdl_n2153, cpphdl_n2153), 0.0083999999999999995, 0.69999999999999996, -1.0);
        // device 1427, IC IC249, analog/basic/mos_track_hold.hpp:39
        I(cpphdl_n2153, Vss) <+ 1.5000000000000001e-12 * ddt(V(cpphdl_n2153, Vss)); // Bench initial voltage = 0.0 V.
        // device 1428, IC IC249, analog/basic/mos_track_hold.hpp:42
        I(TRACK10, cpphdl_n2153) <+ 2.0000000000000002e-15 * ddt(V(TRACK10, cpphdl_n2153)); // Bench initial voltage = -0.0 V.
        // device 1429, IC IC249, analog/basic/mos_track_hold.hpp:43
        I(cpphdl_n2099, cpphdl_n2153) <+ 2.0000000000000002e-15 * ddt(V(cpphdl_n2099, cpphdl_n2153)); // Bench initial voltage = 0.0 V.
        // device 1430, IC IC249, analog/basic/mos_track_hold.hpp:44
        I(cpphdl_n2808, cpphdl_n2153) <+ 1.0000000000000001e-15 * ddt(V(cpphdl_n2808, cpphdl_n2153)); // Bench initial voltage = 0.0 V.
        // device 1431, IC IC252, analog/basic/inverter.hpp:11
        I(cpphdl_n2114, Vdd) <+ cpphdl_channel(V(BIT_N10_0, Vdd), V(cpphdl_n2114, Vdd), 0.080000000000000002, 0.69999999999999996, -1.0);
        // device 1432, IC IC252, analog/basic/inverter.hpp:12
        I(cpphdl_n2114, Vss) <+ cpphdl_channel(V(BIT_N10_0, Vss), V(cpphdl_n2114, Vss), 0.080000000000000002, 0.69999999999999996, 1.0);
        // device 1433, IC IC251, analog/basic/mos_r2r_dac.hpp:27
        I(cpphdl_n2114, Vss) <+ 2.9999999999999998e-15 * ddt(V(cpphdl_n2114, Vss)); // Bench initial voltage = 0.0 V.
        // device 1434, IC IC251, analog/basic/mos_r2r_dac.hpp:28
        I(cpphdl_n2114, cpphdl_n2143) <+ V(cpphdl_n2114, cpphdl_n2143) / 2000.0;
        // device 1435, IC IC251, analog/basic/mos_r2r_dac.hpp:29
        I(cpphdl_n2143, Vss) <+ 2.9999999999999998e-15 * ddt(V(cpphdl_n2143, Vss)); // Bench initial voltage = 0.0 V.
        // device 1436, IC IC253, analog/basic/inverter.hpp:11
        I(cpphdl_n2118, Vdd) <+ cpphdl_channel(V(BIT_N10_1, Vdd), V(cpphdl_n2118, Vdd), 0.080000000000000002, 0.69999999999999996, -1.0);
        // device 1437, IC IC253, analog/basic/inverter.hpp:12
        I(cpphdl_n2118, Vss) <+ cpphdl_channel(V(BIT_N10_1, Vss), V(cpphdl_n2118, Vss), 0.080000000000000002, 0.69999999999999996, 1.0);
        // device 1438, IC IC251, analog/basic/mos_r2r_dac.hpp:27
        I(cpphdl_n2118, Vss) <+ 2.9999999999999998e-15 * ddt(V(cpphdl_n2118, Vss)); // Bench initial voltage = 0.0 V.
        // device 1439, IC IC251, analog/basic/mos_r2r_dac.hpp:28
        I(cpphdl_n2118, cpphdl_n2144) <+ V(cpphdl_n2118, cpphdl_n2144) / 2000.0;
        // device 1440, IC IC251, analog/basic/mos_r2r_dac.hpp:29
        I(cpphdl_n2144, Vss) <+ 2.9999999999999998e-15 * ddt(V(cpphdl_n2144, Vss)); // Bench initial voltage = 0.0 V.
        // device 1441, IC IC251, analog/basic/mos_r2r_dac.hpp:31
        I(cpphdl_n2143, cpphdl_n2144) <+ V(cpphdl_n2143, cpphdl_n2144) / 1000.0;
        // device 1442, IC IC254, analog/basic/inverter.hpp:11
        I(cpphdl_n2122, Vdd) <+ cpphdl_channel(V(BIT_N10_2, Vdd), V(cpphdl_n2122, Vdd), 0.080000000000000002, 0.69999999999999996, -1.0);
        // device 1443, IC IC254, analog/basic/inverter.hpp:12
        I(cpphdl_n2122, Vss) <+ cpphdl_channel(V(BIT_N10_2, Vss), V(cpphdl_n2122, Vss), 0.080000000000000002, 0.69999999999999996, 1.0);
        // device 1444, IC IC251, analog/basic/mos_r2r_dac.hpp:27
        I(cpphdl_n2122, Vss) <+ 2.9999999999999998e-15 * ddt(V(cpphdl_n2122, Vss)); // Bench initial voltage = 0.0 V.
        // device 1445, IC IC251, analog/basic/mos_r2r_dac.hpp:28
        I(cpphdl_n2122, cpphdl_n2145) <+ V(cpphdl_n2122, cpphdl_n2145) / 2000.0;
        // device 1446, IC IC251, analog/basic/mos_r2r_dac.hpp:29
        I(cpphdl_n2145, Vss) <+ 2.9999999999999998e-15 * ddt(V(cpphdl_n2145, Vss)); // Bench initial voltage = 0.0 V.
        // device 1447, IC IC251, analog/basic/mos_r2r_dac.hpp:31
        I(cpphdl_n2144, cpphdl_n2145) <+ V(cpphdl_n2144, cpphdl_n2145) / 1000.0;
        // device 1448, IC IC255, analog/basic/inverter.hpp:11
        I(cpphdl_n2126, Vdd) <+ cpphdl_channel(V(BIT_N10_3, Vdd), V(cpphdl_n2126, Vdd), 0.080000000000000002, 0.69999999999999996, -1.0);
        // device 1449, IC IC255, analog/basic/inverter.hpp:12
        I(cpphdl_n2126, Vss) <+ cpphdl_channel(V(BIT_N10_3, Vss), V(cpphdl_n2126, Vss), 0.080000000000000002, 0.69999999999999996, 1.0);
        // device 1450, IC IC251, analog/basic/mos_r2r_dac.hpp:27
        I(cpphdl_n2126, Vss) <+ 2.9999999999999998e-15 * ddt(V(cpphdl_n2126, Vss)); // Bench initial voltage = 0.0 V.
        // device 1451, IC IC251, analog/basic/mos_r2r_dac.hpp:28
        I(cpphdl_n2126, cpphdl_n2146) <+ V(cpphdl_n2126, cpphdl_n2146) / 2000.0;
        // device 1452, IC IC251, analog/basic/mos_r2r_dac.hpp:29
        I(cpphdl_n2146, Vss) <+ 2.9999999999999998e-15 * ddt(V(cpphdl_n2146, Vss)); // Bench initial voltage = 0.0 V.
        // device 1453, IC IC251, analog/basic/mos_r2r_dac.hpp:31
        I(cpphdl_n2145, cpphdl_n2146) <+ V(cpphdl_n2145, cpphdl_n2146) / 1000.0;
        // device 1454, IC IC256, analog/basic/inverter.hpp:11
        I(cpphdl_n2130, Vdd) <+ cpphdl_channel(V(BIT_N10_4, Vdd), V(cpphdl_n2130, Vdd), 0.080000000000000002, 0.69999999999999996, -1.0);
        // device 1455, IC IC256, analog/basic/inverter.hpp:12
        I(cpphdl_n2130, Vss) <+ cpphdl_channel(V(BIT_N10_4, Vss), V(cpphdl_n2130, Vss), 0.080000000000000002, 0.69999999999999996, 1.0);
        // device 1456, IC IC251, analog/basic/mos_r2r_dac.hpp:27
        I(cpphdl_n2130, Vss) <+ 2.9999999999999998e-15 * ddt(V(cpphdl_n2130, Vss)); // Bench initial voltage = 0.0 V.
        // device 1457, IC IC251, analog/basic/mos_r2r_dac.hpp:28
        I(cpphdl_n2130, cpphdl_n2147) <+ V(cpphdl_n2130, cpphdl_n2147) / 2000.0;
        // device 1458, IC IC251, analog/basic/mos_r2r_dac.hpp:29
        I(cpphdl_n2147, Vss) <+ 2.9999999999999998e-15 * ddt(V(cpphdl_n2147, Vss)); // Bench initial voltage = 0.0 V.
        // device 1459, IC IC251, analog/basic/mos_r2r_dac.hpp:31
        I(cpphdl_n2146, cpphdl_n2147) <+ V(cpphdl_n2146, cpphdl_n2147) / 1000.0;
        // device 1460, IC IC257, analog/basic/inverter.hpp:11
        I(cpphdl_n2134, Vdd) <+ cpphdl_channel(V(BIT_N10_5, Vdd), V(cpphdl_n2134, Vdd), 0.080000000000000002, 0.69999999999999996, -1.0);
        // device 1461, IC IC257, analog/basic/inverter.hpp:12
        I(cpphdl_n2134, Vss) <+ cpphdl_channel(V(BIT_N10_5, Vss), V(cpphdl_n2134, Vss), 0.080000000000000002, 0.69999999999999996, 1.0);
        // device 1462, IC IC251, analog/basic/mos_r2r_dac.hpp:27
        I(cpphdl_n2134, Vss) <+ 2.9999999999999998e-15 * ddt(V(cpphdl_n2134, Vss)); // Bench initial voltage = 0.0 V.
        // device 1463, IC IC251, analog/basic/mos_r2r_dac.hpp:28
        I(cpphdl_n2134, cpphdl_n2148) <+ V(cpphdl_n2134, cpphdl_n2148) / 2000.0;
        // device 1464, IC IC251, analog/basic/mos_r2r_dac.hpp:29
        I(cpphdl_n2148, Vss) <+ 2.9999999999999998e-15 * ddt(V(cpphdl_n2148, Vss)); // Bench initial voltage = 0.0 V.
        // device 1465, IC IC251, analog/basic/mos_r2r_dac.hpp:31
        I(cpphdl_n2147, cpphdl_n2148) <+ V(cpphdl_n2147, cpphdl_n2148) / 1000.0;
        // device 1466, IC IC258, analog/basic/inverter.hpp:11
        I(cpphdl_n2138, Vdd) <+ cpphdl_channel(V(BIT_N10_6, Vdd), V(cpphdl_n2138, Vdd), 0.080000000000000002, 0.69999999999999996, -1.0);
        // device 1467, IC IC258, analog/basic/inverter.hpp:12
        I(cpphdl_n2138, Vss) <+ cpphdl_channel(V(BIT_N10_6, Vss), V(cpphdl_n2138, Vss), 0.080000000000000002, 0.69999999999999996, 1.0);
        // device 1468, IC IC251, analog/basic/mos_r2r_dac.hpp:27
        I(cpphdl_n2138, Vss) <+ 2.9999999999999998e-15 * ddt(V(cpphdl_n2138, Vss)); // Bench initial voltage = 0.0 V.
        // device 1469, IC IC251, analog/basic/mos_r2r_dac.hpp:28
        I(cpphdl_n2138, cpphdl_n2149) <+ V(cpphdl_n2138, cpphdl_n2149) / 2000.0;
        // device 1470, IC IC251, analog/basic/mos_r2r_dac.hpp:29
        I(cpphdl_n2149, Vss) <+ 2.9999999999999998e-15 * ddt(V(cpphdl_n2149, Vss)); // Bench initial voltage = 0.0 V.
        // device 1471, IC IC251, analog/basic/mos_r2r_dac.hpp:31
        I(cpphdl_n2148, cpphdl_n2149) <+ V(cpphdl_n2148, cpphdl_n2149) / 1000.0;
        // device 1472, IC IC259, analog/basic/inverter.hpp:11
        I(cpphdl_n2142, Vdd) <+ cpphdl_channel(V(BIT_N10_7, Vdd), V(cpphdl_n2142, Vdd), 0.080000000000000002, 0.69999999999999996, -1.0);
        // device 1473, IC IC259, analog/basic/inverter.hpp:12
        I(cpphdl_n2142, Vss) <+ cpphdl_channel(V(BIT_N10_7, Vss), V(cpphdl_n2142, Vss), 0.080000000000000002, 0.69999999999999996, 1.0);
        // device 1474, IC IC251, analog/basic/mos_r2r_dac.hpp:27
        I(cpphdl_n2142, Vss) <+ 2.9999999999999998e-15 * ddt(V(cpphdl_n2142, Vss)); // Bench initial voltage = 0.0 V.
        // device 1475, IC IC251, analog/basic/mos_r2r_dac.hpp:28
        I(cpphdl_n2142, cpphdl_n2154) <+ V(cpphdl_n2142, cpphdl_n2154) / 2000.0;
        // device 1476, IC IC251, analog/basic/mos_r2r_dac.hpp:29
        I(cpphdl_n2154, Vss) <+ 2.9999999999999998e-15 * ddt(V(cpphdl_n2154, Vss)); // Bench initial voltage = 0.0 V.
        // device 1477, IC IC251, analog/basic/mos_r2r_dac.hpp:31
        I(cpphdl_n2149, cpphdl_n2154) <+ V(cpphdl_n2149, cpphdl_n2154) / 1000.0;
        // device 1478, IC IC251, analog/basic/mos_r2r_dac.hpp:33
        I(Vss, cpphdl_n2143) <+ V(Vss, cpphdl_n2143) / 2000.0;
        // device 1479, IC IC260, analog/basic/nmos_resistor_amplifier.hpp:23
        I(Vdd, cpphdl_n2163) <+ V(Vdd, cpphdl_n2163) / 1000.0;
        // device 1480, IC IC260, analog/basic/nmos_resistor_amplifier.hpp:24
        I(Vdd, cpphdl_n2162) <+ V(Vdd, cpphdl_n2162) / 1000.0;
        // device 1481, IC IC260, analog/basic/nmos_resistor_amplifier.hpp:25
        I(cpphdl_n2163, cpphdl_n2157) <+ cpphdl_channel(V(cpphdl_n2153, cpphdl_n2157), V(cpphdl_n2163, cpphdl_n2157), 0.0074999999999999997, 0.69999999999999996, 1.0);
        // device 1482, IC IC260, analog/basic/nmos_resistor_amplifier.hpp:26
        I(cpphdl_n2162, cpphdl_n2158) <+ cpphdl_channel(V(cpphdl_n2154, cpphdl_n2158), V(cpphdl_n2162, cpphdl_n2158), 0.0074999999999999997, 0.69999999999999996, 1.0);
        // device 1483, IC IC260, analog/basic/nmos_resistor_amplifier.hpp:27
        I(cpphdl_n2159, cpphdl_n2157) <+ V(cpphdl_n2159, cpphdl_n2157) / 100.0;
        // device 1484, IC IC260, analog/basic/nmos_resistor_amplifier.hpp:28
        I(cpphdl_n2159, cpphdl_n2158) <+ V(cpphdl_n2159, cpphdl_n2158) / 100.0;
        // device 1485, IC IC260, analog/basic/nmos_resistor_amplifier.hpp:29
        I(Vss, cpphdl_n2159) <+ V(Vss, cpphdl_n2159) / 300.0;
        // device 1486, IC IC260, analog/basic/nmos_resistor_amplifier.hpp:30
        I(cpphdl_n2163, Vdd) <+ 2.9999999999999998e-13 * ddt(V(cpphdl_n2163, Vdd)); // Bench initial voltage = 0.0 V.
        // device 1487, IC IC260, analog/basic/nmos_resistor_amplifier.hpp:31
        I(cpphdl_n2162, Vdd) <+ 2.9999999999999998e-13 * ddt(V(cpphdl_n2162, Vdd)); // Bench initial voltage = 0.0 V.
        // device 1488, IC IC260, analog/basic/nmos_resistor_amplifier.hpp:32
        I(cpphdl_n2159, Vss) <+ 4e-14 * ddt(V(cpphdl_n2159, Vss)); // Bench initial voltage = 0.0 V.
        // device 1489, IC IC260, analog/basic/nmos_resistor_amplifier.hpp:34
        I(cpphdl_n2153, cpphdl_n2157) <+ 2e-14 * ddt(V(cpphdl_n2153, cpphdl_n2157)); // Bench initial voltage = 0.0 V.
        // device 1490, IC IC260, analog/basic/nmos_resistor_amplifier.hpp:35
        I(cpphdl_n2154, cpphdl_n2158) <+ 2e-14 * ddt(V(cpphdl_n2154, cpphdl_n2158)); // Bench initial voltage = 0.0 V.
        // device 1491, IC IC260, analog/basic/nmos_resistor_amplifier.hpp:36
        I(cpphdl_n2153, cpphdl_n2163) <+ 2.9999999999999998e-15 * ddt(V(cpphdl_n2153, cpphdl_n2163)); // Bench initial voltage = 0.0 V.
        // device 1492, IC IC260, analog/basic/nmos_resistor_amplifier.hpp:37
        I(cpphdl_n2154, cpphdl_n2162) <+ 2.9999999999999998e-15 * ddt(V(cpphdl_n2154, cpphdl_n2162)); // Bench initial voltage = 0.0 V.
        // device 1493, IC IC261, analog/basic/strongarm_comparator.hpp:28
        I(cpphdl_n2167, cpphdl_n2169) <+ cpphdl_channel(V(cpphdl_n2162, cpphdl_n2169), V(cpphdl_n2167, cpphdl_n2169), 0.0080000000000000002, 0.69999999999999996, 1.0);
        // device 1494, IC IC261, analog/basic/strongarm_comparator.hpp:29
        I(cpphdl_n2168, cpphdl_n2169) <+ cpphdl_channel(V(cpphdl_n2163, cpphdl_n2169), V(cpphdl_n2168, cpphdl_n2169), 0.0080000000000000002, 0.69999999999999996, 1.0);
        // device 1495, IC IC261, analog/basic/strongarm_comparator.hpp:30
        I(cpphdl_n2169, Vss) <+ cpphdl_channel(V(EVALUATE, Vss), V(cpphdl_n2169, Vss), 0.0080000000000000002, 0.69999999999999996, 1.0);
        // device 1496, IC IC261, analog/basic/strongarm_comparator.hpp:33
        I(cpphdl_n2182, cpphdl_n2167) <+ cpphdl_channel(V(cpphdl_n2186, cpphdl_n2167), V(cpphdl_n2182, cpphdl_n2167), 0.0040000000000000001, 0.69999999999999996, 1.0);
        // device 1497, IC IC261, analog/basic/strongarm_comparator.hpp:34
        I(cpphdl_n2186, cpphdl_n2168) <+ cpphdl_channel(V(cpphdl_n2182, cpphdl_n2168), V(cpphdl_n2186, cpphdl_n2168), 0.0040000000000000001, 0.69999999999999996, 1.0);
        // device 1498, IC IC261, analog/basic/strongarm_comparator.hpp:35
        I(cpphdl_n2186, Vdd) <+ cpphdl_channel(V(cpphdl_n2182, Vdd), V(cpphdl_n2186, Vdd), 0.002, 0.69999999999999996, -1.0);
        // device 1499, IC IC261, analog/basic/strongarm_comparator.hpp:36
        I(cpphdl_n2182, Vdd) <+ cpphdl_channel(V(cpphdl_n2186, Vdd), V(cpphdl_n2182, Vdd), 0.002, 0.69999999999999996, -1.0);
        // device 1500, IC IC261, analog/basic/strongarm_comparator.hpp:38
        I(cpphdl_n2167, Vdd) <+ cpphdl_channel(V(EVALUATE, Vdd), V(cpphdl_n2167, Vdd), 0.002, 0.69999999999999996, -1.0);
        // device 1501, IC IC261, analog/basic/strongarm_comparator.hpp:39
        I(cpphdl_n2168, Vdd) <+ cpphdl_channel(V(EVALUATE, Vdd), V(cpphdl_n2168, Vdd), 0.002, 0.69999999999999996, -1.0);
        // device 1502, IC IC261, analog/basic/strongarm_comparator.hpp:40
        I(cpphdl_n2186, Vdd) <+ cpphdl_channel(V(EVALUATE, Vdd), V(cpphdl_n2186, Vdd), 0.002, 0.69999999999999996, -1.0);
        // device 1503, IC IC261, analog/basic/strongarm_comparator.hpp:41
        I(cpphdl_n2182, Vdd) <+ cpphdl_channel(V(EVALUATE, Vdd), V(cpphdl_n2182, Vdd), 0.002, 0.69999999999999996, -1.0);
        // device 1504, IC IC261, analog/basic/strongarm_comparator.hpp:42
        I(cpphdl_n2167, Vss) <+ 2.9999999999999998e-14 * ddt(V(cpphdl_n2167, Vss)); // Bench initial voltage = 0.0 V.
        // device 1505, IC IC261, analog/basic/strongarm_comparator.hpp:43
        I(cpphdl_n2168, Vss) <+ 2.9999999999999998e-14 * ddt(V(cpphdl_n2168, Vss)); // Bench initial voltage = 0.0 V.
        // device 1506, IC IC261, analog/basic/strongarm_comparator.hpp:44
        I(cpphdl_n2169, Vss) <+ 2.9999999999999998e-14 * ddt(V(cpphdl_n2169, Vss)); // Bench initial voltage = 0.0 V.
        // device 1507, IC IC261, analog/basic/strongarm_comparator.hpp:45
        I(cpphdl_n2186, Vss) <+ 5.0000000000000002e-14 * ddt(V(cpphdl_n2186, Vss)); // Bench initial voltage = 0.0 V.
        // device 1508, IC IC261, analog/basic/strongarm_comparator.hpp:46
        I(cpphdl_n2182, Vss) <+ 5.0000000000000002e-14 * ddt(V(cpphdl_n2182, Vss)); // Bench initial voltage = 0.0 V.
        // device 1509, IC IC261, analog/basic/strongarm_comparator.hpp:47
        I(cpphdl_n2162, cpphdl_n2169) <+ 2e-14 * ddt(V(cpphdl_n2162, cpphdl_n2169)); // Bench initial voltage = 0.0 V.
        // device 1510, IC IC261, analog/basic/strongarm_comparator.hpp:48
        I(cpphdl_n2163, cpphdl_n2169) <+ 2e-14 * ddt(V(cpphdl_n2163, cpphdl_n2169)); // Bench initial voltage = 0.0 V.
        // device 1511, IC IC261, analog/basic/strongarm_comparator.hpp:49
        I(cpphdl_n2162, cpphdl_n2167) <+ 2.9999999999999998e-15 * ddt(V(cpphdl_n2162, cpphdl_n2167)); // Bench initial voltage = 0.0 V.
        // device 1512, IC IC261, analog/basic/strongarm_comparator.hpp:50
        I(cpphdl_n2163, cpphdl_n2168) <+ 2.9999999999999998e-15 * ddt(V(cpphdl_n2163, cpphdl_n2168)); // Bench initial voltage = 0.0 V.
        // device 1513, IC IC263, analog/basic/inverter.hpp:11
        I(cpphdl_n2190, Vdd) <+ cpphdl_channel(V(cpphdl_n2182, Vdd), V(cpphdl_n2190, Vdd), 0.001, 0.69999999999999996, -1.0);
        // device 1514, IC IC263, analog/basic/inverter.hpp:12
        I(cpphdl_n2190, Vss) <+ cpphdl_channel(V(cpphdl_n2182, Vss), V(cpphdl_n2190, Vss), 0.001, 0.69999999999999996, 1.0);
        // device 1515, IC IC265, analog/basic/inverter.hpp:11
        I(cpphdl_n2204, Vdd) <+ cpphdl_channel(V(cpphdl_n2190, Vdd), V(cpphdl_n2204, Vdd), 0.0040000000000000001, 0.69999999999999996, -1.0);
        // device 1516, IC IC265, analog/basic/inverter.hpp:12
        I(cpphdl_n2204, Vss) <+ cpphdl_channel(V(cpphdl_n2190, Vss), V(cpphdl_n2204, Vss), 0.0040000000000000001, 0.69999999999999996, 1.0);
        // device 1517, IC IC262, analog/basic/buffered_nand_latch.hpp:34
        I(cpphdl_n2182, Vss) <+ 2.0000000000000002e-15 * ddt(V(cpphdl_n2182, Vss)); // Bench initial voltage = 0.0 V.
        // device 1518, IC IC262, analog/basic/buffered_nand_latch.hpp:35
        I(cpphdl_n2182, cpphdl_n2190) <+ 1.0000000000000001e-15 * ddt(V(cpphdl_n2182, cpphdl_n2190)); // Bench initial voltage = 0.0 V.
        // device 1519, IC IC262, analog/basic/buffered_nand_latch.hpp:36
        I(cpphdl_n2190, Vss) <+ 5e-15 * ddt(V(cpphdl_n2190, Vss)); // Bench initial voltage = 0.0 V.
        // device 1520, IC IC262, analog/basic/buffered_nand_latch.hpp:37
        I(cpphdl_n2190, Vss) <+ 8.0000000000000006e-15 * ddt(V(cpphdl_n2190, Vss)); // Bench initial voltage = 0.0 V.
        // device 1521, IC IC262, analog/basic/buffered_nand_latch.hpp:38
        I(cpphdl_n2204, Vss) <+ 1e-14 * ddt(V(cpphdl_n2204, Vss)); // Bench initial voltage = 0.0 V.
        // device 1522, IC IC264, analog/basic/inverter.hpp:11
        I(cpphdl_n2194, Vdd) <+ cpphdl_channel(V(cpphdl_n2186, Vdd), V(cpphdl_n2194, Vdd), 0.001, 0.69999999999999996, -1.0);
        // device 1523, IC IC264, analog/basic/inverter.hpp:12
        I(cpphdl_n2194, Vss) <+ cpphdl_channel(V(cpphdl_n2186, Vss), V(cpphdl_n2194, Vss), 0.001, 0.69999999999999996, 1.0);
        // device 1524, IC IC266, analog/basic/inverter.hpp:11
        I(cpphdl_n2210, Vdd) <+ cpphdl_channel(V(cpphdl_n2194, Vdd), V(cpphdl_n2210, Vdd), 0.0040000000000000001, 0.69999999999999996, -1.0);
        // device 1525, IC IC266, analog/basic/inverter.hpp:12
        I(cpphdl_n2210, Vss) <+ cpphdl_channel(V(cpphdl_n2194, Vss), V(cpphdl_n2210, Vss), 0.0040000000000000001, 0.69999999999999996, 1.0);
        // device 1526, IC IC262, analog/basic/buffered_nand_latch.hpp:34
        I(cpphdl_n2186, Vss) <+ 2.0000000000000002e-15 * ddt(V(cpphdl_n2186, Vss)); // Bench initial voltage = 0.0 V.
        // device 1527, IC IC262, analog/basic/buffered_nand_latch.hpp:35
        I(cpphdl_n2186, cpphdl_n2194) <+ 1.0000000000000001e-15 * ddt(V(cpphdl_n2186, cpphdl_n2194)); // Bench initial voltage = 0.0 V.
        // device 1528, IC IC262, analog/basic/buffered_nand_latch.hpp:36
        I(cpphdl_n2194, Vss) <+ 5e-15 * ddt(V(cpphdl_n2194, Vss)); // Bench initial voltage = 0.0 V.
        // device 1529, IC IC262, analog/basic/buffered_nand_latch.hpp:37
        I(cpphdl_n2194, Vss) <+ 8.0000000000000006e-15 * ddt(V(cpphdl_n2194, Vss)); // Bench initial voltage = 0.0 V.
        // device 1530, IC IC262, analog/basic/buffered_nand_latch.hpp:38
        I(cpphdl_n2210, Vss) <+ 1e-14 * ddt(V(cpphdl_n2210, Vss)); // Bench initial voltage = 0.0 V.
        // device 1531, IC IC268, analog/basic/cmos_logic.hpp:17
        I(cpphdl_n3003, Vss) <+ 5.0000000000000002e-14 * ddt(V(cpphdl_n3003, Vss)); // Bench initial voltage = 0.0 V.
        // device 1532, IC IC268, analog/basic/cmos_logic.hpp:18
        I(cpphdl_n3003, Vdd) <+ cpphdl_channel(V(cpphdl_n2204, Vdd), V(cpphdl_n3003, Vdd), 0.01, 0.69999999999999996, -1.0);
        // device 1533, IC IC268, analog/basic/cmos_logic.hpp:19
        I(cpphdl_n3003, Vdd) <+ cpphdl_channel(V(cpphdl_n2212, Vdd), V(cpphdl_n3003, Vdd), 0.01, 0.69999999999999996, -1.0);
        // device 1534, IC IC268, analog/basic/cmos_logic.hpp:20
        I(cpphdl_n3003, cpphdl_n2207) <+ cpphdl_channel(V(cpphdl_n2204, cpphdl_n2207), V(cpphdl_n3003, cpphdl_n2207), 0.01, 0.69999999999999996, 1.0);
        // device 1535, IC IC268, analog/basic/cmos_logic.hpp:21
        I(cpphdl_n2207, Vss) <+ cpphdl_channel(V(cpphdl_n2212, Vss), V(cpphdl_n2207, Vss), 0.01, 0.69999999999999996, 1.0);
        // device 1536, IC IC268, analog/basic/cmos_logic.hpp:27
        I(cpphdl_n2207, Vss) <+ 1e-14 * ddt(V(cpphdl_n2207, Vss)); // Bench initial voltage = 0.0 V.
        // device 1537, IC IC269, analog/basic/cmos_logic.hpp:17
        I(cpphdl_n2212, Vss) <+ 5.0000000000000002e-14 * ddt(V(cpphdl_n2212, Vss)); // Bench initial voltage = 0.0 V.
        // device 1538, IC IC269, analog/basic/cmos_logic.hpp:18
        I(cpphdl_n2212, Vdd) <+ cpphdl_channel(V(cpphdl_n2210, Vdd), V(cpphdl_n2212, Vdd), 0.01, 0.69999999999999996, -1.0);
        // device 1539, IC IC269, analog/basic/cmos_logic.hpp:19
        I(cpphdl_n2212, Vdd) <+ cpphdl_channel(V(cpphdl_n3003, Vdd), V(cpphdl_n2212, Vdd), 0.01, 0.69999999999999996, -1.0);
        // device 1540, IC IC269, analog/basic/cmos_logic.hpp:20
        I(cpphdl_n2212, cpphdl_n2213) <+ cpphdl_channel(V(cpphdl_n2210, cpphdl_n2213), V(cpphdl_n2212, cpphdl_n2213), 0.01, 0.69999999999999996, 1.0);
        // device 1541, IC IC269, analog/basic/cmos_logic.hpp:21
        I(cpphdl_n2213, Vss) <+ cpphdl_channel(V(cpphdl_n3003, Vss), V(cpphdl_n2213, Vss), 0.01, 0.69999999999999996, 1.0);
        // device 1542, IC IC269, analog/basic/cmos_logic.hpp:27
        I(cpphdl_n2213, Vss) <+ 1e-14 * ddt(V(cpphdl_n2213, Vss)); // Bench initial voltage = 0.0 V.
        // device 1543, IC IC267, analog/basic/nand_latch.hpp:36
        I(cpphdl_n2204, Vss) <+ 2.9999999999999998e-15 * ddt(V(cpphdl_n2204, Vss)); // Bench initial voltage = 0.0 V.
        // device 1544, IC IC267, analog/basic/nand_latch.hpp:37
        I(cpphdl_n2210, Vss) <+ 2.9999999999999998e-15 * ddt(V(cpphdl_n2210, Vss)); // Bench initial voltage = 0.0 V.
        // device 1545, IC IC270, analog/basic/inverter.hpp:11
        I(cpphdl_n2218, Vdd) <+ cpphdl_channel(V(CLEAR, Vdd), V(cpphdl_n2218, Vdd), 0.01, 0.69999999999999996, -1.0);
        // device 1546, IC IC270, analog/basic/inverter.hpp:12
        I(cpphdl_n2218, Vss) <+ cpphdl_channel(V(CLEAR, Vss), V(cpphdl_n2218, Vss), 0.01, 0.69999999999999996, 1.0);
        // device 1547, IC IC267, analog/basic/nand_latch.hpp:58
        I(cpphdl_n2218, Vss) <+ 2.9999999999999998e-15 * ddt(V(cpphdl_n2218, Vss)); // Bench initial voltage = 0.0 V.
        // device 1548, IC IC267, analog/basic/nand_latch.hpp:59
        I(cpphdl_n3003, Vss) <+ cpphdl_channel(V(CLEAR, Vss), V(cpphdl_n3003, Vss), 0.050000000000000003, 0.69999999999999996, 1.0);
        // device 1549, IC IC267, analog/basic/nand_latch.hpp:60
        I(cpphdl_n2212, Vdd) <+ cpphdl_channel(V(cpphdl_n2218, Vdd), V(cpphdl_n2212, Vdd), 0.050000000000000003, 0.69999999999999996, -1.0);
        // device 1550, IC IC273, analog/basic/inverter.hpp:11
        I(cpphdl_n2242, Vdd) <+ cpphdl_channel(V(TRACK11, Vdd), V(cpphdl_n2242, Vdd), 0.0040000000000000001, 0.69999999999999996, -1.0);
        // device 1551, IC IC273, analog/basic/inverter.hpp:12
        I(cpphdl_n2242, Vss) <+ cpphdl_channel(V(TRACK11, Vss), V(cpphdl_n2242, Vss), 0.0040000000000000001, 0.69999999999999996, 1.0);
        // device 1552, IC IC272, analog/basic/mos_track_hold.hpp:31
        I(cpphdl_n2242, Vss) <+ 2e-14 * ddt(V(cpphdl_n2242, Vss)); // Bench initial voltage = 0.0 V.
        // device 1553, IC IC272, analog/basic/mos_track_hold.hpp:32
        I(cpphdl_n2808, cpphdl_n2296) <+ cpphdl_channel(V(TRACK11, cpphdl_n2296), V(cpphdl_n2808, cpphdl_n2296), 0.029999999999999999, 0.69999999999999996, 1.0);
        // device 1554, IC IC272, analog/basic/mos_track_hold.hpp:33
        I(cpphdl_n2296, cpphdl_n2808) <+ cpphdl_channel(V(cpphdl_n2242, cpphdl_n2808), V(cpphdl_n2296, cpphdl_n2808), 0.014999999999999999, 0.69999999999999996, -1.0);
        // device 1555, IC IC272, analog/basic/mos_track_hold.hpp:37
        I(cpphdl_n2296, cpphdl_n2296) <+ cpphdl_channel(V(cpphdl_n2242, cpphdl_n2296), V(cpphdl_n2296, cpphdl_n2296), 0.016, 0.69999999999999996, 1.0);
        // device 1556, IC IC272, analog/basic/mos_track_hold.hpp:38
        I(cpphdl_n2296, cpphdl_n2296) <+ cpphdl_channel(V(TRACK11, cpphdl_n2296), V(cpphdl_n2296, cpphdl_n2296), 0.0083999999999999995, 0.69999999999999996, -1.0);
        // device 1557, IC IC272, analog/basic/mos_track_hold.hpp:39
        I(cpphdl_n2296, Vss) <+ 1.5000000000000001e-12 * ddt(V(cpphdl_n2296, Vss)); // Bench initial voltage = 0.0 V.
        // device 1558, IC IC272, analog/basic/mos_track_hold.hpp:42
        I(TRACK11, cpphdl_n2296) <+ 2.0000000000000002e-15 * ddt(V(TRACK11, cpphdl_n2296)); // Bench initial voltage = -0.0 V.
        // device 1559, IC IC272, analog/basic/mos_track_hold.hpp:43
        I(cpphdl_n2242, cpphdl_n2296) <+ 2.0000000000000002e-15 * ddt(V(cpphdl_n2242, cpphdl_n2296)); // Bench initial voltage = 0.0 V.
        // device 1560, IC IC272, analog/basic/mos_track_hold.hpp:44
        I(cpphdl_n2808, cpphdl_n2296) <+ 1.0000000000000001e-15 * ddt(V(cpphdl_n2808, cpphdl_n2296)); // Bench initial voltage = 0.0 V.
        // device 1561, IC IC275, analog/basic/inverter.hpp:11
        I(cpphdl_n2257, Vdd) <+ cpphdl_channel(V(BIT_N11_0, Vdd), V(cpphdl_n2257, Vdd), 0.080000000000000002, 0.69999999999999996, -1.0);
        // device 1562, IC IC275, analog/basic/inverter.hpp:12
        I(cpphdl_n2257, Vss) <+ cpphdl_channel(V(BIT_N11_0, Vss), V(cpphdl_n2257, Vss), 0.080000000000000002, 0.69999999999999996, 1.0);
        // device 1563, IC IC274, analog/basic/mos_r2r_dac.hpp:27
        I(cpphdl_n2257, Vss) <+ 2.9999999999999998e-15 * ddt(V(cpphdl_n2257, Vss)); // Bench initial voltage = 0.0 V.
        // device 1564, IC IC274, analog/basic/mos_r2r_dac.hpp:28
        I(cpphdl_n2257, cpphdl_n2286) <+ V(cpphdl_n2257, cpphdl_n2286) / 2000.0;
        // device 1565, IC IC274, analog/basic/mos_r2r_dac.hpp:29
        I(cpphdl_n2286, Vss) <+ 2.9999999999999998e-15 * ddt(V(cpphdl_n2286, Vss)); // Bench initial voltage = 0.0 V.
        // device 1566, IC IC276, analog/basic/inverter.hpp:11
        I(cpphdl_n2261, Vdd) <+ cpphdl_channel(V(BIT_N11_1, Vdd), V(cpphdl_n2261, Vdd), 0.080000000000000002, 0.69999999999999996, -1.0);
        // device 1567, IC IC276, analog/basic/inverter.hpp:12
        I(cpphdl_n2261, Vss) <+ cpphdl_channel(V(BIT_N11_1, Vss), V(cpphdl_n2261, Vss), 0.080000000000000002, 0.69999999999999996, 1.0);
        // device 1568, IC IC274, analog/basic/mos_r2r_dac.hpp:27
        I(cpphdl_n2261, Vss) <+ 2.9999999999999998e-15 * ddt(V(cpphdl_n2261, Vss)); // Bench initial voltage = 0.0 V.
        // device 1569, IC IC274, analog/basic/mos_r2r_dac.hpp:28
        I(cpphdl_n2261, cpphdl_n2287) <+ V(cpphdl_n2261, cpphdl_n2287) / 2000.0;
        // device 1570, IC IC274, analog/basic/mos_r2r_dac.hpp:29
        I(cpphdl_n2287, Vss) <+ 2.9999999999999998e-15 * ddt(V(cpphdl_n2287, Vss)); // Bench initial voltage = 0.0 V.
        // device 1571, IC IC274, analog/basic/mos_r2r_dac.hpp:31
        I(cpphdl_n2286, cpphdl_n2287) <+ V(cpphdl_n2286, cpphdl_n2287) / 1000.0;
        // device 1572, IC IC277, analog/basic/inverter.hpp:11
        I(cpphdl_n2265, Vdd) <+ cpphdl_channel(V(BIT_N11_2, Vdd), V(cpphdl_n2265, Vdd), 0.080000000000000002, 0.69999999999999996, -1.0);
        // device 1573, IC IC277, analog/basic/inverter.hpp:12
        I(cpphdl_n2265, Vss) <+ cpphdl_channel(V(BIT_N11_2, Vss), V(cpphdl_n2265, Vss), 0.080000000000000002, 0.69999999999999996, 1.0);
        // device 1574, IC IC274, analog/basic/mos_r2r_dac.hpp:27
        I(cpphdl_n2265, Vss) <+ 2.9999999999999998e-15 * ddt(V(cpphdl_n2265, Vss)); // Bench initial voltage = 0.0 V.
        // device 1575, IC IC274, analog/basic/mos_r2r_dac.hpp:28
        I(cpphdl_n2265, cpphdl_n2288) <+ V(cpphdl_n2265, cpphdl_n2288) / 2000.0;
        // device 1576, IC IC274, analog/basic/mos_r2r_dac.hpp:29
        I(cpphdl_n2288, Vss) <+ 2.9999999999999998e-15 * ddt(V(cpphdl_n2288, Vss)); // Bench initial voltage = 0.0 V.
        // device 1577, IC IC274, analog/basic/mos_r2r_dac.hpp:31
        I(cpphdl_n2287, cpphdl_n2288) <+ V(cpphdl_n2287, cpphdl_n2288) / 1000.0;
        // device 1578, IC IC278, analog/basic/inverter.hpp:11
        I(cpphdl_n2269, Vdd) <+ cpphdl_channel(V(BIT_N11_3, Vdd), V(cpphdl_n2269, Vdd), 0.080000000000000002, 0.69999999999999996, -1.0);
        // device 1579, IC IC278, analog/basic/inverter.hpp:12
        I(cpphdl_n2269, Vss) <+ cpphdl_channel(V(BIT_N11_3, Vss), V(cpphdl_n2269, Vss), 0.080000000000000002, 0.69999999999999996, 1.0);
        // device 1580, IC IC274, analog/basic/mos_r2r_dac.hpp:27
        I(cpphdl_n2269, Vss) <+ 2.9999999999999998e-15 * ddt(V(cpphdl_n2269, Vss)); // Bench initial voltage = 0.0 V.
        // device 1581, IC IC274, analog/basic/mos_r2r_dac.hpp:28
        I(cpphdl_n2269, cpphdl_n2289) <+ V(cpphdl_n2269, cpphdl_n2289) / 2000.0;
        // device 1582, IC IC274, analog/basic/mos_r2r_dac.hpp:29
        I(cpphdl_n2289, Vss) <+ 2.9999999999999998e-15 * ddt(V(cpphdl_n2289, Vss)); // Bench initial voltage = 0.0 V.
        // device 1583, IC IC274, analog/basic/mos_r2r_dac.hpp:31
        I(cpphdl_n2288, cpphdl_n2289) <+ V(cpphdl_n2288, cpphdl_n2289) / 1000.0;
        // device 1584, IC IC279, analog/basic/inverter.hpp:11
        I(cpphdl_n2273, Vdd) <+ cpphdl_channel(V(BIT_N11_4, Vdd), V(cpphdl_n2273, Vdd), 0.080000000000000002, 0.69999999999999996, -1.0);
        // device 1585, IC IC279, analog/basic/inverter.hpp:12
        I(cpphdl_n2273, Vss) <+ cpphdl_channel(V(BIT_N11_4, Vss), V(cpphdl_n2273, Vss), 0.080000000000000002, 0.69999999999999996, 1.0);
        // device 1586, IC IC274, analog/basic/mos_r2r_dac.hpp:27
        I(cpphdl_n2273, Vss) <+ 2.9999999999999998e-15 * ddt(V(cpphdl_n2273, Vss)); // Bench initial voltage = 0.0 V.
        // device 1587, IC IC274, analog/basic/mos_r2r_dac.hpp:28
        I(cpphdl_n2273, cpphdl_n2290) <+ V(cpphdl_n2273, cpphdl_n2290) / 2000.0;
        // device 1588, IC IC274, analog/basic/mos_r2r_dac.hpp:29
        I(cpphdl_n2290, Vss) <+ 2.9999999999999998e-15 * ddt(V(cpphdl_n2290, Vss)); // Bench initial voltage = 0.0 V.
        // device 1589, IC IC274, analog/basic/mos_r2r_dac.hpp:31
        I(cpphdl_n2289, cpphdl_n2290) <+ V(cpphdl_n2289, cpphdl_n2290) / 1000.0;
        // device 1590, IC IC280, analog/basic/inverter.hpp:11
        I(cpphdl_n2277, Vdd) <+ cpphdl_channel(V(BIT_N11_5, Vdd), V(cpphdl_n2277, Vdd), 0.080000000000000002, 0.69999999999999996, -1.0);
        // device 1591, IC IC280, analog/basic/inverter.hpp:12
        I(cpphdl_n2277, Vss) <+ cpphdl_channel(V(BIT_N11_5, Vss), V(cpphdl_n2277, Vss), 0.080000000000000002, 0.69999999999999996, 1.0);
        // device 1592, IC IC274, analog/basic/mos_r2r_dac.hpp:27
        I(cpphdl_n2277, Vss) <+ 2.9999999999999998e-15 * ddt(V(cpphdl_n2277, Vss)); // Bench initial voltage = 0.0 V.
        // device 1593, IC IC274, analog/basic/mos_r2r_dac.hpp:28
        I(cpphdl_n2277, cpphdl_n2291) <+ V(cpphdl_n2277, cpphdl_n2291) / 2000.0;
        // device 1594, IC IC274, analog/basic/mos_r2r_dac.hpp:29
        I(cpphdl_n2291, Vss) <+ 2.9999999999999998e-15 * ddt(V(cpphdl_n2291, Vss)); // Bench initial voltage = 0.0 V.
        // device 1595, IC IC274, analog/basic/mos_r2r_dac.hpp:31
        I(cpphdl_n2290, cpphdl_n2291) <+ V(cpphdl_n2290, cpphdl_n2291) / 1000.0;
        // device 1596, IC IC281, analog/basic/inverter.hpp:11
        I(cpphdl_n2281, Vdd) <+ cpphdl_channel(V(BIT_N11_6, Vdd), V(cpphdl_n2281, Vdd), 0.080000000000000002, 0.69999999999999996, -1.0);
        // device 1597, IC IC281, analog/basic/inverter.hpp:12
        I(cpphdl_n2281, Vss) <+ cpphdl_channel(V(BIT_N11_6, Vss), V(cpphdl_n2281, Vss), 0.080000000000000002, 0.69999999999999996, 1.0);
        // device 1598, IC IC274, analog/basic/mos_r2r_dac.hpp:27
        I(cpphdl_n2281, Vss) <+ 2.9999999999999998e-15 * ddt(V(cpphdl_n2281, Vss)); // Bench initial voltage = 0.0 V.
        // device 1599, IC IC274, analog/basic/mos_r2r_dac.hpp:28
        I(cpphdl_n2281, cpphdl_n2292) <+ V(cpphdl_n2281, cpphdl_n2292) / 2000.0;
        // device 1600, IC IC274, analog/basic/mos_r2r_dac.hpp:29
        I(cpphdl_n2292, Vss) <+ 2.9999999999999998e-15 * ddt(V(cpphdl_n2292, Vss)); // Bench initial voltage = 0.0 V.
        // device 1601, IC IC274, analog/basic/mos_r2r_dac.hpp:31
        I(cpphdl_n2291, cpphdl_n2292) <+ V(cpphdl_n2291, cpphdl_n2292) / 1000.0;
        // device 1602, IC IC282, analog/basic/inverter.hpp:11
        I(cpphdl_n2285, Vdd) <+ cpphdl_channel(V(BIT_N11_7, Vdd), V(cpphdl_n2285, Vdd), 0.080000000000000002, 0.69999999999999996, -1.0);
        // device 1603, IC IC282, analog/basic/inverter.hpp:12
        I(cpphdl_n2285, Vss) <+ cpphdl_channel(V(BIT_N11_7, Vss), V(cpphdl_n2285, Vss), 0.080000000000000002, 0.69999999999999996, 1.0);
        // device 1604, IC IC274, analog/basic/mos_r2r_dac.hpp:27
        I(cpphdl_n2285, Vss) <+ 2.9999999999999998e-15 * ddt(V(cpphdl_n2285, Vss)); // Bench initial voltage = 0.0 V.
        // device 1605, IC IC274, analog/basic/mos_r2r_dac.hpp:28
        I(cpphdl_n2285, cpphdl_n2297) <+ V(cpphdl_n2285, cpphdl_n2297) / 2000.0;
        // device 1606, IC IC274, analog/basic/mos_r2r_dac.hpp:29
        I(cpphdl_n2297, Vss) <+ 2.9999999999999998e-15 * ddt(V(cpphdl_n2297, Vss)); // Bench initial voltage = 0.0 V.
        // device 1607, IC IC274, analog/basic/mos_r2r_dac.hpp:31
        I(cpphdl_n2292, cpphdl_n2297) <+ V(cpphdl_n2292, cpphdl_n2297) / 1000.0;
        // device 1608, IC IC274, analog/basic/mos_r2r_dac.hpp:33
        I(Vss, cpphdl_n2286) <+ V(Vss, cpphdl_n2286) / 2000.0;
        // device 1609, IC IC283, analog/basic/nmos_resistor_amplifier.hpp:23
        I(Vdd, cpphdl_n2306) <+ V(Vdd, cpphdl_n2306) / 1000.0;
        // device 1610, IC IC283, analog/basic/nmos_resistor_amplifier.hpp:24
        I(Vdd, cpphdl_n2305) <+ V(Vdd, cpphdl_n2305) / 1000.0;
        // device 1611, IC IC283, analog/basic/nmos_resistor_amplifier.hpp:25
        I(cpphdl_n2306, cpphdl_n2300) <+ cpphdl_channel(V(cpphdl_n2296, cpphdl_n2300), V(cpphdl_n2306, cpphdl_n2300), 0.0074999999999999997, 0.69999999999999996, 1.0);
        // device 1612, IC IC283, analog/basic/nmos_resistor_amplifier.hpp:26
        I(cpphdl_n2305, cpphdl_n2301) <+ cpphdl_channel(V(cpphdl_n2297, cpphdl_n2301), V(cpphdl_n2305, cpphdl_n2301), 0.0074999999999999997, 0.69999999999999996, 1.0);
        // device 1613, IC IC283, analog/basic/nmos_resistor_amplifier.hpp:27
        I(cpphdl_n2302, cpphdl_n2300) <+ V(cpphdl_n2302, cpphdl_n2300) / 100.0;
        // device 1614, IC IC283, analog/basic/nmos_resistor_amplifier.hpp:28
        I(cpphdl_n2302, cpphdl_n2301) <+ V(cpphdl_n2302, cpphdl_n2301) / 100.0;
        // device 1615, IC IC283, analog/basic/nmos_resistor_amplifier.hpp:29
        I(Vss, cpphdl_n2302) <+ V(Vss, cpphdl_n2302) / 300.0;
        // device 1616, IC IC283, analog/basic/nmos_resistor_amplifier.hpp:30
        I(cpphdl_n2306, Vdd) <+ 2.9999999999999998e-13 * ddt(V(cpphdl_n2306, Vdd)); // Bench initial voltage = 0.0 V.
        // device 1617, IC IC283, analog/basic/nmos_resistor_amplifier.hpp:31
        I(cpphdl_n2305, Vdd) <+ 2.9999999999999998e-13 * ddt(V(cpphdl_n2305, Vdd)); // Bench initial voltage = 0.0 V.
        // device 1618, IC IC283, analog/basic/nmos_resistor_amplifier.hpp:32
        I(cpphdl_n2302, Vss) <+ 4e-14 * ddt(V(cpphdl_n2302, Vss)); // Bench initial voltage = 0.0 V.
        // device 1619, IC IC283, analog/basic/nmos_resistor_amplifier.hpp:34
        I(cpphdl_n2296, cpphdl_n2300) <+ 2e-14 * ddt(V(cpphdl_n2296, cpphdl_n2300)); // Bench initial voltage = 0.0 V.
        // device 1620, IC IC283, analog/basic/nmos_resistor_amplifier.hpp:35
        I(cpphdl_n2297, cpphdl_n2301) <+ 2e-14 * ddt(V(cpphdl_n2297, cpphdl_n2301)); // Bench initial voltage = 0.0 V.
        // device 1621, IC IC283, analog/basic/nmos_resistor_amplifier.hpp:36
        I(cpphdl_n2296, cpphdl_n2306) <+ 2.9999999999999998e-15 * ddt(V(cpphdl_n2296, cpphdl_n2306)); // Bench initial voltage = 0.0 V.
        // device 1622, IC IC283, analog/basic/nmos_resistor_amplifier.hpp:37
        I(cpphdl_n2297, cpphdl_n2305) <+ 2.9999999999999998e-15 * ddt(V(cpphdl_n2297, cpphdl_n2305)); // Bench initial voltage = 0.0 V.
        // device 1623, IC IC284, analog/basic/strongarm_comparator.hpp:28
        I(cpphdl_n2310, cpphdl_n2312) <+ cpphdl_channel(V(cpphdl_n2305, cpphdl_n2312), V(cpphdl_n2310, cpphdl_n2312), 0.0080000000000000002, 0.69999999999999996, 1.0);
        // device 1624, IC IC284, analog/basic/strongarm_comparator.hpp:29
        I(cpphdl_n2311, cpphdl_n2312) <+ cpphdl_channel(V(cpphdl_n2306, cpphdl_n2312), V(cpphdl_n2311, cpphdl_n2312), 0.0080000000000000002, 0.69999999999999996, 1.0);
        // device 1625, IC IC284, analog/basic/strongarm_comparator.hpp:30
        I(cpphdl_n2312, Vss) <+ cpphdl_channel(V(EVALUATE, Vss), V(cpphdl_n2312, Vss), 0.0080000000000000002, 0.69999999999999996, 1.0);
        // device 1626, IC IC284, analog/basic/strongarm_comparator.hpp:33
        I(cpphdl_n2325, cpphdl_n2310) <+ cpphdl_channel(V(cpphdl_n2329, cpphdl_n2310), V(cpphdl_n2325, cpphdl_n2310), 0.0040000000000000001, 0.69999999999999996, 1.0);
        // device 1627, IC IC284, analog/basic/strongarm_comparator.hpp:34
        I(cpphdl_n2329, cpphdl_n2311) <+ cpphdl_channel(V(cpphdl_n2325, cpphdl_n2311), V(cpphdl_n2329, cpphdl_n2311), 0.0040000000000000001, 0.69999999999999996, 1.0);
        // device 1628, IC IC284, analog/basic/strongarm_comparator.hpp:35
        I(cpphdl_n2329, Vdd) <+ cpphdl_channel(V(cpphdl_n2325, Vdd), V(cpphdl_n2329, Vdd), 0.002, 0.69999999999999996, -1.0);
        // device 1629, IC IC284, analog/basic/strongarm_comparator.hpp:36
        I(cpphdl_n2325, Vdd) <+ cpphdl_channel(V(cpphdl_n2329, Vdd), V(cpphdl_n2325, Vdd), 0.002, 0.69999999999999996, -1.0);
        // device 1630, IC IC284, analog/basic/strongarm_comparator.hpp:38
        I(cpphdl_n2310, Vdd) <+ cpphdl_channel(V(EVALUATE, Vdd), V(cpphdl_n2310, Vdd), 0.002, 0.69999999999999996, -1.0);
        // device 1631, IC IC284, analog/basic/strongarm_comparator.hpp:39
        I(cpphdl_n2311, Vdd) <+ cpphdl_channel(V(EVALUATE, Vdd), V(cpphdl_n2311, Vdd), 0.002, 0.69999999999999996, -1.0);
        // device 1632, IC IC284, analog/basic/strongarm_comparator.hpp:40
        I(cpphdl_n2329, Vdd) <+ cpphdl_channel(V(EVALUATE, Vdd), V(cpphdl_n2329, Vdd), 0.002, 0.69999999999999996, -1.0);
        // device 1633, IC IC284, analog/basic/strongarm_comparator.hpp:41
        I(cpphdl_n2325, Vdd) <+ cpphdl_channel(V(EVALUATE, Vdd), V(cpphdl_n2325, Vdd), 0.002, 0.69999999999999996, -1.0);
        // device 1634, IC IC284, analog/basic/strongarm_comparator.hpp:42
        I(cpphdl_n2310, Vss) <+ 2.9999999999999998e-14 * ddt(V(cpphdl_n2310, Vss)); // Bench initial voltage = 0.0 V.
        // device 1635, IC IC284, analog/basic/strongarm_comparator.hpp:43
        I(cpphdl_n2311, Vss) <+ 2.9999999999999998e-14 * ddt(V(cpphdl_n2311, Vss)); // Bench initial voltage = 0.0 V.
        // device 1636, IC IC284, analog/basic/strongarm_comparator.hpp:44
        I(cpphdl_n2312, Vss) <+ 2.9999999999999998e-14 * ddt(V(cpphdl_n2312, Vss)); // Bench initial voltage = 0.0 V.
        // device 1637, IC IC284, analog/basic/strongarm_comparator.hpp:45
        I(cpphdl_n2329, Vss) <+ 5.0000000000000002e-14 * ddt(V(cpphdl_n2329, Vss)); // Bench initial voltage = 0.0 V.
        // device 1638, IC IC284, analog/basic/strongarm_comparator.hpp:46
        I(cpphdl_n2325, Vss) <+ 5.0000000000000002e-14 * ddt(V(cpphdl_n2325, Vss)); // Bench initial voltage = 0.0 V.
        // device 1639, IC IC284, analog/basic/strongarm_comparator.hpp:47
        I(cpphdl_n2305, cpphdl_n2312) <+ 2e-14 * ddt(V(cpphdl_n2305, cpphdl_n2312)); // Bench initial voltage = 0.0 V.
        // device 1640, IC IC284, analog/basic/strongarm_comparator.hpp:48
        I(cpphdl_n2306, cpphdl_n2312) <+ 2e-14 * ddt(V(cpphdl_n2306, cpphdl_n2312)); // Bench initial voltage = 0.0 V.
        // device 1641, IC IC284, analog/basic/strongarm_comparator.hpp:49
        I(cpphdl_n2305, cpphdl_n2310) <+ 2.9999999999999998e-15 * ddt(V(cpphdl_n2305, cpphdl_n2310)); // Bench initial voltage = 0.0 V.
        // device 1642, IC IC284, analog/basic/strongarm_comparator.hpp:50
        I(cpphdl_n2306, cpphdl_n2311) <+ 2.9999999999999998e-15 * ddt(V(cpphdl_n2306, cpphdl_n2311)); // Bench initial voltage = 0.0 V.
        // device 1643, IC IC286, analog/basic/inverter.hpp:11
        I(cpphdl_n2333, Vdd) <+ cpphdl_channel(V(cpphdl_n2325, Vdd), V(cpphdl_n2333, Vdd), 0.001, 0.69999999999999996, -1.0);
        // device 1644, IC IC286, analog/basic/inverter.hpp:12
        I(cpphdl_n2333, Vss) <+ cpphdl_channel(V(cpphdl_n2325, Vss), V(cpphdl_n2333, Vss), 0.001, 0.69999999999999996, 1.0);
        // device 1645, IC IC288, analog/basic/inverter.hpp:11
        I(cpphdl_n2347, Vdd) <+ cpphdl_channel(V(cpphdl_n2333, Vdd), V(cpphdl_n2347, Vdd), 0.0040000000000000001, 0.69999999999999996, -1.0);
        // device 1646, IC IC288, analog/basic/inverter.hpp:12
        I(cpphdl_n2347, Vss) <+ cpphdl_channel(V(cpphdl_n2333, Vss), V(cpphdl_n2347, Vss), 0.0040000000000000001, 0.69999999999999996, 1.0);
        // device 1647, IC IC285, analog/basic/buffered_nand_latch.hpp:34
        I(cpphdl_n2325, Vss) <+ 2.0000000000000002e-15 * ddt(V(cpphdl_n2325, Vss)); // Bench initial voltage = 0.0 V.
        // device 1648, IC IC285, analog/basic/buffered_nand_latch.hpp:35
        I(cpphdl_n2325, cpphdl_n2333) <+ 1.0000000000000001e-15 * ddt(V(cpphdl_n2325, cpphdl_n2333)); // Bench initial voltage = 0.0 V.
        // device 1649, IC IC285, analog/basic/buffered_nand_latch.hpp:36
        I(cpphdl_n2333, Vss) <+ 5e-15 * ddt(V(cpphdl_n2333, Vss)); // Bench initial voltage = 0.0 V.
        // device 1650, IC IC285, analog/basic/buffered_nand_latch.hpp:37
        I(cpphdl_n2333, Vss) <+ 8.0000000000000006e-15 * ddt(V(cpphdl_n2333, Vss)); // Bench initial voltage = 0.0 V.
        // device 1651, IC IC285, analog/basic/buffered_nand_latch.hpp:38
        I(cpphdl_n2347, Vss) <+ 1e-14 * ddt(V(cpphdl_n2347, Vss)); // Bench initial voltage = 0.0 V.
        // device 1652, IC IC287, analog/basic/inverter.hpp:11
        I(cpphdl_n2337, Vdd) <+ cpphdl_channel(V(cpphdl_n2329, Vdd), V(cpphdl_n2337, Vdd), 0.001, 0.69999999999999996, -1.0);
        // device 1653, IC IC287, analog/basic/inverter.hpp:12
        I(cpphdl_n2337, Vss) <+ cpphdl_channel(V(cpphdl_n2329, Vss), V(cpphdl_n2337, Vss), 0.001, 0.69999999999999996, 1.0);
        // device 1654, IC IC289, analog/basic/inverter.hpp:11
        I(cpphdl_n2353, Vdd) <+ cpphdl_channel(V(cpphdl_n2337, Vdd), V(cpphdl_n2353, Vdd), 0.0040000000000000001, 0.69999999999999996, -1.0);
        // device 1655, IC IC289, analog/basic/inverter.hpp:12
        I(cpphdl_n2353, Vss) <+ cpphdl_channel(V(cpphdl_n2337, Vss), V(cpphdl_n2353, Vss), 0.0040000000000000001, 0.69999999999999996, 1.0);
        // device 1656, IC IC285, analog/basic/buffered_nand_latch.hpp:34
        I(cpphdl_n2329, Vss) <+ 2.0000000000000002e-15 * ddt(V(cpphdl_n2329, Vss)); // Bench initial voltage = 0.0 V.
        // device 1657, IC IC285, analog/basic/buffered_nand_latch.hpp:35
        I(cpphdl_n2329, cpphdl_n2337) <+ 1.0000000000000001e-15 * ddt(V(cpphdl_n2329, cpphdl_n2337)); // Bench initial voltage = 0.0 V.
        // device 1658, IC IC285, analog/basic/buffered_nand_latch.hpp:36
        I(cpphdl_n2337, Vss) <+ 5e-15 * ddt(V(cpphdl_n2337, Vss)); // Bench initial voltage = 0.0 V.
        // device 1659, IC IC285, analog/basic/buffered_nand_latch.hpp:37
        I(cpphdl_n2337, Vss) <+ 8.0000000000000006e-15 * ddt(V(cpphdl_n2337, Vss)); // Bench initial voltage = 0.0 V.
        // device 1660, IC IC285, analog/basic/buffered_nand_latch.hpp:38
        I(cpphdl_n2353, Vss) <+ 1e-14 * ddt(V(cpphdl_n2353, Vss)); // Bench initial voltage = 0.0 V.
        // device 1661, IC IC291, analog/basic/cmos_logic.hpp:17
        I(cpphdl_n3008, Vss) <+ 5.0000000000000002e-14 * ddt(V(cpphdl_n3008, Vss)); // Bench initial voltage = 0.0 V.
        // device 1662, IC IC291, analog/basic/cmos_logic.hpp:18
        I(cpphdl_n3008, Vdd) <+ cpphdl_channel(V(cpphdl_n2347, Vdd), V(cpphdl_n3008, Vdd), 0.01, 0.69999999999999996, -1.0);
        // device 1663, IC IC291, analog/basic/cmos_logic.hpp:19
        I(cpphdl_n3008, Vdd) <+ cpphdl_channel(V(cpphdl_n2355, Vdd), V(cpphdl_n3008, Vdd), 0.01, 0.69999999999999996, -1.0);
        // device 1664, IC IC291, analog/basic/cmos_logic.hpp:20
        I(cpphdl_n3008, cpphdl_n2350) <+ cpphdl_channel(V(cpphdl_n2347, cpphdl_n2350), V(cpphdl_n3008, cpphdl_n2350), 0.01, 0.69999999999999996, 1.0);
        // device 1665, IC IC291, analog/basic/cmos_logic.hpp:21
        I(cpphdl_n2350, Vss) <+ cpphdl_channel(V(cpphdl_n2355, Vss), V(cpphdl_n2350, Vss), 0.01, 0.69999999999999996, 1.0);
        // device 1666, IC IC291, analog/basic/cmos_logic.hpp:27
        I(cpphdl_n2350, Vss) <+ 1e-14 * ddt(V(cpphdl_n2350, Vss)); // Bench initial voltage = 0.0 V.
        // device 1667, IC IC292, analog/basic/cmos_logic.hpp:17
        I(cpphdl_n2355, Vss) <+ 5.0000000000000002e-14 * ddt(V(cpphdl_n2355, Vss)); // Bench initial voltage = 0.0 V.
        // device 1668, IC IC292, analog/basic/cmos_logic.hpp:18
        I(cpphdl_n2355, Vdd) <+ cpphdl_channel(V(cpphdl_n2353, Vdd), V(cpphdl_n2355, Vdd), 0.01, 0.69999999999999996, -1.0);
        // device 1669, IC IC292, analog/basic/cmos_logic.hpp:19
        I(cpphdl_n2355, Vdd) <+ cpphdl_channel(V(cpphdl_n3008, Vdd), V(cpphdl_n2355, Vdd), 0.01, 0.69999999999999996, -1.0);
        // device 1670, IC IC292, analog/basic/cmos_logic.hpp:20
        I(cpphdl_n2355, cpphdl_n2356) <+ cpphdl_channel(V(cpphdl_n2353, cpphdl_n2356), V(cpphdl_n2355, cpphdl_n2356), 0.01, 0.69999999999999996, 1.0);
        // device 1671, IC IC292, analog/basic/cmos_logic.hpp:21
        I(cpphdl_n2356, Vss) <+ cpphdl_channel(V(cpphdl_n3008, Vss), V(cpphdl_n2356, Vss), 0.01, 0.69999999999999996, 1.0);
        // device 1672, IC IC292, analog/basic/cmos_logic.hpp:27
        I(cpphdl_n2356, Vss) <+ 1e-14 * ddt(V(cpphdl_n2356, Vss)); // Bench initial voltage = 0.0 V.
        // device 1673, IC IC290, analog/basic/nand_latch.hpp:36
        I(cpphdl_n2347, Vss) <+ 2.9999999999999998e-15 * ddt(V(cpphdl_n2347, Vss)); // Bench initial voltage = 0.0 V.
        // device 1674, IC IC290, analog/basic/nand_latch.hpp:37
        I(cpphdl_n2353, Vss) <+ 2.9999999999999998e-15 * ddt(V(cpphdl_n2353, Vss)); // Bench initial voltage = 0.0 V.
        // device 1675, IC IC293, analog/basic/inverter.hpp:11
        I(cpphdl_n2361, Vdd) <+ cpphdl_channel(V(CLEAR, Vdd), V(cpphdl_n2361, Vdd), 0.01, 0.69999999999999996, -1.0);
        // device 1676, IC IC293, analog/basic/inverter.hpp:12
        I(cpphdl_n2361, Vss) <+ cpphdl_channel(V(CLEAR, Vss), V(cpphdl_n2361, Vss), 0.01, 0.69999999999999996, 1.0);
        // device 1677, IC IC290, analog/basic/nand_latch.hpp:58
        I(cpphdl_n2361, Vss) <+ 2.9999999999999998e-15 * ddt(V(cpphdl_n2361, Vss)); // Bench initial voltage = 0.0 V.
        // device 1678, IC IC290, analog/basic/nand_latch.hpp:59
        I(cpphdl_n3008, Vss) <+ cpphdl_channel(V(CLEAR, Vss), V(cpphdl_n3008, Vss), 0.050000000000000003, 0.69999999999999996, 1.0);
        // device 1679, IC IC290, analog/basic/nand_latch.hpp:60
        I(cpphdl_n2355, Vdd) <+ cpphdl_channel(V(cpphdl_n2361, Vdd), V(cpphdl_n2355, Vdd), 0.050000000000000003, 0.69999999999999996, -1.0);
        // device 1680, IC IC296, analog/basic/inverter.hpp:11
        I(cpphdl_n2385, Vdd) <+ cpphdl_channel(V(TRACK12, Vdd), V(cpphdl_n2385, Vdd), 0.0040000000000000001, 0.69999999999999996, -1.0);
        // device 1681, IC IC296, analog/basic/inverter.hpp:12
        I(cpphdl_n2385, Vss) <+ cpphdl_channel(V(TRACK12, Vss), V(cpphdl_n2385, Vss), 0.0040000000000000001, 0.69999999999999996, 1.0);
        // device 1682, IC IC295, analog/basic/mos_track_hold.hpp:31
        I(cpphdl_n2385, Vss) <+ 2e-14 * ddt(V(cpphdl_n2385, Vss)); // Bench initial voltage = 0.0 V.
        // device 1683, IC IC295, analog/basic/mos_track_hold.hpp:32
        I(cpphdl_n2808, cpphdl_n2439) <+ cpphdl_channel(V(TRACK12, cpphdl_n2439), V(cpphdl_n2808, cpphdl_n2439), 0.029999999999999999, 0.69999999999999996, 1.0);
        // device 1684, IC IC295, analog/basic/mos_track_hold.hpp:33
        I(cpphdl_n2439, cpphdl_n2808) <+ cpphdl_channel(V(cpphdl_n2385, cpphdl_n2808), V(cpphdl_n2439, cpphdl_n2808), 0.014999999999999999, 0.69999999999999996, -1.0);
        // device 1685, IC IC295, analog/basic/mos_track_hold.hpp:37
        I(cpphdl_n2439, cpphdl_n2439) <+ cpphdl_channel(V(cpphdl_n2385, cpphdl_n2439), V(cpphdl_n2439, cpphdl_n2439), 0.016, 0.69999999999999996, 1.0);
        // device 1686, IC IC295, analog/basic/mos_track_hold.hpp:38
        I(cpphdl_n2439, cpphdl_n2439) <+ cpphdl_channel(V(TRACK12, cpphdl_n2439), V(cpphdl_n2439, cpphdl_n2439), 0.0083999999999999995, 0.69999999999999996, -1.0);
        // device 1687, IC IC295, analog/basic/mos_track_hold.hpp:39
        I(cpphdl_n2439, Vss) <+ 1.5000000000000001e-12 * ddt(V(cpphdl_n2439, Vss)); // Bench initial voltage = 0.0 V.
        // device 1688, IC IC295, analog/basic/mos_track_hold.hpp:42
        I(TRACK12, cpphdl_n2439) <+ 2.0000000000000002e-15 * ddt(V(TRACK12, cpphdl_n2439)); // Bench initial voltage = -0.0 V.
        // device 1689, IC IC295, analog/basic/mos_track_hold.hpp:43
        I(cpphdl_n2385, cpphdl_n2439) <+ 2.0000000000000002e-15 * ddt(V(cpphdl_n2385, cpphdl_n2439)); // Bench initial voltage = 0.0 V.
        // device 1690, IC IC295, analog/basic/mos_track_hold.hpp:44
        I(cpphdl_n2808, cpphdl_n2439) <+ 1.0000000000000001e-15 * ddt(V(cpphdl_n2808, cpphdl_n2439)); // Bench initial voltage = 0.0 V.
        // device 1691, IC IC298, analog/basic/inverter.hpp:11
        I(cpphdl_n2400, Vdd) <+ cpphdl_channel(V(BIT_N12_0, Vdd), V(cpphdl_n2400, Vdd), 0.080000000000000002, 0.69999999999999996, -1.0);
        // device 1692, IC IC298, analog/basic/inverter.hpp:12
        I(cpphdl_n2400, Vss) <+ cpphdl_channel(V(BIT_N12_0, Vss), V(cpphdl_n2400, Vss), 0.080000000000000002, 0.69999999999999996, 1.0);
        // device 1693, IC IC297, analog/basic/mos_r2r_dac.hpp:27
        I(cpphdl_n2400, Vss) <+ 2.9999999999999998e-15 * ddt(V(cpphdl_n2400, Vss)); // Bench initial voltage = 0.0 V.
        // device 1694, IC IC297, analog/basic/mos_r2r_dac.hpp:28
        I(cpphdl_n2400, cpphdl_n2429) <+ V(cpphdl_n2400, cpphdl_n2429) / 2000.0;
        // device 1695, IC IC297, analog/basic/mos_r2r_dac.hpp:29
        I(cpphdl_n2429, Vss) <+ 2.9999999999999998e-15 * ddt(V(cpphdl_n2429, Vss)); // Bench initial voltage = 0.0 V.
        // device 1696, IC IC299, analog/basic/inverter.hpp:11
        I(cpphdl_n2404, Vdd) <+ cpphdl_channel(V(BIT_N12_1, Vdd), V(cpphdl_n2404, Vdd), 0.080000000000000002, 0.69999999999999996, -1.0);
        // device 1697, IC IC299, analog/basic/inverter.hpp:12
        I(cpphdl_n2404, Vss) <+ cpphdl_channel(V(BIT_N12_1, Vss), V(cpphdl_n2404, Vss), 0.080000000000000002, 0.69999999999999996, 1.0);
        // device 1698, IC IC297, analog/basic/mos_r2r_dac.hpp:27
        I(cpphdl_n2404, Vss) <+ 2.9999999999999998e-15 * ddt(V(cpphdl_n2404, Vss)); // Bench initial voltage = 0.0 V.
        // device 1699, IC IC297, analog/basic/mos_r2r_dac.hpp:28
        I(cpphdl_n2404, cpphdl_n2430) <+ V(cpphdl_n2404, cpphdl_n2430) / 2000.0;
        // device 1700, IC IC297, analog/basic/mos_r2r_dac.hpp:29
        I(cpphdl_n2430, Vss) <+ 2.9999999999999998e-15 * ddt(V(cpphdl_n2430, Vss)); // Bench initial voltage = 0.0 V.
        // device 1701, IC IC297, analog/basic/mos_r2r_dac.hpp:31
        I(cpphdl_n2429, cpphdl_n2430) <+ V(cpphdl_n2429, cpphdl_n2430) / 1000.0;
        // device 1702, IC IC300, analog/basic/inverter.hpp:11
        I(cpphdl_n2408, Vdd) <+ cpphdl_channel(V(BIT_N12_2, Vdd), V(cpphdl_n2408, Vdd), 0.080000000000000002, 0.69999999999999996, -1.0);
        // device 1703, IC IC300, analog/basic/inverter.hpp:12
        I(cpphdl_n2408, Vss) <+ cpphdl_channel(V(BIT_N12_2, Vss), V(cpphdl_n2408, Vss), 0.080000000000000002, 0.69999999999999996, 1.0);
        // device 1704, IC IC297, analog/basic/mos_r2r_dac.hpp:27
        I(cpphdl_n2408, Vss) <+ 2.9999999999999998e-15 * ddt(V(cpphdl_n2408, Vss)); // Bench initial voltage = 0.0 V.
        // device 1705, IC IC297, analog/basic/mos_r2r_dac.hpp:28
        I(cpphdl_n2408, cpphdl_n2431) <+ V(cpphdl_n2408, cpphdl_n2431) / 2000.0;
        // device 1706, IC IC297, analog/basic/mos_r2r_dac.hpp:29
        I(cpphdl_n2431, Vss) <+ 2.9999999999999998e-15 * ddt(V(cpphdl_n2431, Vss)); // Bench initial voltage = 0.0 V.
        // device 1707, IC IC297, analog/basic/mos_r2r_dac.hpp:31
        I(cpphdl_n2430, cpphdl_n2431) <+ V(cpphdl_n2430, cpphdl_n2431) / 1000.0;
        // device 1708, IC IC301, analog/basic/inverter.hpp:11
        I(cpphdl_n2412, Vdd) <+ cpphdl_channel(V(BIT_N12_3, Vdd), V(cpphdl_n2412, Vdd), 0.080000000000000002, 0.69999999999999996, -1.0);
        // device 1709, IC IC301, analog/basic/inverter.hpp:12
        I(cpphdl_n2412, Vss) <+ cpphdl_channel(V(BIT_N12_3, Vss), V(cpphdl_n2412, Vss), 0.080000000000000002, 0.69999999999999996, 1.0);
        // device 1710, IC IC297, analog/basic/mos_r2r_dac.hpp:27
        I(cpphdl_n2412, Vss) <+ 2.9999999999999998e-15 * ddt(V(cpphdl_n2412, Vss)); // Bench initial voltage = 0.0 V.
        // device 1711, IC IC297, analog/basic/mos_r2r_dac.hpp:28
        I(cpphdl_n2412, cpphdl_n2432) <+ V(cpphdl_n2412, cpphdl_n2432) / 2000.0;
        // device 1712, IC IC297, analog/basic/mos_r2r_dac.hpp:29
        I(cpphdl_n2432, Vss) <+ 2.9999999999999998e-15 * ddt(V(cpphdl_n2432, Vss)); // Bench initial voltage = 0.0 V.
        // device 1713, IC IC297, analog/basic/mos_r2r_dac.hpp:31
        I(cpphdl_n2431, cpphdl_n2432) <+ V(cpphdl_n2431, cpphdl_n2432) / 1000.0;
        // device 1714, IC IC302, analog/basic/inverter.hpp:11
        I(cpphdl_n2416, Vdd) <+ cpphdl_channel(V(BIT_N12_4, Vdd), V(cpphdl_n2416, Vdd), 0.080000000000000002, 0.69999999999999996, -1.0);
        // device 1715, IC IC302, analog/basic/inverter.hpp:12
        I(cpphdl_n2416, Vss) <+ cpphdl_channel(V(BIT_N12_4, Vss), V(cpphdl_n2416, Vss), 0.080000000000000002, 0.69999999999999996, 1.0);
        // device 1716, IC IC297, analog/basic/mos_r2r_dac.hpp:27
        I(cpphdl_n2416, Vss) <+ 2.9999999999999998e-15 * ddt(V(cpphdl_n2416, Vss)); // Bench initial voltage = 0.0 V.
        // device 1717, IC IC297, analog/basic/mos_r2r_dac.hpp:28
        I(cpphdl_n2416, cpphdl_n2433) <+ V(cpphdl_n2416, cpphdl_n2433) / 2000.0;
        // device 1718, IC IC297, analog/basic/mos_r2r_dac.hpp:29
        I(cpphdl_n2433, Vss) <+ 2.9999999999999998e-15 * ddt(V(cpphdl_n2433, Vss)); // Bench initial voltage = 0.0 V.
        // device 1719, IC IC297, analog/basic/mos_r2r_dac.hpp:31
        I(cpphdl_n2432, cpphdl_n2433) <+ V(cpphdl_n2432, cpphdl_n2433) / 1000.0;
        // device 1720, IC IC303, analog/basic/inverter.hpp:11
        I(cpphdl_n2420, Vdd) <+ cpphdl_channel(V(BIT_N12_5, Vdd), V(cpphdl_n2420, Vdd), 0.080000000000000002, 0.69999999999999996, -1.0);
        // device 1721, IC IC303, analog/basic/inverter.hpp:12
        I(cpphdl_n2420, Vss) <+ cpphdl_channel(V(BIT_N12_5, Vss), V(cpphdl_n2420, Vss), 0.080000000000000002, 0.69999999999999996, 1.0);
        // device 1722, IC IC297, analog/basic/mos_r2r_dac.hpp:27
        I(cpphdl_n2420, Vss) <+ 2.9999999999999998e-15 * ddt(V(cpphdl_n2420, Vss)); // Bench initial voltage = 0.0 V.
        // device 1723, IC IC297, analog/basic/mos_r2r_dac.hpp:28
        I(cpphdl_n2420, cpphdl_n2434) <+ V(cpphdl_n2420, cpphdl_n2434) / 2000.0;
        // device 1724, IC IC297, analog/basic/mos_r2r_dac.hpp:29
        I(cpphdl_n2434, Vss) <+ 2.9999999999999998e-15 * ddt(V(cpphdl_n2434, Vss)); // Bench initial voltage = 0.0 V.
        // device 1725, IC IC297, analog/basic/mos_r2r_dac.hpp:31
        I(cpphdl_n2433, cpphdl_n2434) <+ V(cpphdl_n2433, cpphdl_n2434) / 1000.0;
        // device 1726, IC IC304, analog/basic/inverter.hpp:11
        I(cpphdl_n2424, Vdd) <+ cpphdl_channel(V(BIT_N12_6, Vdd), V(cpphdl_n2424, Vdd), 0.080000000000000002, 0.69999999999999996, -1.0);
        // device 1727, IC IC304, analog/basic/inverter.hpp:12
        I(cpphdl_n2424, Vss) <+ cpphdl_channel(V(BIT_N12_6, Vss), V(cpphdl_n2424, Vss), 0.080000000000000002, 0.69999999999999996, 1.0);
        // device 1728, IC IC297, analog/basic/mos_r2r_dac.hpp:27
        I(cpphdl_n2424, Vss) <+ 2.9999999999999998e-15 * ddt(V(cpphdl_n2424, Vss)); // Bench initial voltage = 0.0 V.
        // device 1729, IC IC297, analog/basic/mos_r2r_dac.hpp:28
        I(cpphdl_n2424, cpphdl_n2435) <+ V(cpphdl_n2424, cpphdl_n2435) / 2000.0;
        // device 1730, IC IC297, analog/basic/mos_r2r_dac.hpp:29
        I(cpphdl_n2435, Vss) <+ 2.9999999999999998e-15 * ddt(V(cpphdl_n2435, Vss)); // Bench initial voltage = 0.0 V.
        // device 1731, IC IC297, analog/basic/mos_r2r_dac.hpp:31
        I(cpphdl_n2434, cpphdl_n2435) <+ V(cpphdl_n2434, cpphdl_n2435) / 1000.0;
        // device 1732, IC IC305, analog/basic/inverter.hpp:11
        I(cpphdl_n2428, Vdd) <+ cpphdl_channel(V(BIT_N12_7, Vdd), V(cpphdl_n2428, Vdd), 0.080000000000000002, 0.69999999999999996, -1.0);
        // device 1733, IC IC305, analog/basic/inverter.hpp:12
        I(cpphdl_n2428, Vss) <+ cpphdl_channel(V(BIT_N12_7, Vss), V(cpphdl_n2428, Vss), 0.080000000000000002, 0.69999999999999996, 1.0);
        // device 1734, IC IC297, analog/basic/mos_r2r_dac.hpp:27
        I(cpphdl_n2428, Vss) <+ 2.9999999999999998e-15 * ddt(V(cpphdl_n2428, Vss)); // Bench initial voltage = 0.0 V.
        // device 1735, IC IC297, analog/basic/mos_r2r_dac.hpp:28
        I(cpphdl_n2428, cpphdl_n2440) <+ V(cpphdl_n2428, cpphdl_n2440) / 2000.0;
        // device 1736, IC IC297, analog/basic/mos_r2r_dac.hpp:29
        I(cpphdl_n2440, Vss) <+ 2.9999999999999998e-15 * ddt(V(cpphdl_n2440, Vss)); // Bench initial voltage = 0.0 V.
        // device 1737, IC IC297, analog/basic/mos_r2r_dac.hpp:31
        I(cpphdl_n2435, cpphdl_n2440) <+ V(cpphdl_n2435, cpphdl_n2440) / 1000.0;
        // device 1738, IC IC297, analog/basic/mos_r2r_dac.hpp:33
        I(Vss, cpphdl_n2429) <+ V(Vss, cpphdl_n2429) / 2000.0;
        // device 1739, IC IC306, analog/basic/nmos_resistor_amplifier.hpp:23
        I(Vdd, cpphdl_n2449) <+ V(Vdd, cpphdl_n2449) / 1000.0;
        // device 1740, IC IC306, analog/basic/nmos_resistor_amplifier.hpp:24
        I(Vdd, cpphdl_n2448) <+ V(Vdd, cpphdl_n2448) / 1000.0;
        // device 1741, IC IC306, analog/basic/nmos_resistor_amplifier.hpp:25
        I(cpphdl_n2449, cpphdl_n2443) <+ cpphdl_channel(V(cpphdl_n2439, cpphdl_n2443), V(cpphdl_n2449, cpphdl_n2443), 0.0074999999999999997, 0.69999999999999996, 1.0);
        // device 1742, IC IC306, analog/basic/nmos_resistor_amplifier.hpp:26
        I(cpphdl_n2448, cpphdl_n2444) <+ cpphdl_channel(V(cpphdl_n2440, cpphdl_n2444), V(cpphdl_n2448, cpphdl_n2444), 0.0074999999999999997, 0.69999999999999996, 1.0);
        // device 1743, IC IC306, analog/basic/nmos_resistor_amplifier.hpp:27
        I(cpphdl_n2445, cpphdl_n2443) <+ V(cpphdl_n2445, cpphdl_n2443) / 100.0;
        // device 1744, IC IC306, analog/basic/nmos_resistor_amplifier.hpp:28
        I(cpphdl_n2445, cpphdl_n2444) <+ V(cpphdl_n2445, cpphdl_n2444) / 100.0;
        // device 1745, IC IC306, analog/basic/nmos_resistor_amplifier.hpp:29
        I(Vss, cpphdl_n2445) <+ V(Vss, cpphdl_n2445) / 300.0;
        // device 1746, IC IC306, analog/basic/nmos_resistor_amplifier.hpp:30
        I(cpphdl_n2449, Vdd) <+ 2.9999999999999998e-13 * ddt(V(cpphdl_n2449, Vdd)); // Bench initial voltage = 0.0 V.
        // device 1747, IC IC306, analog/basic/nmos_resistor_amplifier.hpp:31
        I(cpphdl_n2448, Vdd) <+ 2.9999999999999998e-13 * ddt(V(cpphdl_n2448, Vdd)); // Bench initial voltage = 0.0 V.
        // device 1748, IC IC306, analog/basic/nmos_resistor_amplifier.hpp:32
        I(cpphdl_n2445, Vss) <+ 4e-14 * ddt(V(cpphdl_n2445, Vss)); // Bench initial voltage = 0.0 V.
        // device 1749, IC IC306, analog/basic/nmos_resistor_amplifier.hpp:34
        I(cpphdl_n2439, cpphdl_n2443) <+ 2e-14 * ddt(V(cpphdl_n2439, cpphdl_n2443)); // Bench initial voltage = 0.0 V.
        // device 1750, IC IC306, analog/basic/nmos_resistor_amplifier.hpp:35
        I(cpphdl_n2440, cpphdl_n2444) <+ 2e-14 * ddt(V(cpphdl_n2440, cpphdl_n2444)); // Bench initial voltage = 0.0 V.
        // device 1751, IC IC306, analog/basic/nmos_resistor_amplifier.hpp:36
        I(cpphdl_n2439, cpphdl_n2449) <+ 2.9999999999999998e-15 * ddt(V(cpphdl_n2439, cpphdl_n2449)); // Bench initial voltage = 0.0 V.
        // device 1752, IC IC306, analog/basic/nmos_resistor_amplifier.hpp:37
        I(cpphdl_n2440, cpphdl_n2448) <+ 2.9999999999999998e-15 * ddt(V(cpphdl_n2440, cpphdl_n2448)); // Bench initial voltage = 0.0 V.
        // device 1753, IC IC307, analog/basic/strongarm_comparator.hpp:28
        I(cpphdl_n2453, cpphdl_n2455) <+ cpphdl_channel(V(cpphdl_n2448, cpphdl_n2455), V(cpphdl_n2453, cpphdl_n2455), 0.0080000000000000002, 0.69999999999999996, 1.0);
        // device 1754, IC IC307, analog/basic/strongarm_comparator.hpp:29
        I(cpphdl_n2454, cpphdl_n2455) <+ cpphdl_channel(V(cpphdl_n2449, cpphdl_n2455), V(cpphdl_n2454, cpphdl_n2455), 0.0080000000000000002, 0.69999999999999996, 1.0);
        // device 1755, IC IC307, analog/basic/strongarm_comparator.hpp:30
        I(cpphdl_n2455, Vss) <+ cpphdl_channel(V(EVALUATE, Vss), V(cpphdl_n2455, Vss), 0.0080000000000000002, 0.69999999999999996, 1.0);
        // device 1756, IC IC307, analog/basic/strongarm_comparator.hpp:33
        I(cpphdl_n2468, cpphdl_n2453) <+ cpphdl_channel(V(cpphdl_n2472, cpphdl_n2453), V(cpphdl_n2468, cpphdl_n2453), 0.0040000000000000001, 0.69999999999999996, 1.0);
        // device 1757, IC IC307, analog/basic/strongarm_comparator.hpp:34
        I(cpphdl_n2472, cpphdl_n2454) <+ cpphdl_channel(V(cpphdl_n2468, cpphdl_n2454), V(cpphdl_n2472, cpphdl_n2454), 0.0040000000000000001, 0.69999999999999996, 1.0);
        // device 1758, IC IC307, analog/basic/strongarm_comparator.hpp:35
        I(cpphdl_n2472, Vdd) <+ cpphdl_channel(V(cpphdl_n2468, Vdd), V(cpphdl_n2472, Vdd), 0.002, 0.69999999999999996, -1.0);
        // device 1759, IC IC307, analog/basic/strongarm_comparator.hpp:36
        I(cpphdl_n2468, Vdd) <+ cpphdl_channel(V(cpphdl_n2472, Vdd), V(cpphdl_n2468, Vdd), 0.002, 0.69999999999999996, -1.0);
        // device 1760, IC IC307, analog/basic/strongarm_comparator.hpp:38
        I(cpphdl_n2453, Vdd) <+ cpphdl_channel(V(EVALUATE, Vdd), V(cpphdl_n2453, Vdd), 0.002, 0.69999999999999996, -1.0);
        // device 1761, IC IC307, analog/basic/strongarm_comparator.hpp:39
        I(cpphdl_n2454, Vdd) <+ cpphdl_channel(V(EVALUATE, Vdd), V(cpphdl_n2454, Vdd), 0.002, 0.69999999999999996, -1.0);
        // device 1762, IC IC307, analog/basic/strongarm_comparator.hpp:40
        I(cpphdl_n2472, Vdd) <+ cpphdl_channel(V(EVALUATE, Vdd), V(cpphdl_n2472, Vdd), 0.002, 0.69999999999999996, -1.0);
        // device 1763, IC IC307, analog/basic/strongarm_comparator.hpp:41
        I(cpphdl_n2468, Vdd) <+ cpphdl_channel(V(EVALUATE, Vdd), V(cpphdl_n2468, Vdd), 0.002, 0.69999999999999996, -1.0);
        // device 1764, IC IC307, analog/basic/strongarm_comparator.hpp:42
        I(cpphdl_n2453, Vss) <+ 2.9999999999999998e-14 * ddt(V(cpphdl_n2453, Vss)); // Bench initial voltage = 0.0 V.
        // device 1765, IC IC307, analog/basic/strongarm_comparator.hpp:43
        I(cpphdl_n2454, Vss) <+ 2.9999999999999998e-14 * ddt(V(cpphdl_n2454, Vss)); // Bench initial voltage = 0.0 V.
        // device 1766, IC IC307, analog/basic/strongarm_comparator.hpp:44
        I(cpphdl_n2455, Vss) <+ 2.9999999999999998e-14 * ddt(V(cpphdl_n2455, Vss)); // Bench initial voltage = 0.0 V.
        // device 1767, IC IC307, analog/basic/strongarm_comparator.hpp:45
        I(cpphdl_n2472, Vss) <+ 5.0000000000000002e-14 * ddt(V(cpphdl_n2472, Vss)); // Bench initial voltage = 0.0 V.
        // device 1768, IC IC307, analog/basic/strongarm_comparator.hpp:46
        I(cpphdl_n2468, Vss) <+ 5.0000000000000002e-14 * ddt(V(cpphdl_n2468, Vss)); // Bench initial voltage = 0.0 V.
        // device 1769, IC IC307, analog/basic/strongarm_comparator.hpp:47
        I(cpphdl_n2448, cpphdl_n2455) <+ 2e-14 * ddt(V(cpphdl_n2448, cpphdl_n2455)); // Bench initial voltage = 0.0 V.
        // device 1770, IC IC307, analog/basic/strongarm_comparator.hpp:48
        I(cpphdl_n2449, cpphdl_n2455) <+ 2e-14 * ddt(V(cpphdl_n2449, cpphdl_n2455)); // Bench initial voltage = 0.0 V.
        // device 1771, IC IC307, analog/basic/strongarm_comparator.hpp:49
        I(cpphdl_n2448, cpphdl_n2453) <+ 2.9999999999999998e-15 * ddt(V(cpphdl_n2448, cpphdl_n2453)); // Bench initial voltage = 0.0 V.
        // device 1772, IC IC307, analog/basic/strongarm_comparator.hpp:50
        I(cpphdl_n2449, cpphdl_n2454) <+ 2.9999999999999998e-15 * ddt(V(cpphdl_n2449, cpphdl_n2454)); // Bench initial voltage = 0.0 V.
        // device 1773, IC IC309, analog/basic/inverter.hpp:11
        I(cpphdl_n2476, Vdd) <+ cpphdl_channel(V(cpphdl_n2468, Vdd), V(cpphdl_n2476, Vdd), 0.001, 0.69999999999999996, -1.0);
        // device 1774, IC IC309, analog/basic/inverter.hpp:12
        I(cpphdl_n2476, Vss) <+ cpphdl_channel(V(cpphdl_n2468, Vss), V(cpphdl_n2476, Vss), 0.001, 0.69999999999999996, 1.0);
        // device 1775, IC IC311, analog/basic/inverter.hpp:11
        I(cpphdl_n2490, Vdd) <+ cpphdl_channel(V(cpphdl_n2476, Vdd), V(cpphdl_n2490, Vdd), 0.0040000000000000001, 0.69999999999999996, -1.0);
        // device 1776, IC IC311, analog/basic/inverter.hpp:12
        I(cpphdl_n2490, Vss) <+ cpphdl_channel(V(cpphdl_n2476, Vss), V(cpphdl_n2490, Vss), 0.0040000000000000001, 0.69999999999999996, 1.0);
        // device 1777, IC IC308, analog/basic/buffered_nand_latch.hpp:34
        I(cpphdl_n2468, Vss) <+ 2.0000000000000002e-15 * ddt(V(cpphdl_n2468, Vss)); // Bench initial voltage = 0.0 V.
        // device 1778, IC IC308, analog/basic/buffered_nand_latch.hpp:35
        I(cpphdl_n2468, cpphdl_n2476) <+ 1.0000000000000001e-15 * ddt(V(cpphdl_n2468, cpphdl_n2476)); // Bench initial voltage = 0.0 V.
        // device 1779, IC IC308, analog/basic/buffered_nand_latch.hpp:36
        I(cpphdl_n2476, Vss) <+ 5e-15 * ddt(V(cpphdl_n2476, Vss)); // Bench initial voltage = 0.0 V.
        // device 1780, IC IC308, analog/basic/buffered_nand_latch.hpp:37
        I(cpphdl_n2476, Vss) <+ 8.0000000000000006e-15 * ddt(V(cpphdl_n2476, Vss)); // Bench initial voltage = 0.0 V.
        // device 1781, IC IC308, analog/basic/buffered_nand_latch.hpp:38
        I(cpphdl_n2490, Vss) <+ 1e-14 * ddt(V(cpphdl_n2490, Vss)); // Bench initial voltage = 0.0 V.
        // device 1782, IC IC310, analog/basic/inverter.hpp:11
        I(cpphdl_n2480, Vdd) <+ cpphdl_channel(V(cpphdl_n2472, Vdd), V(cpphdl_n2480, Vdd), 0.001, 0.69999999999999996, -1.0);
        // device 1783, IC IC310, analog/basic/inverter.hpp:12
        I(cpphdl_n2480, Vss) <+ cpphdl_channel(V(cpphdl_n2472, Vss), V(cpphdl_n2480, Vss), 0.001, 0.69999999999999996, 1.0);
        // device 1784, IC IC312, analog/basic/inverter.hpp:11
        I(cpphdl_n2496, Vdd) <+ cpphdl_channel(V(cpphdl_n2480, Vdd), V(cpphdl_n2496, Vdd), 0.0040000000000000001, 0.69999999999999996, -1.0);
        // device 1785, IC IC312, analog/basic/inverter.hpp:12
        I(cpphdl_n2496, Vss) <+ cpphdl_channel(V(cpphdl_n2480, Vss), V(cpphdl_n2496, Vss), 0.0040000000000000001, 0.69999999999999996, 1.0);
        // device 1786, IC IC308, analog/basic/buffered_nand_latch.hpp:34
        I(cpphdl_n2472, Vss) <+ 2.0000000000000002e-15 * ddt(V(cpphdl_n2472, Vss)); // Bench initial voltage = 0.0 V.
        // device 1787, IC IC308, analog/basic/buffered_nand_latch.hpp:35
        I(cpphdl_n2472, cpphdl_n2480) <+ 1.0000000000000001e-15 * ddt(V(cpphdl_n2472, cpphdl_n2480)); // Bench initial voltage = 0.0 V.
        // device 1788, IC IC308, analog/basic/buffered_nand_latch.hpp:36
        I(cpphdl_n2480, Vss) <+ 5e-15 * ddt(V(cpphdl_n2480, Vss)); // Bench initial voltage = 0.0 V.
        // device 1789, IC IC308, analog/basic/buffered_nand_latch.hpp:37
        I(cpphdl_n2480, Vss) <+ 8.0000000000000006e-15 * ddt(V(cpphdl_n2480, Vss)); // Bench initial voltage = 0.0 V.
        // device 1790, IC IC308, analog/basic/buffered_nand_latch.hpp:38
        I(cpphdl_n2496, Vss) <+ 1e-14 * ddt(V(cpphdl_n2496, Vss)); // Bench initial voltage = 0.0 V.
        // device 1791, IC IC314, analog/basic/cmos_logic.hpp:17
        I(cpphdl_n3013, Vss) <+ 5.0000000000000002e-14 * ddt(V(cpphdl_n3013, Vss)); // Bench initial voltage = 0.0 V.
        // device 1792, IC IC314, analog/basic/cmos_logic.hpp:18
        I(cpphdl_n3013, Vdd) <+ cpphdl_channel(V(cpphdl_n2490, Vdd), V(cpphdl_n3013, Vdd), 0.01, 0.69999999999999996, -1.0);
        // device 1793, IC IC314, analog/basic/cmos_logic.hpp:19
        I(cpphdl_n3013, Vdd) <+ cpphdl_channel(V(cpphdl_n2498, Vdd), V(cpphdl_n3013, Vdd), 0.01, 0.69999999999999996, -1.0);
        // device 1794, IC IC314, analog/basic/cmos_logic.hpp:20
        I(cpphdl_n3013, cpphdl_n2493) <+ cpphdl_channel(V(cpphdl_n2490, cpphdl_n2493), V(cpphdl_n3013, cpphdl_n2493), 0.01, 0.69999999999999996, 1.0);
        // device 1795, IC IC314, analog/basic/cmos_logic.hpp:21
        I(cpphdl_n2493, Vss) <+ cpphdl_channel(V(cpphdl_n2498, Vss), V(cpphdl_n2493, Vss), 0.01, 0.69999999999999996, 1.0);
        // device 1796, IC IC314, analog/basic/cmos_logic.hpp:27
        I(cpphdl_n2493, Vss) <+ 1e-14 * ddt(V(cpphdl_n2493, Vss)); // Bench initial voltage = 0.0 V.
        // device 1797, IC IC315, analog/basic/cmos_logic.hpp:17
        I(cpphdl_n2498, Vss) <+ 5.0000000000000002e-14 * ddt(V(cpphdl_n2498, Vss)); // Bench initial voltage = 0.0 V.
        // device 1798, IC IC315, analog/basic/cmos_logic.hpp:18
        I(cpphdl_n2498, Vdd) <+ cpphdl_channel(V(cpphdl_n2496, Vdd), V(cpphdl_n2498, Vdd), 0.01, 0.69999999999999996, -1.0);
        // device 1799, IC IC315, analog/basic/cmos_logic.hpp:19
        I(cpphdl_n2498, Vdd) <+ cpphdl_channel(V(cpphdl_n3013, Vdd), V(cpphdl_n2498, Vdd), 0.01, 0.69999999999999996, -1.0);
        // device 1800, IC IC315, analog/basic/cmos_logic.hpp:20
        I(cpphdl_n2498, cpphdl_n2499) <+ cpphdl_channel(V(cpphdl_n2496, cpphdl_n2499), V(cpphdl_n2498, cpphdl_n2499), 0.01, 0.69999999999999996, 1.0);
        // device 1801, IC IC315, analog/basic/cmos_logic.hpp:21
        I(cpphdl_n2499, Vss) <+ cpphdl_channel(V(cpphdl_n3013, Vss), V(cpphdl_n2499, Vss), 0.01, 0.69999999999999996, 1.0);
        // device 1802, IC IC315, analog/basic/cmos_logic.hpp:27
        I(cpphdl_n2499, Vss) <+ 1e-14 * ddt(V(cpphdl_n2499, Vss)); // Bench initial voltage = 0.0 V.
        // device 1803, IC IC313, analog/basic/nand_latch.hpp:36
        I(cpphdl_n2490, Vss) <+ 2.9999999999999998e-15 * ddt(V(cpphdl_n2490, Vss)); // Bench initial voltage = 0.0 V.
        // device 1804, IC IC313, analog/basic/nand_latch.hpp:37
        I(cpphdl_n2496, Vss) <+ 2.9999999999999998e-15 * ddt(V(cpphdl_n2496, Vss)); // Bench initial voltage = 0.0 V.
        // device 1805, IC IC316, analog/basic/inverter.hpp:11
        I(cpphdl_n2504, Vdd) <+ cpphdl_channel(V(CLEAR, Vdd), V(cpphdl_n2504, Vdd), 0.01, 0.69999999999999996, -1.0);
        // device 1806, IC IC316, analog/basic/inverter.hpp:12
        I(cpphdl_n2504, Vss) <+ cpphdl_channel(V(CLEAR, Vss), V(cpphdl_n2504, Vss), 0.01, 0.69999999999999996, 1.0);
        // device 1807, IC IC313, analog/basic/nand_latch.hpp:58
        I(cpphdl_n2504, Vss) <+ 2.9999999999999998e-15 * ddt(V(cpphdl_n2504, Vss)); // Bench initial voltage = 0.0 V.
        // device 1808, IC IC313, analog/basic/nand_latch.hpp:59
        I(cpphdl_n3013, Vss) <+ cpphdl_channel(V(CLEAR, Vss), V(cpphdl_n3013, Vss), 0.050000000000000003, 0.69999999999999996, 1.0);
        // device 1809, IC IC313, analog/basic/nand_latch.hpp:60
        I(cpphdl_n2498, Vdd) <+ cpphdl_channel(V(cpphdl_n2504, Vdd), V(cpphdl_n2498, Vdd), 0.050000000000000003, 0.69999999999999996, -1.0);
        // device 1810, IC IC319, analog/basic/inverter.hpp:11
        I(cpphdl_n2528, Vdd) <+ cpphdl_channel(V(TRACK13, Vdd), V(cpphdl_n2528, Vdd), 0.0040000000000000001, 0.69999999999999996, -1.0);
        // device 1811, IC IC319, analog/basic/inverter.hpp:12
        I(cpphdl_n2528, Vss) <+ cpphdl_channel(V(TRACK13, Vss), V(cpphdl_n2528, Vss), 0.0040000000000000001, 0.69999999999999996, 1.0);
        // device 1812, IC IC318, analog/basic/mos_track_hold.hpp:31
        I(cpphdl_n2528, Vss) <+ 2e-14 * ddt(V(cpphdl_n2528, Vss)); // Bench initial voltage = 0.0 V.
        // device 1813, IC IC318, analog/basic/mos_track_hold.hpp:32
        I(cpphdl_n2808, cpphdl_n2582) <+ cpphdl_channel(V(TRACK13, cpphdl_n2582), V(cpphdl_n2808, cpphdl_n2582), 0.029999999999999999, 0.69999999999999996, 1.0);
        // device 1814, IC IC318, analog/basic/mos_track_hold.hpp:33
        I(cpphdl_n2582, cpphdl_n2808) <+ cpphdl_channel(V(cpphdl_n2528, cpphdl_n2808), V(cpphdl_n2582, cpphdl_n2808), 0.014999999999999999, 0.69999999999999996, -1.0);
        // device 1815, IC IC318, analog/basic/mos_track_hold.hpp:37
        I(cpphdl_n2582, cpphdl_n2582) <+ cpphdl_channel(V(cpphdl_n2528, cpphdl_n2582), V(cpphdl_n2582, cpphdl_n2582), 0.016, 0.69999999999999996, 1.0);
        // device 1816, IC IC318, analog/basic/mos_track_hold.hpp:38
        I(cpphdl_n2582, cpphdl_n2582) <+ cpphdl_channel(V(TRACK13, cpphdl_n2582), V(cpphdl_n2582, cpphdl_n2582), 0.0083999999999999995, 0.69999999999999996, -1.0);
        // device 1817, IC IC318, analog/basic/mos_track_hold.hpp:39
        I(cpphdl_n2582, Vss) <+ 1.5000000000000001e-12 * ddt(V(cpphdl_n2582, Vss)); // Bench initial voltage = 0.0 V.
        // device 1818, IC IC318, analog/basic/mos_track_hold.hpp:42
        I(TRACK13, cpphdl_n2582) <+ 2.0000000000000002e-15 * ddt(V(TRACK13, cpphdl_n2582)); // Bench initial voltage = -0.0 V.
        // device 1819, IC IC318, analog/basic/mos_track_hold.hpp:43
        I(cpphdl_n2528, cpphdl_n2582) <+ 2.0000000000000002e-15 * ddt(V(cpphdl_n2528, cpphdl_n2582)); // Bench initial voltage = 0.0 V.
        // device 1820, IC IC318, analog/basic/mos_track_hold.hpp:44
        I(cpphdl_n2808, cpphdl_n2582) <+ 1.0000000000000001e-15 * ddt(V(cpphdl_n2808, cpphdl_n2582)); // Bench initial voltage = 0.0 V.
        // device 1821, IC IC321, analog/basic/inverter.hpp:11
        I(cpphdl_n2543, Vdd) <+ cpphdl_channel(V(BIT_N13_0, Vdd), V(cpphdl_n2543, Vdd), 0.080000000000000002, 0.69999999999999996, -1.0);
        // device 1822, IC IC321, analog/basic/inverter.hpp:12
        I(cpphdl_n2543, Vss) <+ cpphdl_channel(V(BIT_N13_0, Vss), V(cpphdl_n2543, Vss), 0.080000000000000002, 0.69999999999999996, 1.0);
        // device 1823, IC IC320, analog/basic/mos_r2r_dac.hpp:27
        I(cpphdl_n2543, Vss) <+ 2.9999999999999998e-15 * ddt(V(cpphdl_n2543, Vss)); // Bench initial voltage = 0.0 V.
        // device 1824, IC IC320, analog/basic/mos_r2r_dac.hpp:28
        I(cpphdl_n2543, cpphdl_n2572) <+ V(cpphdl_n2543, cpphdl_n2572) / 2000.0;
        // device 1825, IC IC320, analog/basic/mos_r2r_dac.hpp:29
        I(cpphdl_n2572, Vss) <+ 2.9999999999999998e-15 * ddt(V(cpphdl_n2572, Vss)); // Bench initial voltage = 0.0 V.
        // device 1826, IC IC322, analog/basic/inverter.hpp:11
        I(cpphdl_n2547, Vdd) <+ cpphdl_channel(V(BIT_N13_1, Vdd), V(cpphdl_n2547, Vdd), 0.080000000000000002, 0.69999999999999996, -1.0);
        // device 1827, IC IC322, analog/basic/inverter.hpp:12
        I(cpphdl_n2547, Vss) <+ cpphdl_channel(V(BIT_N13_1, Vss), V(cpphdl_n2547, Vss), 0.080000000000000002, 0.69999999999999996, 1.0);
        // device 1828, IC IC320, analog/basic/mos_r2r_dac.hpp:27
        I(cpphdl_n2547, Vss) <+ 2.9999999999999998e-15 * ddt(V(cpphdl_n2547, Vss)); // Bench initial voltage = 0.0 V.
        // device 1829, IC IC320, analog/basic/mos_r2r_dac.hpp:28
        I(cpphdl_n2547, cpphdl_n2573) <+ V(cpphdl_n2547, cpphdl_n2573) / 2000.0;
        // device 1830, IC IC320, analog/basic/mos_r2r_dac.hpp:29
        I(cpphdl_n2573, Vss) <+ 2.9999999999999998e-15 * ddt(V(cpphdl_n2573, Vss)); // Bench initial voltage = 0.0 V.
        // device 1831, IC IC320, analog/basic/mos_r2r_dac.hpp:31
        I(cpphdl_n2572, cpphdl_n2573) <+ V(cpphdl_n2572, cpphdl_n2573) / 1000.0;
        // device 1832, IC IC323, analog/basic/inverter.hpp:11
        I(cpphdl_n2551, Vdd) <+ cpphdl_channel(V(BIT_N13_2, Vdd), V(cpphdl_n2551, Vdd), 0.080000000000000002, 0.69999999999999996, -1.0);
        // device 1833, IC IC323, analog/basic/inverter.hpp:12
        I(cpphdl_n2551, Vss) <+ cpphdl_channel(V(BIT_N13_2, Vss), V(cpphdl_n2551, Vss), 0.080000000000000002, 0.69999999999999996, 1.0);
        // device 1834, IC IC320, analog/basic/mos_r2r_dac.hpp:27
        I(cpphdl_n2551, Vss) <+ 2.9999999999999998e-15 * ddt(V(cpphdl_n2551, Vss)); // Bench initial voltage = 0.0 V.
        // device 1835, IC IC320, analog/basic/mos_r2r_dac.hpp:28
        I(cpphdl_n2551, cpphdl_n2574) <+ V(cpphdl_n2551, cpphdl_n2574) / 2000.0;
        // device 1836, IC IC320, analog/basic/mos_r2r_dac.hpp:29
        I(cpphdl_n2574, Vss) <+ 2.9999999999999998e-15 * ddt(V(cpphdl_n2574, Vss)); // Bench initial voltage = 0.0 V.
        // device 1837, IC IC320, analog/basic/mos_r2r_dac.hpp:31
        I(cpphdl_n2573, cpphdl_n2574) <+ V(cpphdl_n2573, cpphdl_n2574) / 1000.0;
        // device 1838, IC IC324, analog/basic/inverter.hpp:11
        I(cpphdl_n2555, Vdd) <+ cpphdl_channel(V(BIT_N13_3, Vdd), V(cpphdl_n2555, Vdd), 0.080000000000000002, 0.69999999999999996, -1.0);
        // device 1839, IC IC324, analog/basic/inverter.hpp:12
        I(cpphdl_n2555, Vss) <+ cpphdl_channel(V(BIT_N13_3, Vss), V(cpphdl_n2555, Vss), 0.080000000000000002, 0.69999999999999996, 1.0);
        // device 1840, IC IC320, analog/basic/mos_r2r_dac.hpp:27
        I(cpphdl_n2555, Vss) <+ 2.9999999999999998e-15 * ddt(V(cpphdl_n2555, Vss)); // Bench initial voltage = 0.0 V.
        // device 1841, IC IC320, analog/basic/mos_r2r_dac.hpp:28
        I(cpphdl_n2555, cpphdl_n2575) <+ V(cpphdl_n2555, cpphdl_n2575) / 2000.0;
        // device 1842, IC IC320, analog/basic/mos_r2r_dac.hpp:29
        I(cpphdl_n2575, Vss) <+ 2.9999999999999998e-15 * ddt(V(cpphdl_n2575, Vss)); // Bench initial voltage = 0.0 V.
        // device 1843, IC IC320, analog/basic/mos_r2r_dac.hpp:31
        I(cpphdl_n2574, cpphdl_n2575) <+ V(cpphdl_n2574, cpphdl_n2575) / 1000.0;
        // device 1844, IC IC325, analog/basic/inverter.hpp:11
        I(cpphdl_n2559, Vdd) <+ cpphdl_channel(V(BIT_N13_4, Vdd), V(cpphdl_n2559, Vdd), 0.080000000000000002, 0.69999999999999996, -1.0);
        // device 1845, IC IC325, analog/basic/inverter.hpp:12
        I(cpphdl_n2559, Vss) <+ cpphdl_channel(V(BIT_N13_4, Vss), V(cpphdl_n2559, Vss), 0.080000000000000002, 0.69999999999999996, 1.0);
        // device 1846, IC IC320, analog/basic/mos_r2r_dac.hpp:27
        I(cpphdl_n2559, Vss) <+ 2.9999999999999998e-15 * ddt(V(cpphdl_n2559, Vss)); // Bench initial voltage = 0.0 V.
        // device 1847, IC IC320, analog/basic/mos_r2r_dac.hpp:28
        I(cpphdl_n2559, cpphdl_n2576) <+ V(cpphdl_n2559, cpphdl_n2576) / 2000.0;
        // device 1848, IC IC320, analog/basic/mos_r2r_dac.hpp:29
        I(cpphdl_n2576, Vss) <+ 2.9999999999999998e-15 * ddt(V(cpphdl_n2576, Vss)); // Bench initial voltage = 0.0 V.
        // device 1849, IC IC320, analog/basic/mos_r2r_dac.hpp:31
        I(cpphdl_n2575, cpphdl_n2576) <+ V(cpphdl_n2575, cpphdl_n2576) / 1000.0;
        // device 1850, IC IC326, analog/basic/inverter.hpp:11
        I(cpphdl_n2563, Vdd) <+ cpphdl_channel(V(BIT_N13_5, Vdd), V(cpphdl_n2563, Vdd), 0.080000000000000002, 0.69999999999999996, -1.0);
        // device 1851, IC IC326, analog/basic/inverter.hpp:12
        I(cpphdl_n2563, Vss) <+ cpphdl_channel(V(BIT_N13_5, Vss), V(cpphdl_n2563, Vss), 0.080000000000000002, 0.69999999999999996, 1.0);
        // device 1852, IC IC320, analog/basic/mos_r2r_dac.hpp:27
        I(cpphdl_n2563, Vss) <+ 2.9999999999999998e-15 * ddt(V(cpphdl_n2563, Vss)); // Bench initial voltage = 0.0 V.
        // device 1853, IC IC320, analog/basic/mos_r2r_dac.hpp:28
        I(cpphdl_n2563, cpphdl_n2577) <+ V(cpphdl_n2563, cpphdl_n2577) / 2000.0;
        // device 1854, IC IC320, analog/basic/mos_r2r_dac.hpp:29
        I(cpphdl_n2577, Vss) <+ 2.9999999999999998e-15 * ddt(V(cpphdl_n2577, Vss)); // Bench initial voltage = 0.0 V.
        // device 1855, IC IC320, analog/basic/mos_r2r_dac.hpp:31
        I(cpphdl_n2576, cpphdl_n2577) <+ V(cpphdl_n2576, cpphdl_n2577) / 1000.0;
        // device 1856, IC IC327, analog/basic/inverter.hpp:11
        I(cpphdl_n2567, Vdd) <+ cpphdl_channel(V(BIT_N13_6, Vdd), V(cpphdl_n2567, Vdd), 0.080000000000000002, 0.69999999999999996, -1.0);
        // device 1857, IC IC327, analog/basic/inverter.hpp:12
        I(cpphdl_n2567, Vss) <+ cpphdl_channel(V(BIT_N13_6, Vss), V(cpphdl_n2567, Vss), 0.080000000000000002, 0.69999999999999996, 1.0);
        // device 1858, IC IC320, analog/basic/mos_r2r_dac.hpp:27
        I(cpphdl_n2567, Vss) <+ 2.9999999999999998e-15 * ddt(V(cpphdl_n2567, Vss)); // Bench initial voltage = 0.0 V.
        // device 1859, IC IC320, analog/basic/mos_r2r_dac.hpp:28
        I(cpphdl_n2567, cpphdl_n2578) <+ V(cpphdl_n2567, cpphdl_n2578) / 2000.0;
        // device 1860, IC IC320, analog/basic/mos_r2r_dac.hpp:29
        I(cpphdl_n2578, Vss) <+ 2.9999999999999998e-15 * ddt(V(cpphdl_n2578, Vss)); // Bench initial voltage = 0.0 V.
        // device 1861, IC IC320, analog/basic/mos_r2r_dac.hpp:31
        I(cpphdl_n2577, cpphdl_n2578) <+ V(cpphdl_n2577, cpphdl_n2578) / 1000.0;
        // device 1862, IC IC328, analog/basic/inverter.hpp:11
        I(cpphdl_n2571, Vdd) <+ cpphdl_channel(V(BIT_N13_7, Vdd), V(cpphdl_n2571, Vdd), 0.080000000000000002, 0.69999999999999996, -1.0);
        // device 1863, IC IC328, analog/basic/inverter.hpp:12
        I(cpphdl_n2571, Vss) <+ cpphdl_channel(V(BIT_N13_7, Vss), V(cpphdl_n2571, Vss), 0.080000000000000002, 0.69999999999999996, 1.0);
        // device 1864, IC IC320, analog/basic/mos_r2r_dac.hpp:27
        I(cpphdl_n2571, Vss) <+ 2.9999999999999998e-15 * ddt(V(cpphdl_n2571, Vss)); // Bench initial voltage = 0.0 V.
        // device 1865, IC IC320, analog/basic/mos_r2r_dac.hpp:28
        I(cpphdl_n2571, cpphdl_n2583) <+ V(cpphdl_n2571, cpphdl_n2583) / 2000.0;
        // device 1866, IC IC320, analog/basic/mos_r2r_dac.hpp:29
        I(cpphdl_n2583, Vss) <+ 2.9999999999999998e-15 * ddt(V(cpphdl_n2583, Vss)); // Bench initial voltage = 0.0 V.
        // device 1867, IC IC320, analog/basic/mos_r2r_dac.hpp:31
        I(cpphdl_n2578, cpphdl_n2583) <+ V(cpphdl_n2578, cpphdl_n2583) / 1000.0;
        // device 1868, IC IC320, analog/basic/mos_r2r_dac.hpp:33
        I(Vss, cpphdl_n2572) <+ V(Vss, cpphdl_n2572) / 2000.0;
        // device 1869, IC IC329, analog/basic/nmos_resistor_amplifier.hpp:23
        I(Vdd, cpphdl_n2592) <+ V(Vdd, cpphdl_n2592) / 1000.0;
        // device 1870, IC IC329, analog/basic/nmos_resistor_amplifier.hpp:24
        I(Vdd, cpphdl_n2591) <+ V(Vdd, cpphdl_n2591) / 1000.0;
        // device 1871, IC IC329, analog/basic/nmos_resistor_amplifier.hpp:25
        I(cpphdl_n2592, cpphdl_n2586) <+ cpphdl_channel(V(cpphdl_n2582, cpphdl_n2586), V(cpphdl_n2592, cpphdl_n2586), 0.0074999999999999997, 0.69999999999999996, 1.0);
        // device 1872, IC IC329, analog/basic/nmos_resistor_amplifier.hpp:26
        I(cpphdl_n2591, cpphdl_n2587) <+ cpphdl_channel(V(cpphdl_n2583, cpphdl_n2587), V(cpphdl_n2591, cpphdl_n2587), 0.0074999999999999997, 0.69999999999999996, 1.0);
        // device 1873, IC IC329, analog/basic/nmos_resistor_amplifier.hpp:27
        I(cpphdl_n2588, cpphdl_n2586) <+ V(cpphdl_n2588, cpphdl_n2586) / 100.0;
        // device 1874, IC IC329, analog/basic/nmos_resistor_amplifier.hpp:28
        I(cpphdl_n2588, cpphdl_n2587) <+ V(cpphdl_n2588, cpphdl_n2587) / 100.0;
        // device 1875, IC IC329, analog/basic/nmos_resistor_amplifier.hpp:29
        I(Vss, cpphdl_n2588) <+ V(Vss, cpphdl_n2588) / 300.0;
        // device 1876, IC IC329, analog/basic/nmos_resistor_amplifier.hpp:30
        I(cpphdl_n2592, Vdd) <+ 2.9999999999999998e-13 * ddt(V(cpphdl_n2592, Vdd)); // Bench initial voltage = 0.0 V.
        // device 1877, IC IC329, analog/basic/nmos_resistor_amplifier.hpp:31
        I(cpphdl_n2591, Vdd) <+ 2.9999999999999998e-13 * ddt(V(cpphdl_n2591, Vdd)); // Bench initial voltage = 0.0 V.
        // device 1878, IC IC329, analog/basic/nmos_resistor_amplifier.hpp:32
        I(cpphdl_n2588, Vss) <+ 4e-14 * ddt(V(cpphdl_n2588, Vss)); // Bench initial voltage = 0.0 V.
        // device 1879, IC IC329, analog/basic/nmos_resistor_amplifier.hpp:34
        I(cpphdl_n2582, cpphdl_n2586) <+ 2e-14 * ddt(V(cpphdl_n2582, cpphdl_n2586)); // Bench initial voltage = 0.0 V.
        // device 1880, IC IC329, analog/basic/nmos_resistor_amplifier.hpp:35
        I(cpphdl_n2583, cpphdl_n2587) <+ 2e-14 * ddt(V(cpphdl_n2583, cpphdl_n2587)); // Bench initial voltage = 0.0 V.
        // device 1881, IC IC329, analog/basic/nmos_resistor_amplifier.hpp:36
        I(cpphdl_n2582, cpphdl_n2592) <+ 2.9999999999999998e-15 * ddt(V(cpphdl_n2582, cpphdl_n2592)); // Bench initial voltage = 0.0 V.
        // device 1882, IC IC329, analog/basic/nmos_resistor_amplifier.hpp:37
        I(cpphdl_n2583, cpphdl_n2591) <+ 2.9999999999999998e-15 * ddt(V(cpphdl_n2583, cpphdl_n2591)); // Bench initial voltage = 0.0 V.
        // device 1883, IC IC330, analog/basic/strongarm_comparator.hpp:28
        I(cpphdl_n2596, cpphdl_n2598) <+ cpphdl_channel(V(cpphdl_n2591, cpphdl_n2598), V(cpphdl_n2596, cpphdl_n2598), 0.0080000000000000002, 0.69999999999999996, 1.0);
        // device 1884, IC IC330, analog/basic/strongarm_comparator.hpp:29
        I(cpphdl_n2597, cpphdl_n2598) <+ cpphdl_channel(V(cpphdl_n2592, cpphdl_n2598), V(cpphdl_n2597, cpphdl_n2598), 0.0080000000000000002, 0.69999999999999996, 1.0);
        // device 1885, IC IC330, analog/basic/strongarm_comparator.hpp:30
        I(cpphdl_n2598, Vss) <+ cpphdl_channel(V(EVALUATE, Vss), V(cpphdl_n2598, Vss), 0.0080000000000000002, 0.69999999999999996, 1.0);
        // device 1886, IC IC330, analog/basic/strongarm_comparator.hpp:33
        I(cpphdl_n2611, cpphdl_n2596) <+ cpphdl_channel(V(cpphdl_n2615, cpphdl_n2596), V(cpphdl_n2611, cpphdl_n2596), 0.0040000000000000001, 0.69999999999999996, 1.0);
        // device 1887, IC IC330, analog/basic/strongarm_comparator.hpp:34
        I(cpphdl_n2615, cpphdl_n2597) <+ cpphdl_channel(V(cpphdl_n2611, cpphdl_n2597), V(cpphdl_n2615, cpphdl_n2597), 0.0040000000000000001, 0.69999999999999996, 1.0);
        // device 1888, IC IC330, analog/basic/strongarm_comparator.hpp:35
        I(cpphdl_n2615, Vdd) <+ cpphdl_channel(V(cpphdl_n2611, Vdd), V(cpphdl_n2615, Vdd), 0.002, 0.69999999999999996, -1.0);
        // device 1889, IC IC330, analog/basic/strongarm_comparator.hpp:36
        I(cpphdl_n2611, Vdd) <+ cpphdl_channel(V(cpphdl_n2615, Vdd), V(cpphdl_n2611, Vdd), 0.002, 0.69999999999999996, -1.0);
        // device 1890, IC IC330, analog/basic/strongarm_comparator.hpp:38
        I(cpphdl_n2596, Vdd) <+ cpphdl_channel(V(EVALUATE, Vdd), V(cpphdl_n2596, Vdd), 0.002, 0.69999999999999996, -1.0);
        // device 1891, IC IC330, analog/basic/strongarm_comparator.hpp:39
        I(cpphdl_n2597, Vdd) <+ cpphdl_channel(V(EVALUATE, Vdd), V(cpphdl_n2597, Vdd), 0.002, 0.69999999999999996, -1.0);
        // device 1892, IC IC330, analog/basic/strongarm_comparator.hpp:40
        I(cpphdl_n2615, Vdd) <+ cpphdl_channel(V(EVALUATE, Vdd), V(cpphdl_n2615, Vdd), 0.002, 0.69999999999999996, -1.0);
        // device 1893, IC IC330, analog/basic/strongarm_comparator.hpp:41
        I(cpphdl_n2611, Vdd) <+ cpphdl_channel(V(EVALUATE, Vdd), V(cpphdl_n2611, Vdd), 0.002, 0.69999999999999996, -1.0);
        // device 1894, IC IC330, analog/basic/strongarm_comparator.hpp:42
        I(cpphdl_n2596, Vss) <+ 2.9999999999999998e-14 * ddt(V(cpphdl_n2596, Vss)); // Bench initial voltage = 0.0 V.
        // device 1895, IC IC330, analog/basic/strongarm_comparator.hpp:43
        I(cpphdl_n2597, Vss) <+ 2.9999999999999998e-14 * ddt(V(cpphdl_n2597, Vss)); // Bench initial voltage = 0.0 V.
        // device 1896, IC IC330, analog/basic/strongarm_comparator.hpp:44
        I(cpphdl_n2598, Vss) <+ 2.9999999999999998e-14 * ddt(V(cpphdl_n2598, Vss)); // Bench initial voltage = 0.0 V.
        // device 1897, IC IC330, analog/basic/strongarm_comparator.hpp:45
        I(cpphdl_n2615, Vss) <+ 5.0000000000000002e-14 * ddt(V(cpphdl_n2615, Vss)); // Bench initial voltage = 0.0 V.
        // device 1898, IC IC330, analog/basic/strongarm_comparator.hpp:46
        I(cpphdl_n2611, Vss) <+ 5.0000000000000002e-14 * ddt(V(cpphdl_n2611, Vss)); // Bench initial voltage = 0.0 V.
        // device 1899, IC IC330, analog/basic/strongarm_comparator.hpp:47
        I(cpphdl_n2591, cpphdl_n2598) <+ 2e-14 * ddt(V(cpphdl_n2591, cpphdl_n2598)); // Bench initial voltage = 0.0 V.
        // device 1900, IC IC330, analog/basic/strongarm_comparator.hpp:48
        I(cpphdl_n2592, cpphdl_n2598) <+ 2e-14 * ddt(V(cpphdl_n2592, cpphdl_n2598)); // Bench initial voltage = 0.0 V.
        // device 1901, IC IC330, analog/basic/strongarm_comparator.hpp:49
        I(cpphdl_n2591, cpphdl_n2596) <+ 2.9999999999999998e-15 * ddt(V(cpphdl_n2591, cpphdl_n2596)); // Bench initial voltage = 0.0 V.
        // device 1902, IC IC330, analog/basic/strongarm_comparator.hpp:50
        I(cpphdl_n2592, cpphdl_n2597) <+ 2.9999999999999998e-15 * ddt(V(cpphdl_n2592, cpphdl_n2597)); // Bench initial voltage = 0.0 V.
        // device 1903, IC IC332, analog/basic/inverter.hpp:11
        I(cpphdl_n2619, Vdd) <+ cpphdl_channel(V(cpphdl_n2611, Vdd), V(cpphdl_n2619, Vdd), 0.001, 0.69999999999999996, -1.0);
        // device 1904, IC IC332, analog/basic/inverter.hpp:12
        I(cpphdl_n2619, Vss) <+ cpphdl_channel(V(cpphdl_n2611, Vss), V(cpphdl_n2619, Vss), 0.001, 0.69999999999999996, 1.0);
        // device 1905, IC IC334, analog/basic/inverter.hpp:11
        I(cpphdl_n2633, Vdd) <+ cpphdl_channel(V(cpphdl_n2619, Vdd), V(cpphdl_n2633, Vdd), 0.0040000000000000001, 0.69999999999999996, -1.0);
        // device 1906, IC IC334, analog/basic/inverter.hpp:12
        I(cpphdl_n2633, Vss) <+ cpphdl_channel(V(cpphdl_n2619, Vss), V(cpphdl_n2633, Vss), 0.0040000000000000001, 0.69999999999999996, 1.0);
        // device 1907, IC IC331, analog/basic/buffered_nand_latch.hpp:34
        I(cpphdl_n2611, Vss) <+ 2.0000000000000002e-15 * ddt(V(cpphdl_n2611, Vss)); // Bench initial voltage = 0.0 V.
        // device 1908, IC IC331, analog/basic/buffered_nand_latch.hpp:35
        I(cpphdl_n2611, cpphdl_n2619) <+ 1.0000000000000001e-15 * ddt(V(cpphdl_n2611, cpphdl_n2619)); // Bench initial voltage = 0.0 V.
        // device 1909, IC IC331, analog/basic/buffered_nand_latch.hpp:36
        I(cpphdl_n2619, Vss) <+ 5e-15 * ddt(V(cpphdl_n2619, Vss)); // Bench initial voltage = 0.0 V.
        // device 1910, IC IC331, analog/basic/buffered_nand_latch.hpp:37
        I(cpphdl_n2619, Vss) <+ 8.0000000000000006e-15 * ddt(V(cpphdl_n2619, Vss)); // Bench initial voltage = 0.0 V.
        // device 1911, IC IC331, analog/basic/buffered_nand_latch.hpp:38
        I(cpphdl_n2633, Vss) <+ 1e-14 * ddt(V(cpphdl_n2633, Vss)); // Bench initial voltage = 0.0 V.
        // device 1912, IC IC333, analog/basic/inverter.hpp:11
        I(cpphdl_n2623, Vdd) <+ cpphdl_channel(V(cpphdl_n2615, Vdd), V(cpphdl_n2623, Vdd), 0.001, 0.69999999999999996, -1.0);
        // device 1913, IC IC333, analog/basic/inverter.hpp:12
        I(cpphdl_n2623, Vss) <+ cpphdl_channel(V(cpphdl_n2615, Vss), V(cpphdl_n2623, Vss), 0.001, 0.69999999999999996, 1.0);
        // device 1914, IC IC335, analog/basic/inverter.hpp:11
        I(cpphdl_n2639, Vdd) <+ cpphdl_channel(V(cpphdl_n2623, Vdd), V(cpphdl_n2639, Vdd), 0.0040000000000000001, 0.69999999999999996, -1.0);
        // device 1915, IC IC335, analog/basic/inverter.hpp:12
        I(cpphdl_n2639, Vss) <+ cpphdl_channel(V(cpphdl_n2623, Vss), V(cpphdl_n2639, Vss), 0.0040000000000000001, 0.69999999999999996, 1.0);
        // device 1916, IC IC331, analog/basic/buffered_nand_latch.hpp:34
        I(cpphdl_n2615, Vss) <+ 2.0000000000000002e-15 * ddt(V(cpphdl_n2615, Vss)); // Bench initial voltage = 0.0 V.
        // device 1917, IC IC331, analog/basic/buffered_nand_latch.hpp:35
        I(cpphdl_n2615, cpphdl_n2623) <+ 1.0000000000000001e-15 * ddt(V(cpphdl_n2615, cpphdl_n2623)); // Bench initial voltage = 0.0 V.
        // device 1918, IC IC331, analog/basic/buffered_nand_latch.hpp:36
        I(cpphdl_n2623, Vss) <+ 5e-15 * ddt(V(cpphdl_n2623, Vss)); // Bench initial voltage = 0.0 V.
        // device 1919, IC IC331, analog/basic/buffered_nand_latch.hpp:37
        I(cpphdl_n2623, Vss) <+ 8.0000000000000006e-15 * ddt(V(cpphdl_n2623, Vss)); // Bench initial voltage = 0.0 V.
        // device 1920, IC IC331, analog/basic/buffered_nand_latch.hpp:38
        I(cpphdl_n2639, Vss) <+ 1e-14 * ddt(V(cpphdl_n2639, Vss)); // Bench initial voltage = 0.0 V.
        // device 1921, IC IC337, analog/basic/cmos_logic.hpp:17
        I(cpphdl_n3018, Vss) <+ 5.0000000000000002e-14 * ddt(V(cpphdl_n3018, Vss)); // Bench initial voltage = 0.0 V.
        // device 1922, IC IC337, analog/basic/cmos_logic.hpp:18
        I(cpphdl_n3018, Vdd) <+ cpphdl_channel(V(cpphdl_n2633, Vdd), V(cpphdl_n3018, Vdd), 0.01, 0.69999999999999996, -1.0);
        // device 1923, IC IC337, analog/basic/cmos_logic.hpp:19
        I(cpphdl_n3018, Vdd) <+ cpphdl_channel(V(cpphdl_n2641, Vdd), V(cpphdl_n3018, Vdd), 0.01, 0.69999999999999996, -1.0);
        // device 1924, IC IC337, analog/basic/cmos_logic.hpp:20
        I(cpphdl_n3018, cpphdl_n2636) <+ cpphdl_channel(V(cpphdl_n2633, cpphdl_n2636), V(cpphdl_n3018, cpphdl_n2636), 0.01, 0.69999999999999996, 1.0);
        // device 1925, IC IC337, analog/basic/cmos_logic.hpp:21
        I(cpphdl_n2636, Vss) <+ cpphdl_channel(V(cpphdl_n2641, Vss), V(cpphdl_n2636, Vss), 0.01, 0.69999999999999996, 1.0);
        // device 1926, IC IC337, analog/basic/cmos_logic.hpp:27
        I(cpphdl_n2636, Vss) <+ 1e-14 * ddt(V(cpphdl_n2636, Vss)); // Bench initial voltage = 0.0 V.
        // device 1927, IC IC338, analog/basic/cmos_logic.hpp:17
        I(cpphdl_n2641, Vss) <+ 5.0000000000000002e-14 * ddt(V(cpphdl_n2641, Vss)); // Bench initial voltage = 0.0 V.
        // device 1928, IC IC338, analog/basic/cmos_logic.hpp:18
        I(cpphdl_n2641, Vdd) <+ cpphdl_channel(V(cpphdl_n2639, Vdd), V(cpphdl_n2641, Vdd), 0.01, 0.69999999999999996, -1.0);
        // device 1929, IC IC338, analog/basic/cmos_logic.hpp:19
        I(cpphdl_n2641, Vdd) <+ cpphdl_channel(V(cpphdl_n3018, Vdd), V(cpphdl_n2641, Vdd), 0.01, 0.69999999999999996, -1.0);
        // device 1930, IC IC338, analog/basic/cmos_logic.hpp:20
        I(cpphdl_n2641, cpphdl_n2642) <+ cpphdl_channel(V(cpphdl_n2639, cpphdl_n2642), V(cpphdl_n2641, cpphdl_n2642), 0.01, 0.69999999999999996, 1.0);
        // device 1931, IC IC338, analog/basic/cmos_logic.hpp:21
        I(cpphdl_n2642, Vss) <+ cpphdl_channel(V(cpphdl_n3018, Vss), V(cpphdl_n2642, Vss), 0.01, 0.69999999999999996, 1.0);
        // device 1932, IC IC338, analog/basic/cmos_logic.hpp:27
        I(cpphdl_n2642, Vss) <+ 1e-14 * ddt(V(cpphdl_n2642, Vss)); // Bench initial voltage = 0.0 V.
        // device 1933, IC IC336, analog/basic/nand_latch.hpp:36
        I(cpphdl_n2633, Vss) <+ 2.9999999999999998e-15 * ddt(V(cpphdl_n2633, Vss)); // Bench initial voltage = 0.0 V.
        // device 1934, IC IC336, analog/basic/nand_latch.hpp:37
        I(cpphdl_n2639, Vss) <+ 2.9999999999999998e-15 * ddt(V(cpphdl_n2639, Vss)); // Bench initial voltage = 0.0 V.
        // device 1935, IC IC339, analog/basic/inverter.hpp:11
        I(cpphdl_n2647, Vdd) <+ cpphdl_channel(V(CLEAR, Vdd), V(cpphdl_n2647, Vdd), 0.01, 0.69999999999999996, -1.0);
        // device 1936, IC IC339, analog/basic/inverter.hpp:12
        I(cpphdl_n2647, Vss) <+ cpphdl_channel(V(CLEAR, Vss), V(cpphdl_n2647, Vss), 0.01, 0.69999999999999996, 1.0);
        // device 1937, IC IC336, analog/basic/nand_latch.hpp:58
        I(cpphdl_n2647, Vss) <+ 2.9999999999999998e-15 * ddt(V(cpphdl_n2647, Vss)); // Bench initial voltage = 0.0 V.
        // device 1938, IC IC336, analog/basic/nand_latch.hpp:59
        I(cpphdl_n3018, Vss) <+ cpphdl_channel(V(CLEAR, Vss), V(cpphdl_n3018, Vss), 0.050000000000000003, 0.69999999999999996, 1.0);
        // device 1939, IC IC336, analog/basic/nand_latch.hpp:60
        I(cpphdl_n2641, Vdd) <+ cpphdl_channel(V(cpphdl_n2647, Vdd), V(cpphdl_n2641, Vdd), 0.050000000000000003, 0.69999999999999996, -1.0);
        // device 1940, IC IC342, analog/basic/inverter.hpp:11
        I(cpphdl_n2671, Vdd) <+ cpphdl_channel(V(TRACK14, Vdd), V(cpphdl_n2671, Vdd), 0.0040000000000000001, 0.69999999999999996, -1.0);
        // device 1941, IC IC342, analog/basic/inverter.hpp:12
        I(cpphdl_n2671, Vss) <+ cpphdl_channel(V(TRACK14, Vss), V(cpphdl_n2671, Vss), 0.0040000000000000001, 0.69999999999999996, 1.0);
        // device 1942, IC IC341, analog/basic/mos_track_hold.hpp:31
        I(cpphdl_n2671, Vss) <+ 2e-14 * ddt(V(cpphdl_n2671, Vss)); // Bench initial voltage = 0.0 V.
        // device 1943, IC IC341, analog/basic/mos_track_hold.hpp:32
        I(cpphdl_n2808, cpphdl_n2725) <+ cpphdl_channel(V(TRACK14, cpphdl_n2725), V(cpphdl_n2808, cpphdl_n2725), 0.029999999999999999, 0.69999999999999996, 1.0);
        // device 1944, IC IC341, analog/basic/mos_track_hold.hpp:33
        I(cpphdl_n2725, cpphdl_n2808) <+ cpphdl_channel(V(cpphdl_n2671, cpphdl_n2808), V(cpphdl_n2725, cpphdl_n2808), 0.014999999999999999, 0.69999999999999996, -1.0);
        // device 1945, IC IC341, analog/basic/mos_track_hold.hpp:37
        I(cpphdl_n2725, cpphdl_n2725) <+ cpphdl_channel(V(cpphdl_n2671, cpphdl_n2725), V(cpphdl_n2725, cpphdl_n2725), 0.016, 0.69999999999999996, 1.0);
        // device 1946, IC IC341, analog/basic/mos_track_hold.hpp:38
        I(cpphdl_n2725, cpphdl_n2725) <+ cpphdl_channel(V(TRACK14, cpphdl_n2725), V(cpphdl_n2725, cpphdl_n2725), 0.0083999999999999995, 0.69999999999999996, -1.0);
        // device 1947, IC IC341, analog/basic/mos_track_hold.hpp:39
        I(cpphdl_n2725, Vss) <+ 1.5000000000000001e-12 * ddt(V(cpphdl_n2725, Vss)); // Bench initial voltage = 0.0 V.
        // device 1948, IC IC341, analog/basic/mos_track_hold.hpp:42
        I(TRACK14, cpphdl_n2725) <+ 2.0000000000000002e-15 * ddt(V(TRACK14, cpphdl_n2725)); // Bench initial voltage = -0.0 V.
        // device 1949, IC IC341, analog/basic/mos_track_hold.hpp:43
        I(cpphdl_n2671, cpphdl_n2725) <+ 2.0000000000000002e-15 * ddt(V(cpphdl_n2671, cpphdl_n2725)); // Bench initial voltage = 0.0 V.
        // device 1950, IC IC341, analog/basic/mos_track_hold.hpp:44
        I(cpphdl_n2808, cpphdl_n2725) <+ 1.0000000000000001e-15 * ddt(V(cpphdl_n2808, cpphdl_n2725)); // Bench initial voltage = 0.0 V.
        // device 1951, IC IC344, analog/basic/inverter.hpp:11
        I(cpphdl_n2686, Vdd) <+ cpphdl_channel(V(BIT_N14_0, Vdd), V(cpphdl_n2686, Vdd), 0.080000000000000002, 0.69999999999999996, -1.0);
        // device 1952, IC IC344, analog/basic/inverter.hpp:12
        I(cpphdl_n2686, Vss) <+ cpphdl_channel(V(BIT_N14_0, Vss), V(cpphdl_n2686, Vss), 0.080000000000000002, 0.69999999999999996, 1.0);
        // device 1953, IC IC343, analog/basic/mos_r2r_dac.hpp:27
        I(cpphdl_n2686, Vss) <+ 2.9999999999999998e-15 * ddt(V(cpphdl_n2686, Vss)); // Bench initial voltage = 0.0 V.
        // device 1954, IC IC343, analog/basic/mos_r2r_dac.hpp:28
        I(cpphdl_n2686, cpphdl_n2715) <+ V(cpphdl_n2686, cpphdl_n2715) / 2000.0;
        // device 1955, IC IC343, analog/basic/mos_r2r_dac.hpp:29
        I(cpphdl_n2715, Vss) <+ 2.9999999999999998e-15 * ddt(V(cpphdl_n2715, Vss)); // Bench initial voltage = 0.0 V.
        // device 1956, IC IC345, analog/basic/inverter.hpp:11
        I(cpphdl_n2690, Vdd) <+ cpphdl_channel(V(BIT_N14_1, Vdd), V(cpphdl_n2690, Vdd), 0.080000000000000002, 0.69999999999999996, -1.0);
        // device 1957, IC IC345, analog/basic/inverter.hpp:12
        I(cpphdl_n2690, Vss) <+ cpphdl_channel(V(BIT_N14_1, Vss), V(cpphdl_n2690, Vss), 0.080000000000000002, 0.69999999999999996, 1.0);
        // device 1958, IC IC343, analog/basic/mos_r2r_dac.hpp:27
        I(cpphdl_n2690, Vss) <+ 2.9999999999999998e-15 * ddt(V(cpphdl_n2690, Vss)); // Bench initial voltage = 0.0 V.
        // device 1959, IC IC343, analog/basic/mos_r2r_dac.hpp:28
        I(cpphdl_n2690, cpphdl_n2716) <+ V(cpphdl_n2690, cpphdl_n2716) / 2000.0;
        // device 1960, IC IC343, analog/basic/mos_r2r_dac.hpp:29
        I(cpphdl_n2716, Vss) <+ 2.9999999999999998e-15 * ddt(V(cpphdl_n2716, Vss)); // Bench initial voltage = 0.0 V.
        // device 1961, IC IC343, analog/basic/mos_r2r_dac.hpp:31
        I(cpphdl_n2715, cpphdl_n2716) <+ V(cpphdl_n2715, cpphdl_n2716) / 1000.0;
        // device 1962, IC IC346, analog/basic/inverter.hpp:11
        I(cpphdl_n2694, Vdd) <+ cpphdl_channel(V(BIT_N14_2, Vdd), V(cpphdl_n2694, Vdd), 0.080000000000000002, 0.69999999999999996, -1.0);
        // device 1963, IC IC346, analog/basic/inverter.hpp:12
        I(cpphdl_n2694, Vss) <+ cpphdl_channel(V(BIT_N14_2, Vss), V(cpphdl_n2694, Vss), 0.080000000000000002, 0.69999999999999996, 1.0);
        // device 1964, IC IC343, analog/basic/mos_r2r_dac.hpp:27
        I(cpphdl_n2694, Vss) <+ 2.9999999999999998e-15 * ddt(V(cpphdl_n2694, Vss)); // Bench initial voltage = 0.0 V.
        // device 1965, IC IC343, analog/basic/mos_r2r_dac.hpp:28
        I(cpphdl_n2694, cpphdl_n2717) <+ V(cpphdl_n2694, cpphdl_n2717) / 2000.0;
        // device 1966, IC IC343, analog/basic/mos_r2r_dac.hpp:29
        I(cpphdl_n2717, Vss) <+ 2.9999999999999998e-15 * ddt(V(cpphdl_n2717, Vss)); // Bench initial voltage = 0.0 V.
        // device 1967, IC IC343, analog/basic/mos_r2r_dac.hpp:31
        I(cpphdl_n2716, cpphdl_n2717) <+ V(cpphdl_n2716, cpphdl_n2717) / 1000.0;
        // device 1968, IC IC347, analog/basic/inverter.hpp:11
        I(cpphdl_n2698, Vdd) <+ cpphdl_channel(V(BIT_N14_3, Vdd), V(cpphdl_n2698, Vdd), 0.080000000000000002, 0.69999999999999996, -1.0);
        // device 1969, IC IC347, analog/basic/inverter.hpp:12
        I(cpphdl_n2698, Vss) <+ cpphdl_channel(V(BIT_N14_3, Vss), V(cpphdl_n2698, Vss), 0.080000000000000002, 0.69999999999999996, 1.0);
        // device 1970, IC IC343, analog/basic/mos_r2r_dac.hpp:27
        I(cpphdl_n2698, Vss) <+ 2.9999999999999998e-15 * ddt(V(cpphdl_n2698, Vss)); // Bench initial voltage = 0.0 V.
        // device 1971, IC IC343, analog/basic/mos_r2r_dac.hpp:28
        I(cpphdl_n2698, cpphdl_n2718) <+ V(cpphdl_n2698, cpphdl_n2718) / 2000.0;
        // device 1972, IC IC343, analog/basic/mos_r2r_dac.hpp:29
        I(cpphdl_n2718, Vss) <+ 2.9999999999999998e-15 * ddt(V(cpphdl_n2718, Vss)); // Bench initial voltage = 0.0 V.
        // device 1973, IC IC343, analog/basic/mos_r2r_dac.hpp:31
        I(cpphdl_n2717, cpphdl_n2718) <+ V(cpphdl_n2717, cpphdl_n2718) / 1000.0;
        // device 1974, IC IC348, analog/basic/inverter.hpp:11
        I(cpphdl_n2702, Vdd) <+ cpphdl_channel(V(BIT_N14_4, Vdd), V(cpphdl_n2702, Vdd), 0.080000000000000002, 0.69999999999999996, -1.0);
        // device 1975, IC IC348, analog/basic/inverter.hpp:12
        I(cpphdl_n2702, Vss) <+ cpphdl_channel(V(BIT_N14_4, Vss), V(cpphdl_n2702, Vss), 0.080000000000000002, 0.69999999999999996, 1.0);
        // device 1976, IC IC343, analog/basic/mos_r2r_dac.hpp:27
        I(cpphdl_n2702, Vss) <+ 2.9999999999999998e-15 * ddt(V(cpphdl_n2702, Vss)); // Bench initial voltage = 0.0 V.
        // device 1977, IC IC343, analog/basic/mos_r2r_dac.hpp:28
        I(cpphdl_n2702, cpphdl_n2719) <+ V(cpphdl_n2702, cpphdl_n2719) / 2000.0;
        // device 1978, IC IC343, analog/basic/mos_r2r_dac.hpp:29
        I(cpphdl_n2719, Vss) <+ 2.9999999999999998e-15 * ddt(V(cpphdl_n2719, Vss)); // Bench initial voltage = 0.0 V.
        // device 1979, IC IC343, analog/basic/mos_r2r_dac.hpp:31
        I(cpphdl_n2718, cpphdl_n2719) <+ V(cpphdl_n2718, cpphdl_n2719) / 1000.0;
        // device 1980, IC IC349, analog/basic/inverter.hpp:11
        I(cpphdl_n2706, Vdd) <+ cpphdl_channel(V(BIT_N14_5, Vdd), V(cpphdl_n2706, Vdd), 0.080000000000000002, 0.69999999999999996, -1.0);
        // device 1981, IC IC349, analog/basic/inverter.hpp:12
        I(cpphdl_n2706, Vss) <+ cpphdl_channel(V(BIT_N14_5, Vss), V(cpphdl_n2706, Vss), 0.080000000000000002, 0.69999999999999996, 1.0);
        // device 1982, IC IC343, analog/basic/mos_r2r_dac.hpp:27
        I(cpphdl_n2706, Vss) <+ 2.9999999999999998e-15 * ddt(V(cpphdl_n2706, Vss)); // Bench initial voltage = 0.0 V.
        // device 1983, IC IC343, analog/basic/mos_r2r_dac.hpp:28
        I(cpphdl_n2706, cpphdl_n2720) <+ V(cpphdl_n2706, cpphdl_n2720) / 2000.0;
        // device 1984, IC IC343, analog/basic/mos_r2r_dac.hpp:29
        I(cpphdl_n2720, Vss) <+ 2.9999999999999998e-15 * ddt(V(cpphdl_n2720, Vss)); // Bench initial voltage = 0.0 V.
        // device 1985, IC IC343, analog/basic/mos_r2r_dac.hpp:31
        I(cpphdl_n2719, cpphdl_n2720) <+ V(cpphdl_n2719, cpphdl_n2720) / 1000.0;
        // device 1986, IC IC350, analog/basic/inverter.hpp:11
        I(cpphdl_n2710, Vdd) <+ cpphdl_channel(V(BIT_N14_6, Vdd), V(cpphdl_n2710, Vdd), 0.080000000000000002, 0.69999999999999996, -1.0);
        // device 1987, IC IC350, analog/basic/inverter.hpp:12
        I(cpphdl_n2710, Vss) <+ cpphdl_channel(V(BIT_N14_6, Vss), V(cpphdl_n2710, Vss), 0.080000000000000002, 0.69999999999999996, 1.0);
        // device 1988, IC IC343, analog/basic/mos_r2r_dac.hpp:27
        I(cpphdl_n2710, Vss) <+ 2.9999999999999998e-15 * ddt(V(cpphdl_n2710, Vss)); // Bench initial voltage = 0.0 V.
        // device 1989, IC IC343, analog/basic/mos_r2r_dac.hpp:28
        I(cpphdl_n2710, cpphdl_n2721) <+ V(cpphdl_n2710, cpphdl_n2721) / 2000.0;
        // device 1990, IC IC343, analog/basic/mos_r2r_dac.hpp:29
        I(cpphdl_n2721, Vss) <+ 2.9999999999999998e-15 * ddt(V(cpphdl_n2721, Vss)); // Bench initial voltage = 0.0 V.
        // device 1991, IC IC343, analog/basic/mos_r2r_dac.hpp:31
        I(cpphdl_n2720, cpphdl_n2721) <+ V(cpphdl_n2720, cpphdl_n2721) / 1000.0;
        // device 1992, IC IC351, analog/basic/inverter.hpp:11
        I(cpphdl_n2714, Vdd) <+ cpphdl_channel(V(BIT_N14_7, Vdd), V(cpphdl_n2714, Vdd), 0.080000000000000002, 0.69999999999999996, -1.0);
        // device 1993, IC IC351, analog/basic/inverter.hpp:12
        I(cpphdl_n2714, Vss) <+ cpphdl_channel(V(BIT_N14_7, Vss), V(cpphdl_n2714, Vss), 0.080000000000000002, 0.69999999999999996, 1.0);
        // device 1994, IC IC343, analog/basic/mos_r2r_dac.hpp:27
        I(cpphdl_n2714, Vss) <+ 2.9999999999999998e-15 * ddt(V(cpphdl_n2714, Vss)); // Bench initial voltage = 0.0 V.
        // device 1995, IC IC343, analog/basic/mos_r2r_dac.hpp:28
        I(cpphdl_n2714, cpphdl_n2726) <+ V(cpphdl_n2714, cpphdl_n2726) / 2000.0;
        // device 1996, IC IC343, analog/basic/mos_r2r_dac.hpp:29
        I(cpphdl_n2726, Vss) <+ 2.9999999999999998e-15 * ddt(V(cpphdl_n2726, Vss)); // Bench initial voltage = 0.0 V.
        // device 1997, IC IC343, analog/basic/mos_r2r_dac.hpp:31
        I(cpphdl_n2721, cpphdl_n2726) <+ V(cpphdl_n2721, cpphdl_n2726) / 1000.0;
        // device 1998, IC IC343, analog/basic/mos_r2r_dac.hpp:33
        I(Vss, cpphdl_n2715) <+ V(Vss, cpphdl_n2715) / 2000.0;
        // device 1999, IC IC352, analog/basic/nmos_resistor_amplifier.hpp:23
        I(Vdd, cpphdl_n2735) <+ V(Vdd, cpphdl_n2735) / 1000.0;
        // device 2000, IC IC352, analog/basic/nmos_resistor_amplifier.hpp:24
        I(Vdd, cpphdl_n2734) <+ V(Vdd, cpphdl_n2734) / 1000.0;
        // device 2001, IC IC352, analog/basic/nmos_resistor_amplifier.hpp:25
        I(cpphdl_n2735, cpphdl_n2729) <+ cpphdl_channel(V(cpphdl_n2725, cpphdl_n2729), V(cpphdl_n2735, cpphdl_n2729), 0.0074999999999999997, 0.69999999999999996, 1.0);
        // device 2002, IC IC352, analog/basic/nmos_resistor_amplifier.hpp:26
        I(cpphdl_n2734, cpphdl_n2730) <+ cpphdl_channel(V(cpphdl_n2726, cpphdl_n2730), V(cpphdl_n2734, cpphdl_n2730), 0.0074999999999999997, 0.69999999999999996, 1.0);
        // device 2003, IC IC352, analog/basic/nmos_resistor_amplifier.hpp:27
        I(cpphdl_n2731, cpphdl_n2729) <+ V(cpphdl_n2731, cpphdl_n2729) / 100.0;
        // device 2004, IC IC352, analog/basic/nmos_resistor_amplifier.hpp:28
        I(cpphdl_n2731, cpphdl_n2730) <+ V(cpphdl_n2731, cpphdl_n2730) / 100.0;
        // device 2005, IC IC352, analog/basic/nmos_resistor_amplifier.hpp:29
        I(Vss, cpphdl_n2731) <+ V(Vss, cpphdl_n2731) / 300.0;
        // device 2006, IC IC352, analog/basic/nmos_resistor_amplifier.hpp:30
        I(cpphdl_n2735, Vdd) <+ 2.9999999999999998e-13 * ddt(V(cpphdl_n2735, Vdd)); // Bench initial voltage = 0.0 V.
        // device 2007, IC IC352, analog/basic/nmos_resistor_amplifier.hpp:31
        I(cpphdl_n2734, Vdd) <+ 2.9999999999999998e-13 * ddt(V(cpphdl_n2734, Vdd)); // Bench initial voltage = 0.0 V.
        // device 2008, IC IC352, analog/basic/nmos_resistor_amplifier.hpp:32
        I(cpphdl_n2731, Vss) <+ 4e-14 * ddt(V(cpphdl_n2731, Vss)); // Bench initial voltage = 0.0 V.
        // device 2009, IC IC352, analog/basic/nmos_resistor_amplifier.hpp:34
        I(cpphdl_n2725, cpphdl_n2729) <+ 2e-14 * ddt(V(cpphdl_n2725, cpphdl_n2729)); // Bench initial voltage = 0.0 V.
        // device 2010, IC IC352, analog/basic/nmos_resistor_amplifier.hpp:35
        I(cpphdl_n2726, cpphdl_n2730) <+ 2e-14 * ddt(V(cpphdl_n2726, cpphdl_n2730)); // Bench initial voltage = 0.0 V.
        // device 2011, IC IC352, analog/basic/nmos_resistor_amplifier.hpp:36
        I(cpphdl_n2725, cpphdl_n2735) <+ 2.9999999999999998e-15 * ddt(V(cpphdl_n2725, cpphdl_n2735)); // Bench initial voltage = 0.0 V.
        // device 2012, IC IC352, analog/basic/nmos_resistor_amplifier.hpp:37
        I(cpphdl_n2726, cpphdl_n2734) <+ 2.9999999999999998e-15 * ddt(V(cpphdl_n2726, cpphdl_n2734)); // Bench initial voltage = 0.0 V.
        // device 2013, IC IC353, analog/basic/strongarm_comparator.hpp:28
        I(cpphdl_n2739, cpphdl_n2741) <+ cpphdl_channel(V(cpphdl_n2734, cpphdl_n2741), V(cpphdl_n2739, cpphdl_n2741), 0.0080000000000000002, 0.69999999999999996, 1.0);
        // device 2014, IC IC353, analog/basic/strongarm_comparator.hpp:29
        I(cpphdl_n2740, cpphdl_n2741) <+ cpphdl_channel(V(cpphdl_n2735, cpphdl_n2741), V(cpphdl_n2740, cpphdl_n2741), 0.0080000000000000002, 0.69999999999999996, 1.0);
        // device 2015, IC IC353, analog/basic/strongarm_comparator.hpp:30
        I(cpphdl_n2741, Vss) <+ cpphdl_channel(V(EVALUATE, Vss), V(cpphdl_n2741, Vss), 0.0080000000000000002, 0.69999999999999996, 1.0);
        // device 2016, IC IC353, analog/basic/strongarm_comparator.hpp:33
        I(cpphdl_n2754, cpphdl_n2739) <+ cpphdl_channel(V(cpphdl_n2758, cpphdl_n2739), V(cpphdl_n2754, cpphdl_n2739), 0.0040000000000000001, 0.69999999999999996, 1.0);
        // device 2017, IC IC353, analog/basic/strongarm_comparator.hpp:34
        I(cpphdl_n2758, cpphdl_n2740) <+ cpphdl_channel(V(cpphdl_n2754, cpphdl_n2740), V(cpphdl_n2758, cpphdl_n2740), 0.0040000000000000001, 0.69999999999999996, 1.0);
        // device 2018, IC IC353, analog/basic/strongarm_comparator.hpp:35
        I(cpphdl_n2758, Vdd) <+ cpphdl_channel(V(cpphdl_n2754, Vdd), V(cpphdl_n2758, Vdd), 0.002, 0.69999999999999996, -1.0);
        // device 2019, IC IC353, analog/basic/strongarm_comparator.hpp:36
        I(cpphdl_n2754, Vdd) <+ cpphdl_channel(V(cpphdl_n2758, Vdd), V(cpphdl_n2754, Vdd), 0.002, 0.69999999999999996, -1.0);
        // device 2020, IC IC353, analog/basic/strongarm_comparator.hpp:38
        I(cpphdl_n2739, Vdd) <+ cpphdl_channel(V(EVALUATE, Vdd), V(cpphdl_n2739, Vdd), 0.002, 0.69999999999999996, -1.0);
        // device 2021, IC IC353, analog/basic/strongarm_comparator.hpp:39
        I(cpphdl_n2740, Vdd) <+ cpphdl_channel(V(EVALUATE, Vdd), V(cpphdl_n2740, Vdd), 0.002, 0.69999999999999996, -1.0);
        // device 2022, IC IC353, analog/basic/strongarm_comparator.hpp:40
        I(cpphdl_n2758, Vdd) <+ cpphdl_channel(V(EVALUATE, Vdd), V(cpphdl_n2758, Vdd), 0.002, 0.69999999999999996, -1.0);
        // device 2023, IC IC353, analog/basic/strongarm_comparator.hpp:41
        I(cpphdl_n2754, Vdd) <+ cpphdl_channel(V(EVALUATE, Vdd), V(cpphdl_n2754, Vdd), 0.002, 0.69999999999999996, -1.0);
        // device 2024, IC IC353, analog/basic/strongarm_comparator.hpp:42
        I(cpphdl_n2739, Vss) <+ 2.9999999999999998e-14 * ddt(V(cpphdl_n2739, Vss)); // Bench initial voltage = 0.0 V.
        // device 2025, IC IC353, analog/basic/strongarm_comparator.hpp:43
        I(cpphdl_n2740, Vss) <+ 2.9999999999999998e-14 * ddt(V(cpphdl_n2740, Vss)); // Bench initial voltage = 0.0 V.
        // device 2026, IC IC353, analog/basic/strongarm_comparator.hpp:44
        I(cpphdl_n2741, Vss) <+ 2.9999999999999998e-14 * ddt(V(cpphdl_n2741, Vss)); // Bench initial voltage = 0.0 V.
        // device 2027, IC IC353, analog/basic/strongarm_comparator.hpp:45
        I(cpphdl_n2758, Vss) <+ 5.0000000000000002e-14 * ddt(V(cpphdl_n2758, Vss)); // Bench initial voltage = 0.0 V.
        // device 2028, IC IC353, analog/basic/strongarm_comparator.hpp:46
        I(cpphdl_n2754, Vss) <+ 5.0000000000000002e-14 * ddt(V(cpphdl_n2754, Vss)); // Bench initial voltage = 0.0 V.
        // device 2029, IC IC353, analog/basic/strongarm_comparator.hpp:47
        I(cpphdl_n2734, cpphdl_n2741) <+ 2e-14 * ddt(V(cpphdl_n2734, cpphdl_n2741)); // Bench initial voltage = 0.0 V.
        // device 2030, IC IC353, analog/basic/strongarm_comparator.hpp:48
        I(cpphdl_n2735, cpphdl_n2741) <+ 2e-14 * ddt(V(cpphdl_n2735, cpphdl_n2741)); // Bench initial voltage = 0.0 V.
        // device 2031, IC IC353, analog/basic/strongarm_comparator.hpp:49
        I(cpphdl_n2734, cpphdl_n2739) <+ 2.9999999999999998e-15 * ddt(V(cpphdl_n2734, cpphdl_n2739)); // Bench initial voltage = 0.0 V.
        // device 2032, IC IC353, analog/basic/strongarm_comparator.hpp:50
        I(cpphdl_n2735, cpphdl_n2740) <+ 2.9999999999999998e-15 * ddt(V(cpphdl_n2735, cpphdl_n2740)); // Bench initial voltage = 0.0 V.
        // device 2033, IC IC355, analog/basic/inverter.hpp:11
        I(cpphdl_n2762, Vdd) <+ cpphdl_channel(V(cpphdl_n2754, Vdd), V(cpphdl_n2762, Vdd), 0.001, 0.69999999999999996, -1.0);
        // device 2034, IC IC355, analog/basic/inverter.hpp:12
        I(cpphdl_n2762, Vss) <+ cpphdl_channel(V(cpphdl_n2754, Vss), V(cpphdl_n2762, Vss), 0.001, 0.69999999999999996, 1.0);
        // device 2035, IC IC357, analog/basic/inverter.hpp:11
        I(cpphdl_n2776, Vdd) <+ cpphdl_channel(V(cpphdl_n2762, Vdd), V(cpphdl_n2776, Vdd), 0.0040000000000000001, 0.69999999999999996, -1.0);
        // device 2036, IC IC357, analog/basic/inverter.hpp:12
        I(cpphdl_n2776, Vss) <+ cpphdl_channel(V(cpphdl_n2762, Vss), V(cpphdl_n2776, Vss), 0.0040000000000000001, 0.69999999999999996, 1.0);
        // device 2037, IC IC354, analog/basic/buffered_nand_latch.hpp:34
        I(cpphdl_n2754, Vss) <+ 2.0000000000000002e-15 * ddt(V(cpphdl_n2754, Vss)); // Bench initial voltage = 0.0 V.
        // device 2038, IC IC354, analog/basic/buffered_nand_latch.hpp:35
        I(cpphdl_n2754, cpphdl_n2762) <+ 1.0000000000000001e-15 * ddt(V(cpphdl_n2754, cpphdl_n2762)); // Bench initial voltage = 0.0 V.
        // device 2039, IC IC354, analog/basic/buffered_nand_latch.hpp:36
        I(cpphdl_n2762, Vss) <+ 5e-15 * ddt(V(cpphdl_n2762, Vss)); // Bench initial voltage = 0.0 V.
        // device 2040, IC IC354, analog/basic/buffered_nand_latch.hpp:37
        I(cpphdl_n2762, Vss) <+ 8.0000000000000006e-15 * ddt(V(cpphdl_n2762, Vss)); // Bench initial voltage = 0.0 V.
        // device 2041, IC IC354, analog/basic/buffered_nand_latch.hpp:38
        I(cpphdl_n2776, Vss) <+ 1e-14 * ddt(V(cpphdl_n2776, Vss)); // Bench initial voltage = 0.0 V.
        // device 2042, IC IC356, analog/basic/inverter.hpp:11
        I(cpphdl_n2766, Vdd) <+ cpphdl_channel(V(cpphdl_n2758, Vdd), V(cpphdl_n2766, Vdd), 0.001, 0.69999999999999996, -1.0);
        // device 2043, IC IC356, analog/basic/inverter.hpp:12
        I(cpphdl_n2766, Vss) <+ cpphdl_channel(V(cpphdl_n2758, Vss), V(cpphdl_n2766, Vss), 0.001, 0.69999999999999996, 1.0);
        // device 2044, IC IC358, analog/basic/inverter.hpp:11
        I(cpphdl_n2782, Vdd) <+ cpphdl_channel(V(cpphdl_n2766, Vdd), V(cpphdl_n2782, Vdd), 0.0040000000000000001, 0.69999999999999996, -1.0);
        // device 2045, IC IC358, analog/basic/inverter.hpp:12
        I(cpphdl_n2782, Vss) <+ cpphdl_channel(V(cpphdl_n2766, Vss), V(cpphdl_n2782, Vss), 0.0040000000000000001, 0.69999999999999996, 1.0);
        // device 2046, IC IC354, analog/basic/buffered_nand_latch.hpp:34
        I(cpphdl_n2758, Vss) <+ 2.0000000000000002e-15 * ddt(V(cpphdl_n2758, Vss)); // Bench initial voltage = 0.0 V.
        // device 2047, IC IC354, analog/basic/buffered_nand_latch.hpp:35
        I(cpphdl_n2758, cpphdl_n2766) <+ 1.0000000000000001e-15 * ddt(V(cpphdl_n2758, cpphdl_n2766)); // Bench initial voltage = 0.0 V.
        // device 2048, IC IC354, analog/basic/buffered_nand_latch.hpp:36
        I(cpphdl_n2766, Vss) <+ 5e-15 * ddt(V(cpphdl_n2766, Vss)); // Bench initial voltage = 0.0 V.
        // device 2049, IC IC354, analog/basic/buffered_nand_latch.hpp:37
        I(cpphdl_n2766, Vss) <+ 8.0000000000000006e-15 * ddt(V(cpphdl_n2766, Vss)); // Bench initial voltage = 0.0 V.
        // device 2050, IC IC354, analog/basic/buffered_nand_latch.hpp:38
        I(cpphdl_n2782, Vss) <+ 1e-14 * ddt(V(cpphdl_n2782, Vss)); // Bench initial voltage = 0.0 V.
        // device 2051, IC IC360, analog/basic/cmos_logic.hpp:17
        I(cpphdl_n3023, Vss) <+ 5.0000000000000002e-14 * ddt(V(cpphdl_n3023, Vss)); // Bench initial voltage = 0.0 V.
        // device 2052, IC IC360, analog/basic/cmos_logic.hpp:18
        I(cpphdl_n3023, Vdd) <+ cpphdl_channel(V(cpphdl_n2776, Vdd), V(cpphdl_n3023, Vdd), 0.01, 0.69999999999999996, -1.0);
        // device 2053, IC IC360, analog/basic/cmos_logic.hpp:19
        I(cpphdl_n3023, Vdd) <+ cpphdl_channel(V(cpphdl_n2784, Vdd), V(cpphdl_n3023, Vdd), 0.01, 0.69999999999999996, -1.0);
        // device 2054, IC IC360, analog/basic/cmos_logic.hpp:20
        I(cpphdl_n3023, cpphdl_n2779) <+ cpphdl_channel(V(cpphdl_n2776, cpphdl_n2779), V(cpphdl_n3023, cpphdl_n2779), 0.01, 0.69999999999999996, 1.0);
        // device 2055, IC IC360, analog/basic/cmos_logic.hpp:21
        I(cpphdl_n2779, Vss) <+ cpphdl_channel(V(cpphdl_n2784, Vss), V(cpphdl_n2779, Vss), 0.01, 0.69999999999999996, 1.0);
        // device 2056, IC IC360, analog/basic/cmos_logic.hpp:27
        I(cpphdl_n2779, Vss) <+ 1e-14 * ddt(V(cpphdl_n2779, Vss)); // Bench initial voltage = 0.0 V.
        // device 2057, IC IC361, analog/basic/cmos_logic.hpp:17
        I(cpphdl_n2784, Vss) <+ 5.0000000000000002e-14 * ddt(V(cpphdl_n2784, Vss)); // Bench initial voltage = 0.0 V.
        // device 2058, IC IC361, analog/basic/cmos_logic.hpp:18
        I(cpphdl_n2784, Vdd) <+ cpphdl_channel(V(cpphdl_n2782, Vdd), V(cpphdl_n2784, Vdd), 0.01, 0.69999999999999996, -1.0);
        // device 2059, IC IC361, analog/basic/cmos_logic.hpp:19
        I(cpphdl_n2784, Vdd) <+ cpphdl_channel(V(cpphdl_n3023, Vdd), V(cpphdl_n2784, Vdd), 0.01, 0.69999999999999996, -1.0);
        // device 2060, IC IC361, analog/basic/cmos_logic.hpp:20
        I(cpphdl_n2784, cpphdl_n2785) <+ cpphdl_channel(V(cpphdl_n2782, cpphdl_n2785), V(cpphdl_n2784, cpphdl_n2785), 0.01, 0.69999999999999996, 1.0);
        // device 2061, IC IC361, analog/basic/cmos_logic.hpp:21
        I(cpphdl_n2785, Vss) <+ cpphdl_channel(V(cpphdl_n3023, Vss), V(cpphdl_n2785, Vss), 0.01, 0.69999999999999996, 1.0);
        // device 2062, IC IC361, analog/basic/cmos_logic.hpp:27
        I(cpphdl_n2785, Vss) <+ 1e-14 * ddt(V(cpphdl_n2785, Vss)); // Bench initial voltage = 0.0 V.
        // device 2063, IC IC359, analog/basic/nand_latch.hpp:36
        I(cpphdl_n2776, Vss) <+ 2.9999999999999998e-15 * ddt(V(cpphdl_n2776, Vss)); // Bench initial voltage = 0.0 V.
        // device 2064, IC IC359, analog/basic/nand_latch.hpp:37
        I(cpphdl_n2782, Vss) <+ 2.9999999999999998e-15 * ddt(V(cpphdl_n2782, Vss)); // Bench initial voltage = 0.0 V.
        // device 2065, IC IC362, analog/basic/inverter.hpp:11
        I(cpphdl_n2790, Vdd) <+ cpphdl_channel(V(CLEAR, Vdd), V(cpphdl_n2790, Vdd), 0.01, 0.69999999999999996, -1.0);
        // device 2066, IC IC362, analog/basic/inverter.hpp:12
        I(cpphdl_n2790, Vss) <+ cpphdl_channel(V(CLEAR, Vss), V(cpphdl_n2790, Vss), 0.01, 0.69999999999999996, 1.0);
        // device 2067, IC IC359, analog/basic/nand_latch.hpp:58
        I(cpphdl_n2790, Vss) <+ 2.9999999999999998e-15 * ddt(V(cpphdl_n2790, Vss)); // Bench initial voltage = 0.0 V.
        // device 2068, IC IC359, analog/basic/nand_latch.hpp:59
        I(cpphdl_n3023, Vss) <+ cpphdl_channel(V(CLEAR, Vss), V(cpphdl_n3023, Vss), 0.050000000000000003, 0.69999999999999996, 1.0);
        // device 2069, IC IC359, analog/basic/nand_latch.hpp:60
        I(cpphdl_n2784, Vdd) <+ cpphdl_channel(V(cpphdl_n2790, Vdd), V(cpphdl_n2784, Vdd), 0.050000000000000003, 0.69999999999999996, -1.0);
        // device 2070, IC IC365, analog/basic/inverter.hpp:11
        I(cpphdl_n2814, Vdd) <+ cpphdl_channel(V(TRACK15, Vdd), V(cpphdl_n2814, Vdd), 0.0040000000000000001, 0.69999999999999996, -1.0);
        // device 2071, IC IC365, analog/basic/inverter.hpp:12
        I(cpphdl_n2814, Vss) <+ cpphdl_channel(V(TRACK15, Vss), V(cpphdl_n2814, Vss), 0.0040000000000000001, 0.69999999999999996, 1.0);
        // device 2072, IC IC364, analog/basic/mos_track_hold.hpp:31
        I(cpphdl_n2814, Vss) <+ 2e-14 * ddt(V(cpphdl_n2814, Vss)); // Bench initial voltage = 0.0 V.
        // device 2073, IC IC364, analog/basic/mos_track_hold.hpp:32
        I(cpphdl_n2808, cpphdl_n2868) <+ cpphdl_channel(V(TRACK15, cpphdl_n2868), V(cpphdl_n2808, cpphdl_n2868), 0.029999999999999999, 0.69999999999999996, 1.0);
        // device 2074, IC IC364, analog/basic/mos_track_hold.hpp:33
        I(cpphdl_n2868, cpphdl_n2808) <+ cpphdl_channel(V(cpphdl_n2814, cpphdl_n2808), V(cpphdl_n2868, cpphdl_n2808), 0.014999999999999999, 0.69999999999999996, -1.0);
        // device 2075, IC IC364, analog/basic/mos_track_hold.hpp:37
        I(cpphdl_n2868, cpphdl_n2868) <+ cpphdl_channel(V(cpphdl_n2814, cpphdl_n2868), V(cpphdl_n2868, cpphdl_n2868), 0.016, 0.69999999999999996, 1.0);
        // device 2076, IC IC364, analog/basic/mos_track_hold.hpp:38
        I(cpphdl_n2868, cpphdl_n2868) <+ cpphdl_channel(V(TRACK15, cpphdl_n2868), V(cpphdl_n2868, cpphdl_n2868), 0.0083999999999999995, 0.69999999999999996, -1.0);
        // device 2077, IC IC364, analog/basic/mos_track_hold.hpp:39
        I(cpphdl_n2868, Vss) <+ 1.5000000000000001e-12 * ddt(V(cpphdl_n2868, Vss)); // Bench initial voltage = 0.0 V.
        // device 2078, IC IC364, analog/basic/mos_track_hold.hpp:42
        I(TRACK15, cpphdl_n2868) <+ 2.0000000000000002e-15 * ddt(V(TRACK15, cpphdl_n2868)); // Bench initial voltage = -0.0 V.
        // device 2079, IC IC364, analog/basic/mos_track_hold.hpp:43
        I(cpphdl_n2814, cpphdl_n2868) <+ 2.0000000000000002e-15 * ddt(V(cpphdl_n2814, cpphdl_n2868)); // Bench initial voltage = 0.0 V.
        // device 2080, IC IC364, analog/basic/mos_track_hold.hpp:44
        I(cpphdl_n2808, cpphdl_n2868) <+ 1.0000000000000001e-15 * ddt(V(cpphdl_n2808, cpphdl_n2868)); // Bench initial voltage = 0.0 V.
        // device 2081, IC IC367, analog/basic/inverter.hpp:11
        I(cpphdl_n2829, Vdd) <+ cpphdl_channel(V(BIT_N15_0, Vdd), V(cpphdl_n2829, Vdd), 0.080000000000000002, 0.69999999999999996, -1.0);
        // device 2082, IC IC367, analog/basic/inverter.hpp:12
        I(cpphdl_n2829, Vss) <+ cpphdl_channel(V(BIT_N15_0, Vss), V(cpphdl_n2829, Vss), 0.080000000000000002, 0.69999999999999996, 1.0);
        // device 2083, IC IC366, analog/basic/mos_r2r_dac.hpp:27
        I(cpphdl_n2829, Vss) <+ 2.9999999999999998e-15 * ddt(V(cpphdl_n2829, Vss)); // Bench initial voltage = 0.0 V.
        // device 2084, IC IC366, analog/basic/mos_r2r_dac.hpp:28
        I(cpphdl_n2829, cpphdl_n2858) <+ V(cpphdl_n2829, cpphdl_n2858) / 2000.0;
        // device 2085, IC IC366, analog/basic/mos_r2r_dac.hpp:29
        I(cpphdl_n2858, Vss) <+ 2.9999999999999998e-15 * ddt(V(cpphdl_n2858, Vss)); // Bench initial voltage = 0.0 V.
        // device 2086, IC IC368, analog/basic/inverter.hpp:11
        I(cpphdl_n2833, Vdd) <+ cpphdl_channel(V(BIT_N15_1, Vdd), V(cpphdl_n2833, Vdd), 0.080000000000000002, 0.69999999999999996, -1.0);
        // device 2087, IC IC368, analog/basic/inverter.hpp:12
        I(cpphdl_n2833, Vss) <+ cpphdl_channel(V(BIT_N15_1, Vss), V(cpphdl_n2833, Vss), 0.080000000000000002, 0.69999999999999996, 1.0);
        // device 2088, IC IC366, analog/basic/mos_r2r_dac.hpp:27
        I(cpphdl_n2833, Vss) <+ 2.9999999999999998e-15 * ddt(V(cpphdl_n2833, Vss)); // Bench initial voltage = 0.0 V.
        // device 2089, IC IC366, analog/basic/mos_r2r_dac.hpp:28
        I(cpphdl_n2833, cpphdl_n2859) <+ V(cpphdl_n2833, cpphdl_n2859) / 2000.0;
        // device 2090, IC IC366, analog/basic/mos_r2r_dac.hpp:29
        I(cpphdl_n2859, Vss) <+ 2.9999999999999998e-15 * ddt(V(cpphdl_n2859, Vss)); // Bench initial voltage = 0.0 V.
        // device 2091, IC IC366, analog/basic/mos_r2r_dac.hpp:31
        I(cpphdl_n2858, cpphdl_n2859) <+ V(cpphdl_n2858, cpphdl_n2859) / 1000.0;
        // device 2092, IC IC369, analog/basic/inverter.hpp:11
        I(cpphdl_n2837, Vdd) <+ cpphdl_channel(V(BIT_N15_2, Vdd), V(cpphdl_n2837, Vdd), 0.080000000000000002, 0.69999999999999996, -1.0);
        // device 2093, IC IC369, analog/basic/inverter.hpp:12
        I(cpphdl_n2837, Vss) <+ cpphdl_channel(V(BIT_N15_2, Vss), V(cpphdl_n2837, Vss), 0.080000000000000002, 0.69999999999999996, 1.0);
        // device 2094, IC IC366, analog/basic/mos_r2r_dac.hpp:27
        I(cpphdl_n2837, Vss) <+ 2.9999999999999998e-15 * ddt(V(cpphdl_n2837, Vss)); // Bench initial voltage = 0.0 V.
        // device 2095, IC IC366, analog/basic/mos_r2r_dac.hpp:28
        I(cpphdl_n2837, cpphdl_n2860) <+ V(cpphdl_n2837, cpphdl_n2860) / 2000.0;
        // device 2096, IC IC366, analog/basic/mos_r2r_dac.hpp:29
        I(cpphdl_n2860, Vss) <+ 2.9999999999999998e-15 * ddt(V(cpphdl_n2860, Vss)); // Bench initial voltage = 0.0 V.
        // device 2097, IC IC366, analog/basic/mos_r2r_dac.hpp:31
        I(cpphdl_n2859, cpphdl_n2860) <+ V(cpphdl_n2859, cpphdl_n2860) / 1000.0;
        // device 2098, IC IC370, analog/basic/inverter.hpp:11
        I(cpphdl_n2841, Vdd) <+ cpphdl_channel(V(BIT_N15_3, Vdd), V(cpphdl_n2841, Vdd), 0.080000000000000002, 0.69999999999999996, -1.0);
        // device 2099, IC IC370, analog/basic/inverter.hpp:12
        I(cpphdl_n2841, Vss) <+ cpphdl_channel(V(BIT_N15_3, Vss), V(cpphdl_n2841, Vss), 0.080000000000000002, 0.69999999999999996, 1.0);
        // device 2100, IC IC366, analog/basic/mos_r2r_dac.hpp:27
        I(cpphdl_n2841, Vss) <+ 2.9999999999999998e-15 * ddt(V(cpphdl_n2841, Vss)); // Bench initial voltage = 0.0 V.
        // device 2101, IC IC366, analog/basic/mos_r2r_dac.hpp:28
        I(cpphdl_n2841, cpphdl_n2861) <+ V(cpphdl_n2841, cpphdl_n2861) / 2000.0;
        // device 2102, IC IC366, analog/basic/mos_r2r_dac.hpp:29
        I(cpphdl_n2861, Vss) <+ 2.9999999999999998e-15 * ddt(V(cpphdl_n2861, Vss)); // Bench initial voltage = 0.0 V.
        // device 2103, IC IC366, analog/basic/mos_r2r_dac.hpp:31
        I(cpphdl_n2860, cpphdl_n2861) <+ V(cpphdl_n2860, cpphdl_n2861) / 1000.0;
        // device 2104, IC IC371, analog/basic/inverter.hpp:11
        I(cpphdl_n2845, Vdd) <+ cpphdl_channel(V(BIT_N15_4, Vdd), V(cpphdl_n2845, Vdd), 0.080000000000000002, 0.69999999999999996, -1.0);
        // device 2105, IC IC371, analog/basic/inverter.hpp:12
        I(cpphdl_n2845, Vss) <+ cpphdl_channel(V(BIT_N15_4, Vss), V(cpphdl_n2845, Vss), 0.080000000000000002, 0.69999999999999996, 1.0);
        // device 2106, IC IC366, analog/basic/mos_r2r_dac.hpp:27
        I(cpphdl_n2845, Vss) <+ 2.9999999999999998e-15 * ddt(V(cpphdl_n2845, Vss)); // Bench initial voltage = 0.0 V.
        // device 2107, IC IC366, analog/basic/mos_r2r_dac.hpp:28
        I(cpphdl_n2845, cpphdl_n2862) <+ V(cpphdl_n2845, cpphdl_n2862) / 2000.0;
        // device 2108, IC IC366, analog/basic/mos_r2r_dac.hpp:29
        I(cpphdl_n2862, Vss) <+ 2.9999999999999998e-15 * ddt(V(cpphdl_n2862, Vss)); // Bench initial voltage = 0.0 V.
        // device 2109, IC IC366, analog/basic/mos_r2r_dac.hpp:31
        I(cpphdl_n2861, cpphdl_n2862) <+ V(cpphdl_n2861, cpphdl_n2862) / 1000.0;
        // device 2110, IC IC372, analog/basic/inverter.hpp:11
        I(cpphdl_n2849, Vdd) <+ cpphdl_channel(V(BIT_N15_5, Vdd), V(cpphdl_n2849, Vdd), 0.080000000000000002, 0.69999999999999996, -1.0);
        // device 2111, IC IC372, analog/basic/inverter.hpp:12
        I(cpphdl_n2849, Vss) <+ cpphdl_channel(V(BIT_N15_5, Vss), V(cpphdl_n2849, Vss), 0.080000000000000002, 0.69999999999999996, 1.0);
        // device 2112, IC IC366, analog/basic/mos_r2r_dac.hpp:27
        I(cpphdl_n2849, Vss) <+ 2.9999999999999998e-15 * ddt(V(cpphdl_n2849, Vss)); // Bench initial voltage = 0.0 V.
        // device 2113, IC IC366, analog/basic/mos_r2r_dac.hpp:28
        I(cpphdl_n2849, cpphdl_n2863) <+ V(cpphdl_n2849, cpphdl_n2863) / 2000.0;
        // device 2114, IC IC366, analog/basic/mos_r2r_dac.hpp:29
        I(cpphdl_n2863, Vss) <+ 2.9999999999999998e-15 * ddt(V(cpphdl_n2863, Vss)); // Bench initial voltage = 0.0 V.
        // device 2115, IC IC366, analog/basic/mos_r2r_dac.hpp:31
        I(cpphdl_n2862, cpphdl_n2863) <+ V(cpphdl_n2862, cpphdl_n2863) / 1000.0;
        // device 2116, IC IC373, analog/basic/inverter.hpp:11
        I(cpphdl_n2853, Vdd) <+ cpphdl_channel(V(BIT_N15_6, Vdd), V(cpphdl_n2853, Vdd), 0.080000000000000002, 0.69999999999999996, -1.0);
        // device 2117, IC IC373, analog/basic/inverter.hpp:12
        I(cpphdl_n2853, Vss) <+ cpphdl_channel(V(BIT_N15_6, Vss), V(cpphdl_n2853, Vss), 0.080000000000000002, 0.69999999999999996, 1.0);
        // device 2118, IC IC366, analog/basic/mos_r2r_dac.hpp:27
        I(cpphdl_n2853, Vss) <+ 2.9999999999999998e-15 * ddt(V(cpphdl_n2853, Vss)); // Bench initial voltage = 0.0 V.
        // device 2119, IC IC366, analog/basic/mos_r2r_dac.hpp:28
        I(cpphdl_n2853, cpphdl_n2864) <+ V(cpphdl_n2853, cpphdl_n2864) / 2000.0;
        // device 2120, IC IC366, analog/basic/mos_r2r_dac.hpp:29
        I(cpphdl_n2864, Vss) <+ 2.9999999999999998e-15 * ddt(V(cpphdl_n2864, Vss)); // Bench initial voltage = 0.0 V.
        // device 2121, IC IC366, analog/basic/mos_r2r_dac.hpp:31
        I(cpphdl_n2863, cpphdl_n2864) <+ V(cpphdl_n2863, cpphdl_n2864) / 1000.0;
        // device 2122, IC IC374, analog/basic/inverter.hpp:11
        I(cpphdl_n2857, Vdd) <+ cpphdl_channel(V(BIT_N15_7, Vdd), V(cpphdl_n2857, Vdd), 0.080000000000000002, 0.69999999999999996, -1.0);
        // device 2123, IC IC374, analog/basic/inverter.hpp:12
        I(cpphdl_n2857, Vss) <+ cpphdl_channel(V(BIT_N15_7, Vss), V(cpphdl_n2857, Vss), 0.080000000000000002, 0.69999999999999996, 1.0);
        // device 2124, IC IC366, analog/basic/mos_r2r_dac.hpp:27
        I(cpphdl_n2857, Vss) <+ 2.9999999999999998e-15 * ddt(V(cpphdl_n2857, Vss)); // Bench initial voltage = 0.0 V.
        // device 2125, IC IC366, analog/basic/mos_r2r_dac.hpp:28
        I(cpphdl_n2857, cpphdl_n2869) <+ V(cpphdl_n2857, cpphdl_n2869) / 2000.0;
        // device 2126, IC IC366, analog/basic/mos_r2r_dac.hpp:29
        I(cpphdl_n2869, Vss) <+ 2.9999999999999998e-15 * ddt(V(cpphdl_n2869, Vss)); // Bench initial voltage = 0.0 V.
        // device 2127, IC IC366, analog/basic/mos_r2r_dac.hpp:31
        I(cpphdl_n2864, cpphdl_n2869) <+ V(cpphdl_n2864, cpphdl_n2869) / 1000.0;
        // device 2128, IC IC366, analog/basic/mos_r2r_dac.hpp:33
        I(Vss, cpphdl_n2858) <+ V(Vss, cpphdl_n2858) / 2000.0;
        // device 2129, IC IC375, analog/basic/nmos_resistor_amplifier.hpp:23
        I(Vdd, cpphdl_n2878) <+ V(Vdd, cpphdl_n2878) / 1000.0;
        // device 2130, IC IC375, analog/basic/nmos_resistor_amplifier.hpp:24
        I(Vdd, cpphdl_n2877) <+ V(Vdd, cpphdl_n2877) / 1000.0;
        // device 2131, IC IC375, analog/basic/nmos_resistor_amplifier.hpp:25
        I(cpphdl_n2878, cpphdl_n2872) <+ cpphdl_channel(V(cpphdl_n2868, cpphdl_n2872), V(cpphdl_n2878, cpphdl_n2872), 0.0074999999999999997, 0.69999999999999996, 1.0);
        // device 2132, IC IC375, analog/basic/nmos_resistor_amplifier.hpp:26
        I(cpphdl_n2877, cpphdl_n2873) <+ cpphdl_channel(V(cpphdl_n2869, cpphdl_n2873), V(cpphdl_n2877, cpphdl_n2873), 0.0074999999999999997, 0.69999999999999996, 1.0);
        // device 2133, IC IC375, analog/basic/nmos_resistor_amplifier.hpp:27
        I(cpphdl_n2874, cpphdl_n2872) <+ V(cpphdl_n2874, cpphdl_n2872) / 100.0;
        // device 2134, IC IC375, analog/basic/nmos_resistor_amplifier.hpp:28
        I(cpphdl_n2874, cpphdl_n2873) <+ V(cpphdl_n2874, cpphdl_n2873) / 100.0;
        // device 2135, IC IC375, analog/basic/nmos_resistor_amplifier.hpp:29
        I(Vss, cpphdl_n2874) <+ V(Vss, cpphdl_n2874) / 300.0;
        // device 2136, IC IC375, analog/basic/nmos_resistor_amplifier.hpp:30
        I(cpphdl_n2878, Vdd) <+ 2.9999999999999998e-13 * ddt(V(cpphdl_n2878, Vdd)); // Bench initial voltage = 0.0 V.
        // device 2137, IC IC375, analog/basic/nmos_resistor_amplifier.hpp:31
        I(cpphdl_n2877, Vdd) <+ 2.9999999999999998e-13 * ddt(V(cpphdl_n2877, Vdd)); // Bench initial voltage = 0.0 V.
        // device 2138, IC IC375, analog/basic/nmos_resistor_amplifier.hpp:32
        I(cpphdl_n2874, Vss) <+ 4e-14 * ddt(V(cpphdl_n2874, Vss)); // Bench initial voltage = 0.0 V.
        // device 2139, IC IC375, analog/basic/nmos_resistor_amplifier.hpp:34
        I(cpphdl_n2868, cpphdl_n2872) <+ 2e-14 * ddt(V(cpphdl_n2868, cpphdl_n2872)); // Bench initial voltage = 0.0 V.
        // device 2140, IC IC375, analog/basic/nmos_resistor_amplifier.hpp:35
        I(cpphdl_n2869, cpphdl_n2873) <+ 2e-14 * ddt(V(cpphdl_n2869, cpphdl_n2873)); // Bench initial voltage = 0.0 V.
        // device 2141, IC IC375, analog/basic/nmos_resistor_amplifier.hpp:36
        I(cpphdl_n2868, cpphdl_n2878) <+ 2.9999999999999998e-15 * ddt(V(cpphdl_n2868, cpphdl_n2878)); // Bench initial voltage = 0.0 V.
        // device 2142, IC IC375, analog/basic/nmos_resistor_amplifier.hpp:37
        I(cpphdl_n2869, cpphdl_n2877) <+ 2.9999999999999998e-15 * ddt(V(cpphdl_n2869, cpphdl_n2877)); // Bench initial voltage = 0.0 V.
        // device 2143, IC IC376, analog/basic/strongarm_comparator.hpp:28
        I(cpphdl_n2882, cpphdl_n2884) <+ cpphdl_channel(V(cpphdl_n2877, cpphdl_n2884), V(cpphdl_n2882, cpphdl_n2884), 0.0080000000000000002, 0.69999999999999996, 1.0);
        // device 2144, IC IC376, analog/basic/strongarm_comparator.hpp:29
        I(cpphdl_n2883, cpphdl_n2884) <+ cpphdl_channel(V(cpphdl_n2878, cpphdl_n2884), V(cpphdl_n2883, cpphdl_n2884), 0.0080000000000000002, 0.69999999999999996, 1.0);
        // device 2145, IC IC376, analog/basic/strongarm_comparator.hpp:30
        I(cpphdl_n2884, Vss) <+ cpphdl_channel(V(EVALUATE, Vss), V(cpphdl_n2884, Vss), 0.0080000000000000002, 0.69999999999999996, 1.0);
        // device 2146, IC IC376, analog/basic/strongarm_comparator.hpp:33
        I(cpphdl_n2897, cpphdl_n2882) <+ cpphdl_channel(V(cpphdl_n2901, cpphdl_n2882), V(cpphdl_n2897, cpphdl_n2882), 0.0040000000000000001, 0.69999999999999996, 1.0);
        // device 2147, IC IC376, analog/basic/strongarm_comparator.hpp:34
        I(cpphdl_n2901, cpphdl_n2883) <+ cpphdl_channel(V(cpphdl_n2897, cpphdl_n2883), V(cpphdl_n2901, cpphdl_n2883), 0.0040000000000000001, 0.69999999999999996, 1.0);
        // device 2148, IC IC376, analog/basic/strongarm_comparator.hpp:35
        I(cpphdl_n2901, Vdd) <+ cpphdl_channel(V(cpphdl_n2897, Vdd), V(cpphdl_n2901, Vdd), 0.002, 0.69999999999999996, -1.0);
        // device 2149, IC IC376, analog/basic/strongarm_comparator.hpp:36
        I(cpphdl_n2897, Vdd) <+ cpphdl_channel(V(cpphdl_n2901, Vdd), V(cpphdl_n2897, Vdd), 0.002, 0.69999999999999996, -1.0);
        // device 2150, IC IC376, analog/basic/strongarm_comparator.hpp:38
        I(cpphdl_n2882, Vdd) <+ cpphdl_channel(V(EVALUATE, Vdd), V(cpphdl_n2882, Vdd), 0.002, 0.69999999999999996, -1.0);
        // device 2151, IC IC376, analog/basic/strongarm_comparator.hpp:39
        I(cpphdl_n2883, Vdd) <+ cpphdl_channel(V(EVALUATE, Vdd), V(cpphdl_n2883, Vdd), 0.002, 0.69999999999999996, -1.0);
        // device 2152, IC IC376, analog/basic/strongarm_comparator.hpp:40
        I(cpphdl_n2901, Vdd) <+ cpphdl_channel(V(EVALUATE, Vdd), V(cpphdl_n2901, Vdd), 0.002, 0.69999999999999996, -1.0);
        // device 2153, IC IC376, analog/basic/strongarm_comparator.hpp:41
        I(cpphdl_n2897, Vdd) <+ cpphdl_channel(V(EVALUATE, Vdd), V(cpphdl_n2897, Vdd), 0.002, 0.69999999999999996, -1.0);
        // device 2154, IC IC376, analog/basic/strongarm_comparator.hpp:42
        I(cpphdl_n2882, Vss) <+ 2.9999999999999998e-14 * ddt(V(cpphdl_n2882, Vss)); // Bench initial voltage = 0.0 V.
        // device 2155, IC IC376, analog/basic/strongarm_comparator.hpp:43
        I(cpphdl_n2883, Vss) <+ 2.9999999999999998e-14 * ddt(V(cpphdl_n2883, Vss)); // Bench initial voltage = 0.0 V.
        // device 2156, IC IC376, analog/basic/strongarm_comparator.hpp:44
        I(cpphdl_n2884, Vss) <+ 2.9999999999999998e-14 * ddt(V(cpphdl_n2884, Vss)); // Bench initial voltage = 0.0 V.
        // device 2157, IC IC376, analog/basic/strongarm_comparator.hpp:45
        I(cpphdl_n2901, Vss) <+ 5.0000000000000002e-14 * ddt(V(cpphdl_n2901, Vss)); // Bench initial voltage = 0.0 V.
        // device 2158, IC IC376, analog/basic/strongarm_comparator.hpp:46
        I(cpphdl_n2897, Vss) <+ 5.0000000000000002e-14 * ddt(V(cpphdl_n2897, Vss)); // Bench initial voltage = 0.0 V.
        // device 2159, IC IC376, analog/basic/strongarm_comparator.hpp:47
        I(cpphdl_n2877, cpphdl_n2884) <+ 2e-14 * ddt(V(cpphdl_n2877, cpphdl_n2884)); // Bench initial voltage = 0.0 V.
        // device 2160, IC IC376, analog/basic/strongarm_comparator.hpp:48
        I(cpphdl_n2878, cpphdl_n2884) <+ 2e-14 * ddt(V(cpphdl_n2878, cpphdl_n2884)); // Bench initial voltage = 0.0 V.
        // device 2161, IC IC376, analog/basic/strongarm_comparator.hpp:49
        I(cpphdl_n2877, cpphdl_n2882) <+ 2.9999999999999998e-15 * ddt(V(cpphdl_n2877, cpphdl_n2882)); // Bench initial voltage = 0.0 V.
        // device 2162, IC IC376, analog/basic/strongarm_comparator.hpp:50
        I(cpphdl_n2878, cpphdl_n2883) <+ 2.9999999999999998e-15 * ddt(V(cpphdl_n2878, cpphdl_n2883)); // Bench initial voltage = 0.0 V.
        // device 2163, IC IC378, analog/basic/inverter.hpp:11
        I(cpphdl_n2905, Vdd) <+ cpphdl_channel(V(cpphdl_n2897, Vdd), V(cpphdl_n2905, Vdd), 0.001, 0.69999999999999996, -1.0);
        // device 2164, IC IC378, analog/basic/inverter.hpp:12
        I(cpphdl_n2905, Vss) <+ cpphdl_channel(V(cpphdl_n2897, Vss), V(cpphdl_n2905, Vss), 0.001, 0.69999999999999996, 1.0);
        // device 2165, IC IC380, analog/basic/inverter.hpp:11
        I(cpphdl_n2919, Vdd) <+ cpphdl_channel(V(cpphdl_n2905, Vdd), V(cpphdl_n2919, Vdd), 0.0040000000000000001, 0.69999999999999996, -1.0);
        // device 2166, IC IC380, analog/basic/inverter.hpp:12
        I(cpphdl_n2919, Vss) <+ cpphdl_channel(V(cpphdl_n2905, Vss), V(cpphdl_n2919, Vss), 0.0040000000000000001, 0.69999999999999996, 1.0);
        // device 2167, IC IC377, analog/basic/buffered_nand_latch.hpp:34
        I(cpphdl_n2897, Vss) <+ 2.0000000000000002e-15 * ddt(V(cpphdl_n2897, Vss)); // Bench initial voltage = 0.0 V.
        // device 2168, IC IC377, analog/basic/buffered_nand_latch.hpp:35
        I(cpphdl_n2897, cpphdl_n2905) <+ 1.0000000000000001e-15 * ddt(V(cpphdl_n2897, cpphdl_n2905)); // Bench initial voltage = 0.0 V.
        // device 2169, IC IC377, analog/basic/buffered_nand_latch.hpp:36
        I(cpphdl_n2905, Vss) <+ 5e-15 * ddt(V(cpphdl_n2905, Vss)); // Bench initial voltage = 0.0 V.
        // device 2170, IC IC377, analog/basic/buffered_nand_latch.hpp:37
        I(cpphdl_n2905, Vss) <+ 8.0000000000000006e-15 * ddt(V(cpphdl_n2905, Vss)); // Bench initial voltage = 0.0 V.
        // device 2171, IC IC377, analog/basic/buffered_nand_latch.hpp:38
        I(cpphdl_n2919, Vss) <+ 1e-14 * ddt(V(cpphdl_n2919, Vss)); // Bench initial voltage = 0.0 V.
        // device 2172, IC IC379, analog/basic/inverter.hpp:11
        I(cpphdl_n2909, Vdd) <+ cpphdl_channel(V(cpphdl_n2901, Vdd), V(cpphdl_n2909, Vdd), 0.001, 0.69999999999999996, -1.0);
        // device 2173, IC IC379, analog/basic/inverter.hpp:12
        I(cpphdl_n2909, Vss) <+ cpphdl_channel(V(cpphdl_n2901, Vss), V(cpphdl_n2909, Vss), 0.001, 0.69999999999999996, 1.0);
        // device 2174, IC IC381, analog/basic/inverter.hpp:11
        I(cpphdl_n2925, Vdd) <+ cpphdl_channel(V(cpphdl_n2909, Vdd), V(cpphdl_n2925, Vdd), 0.0040000000000000001, 0.69999999999999996, -1.0);
        // device 2175, IC IC381, analog/basic/inverter.hpp:12
        I(cpphdl_n2925, Vss) <+ cpphdl_channel(V(cpphdl_n2909, Vss), V(cpphdl_n2925, Vss), 0.0040000000000000001, 0.69999999999999996, 1.0);
        // device 2176, IC IC377, analog/basic/buffered_nand_latch.hpp:34
        I(cpphdl_n2901, Vss) <+ 2.0000000000000002e-15 * ddt(V(cpphdl_n2901, Vss)); // Bench initial voltage = 0.0 V.
        // device 2177, IC IC377, analog/basic/buffered_nand_latch.hpp:35
        I(cpphdl_n2901, cpphdl_n2909) <+ 1.0000000000000001e-15 * ddt(V(cpphdl_n2901, cpphdl_n2909)); // Bench initial voltage = 0.0 V.
        // device 2178, IC IC377, analog/basic/buffered_nand_latch.hpp:36
        I(cpphdl_n2909, Vss) <+ 5e-15 * ddt(V(cpphdl_n2909, Vss)); // Bench initial voltage = 0.0 V.
        // device 2179, IC IC377, analog/basic/buffered_nand_latch.hpp:37
        I(cpphdl_n2909, Vss) <+ 8.0000000000000006e-15 * ddt(V(cpphdl_n2909, Vss)); // Bench initial voltage = 0.0 V.
        // device 2180, IC IC377, analog/basic/buffered_nand_latch.hpp:38
        I(cpphdl_n2925, Vss) <+ 1e-14 * ddt(V(cpphdl_n2925, Vss)); // Bench initial voltage = 0.0 V.
        // device 2181, IC IC383, analog/basic/cmos_logic.hpp:17
        I(cpphdl_n3028, Vss) <+ 5.0000000000000002e-14 * ddt(V(cpphdl_n3028, Vss)); // Bench initial voltage = 0.0 V.
        // device 2182, IC IC383, analog/basic/cmos_logic.hpp:18
        I(cpphdl_n3028, Vdd) <+ cpphdl_channel(V(cpphdl_n2919, Vdd), V(cpphdl_n3028, Vdd), 0.01, 0.69999999999999996, -1.0);
        // device 2183, IC IC383, analog/basic/cmos_logic.hpp:19
        I(cpphdl_n3028, Vdd) <+ cpphdl_channel(V(cpphdl_n2927, Vdd), V(cpphdl_n3028, Vdd), 0.01, 0.69999999999999996, -1.0);
        // device 2184, IC IC383, analog/basic/cmos_logic.hpp:20
        I(cpphdl_n3028, cpphdl_n2922) <+ cpphdl_channel(V(cpphdl_n2919, cpphdl_n2922), V(cpphdl_n3028, cpphdl_n2922), 0.01, 0.69999999999999996, 1.0);
        // device 2185, IC IC383, analog/basic/cmos_logic.hpp:21
        I(cpphdl_n2922, Vss) <+ cpphdl_channel(V(cpphdl_n2927, Vss), V(cpphdl_n2922, Vss), 0.01, 0.69999999999999996, 1.0);
        // device 2186, IC IC383, analog/basic/cmos_logic.hpp:27
        I(cpphdl_n2922, Vss) <+ 1e-14 * ddt(V(cpphdl_n2922, Vss)); // Bench initial voltage = 0.0 V.
        // device 2187, IC IC384, analog/basic/cmos_logic.hpp:17
        I(cpphdl_n2927, Vss) <+ 5.0000000000000002e-14 * ddt(V(cpphdl_n2927, Vss)); // Bench initial voltage = 0.0 V.
        // device 2188, IC IC384, analog/basic/cmos_logic.hpp:18
        I(cpphdl_n2927, Vdd) <+ cpphdl_channel(V(cpphdl_n2925, Vdd), V(cpphdl_n2927, Vdd), 0.01, 0.69999999999999996, -1.0);
        // device 2189, IC IC384, analog/basic/cmos_logic.hpp:19
        I(cpphdl_n2927, Vdd) <+ cpphdl_channel(V(cpphdl_n3028, Vdd), V(cpphdl_n2927, Vdd), 0.01, 0.69999999999999996, -1.0);
        // device 2190, IC IC384, analog/basic/cmos_logic.hpp:20
        I(cpphdl_n2927, cpphdl_n2928) <+ cpphdl_channel(V(cpphdl_n2925, cpphdl_n2928), V(cpphdl_n2927, cpphdl_n2928), 0.01, 0.69999999999999996, 1.0);
        // device 2191, IC IC384, analog/basic/cmos_logic.hpp:21
        I(cpphdl_n2928, Vss) <+ cpphdl_channel(V(cpphdl_n3028, Vss), V(cpphdl_n2928, Vss), 0.01, 0.69999999999999996, 1.0);
        // device 2192, IC IC384, analog/basic/cmos_logic.hpp:27
        I(cpphdl_n2928, Vss) <+ 1e-14 * ddt(V(cpphdl_n2928, Vss)); // Bench initial voltage = 0.0 V.
        // device 2193, IC IC382, analog/basic/nand_latch.hpp:36
        I(cpphdl_n2919, Vss) <+ 2.9999999999999998e-15 * ddt(V(cpphdl_n2919, Vss)); // Bench initial voltage = 0.0 V.
        // device 2194, IC IC382, analog/basic/nand_latch.hpp:37
        I(cpphdl_n2925, Vss) <+ 2.9999999999999998e-15 * ddt(V(cpphdl_n2925, Vss)); // Bench initial voltage = 0.0 V.
        // device 2195, IC IC385, analog/basic/inverter.hpp:11
        I(cpphdl_n2933, Vdd) <+ cpphdl_channel(V(CLEAR, Vdd), V(cpphdl_n2933, Vdd), 0.01, 0.69999999999999996, -1.0);
        // device 2196, IC IC385, analog/basic/inverter.hpp:12
        I(cpphdl_n2933, Vss) <+ cpphdl_channel(V(CLEAR, Vss), V(cpphdl_n2933, Vss), 0.01, 0.69999999999999996, 1.0);
        // device 2197, IC IC382, analog/basic/nand_latch.hpp:58
        I(cpphdl_n2933, Vss) <+ 2.9999999999999998e-15 * ddt(V(cpphdl_n2933, Vss)); // Bench initial voltage = 0.0 V.
        // device 2198, IC IC382, analog/basic/nand_latch.hpp:59
        I(cpphdl_n3028, Vss) <+ cpphdl_channel(V(CLEAR, Vss), V(cpphdl_n3028, Vss), 0.050000000000000003, 0.69999999999999996, 1.0);
        // device 2199, IC IC382, analog/basic/nand_latch.hpp:60
        I(cpphdl_n2927, Vdd) <+ cpphdl_channel(V(cpphdl_n2933, Vdd), V(cpphdl_n2927, Vdd), 0.050000000000000003, 0.69999999999999996, -1.0);
        // device 2200, IC IC386, analog/basic/level_down.hpp:23
        I(cpphdl_n2955, Vlogic) <+ cpphdl_channel(V(Vss, Vlogic), V(cpphdl_n2955, Vlogic), 0.00050000000000000001, 0.34999999999999998, -1.0);
        // device 2201, IC IC386, analog/basic/level_down.hpp:24
        I(cpphdl_n2955, Vss) <+ cpphdl_channel(V(cpphdl_n2953, Vss), V(cpphdl_n2955, Vss), 0.0040000000000000001, 0.69999999999999996, 1.0);
        // device 2202, IC IC386, analog/basic/level_down.hpp:25
        I(CORE_DECISION0, Vlogic) <+ cpphdl_channel(V(cpphdl_n2955, Vlogic), V(CORE_DECISION0, Vlogic), 0.0050000000000000001, 0.34999999999999998, -1.0);
        // device 2203, IC IC386, analog/basic/level_down.hpp:26
        I(CORE_DECISION0, Vss) <+ cpphdl_channel(V(cpphdl_n2955, Vss), V(CORE_DECISION0, Vss), 0.01, 0.34999999999999998, 1.0);
        // device 2204, IC IC386, analog/basic/level_down.hpp:27
        I(cpphdl_n2953, Vss) <+ 5e-15 * ddt(V(cpphdl_n2953, Vss)); // Bench initial voltage = 0.0 V.
        // device 2205, IC IC386, analog/basic/level_down.hpp:28
        I(cpphdl_n2953, Vlogic) <+ 5e-15 * ddt(V(cpphdl_n2953, Vlogic)); // Bench initial voltage = 0.0 V.
        // device 2206, IC IC386, analog/basic/level_down.hpp:29
        I(cpphdl_n2953, cpphdl_n2955) <+ 2.0000000000000002e-15 * ddt(V(cpphdl_n2953, cpphdl_n2955)); // Bench initial voltage = 0.0 V.
        // device 2207, IC IC386, analog/basic/level_down.hpp:30
        I(cpphdl_n2955, Vss) <+ 8e-14 * ddt(V(cpphdl_n2955, Vss)); // Bench initial voltage = 0.0 V.
        // device 2208, IC IC386, analog/basic/level_down.hpp:31
        I(cpphdl_n2955, Vlogic) <+ 5e-15 * ddt(V(cpphdl_n2955, Vlogic)); // Bench initial voltage = 0.0 V.
        // device 2209, IC IC386, analog/basic/level_down.hpp:32
        I(cpphdl_n2955, CORE_DECISION0) <+ 2.0000000000000002e-15 * ddt(V(cpphdl_n2955, CORE_DECISION0)); // Bench initial voltage = 0.0 V.
        // device 2210, IC IC386, analog/basic/level_down.hpp:33
        I(CORE_DECISION0, Vss) <+ 1e-14 * ddt(V(CORE_DECISION0, Vss)); // Bench initial voltage = 0.0 V.
        // device 2211, IC IC387, analog/basic/level_down.hpp:23
        I(cpphdl_n2960, Vlogic) <+ cpphdl_channel(V(Vss, Vlogic), V(cpphdl_n2960, Vlogic), 0.00050000000000000001, 0.34999999999999998, -1.0);
        // device 2212, IC IC387, analog/basic/level_down.hpp:24
        I(cpphdl_n2960, Vss) <+ cpphdl_channel(V(cpphdl_n2958, Vss), V(cpphdl_n2960, Vss), 0.0040000000000000001, 0.69999999999999996, 1.0);
        // device 2213, IC IC387, analog/basic/level_down.hpp:25
        I(CORE_DECISION1, Vlogic) <+ cpphdl_channel(V(cpphdl_n2960, Vlogic), V(CORE_DECISION1, Vlogic), 0.0050000000000000001, 0.34999999999999998, -1.0);
        // device 2214, IC IC387, analog/basic/level_down.hpp:26
        I(CORE_DECISION1, Vss) <+ cpphdl_channel(V(cpphdl_n2960, Vss), V(CORE_DECISION1, Vss), 0.01, 0.34999999999999998, 1.0);
        // device 2215, IC IC387, analog/basic/level_down.hpp:27
        I(cpphdl_n2958, Vss) <+ 5e-15 * ddt(V(cpphdl_n2958, Vss)); // Bench initial voltage = 0.0 V.
        // device 2216, IC IC387, analog/basic/level_down.hpp:28
        I(cpphdl_n2958, Vlogic) <+ 5e-15 * ddt(V(cpphdl_n2958, Vlogic)); // Bench initial voltage = 0.0 V.
        // device 2217, IC IC387, analog/basic/level_down.hpp:29
        I(cpphdl_n2958, cpphdl_n2960) <+ 2.0000000000000002e-15 * ddt(V(cpphdl_n2958, cpphdl_n2960)); // Bench initial voltage = 0.0 V.
        // device 2218, IC IC387, analog/basic/level_down.hpp:30
        I(cpphdl_n2960, Vss) <+ 8e-14 * ddt(V(cpphdl_n2960, Vss)); // Bench initial voltage = 0.0 V.
        // device 2219, IC IC387, analog/basic/level_down.hpp:31
        I(cpphdl_n2960, Vlogic) <+ 5e-15 * ddt(V(cpphdl_n2960, Vlogic)); // Bench initial voltage = 0.0 V.
        // device 2220, IC IC387, analog/basic/level_down.hpp:32
        I(cpphdl_n2960, CORE_DECISION1) <+ 2.0000000000000002e-15 * ddt(V(cpphdl_n2960, CORE_DECISION1)); // Bench initial voltage = 0.0 V.
        // device 2221, IC IC387, analog/basic/level_down.hpp:33
        I(CORE_DECISION1, Vss) <+ 1e-14 * ddt(V(CORE_DECISION1, Vss)); // Bench initial voltage = 0.0 V.
        // device 2222, IC IC388, analog/basic/level_down.hpp:23
        I(cpphdl_n2965, Vlogic) <+ cpphdl_channel(V(Vss, Vlogic), V(cpphdl_n2965, Vlogic), 0.00050000000000000001, 0.34999999999999998, -1.0);
        // device 2223, IC IC388, analog/basic/level_down.hpp:24
        I(cpphdl_n2965, Vss) <+ cpphdl_channel(V(cpphdl_n2963, Vss), V(cpphdl_n2965, Vss), 0.0040000000000000001, 0.69999999999999996, 1.0);
        // device 2224, IC IC388, analog/basic/level_down.hpp:25
        I(CORE_DECISION2, Vlogic) <+ cpphdl_channel(V(cpphdl_n2965, Vlogic), V(CORE_DECISION2, Vlogic), 0.0050000000000000001, 0.34999999999999998, -1.0);
        // device 2225, IC IC388, analog/basic/level_down.hpp:26
        I(CORE_DECISION2, Vss) <+ cpphdl_channel(V(cpphdl_n2965, Vss), V(CORE_DECISION2, Vss), 0.01, 0.34999999999999998, 1.0);
        // device 2226, IC IC388, analog/basic/level_down.hpp:27
        I(cpphdl_n2963, Vss) <+ 5e-15 * ddt(V(cpphdl_n2963, Vss)); // Bench initial voltage = 0.0 V.
        // device 2227, IC IC388, analog/basic/level_down.hpp:28
        I(cpphdl_n2963, Vlogic) <+ 5e-15 * ddt(V(cpphdl_n2963, Vlogic)); // Bench initial voltage = 0.0 V.
        // device 2228, IC IC388, analog/basic/level_down.hpp:29
        I(cpphdl_n2963, cpphdl_n2965) <+ 2.0000000000000002e-15 * ddt(V(cpphdl_n2963, cpphdl_n2965)); // Bench initial voltage = 0.0 V.
        // device 2229, IC IC388, analog/basic/level_down.hpp:30
        I(cpphdl_n2965, Vss) <+ 8e-14 * ddt(V(cpphdl_n2965, Vss)); // Bench initial voltage = 0.0 V.
        // device 2230, IC IC388, analog/basic/level_down.hpp:31
        I(cpphdl_n2965, Vlogic) <+ 5e-15 * ddt(V(cpphdl_n2965, Vlogic)); // Bench initial voltage = 0.0 V.
        // device 2231, IC IC388, analog/basic/level_down.hpp:32
        I(cpphdl_n2965, CORE_DECISION2) <+ 2.0000000000000002e-15 * ddt(V(cpphdl_n2965, CORE_DECISION2)); // Bench initial voltage = 0.0 V.
        // device 2232, IC IC388, analog/basic/level_down.hpp:33
        I(CORE_DECISION2, Vss) <+ 1e-14 * ddt(V(CORE_DECISION2, Vss)); // Bench initial voltage = 0.0 V.
        // device 2233, IC IC389, analog/basic/level_down.hpp:23
        I(cpphdl_n2970, Vlogic) <+ cpphdl_channel(V(Vss, Vlogic), V(cpphdl_n2970, Vlogic), 0.00050000000000000001, 0.34999999999999998, -1.0);
        // device 2234, IC IC389, analog/basic/level_down.hpp:24
        I(cpphdl_n2970, Vss) <+ cpphdl_channel(V(cpphdl_n2968, Vss), V(cpphdl_n2970, Vss), 0.0040000000000000001, 0.69999999999999996, 1.0);
        // device 2235, IC IC389, analog/basic/level_down.hpp:25
        I(CORE_DECISION3, Vlogic) <+ cpphdl_channel(V(cpphdl_n2970, Vlogic), V(CORE_DECISION3, Vlogic), 0.0050000000000000001, 0.34999999999999998, -1.0);
        // device 2236, IC IC389, analog/basic/level_down.hpp:26
        I(CORE_DECISION3, Vss) <+ cpphdl_channel(V(cpphdl_n2970, Vss), V(CORE_DECISION3, Vss), 0.01, 0.34999999999999998, 1.0);
        // device 2237, IC IC389, analog/basic/level_down.hpp:27
        I(cpphdl_n2968, Vss) <+ 5e-15 * ddt(V(cpphdl_n2968, Vss)); // Bench initial voltage = 0.0 V.
        // device 2238, IC IC389, analog/basic/level_down.hpp:28
        I(cpphdl_n2968, Vlogic) <+ 5e-15 * ddt(V(cpphdl_n2968, Vlogic)); // Bench initial voltage = 0.0 V.
        // device 2239, IC IC389, analog/basic/level_down.hpp:29
        I(cpphdl_n2968, cpphdl_n2970) <+ 2.0000000000000002e-15 * ddt(V(cpphdl_n2968, cpphdl_n2970)); // Bench initial voltage = 0.0 V.
        // device 2240, IC IC389, analog/basic/level_down.hpp:30
        I(cpphdl_n2970, Vss) <+ 8e-14 * ddt(V(cpphdl_n2970, Vss)); // Bench initial voltage = 0.0 V.
        // device 2241, IC IC389, analog/basic/level_down.hpp:31
        I(cpphdl_n2970, Vlogic) <+ 5e-15 * ddt(V(cpphdl_n2970, Vlogic)); // Bench initial voltage = 0.0 V.
        // device 2242, IC IC389, analog/basic/level_down.hpp:32
        I(cpphdl_n2970, CORE_DECISION3) <+ 2.0000000000000002e-15 * ddt(V(cpphdl_n2970, CORE_DECISION3)); // Bench initial voltage = 0.0 V.
        // device 2243, IC IC389, analog/basic/level_down.hpp:33
        I(CORE_DECISION3, Vss) <+ 1e-14 * ddt(V(CORE_DECISION3, Vss)); // Bench initial voltage = 0.0 V.
        // device 2244, IC IC390, analog/basic/level_down.hpp:23
        I(cpphdl_n2975, Vlogic) <+ cpphdl_channel(V(Vss, Vlogic), V(cpphdl_n2975, Vlogic), 0.00050000000000000001, 0.34999999999999998, -1.0);
        // device 2245, IC IC390, analog/basic/level_down.hpp:24
        I(cpphdl_n2975, Vss) <+ cpphdl_channel(V(cpphdl_n2973, Vss), V(cpphdl_n2975, Vss), 0.0040000000000000001, 0.69999999999999996, 1.0);
        // device 2246, IC IC390, analog/basic/level_down.hpp:25
        I(CORE_DECISION4, Vlogic) <+ cpphdl_channel(V(cpphdl_n2975, Vlogic), V(CORE_DECISION4, Vlogic), 0.0050000000000000001, 0.34999999999999998, -1.0);
        // device 2247, IC IC390, analog/basic/level_down.hpp:26
        I(CORE_DECISION4, Vss) <+ cpphdl_channel(V(cpphdl_n2975, Vss), V(CORE_DECISION4, Vss), 0.01, 0.34999999999999998, 1.0);
        // device 2248, IC IC390, analog/basic/level_down.hpp:27
        I(cpphdl_n2973, Vss) <+ 5e-15 * ddt(V(cpphdl_n2973, Vss)); // Bench initial voltage = 0.0 V.
        // device 2249, IC IC390, analog/basic/level_down.hpp:28
        I(cpphdl_n2973, Vlogic) <+ 5e-15 * ddt(V(cpphdl_n2973, Vlogic)); // Bench initial voltage = 0.0 V.
        // device 2250, IC IC390, analog/basic/level_down.hpp:29
        I(cpphdl_n2973, cpphdl_n2975) <+ 2.0000000000000002e-15 * ddt(V(cpphdl_n2973, cpphdl_n2975)); // Bench initial voltage = 0.0 V.
        // device 2251, IC IC390, analog/basic/level_down.hpp:30
        I(cpphdl_n2975, Vss) <+ 8e-14 * ddt(V(cpphdl_n2975, Vss)); // Bench initial voltage = 0.0 V.
        // device 2252, IC IC390, analog/basic/level_down.hpp:31
        I(cpphdl_n2975, Vlogic) <+ 5e-15 * ddt(V(cpphdl_n2975, Vlogic)); // Bench initial voltage = 0.0 V.
        // device 2253, IC IC390, analog/basic/level_down.hpp:32
        I(cpphdl_n2975, CORE_DECISION4) <+ 2.0000000000000002e-15 * ddt(V(cpphdl_n2975, CORE_DECISION4)); // Bench initial voltage = 0.0 V.
        // device 2254, IC IC390, analog/basic/level_down.hpp:33
        I(CORE_DECISION4, Vss) <+ 1e-14 * ddt(V(CORE_DECISION4, Vss)); // Bench initial voltage = 0.0 V.
        // device 2255, IC IC391, analog/basic/level_down.hpp:23
        I(cpphdl_n2980, Vlogic) <+ cpphdl_channel(V(Vss, Vlogic), V(cpphdl_n2980, Vlogic), 0.00050000000000000001, 0.34999999999999998, -1.0);
        // device 2256, IC IC391, analog/basic/level_down.hpp:24
        I(cpphdl_n2980, Vss) <+ cpphdl_channel(V(cpphdl_n2978, Vss), V(cpphdl_n2980, Vss), 0.0040000000000000001, 0.69999999999999996, 1.0);
        // device 2257, IC IC391, analog/basic/level_down.hpp:25
        I(CORE_DECISION5, Vlogic) <+ cpphdl_channel(V(cpphdl_n2980, Vlogic), V(CORE_DECISION5, Vlogic), 0.0050000000000000001, 0.34999999999999998, -1.0);
        // device 2258, IC IC391, analog/basic/level_down.hpp:26
        I(CORE_DECISION5, Vss) <+ cpphdl_channel(V(cpphdl_n2980, Vss), V(CORE_DECISION5, Vss), 0.01, 0.34999999999999998, 1.0);
        // device 2259, IC IC391, analog/basic/level_down.hpp:27
        I(cpphdl_n2978, Vss) <+ 5e-15 * ddt(V(cpphdl_n2978, Vss)); // Bench initial voltage = 0.0 V.
        // device 2260, IC IC391, analog/basic/level_down.hpp:28
        I(cpphdl_n2978, Vlogic) <+ 5e-15 * ddt(V(cpphdl_n2978, Vlogic)); // Bench initial voltage = 0.0 V.
        // device 2261, IC IC391, analog/basic/level_down.hpp:29
        I(cpphdl_n2978, cpphdl_n2980) <+ 2.0000000000000002e-15 * ddt(V(cpphdl_n2978, cpphdl_n2980)); // Bench initial voltage = 0.0 V.
        // device 2262, IC IC391, analog/basic/level_down.hpp:30
        I(cpphdl_n2980, Vss) <+ 8e-14 * ddt(V(cpphdl_n2980, Vss)); // Bench initial voltage = 0.0 V.
        // device 2263, IC IC391, analog/basic/level_down.hpp:31
        I(cpphdl_n2980, Vlogic) <+ 5e-15 * ddt(V(cpphdl_n2980, Vlogic)); // Bench initial voltage = 0.0 V.
        // device 2264, IC IC391, analog/basic/level_down.hpp:32
        I(cpphdl_n2980, CORE_DECISION5) <+ 2.0000000000000002e-15 * ddt(V(cpphdl_n2980, CORE_DECISION5)); // Bench initial voltage = 0.0 V.
        // device 2265, IC IC391, analog/basic/level_down.hpp:33
        I(CORE_DECISION5, Vss) <+ 1e-14 * ddt(V(CORE_DECISION5, Vss)); // Bench initial voltage = 0.0 V.
        // device 2266, IC IC392, analog/basic/level_down.hpp:23
        I(cpphdl_n2985, Vlogic) <+ cpphdl_channel(V(Vss, Vlogic), V(cpphdl_n2985, Vlogic), 0.00050000000000000001, 0.34999999999999998, -1.0);
        // device 2267, IC IC392, analog/basic/level_down.hpp:24
        I(cpphdl_n2985, Vss) <+ cpphdl_channel(V(cpphdl_n2983, Vss), V(cpphdl_n2985, Vss), 0.0040000000000000001, 0.69999999999999996, 1.0);
        // device 2268, IC IC392, analog/basic/level_down.hpp:25
        I(CORE_DECISION6, Vlogic) <+ cpphdl_channel(V(cpphdl_n2985, Vlogic), V(CORE_DECISION6, Vlogic), 0.0050000000000000001, 0.34999999999999998, -1.0);
        // device 2269, IC IC392, analog/basic/level_down.hpp:26
        I(CORE_DECISION6, Vss) <+ cpphdl_channel(V(cpphdl_n2985, Vss), V(CORE_DECISION6, Vss), 0.01, 0.34999999999999998, 1.0);
        // device 2270, IC IC392, analog/basic/level_down.hpp:27
        I(cpphdl_n2983, Vss) <+ 5e-15 * ddt(V(cpphdl_n2983, Vss)); // Bench initial voltage = 0.0 V.
        // device 2271, IC IC392, analog/basic/level_down.hpp:28
        I(cpphdl_n2983, Vlogic) <+ 5e-15 * ddt(V(cpphdl_n2983, Vlogic)); // Bench initial voltage = 0.0 V.
        // device 2272, IC IC392, analog/basic/level_down.hpp:29
        I(cpphdl_n2983, cpphdl_n2985) <+ 2.0000000000000002e-15 * ddt(V(cpphdl_n2983, cpphdl_n2985)); // Bench initial voltage = 0.0 V.
        // device 2273, IC IC392, analog/basic/level_down.hpp:30
        I(cpphdl_n2985, Vss) <+ 8e-14 * ddt(V(cpphdl_n2985, Vss)); // Bench initial voltage = 0.0 V.
        // device 2274, IC IC392, analog/basic/level_down.hpp:31
        I(cpphdl_n2985, Vlogic) <+ 5e-15 * ddt(V(cpphdl_n2985, Vlogic)); // Bench initial voltage = 0.0 V.
        // device 2275, IC IC392, analog/basic/level_down.hpp:32
        I(cpphdl_n2985, CORE_DECISION6) <+ 2.0000000000000002e-15 * ddt(V(cpphdl_n2985, CORE_DECISION6)); // Bench initial voltage = 0.0 V.
        // device 2276, IC IC392, analog/basic/level_down.hpp:33
        I(CORE_DECISION6, Vss) <+ 1e-14 * ddt(V(CORE_DECISION6, Vss)); // Bench initial voltage = 0.0 V.
        // device 2277, IC IC393, analog/basic/level_down.hpp:23
        I(cpphdl_n2990, Vlogic) <+ cpphdl_channel(V(Vss, Vlogic), V(cpphdl_n2990, Vlogic), 0.00050000000000000001, 0.34999999999999998, -1.0);
        // device 2278, IC IC393, analog/basic/level_down.hpp:24
        I(cpphdl_n2990, Vss) <+ cpphdl_channel(V(cpphdl_n2988, Vss), V(cpphdl_n2990, Vss), 0.0040000000000000001, 0.69999999999999996, 1.0);
        // device 2279, IC IC393, analog/basic/level_down.hpp:25
        I(CORE_DECISION7, Vlogic) <+ cpphdl_channel(V(cpphdl_n2990, Vlogic), V(CORE_DECISION7, Vlogic), 0.0050000000000000001, 0.34999999999999998, -1.0);
        // device 2280, IC IC393, analog/basic/level_down.hpp:26
        I(CORE_DECISION7, Vss) <+ cpphdl_channel(V(cpphdl_n2990, Vss), V(CORE_DECISION7, Vss), 0.01, 0.34999999999999998, 1.0);
        // device 2281, IC IC393, analog/basic/level_down.hpp:27
        I(cpphdl_n2988, Vss) <+ 5e-15 * ddt(V(cpphdl_n2988, Vss)); // Bench initial voltage = 0.0 V.
        // device 2282, IC IC393, analog/basic/level_down.hpp:28
        I(cpphdl_n2988, Vlogic) <+ 5e-15 * ddt(V(cpphdl_n2988, Vlogic)); // Bench initial voltage = 0.0 V.
        // device 2283, IC IC393, analog/basic/level_down.hpp:29
        I(cpphdl_n2988, cpphdl_n2990) <+ 2.0000000000000002e-15 * ddt(V(cpphdl_n2988, cpphdl_n2990)); // Bench initial voltage = 0.0 V.
        // device 2284, IC IC393, analog/basic/level_down.hpp:30
        I(cpphdl_n2990, Vss) <+ 8e-14 * ddt(V(cpphdl_n2990, Vss)); // Bench initial voltage = 0.0 V.
        // device 2285, IC IC393, analog/basic/level_down.hpp:31
        I(cpphdl_n2990, Vlogic) <+ 5e-15 * ddt(V(cpphdl_n2990, Vlogic)); // Bench initial voltage = 0.0 V.
        // device 2286, IC IC393, analog/basic/level_down.hpp:32
        I(cpphdl_n2990, CORE_DECISION7) <+ 2.0000000000000002e-15 * ddt(V(cpphdl_n2990, CORE_DECISION7)); // Bench initial voltage = 0.0 V.
        // device 2287, IC IC393, analog/basic/level_down.hpp:33
        I(CORE_DECISION7, Vss) <+ 1e-14 * ddt(V(CORE_DECISION7, Vss)); // Bench initial voltage = 0.0 V.
        // device 2288, IC IC394, analog/basic/level_down.hpp:23
        I(cpphdl_n2995, Vlogic) <+ cpphdl_channel(V(Vss, Vlogic), V(cpphdl_n2995, Vlogic), 0.00050000000000000001, 0.34999999999999998, -1.0);
        // device 2289, IC IC394, analog/basic/level_down.hpp:24
        I(cpphdl_n2995, Vss) <+ cpphdl_channel(V(cpphdl_n2993, Vss), V(cpphdl_n2995, Vss), 0.0040000000000000001, 0.69999999999999996, 1.0);
        // device 2290, IC IC394, analog/basic/level_down.hpp:25
        I(CORE_DECISION8, Vlogic) <+ cpphdl_channel(V(cpphdl_n2995, Vlogic), V(CORE_DECISION8, Vlogic), 0.0050000000000000001, 0.34999999999999998, -1.0);
        // device 2291, IC IC394, analog/basic/level_down.hpp:26
        I(CORE_DECISION8, Vss) <+ cpphdl_channel(V(cpphdl_n2995, Vss), V(CORE_DECISION8, Vss), 0.01, 0.34999999999999998, 1.0);
        // device 2292, IC IC394, analog/basic/level_down.hpp:27
        I(cpphdl_n2993, Vss) <+ 5e-15 * ddt(V(cpphdl_n2993, Vss)); // Bench initial voltage = 0.0 V.
        // device 2293, IC IC394, analog/basic/level_down.hpp:28
        I(cpphdl_n2993, Vlogic) <+ 5e-15 * ddt(V(cpphdl_n2993, Vlogic)); // Bench initial voltage = 0.0 V.
        // device 2294, IC IC394, analog/basic/level_down.hpp:29
        I(cpphdl_n2993, cpphdl_n2995) <+ 2.0000000000000002e-15 * ddt(V(cpphdl_n2993, cpphdl_n2995)); // Bench initial voltage = 0.0 V.
        // device 2295, IC IC394, analog/basic/level_down.hpp:30
        I(cpphdl_n2995, Vss) <+ 8e-14 * ddt(V(cpphdl_n2995, Vss)); // Bench initial voltage = 0.0 V.
        // device 2296, IC IC394, analog/basic/level_down.hpp:31
        I(cpphdl_n2995, Vlogic) <+ 5e-15 * ddt(V(cpphdl_n2995, Vlogic)); // Bench initial voltage = 0.0 V.
        // device 2297, IC IC394, analog/basic/level_down.hpp:32
        I(cpphdl_n2995, CORE_DECISION8) <+ 2.0000000000000002e-15 * ddt(V(cpphdl_n2995, CORE_DECISION8)); // Bench initial voltage = 0.0 V.
        // device 2298, IC IC394, analog/basic/level_down.hpp:33
        I(CORE_DECISION8, Vss) <+ 1e-14 * ddt(V(CORE_DECISION8, Vss)); // Bench initial voltage = 0.0 V.
        // device 2299, IC IC395, analog/basic/level_down.hpp:23
        I(cpphdl_n3000, Vlogic) <+ cpphdl_channel(V(Vss, Vlogic), V(cpphdl_n3000, Vlogic), 0.00050000000000000001, 0.34999999999999998, -1.0);
        // device 2300, IC IC395, analog/basic/level_down.hpp:24
        I(cpphdl_n3000, Vss) <+ cpphdl_channel(V(cpphdl_n2998, Vss), V(cpphdl_n3000, Vss), 0.0040000000000000001, 0.69999999999999996, 1.0);
        // device 2301, IC IC395, analog/basic/level_down.hpp:25
        I(CORE_DECISION9, Vlogic) <+ cpphdl_channel(V(cpphdl_n3000, Vlogic), V(CORE_DECISION9, Vlogic), 0.0050000000000000001, 0.34999999999999998, -1.0);
        // device 2302, IC IC395, analog/basic/level_down.hpp:26
        I(CORE_DECISION9, Vss) <+ cpphdl_channel(V(cpphdl_n3000, Vss), V(CORE_DECISION9, Vss), 0.01, 0.34999999999999998, 1.0);
        // device 2303, IC IC395, analog/basic/level_down.hpp:27
        I(cpphdl_n2998, Vss) <+ 5e-15 * ddt(V(cpphdl_n2998, Vss)); // Bench initial voltage = 0.0 V.
        // device 2304, IC IC395, analog/basic/level_down.hpp:28
        I(cpphdl_n2998, Vlogic) <+ 5e-15 * ddt(V(cpphdl_n2998, Vlogic)); // Bench initial voltage = 0.0 V.
        // device 2305, IC IC395, analog/basic/level_down.hpp:29
        I(cpphdl_n2998, cpphdl_n3000) <+ 2.0000000000000002e-15 * ddt(V(cpphdl_n2998, cpphdl_n3000)); // Bench initial voltage = 0.0 V.
        // device 2306, IC IC395, analog/basic/level_down.hpp:30
        I(cpphdl_n3000, Vss) <+ 8e-14 * ddt(V(cpphdl_n3000, Vss)); // Bench initial voltage = 0.0 V.
        // device 2307, IC IC395, analog/basic/level_down.hpp:31
        I(cpphdl_n3000, Vlogic) <+ 5e-15 * ddt(V(cpphdl_n3000, Vlogic)); // Bench initial voltage = 0.0 V.
        // device 2308, IC IC395, analog/basic/level_down.hpp:32
        I(cpphdl_n3000, CORE_DECISION9) <+ 2.0000000000000002e-15 * ddt(V(cpphdl_n3000, CORE_DECISION9)); // Bench initial voltage = 0.0 V.
        // device 2309, IC IC395, analog/basic/level_down.hpp:33
        I(CORE_DECISION9, Vss) <+ 1e-14 * ddt(V(CORE_DECISION9, Vss)); // Bench initial voltage = 0.0 V.
        // device 2310, IC IC396, analog/basic/level_down.hpp:23
        I(cpphdl_n3005, Vlogic) <+ cpphdl_channel(V(Vss, Vlogic), V(cpphdl_n3005, Vlogic), 0.00050000000000000001, 0.34999999999999998, -1.0);
        // device 2311, IC IC396, analog/basic/level_down.hpp:24
        I(cpphdl_n3005, Vss) <+ cpphdl_channel(V(cpphdl_n3003, Vss), V(cpphdl_n3005, Vss), 0.0040000000000000001, 0.69999999999999996, 1.0);
        // device 2312, IC IC396, analog/basic/level_down.hpp:25
        I(CORE_DECISION10, Vlogic) <+ cpphdl_channel(V(cpphdl_n3005, Vlogic), V(CORE_DECISION10, Vlogic), 0.0050000000000000001, 0.34999999999999998, -1.0);
        // device 2313, IC IC396, analog/basic/level_down.hpp:26
        I(CORE_DECISION10, Vss) <+ cpphdl_channel(V(cpphdl_n3005, Vss), V(CORE_DECISION10, Vss), 0.01, 0.34999999999999998, 1.0);
        // device 2314, IC IC396, analog/basic/level_down.hpp:27
        I(cpphdl_n3003, Vss) <+ 5e-15 * ddt(V(cpphdl_n3003, Vss)); // Bench initial voltage = 0.0 V.
        // device 2315, IC IC396, analog/basic/level_down.hpp:28
        I(cpphdl_n3003, Vlogic) <+ 5e-15 * ddt(V(cpphdl_n3003, Vlogic)); // Bench initial voltage = 0.0 V.
        // device 2316, IC IC396, analog/basic/level_down.hpp:29
        I(cpphdl_n3003, cpphdl_n3005) <+ 2.0000000000000002e-15 * ddt(V(cpphdl_n3003, cpphdl_n3005)); // Bench initial voltage = 0.0 V.
        // device 2317, IC IC396, analog/basic/level_down.hpp:30
        I(cpphdl_n3005, Vss) <+ 8e-14 * ddt(V(cpphdl_n3005, Vss)); // Bench initial voltage = 0.0 V.
        // device 2318, IC IC396, analog/basic/level_down.hpp:31
        I(cpphdl_n3005, Vlogic) <+ 5e-15 * ddt(V(cpphdl_n3005, Vlogic)); // Bench initial voltage = 0.0 V.
        // device 2319, IC IC396, analog/basic/level_down.hpp:32
        I(cpphdl_n3005, CORE_DECISION10) <+ 2.0000000000000002e-15 * ddt(V(cpphdl_n3005, CORE_DECISION10)); // Bench initial voltage = 0.0 V.
        // device 2320, IC IC396, analog/basic/level_down.hpp:33
        I(CORE_DECISION10, Vss) <+ 1e-14 * ddt(V(CORE_DECISION10, Vss)); // Bench initial voltage = 0.0 V.
        // device 2321, IC IC397, analog/basic/level_down.hpp:23
        I(cpphdl_n3010, Vlogic) <+ cpphdl_channel(V(Vss, Vlogic), V(cpphdl_n3010, Vlogic), 0.00050000000000000001, 0.34999999999999998, -1.0);
        // device 2322, IC IC397, analog/basic/level_down.hpp:24
        I(cpphdl_n3010, Vss) <+ cpphdl_channel(V(cpphdl_n3008, Vss), V(cpphdl_n3010, Vss), 0.0040000000000000001, 0.69999999999999996, 1.0);
        // device 2323, IC IC397, analog/basic/level_down.hpp:25
        I(CORE_DECISION11, Vlogic) <+ cpphdl_channel(V(cpphdl_n3010, Vlogic), V(CORE_DECISION11, Vlogic), 0.0050000000000000001, 0.34999999999999998, -1.0);
        // device 2324, IC IC397, analog/basic/level_down.hpp:26
        I(CORE_DECISION11, Vss) <+ cpphdl_channel(V(cpphdl_n3010, Vss), V(CORE_DECISION11, Vss), 0.01, 0.34999999999999998, 1.0);
        // device 2325, IC IC397, analog/basic/level_down.hpp:27
        I(cpphdl_n3008, Vss) <+ 5e-15 * ddt(V(cpphdl_n3008, Vss)); // Bench initial voltage = 0.0 V.
        // device 2326, IC IC397, analog/basic/level_down.hpp:28
        I(cpphdl_n3008, Vlogic) <+ 5e-15 * ddt(V(cpphdl_n3008, Vlogic)); // Bench initial voltage = 0.0 V.
        // device 2327, IC IC397, analog/basic/level_down.hpp:29
        I(cpphdl_n3008, cpphdl_n3010) <+ 2.0000000000000002e-15 * ddt(V(cpphdl_n3008, cpphdl_n3010)); // Bench initial voltage = 0.0 V.
        // device 2328, IC IC397, analog/basic/level_down.hpp:30
        I(cpphdl_n3010, Vss) <+ 8e-14 * ddt(V(cpphdl_n3010, Vss)); // Bench initial voltage = 0.0 V.
        // device 2329, IC IC397, analog/basic/level_down.hpp:31
        I(cpphdl_n3010, Vlogic) <+ 5e-15 * ddt(V(cpphdl_n3010, Vlogic)); // Bench initial voltage = 0.0 V.
        // device 2330, IC IC397, analog/basic/level_down.hpp:32
        I(cpphdl_n3010, CORE_DECISION11) <+ 2.0000000000000002e-15 * ddt(V(cpphdl_n3010, CORE_DECISION11)); // Bench initial voltage = 0.0 V.
        // device 2331, IC IC397, analog/basic/level_down.hpp:33
        I(CORE_DECISION11, Vss) <+ 1e-14 * ddt(V(CORE_DECISION11, Vss)); // Bench initial voltage = 0.0 V.
        // device 2332, IC IC398, analog/basic/level_down.hpp:23
        I(cpphdl_n3015, Vlogic) <+ cpphdl_channel(V(Vss, Vlogic), V(cpphdl_n3015, Vlogic), 0.00050000000000000001, 0.34999999999999998, -1.0);
        // device 2333, IC IC398, analog/basic/level_down.hpp:24
        I(cpphdl_n3015, Vss) <+ cpphdl_channel(V(cpphdl_n3013, Vss), V(cpphdl_n3015, Vss), 0.0040000000000000001, 0.69999999999999996, 1.0);
        // device 2334, IC IC398, analog/basic/level_down.hpp:25
        I(CORE_DECISION12, Vlogic) <+ cpphdl_channel(V(cpphdl_n3015, Vlogic), V(CORE_DECISION12, Vlogic), 0.0050000000000000001, 0.34999999999999998, -1.0);
        // device 2335, IC IC398, analog/basic/level_down.hpp:26
        I(CORE_DECISION12, Vss) <+ cpphdl_channel(V(cpphdl_n3015, Vss), V(CORE_DECISION12, Vss), 0.01, 0.34999999999999998, 1.0);
        // device 2336, IC IC398, analog/basic/level_down.hpp:27
        I(cpphdl_n3013, Vss) <+ 5e-15 * ddt(V(cpphdl_n3013, Vss)); // Bench initial voltage = 0.0 V.
        // device 2337, IC IC398, analog/basic/level_down.hpp:28
        I(cpphdl_n3013, Vlogic) <+ 5e-15 * ddt(V(cpphdl_n3013, Vlogic)); // Bench initial voltage = 0.0 V.
        // device 2338, IC IC398, analog/basic/level_down.hpp:29
        I(cpphdl_n3013, cpphdl_n3015) <+ 2.0000000000000002e-15 * ddt(V(cpphdl_n3013, cpphdl_n3015)); // Bench initial voltage = 0.0 V.
        // device 2339, IC IC398, analog/basic/level_down.hpp:30
        I(cpphdl_n3015, Vss) <+ 8e-14 * ddt(V(cpphdl_n3015, Vss)); // Bench initial voltage = 0.0 V.
        // device 2340, IC IC398, analog/basic/level_down.hpp:31
        I(cpphdl_n3015, Vlogic) <+ 5e-15 * ddt(V(cpphdl_n3015, Vlogic)); // Bench initial voltage = 0.0 V.
        // device 2341, IC IC398, analog/basic/level_down.hpp:32
        I(cpphdl_n3015, CORE_DECISION12) <+ 2.0000000000000002e-15 * ddt(V(cpphdl_n3015, CORE_DECISION12)); // Bench initial voltage = 0.0 V.
        // device 2342, IC IC398, analog/basic/level_down.hpp:33
        I(CORE_DECISION12, Vss) <+ 1e-14 * ddt(V(CORE_DECISION12, Vss)); // Bench initial voltage = 0.0 V.
        // device 2343, IC IC399, analog/basic/level_down.hpp:23
        I(cpphdl_n3020, Vlogic) <+ cpphdl_channel(V(Vss, Vlogic), V(cpphdl_n3020, Vlogic), 0.00050000000000000001, 0.34999999999999998, -1.0);
        // device 2344, IC IC399, analog/basic/level_down.hpp:24
        I(cpphdl_n3020, Vss) <+ cpphdl_channel(V(cpphdl_n3018, Vss), V(cpphdl_n3020, Vss), 0.0040000000000000001, 0.69999999999999996, 1.0);
        // device 2345, IC IC399, analog/basic/level_down.hpp:25
        I(CORE_DECISION13, Vlogic) <+ cpphdl_channel(V(cpphdl_n3020, Vlogic), V(CORE_DECISION13, Vlogic), 0.0050000000000000001, 0.34999999999999998, -1.0);
        // device 2346, IC IC399, analog/basic/level_down.hpp:26
        I(CORE_DECISION13, Vss) <+ cpphdl_channel(V(cpphdl_n3020, Vss), V(CORE_DECISION13, Vss), 0.01, 0.34999999999999998, 1.0);
        // device 2347, IC IC399, analog/basic/level_down.hpp:27
        I(cpphdl_n3018, Vss) <+ 5e-15 * ddt(V(cpphdl_n3018, Vss)); // Bench initial voltage = 0.0 V.
        // device 2348, IC IC399, analog/basic/level_down.hpp:28
        I(cpphdl_n3018, Vlogic) <+ 5e-15 * ddt(V(cpphdl_n3018, Vlogic)); // Bench initial voltage = 0.0 V.
        // device 2349, IC IC399, analog/basic/level_down.hpp:29
        I(cpphdl_n3018, cpphdl_n3020) <+ 2.0000000000000002e-15 * ddt(V(cpphdl_n3018, cpphdl_n3020)); // Bench initial voltage = 0.0 V.
        // device 2350, IC IC399, analog/basic/level_down.hpp:30
        I(cpphdl_n3020, Vss) <+ 8e-14 * ddt(V(cpphdl_n3020, Vss)); // Bench initial voltage = 0.0 V.
        // device 2351, IC IC399, analog/basic/level_down.hpp:31
        I(cpphdl_n3020, Vlogic) <+ 5e-15 * ddt(V(cpphdl_n3020, Vlogic)); // Bench initial voltage = 0.0 V.
        // device 2352, IC IC399, analog/basic/level_down.hpp:32
        I(cpphdl_n3020, CORE_DECISION13) <+ 2.0000000000000002e-15 * ddt(V(cpphdl_n3020, CORE_DECISION13)); // Bench initial voltage = 0.0 V.
        // device 2353, IC IC399, analog/basic/level_down.hpp:33
        I(CORE_DECISION13, Vss) <+ 1e-14 * ddt(V(CORE_DECISION13, Vss)); // Bench initial voltage = 0.0 V.
        // device 2354, IC IC400, analog/basic/level_down.hpp:23
        I(cpphdl_n3025, Vlogic) <+ cpphdl_channel(V(Vss, Vlogic), V(cpphdl_n3025, Vlogic), 0.00050000000000000001, 0.34999999999999998, -1.0);
        // device 2355, IC IC400, analog/basic/level_down.hpp:24
        I(cpphdl_n3025, Vss) <+ cpphdl_channel(V(cpphdl_n3023, Vss), V(cpphdl_n3025, Vss), 0.0040000000000000001, 0.69999999999999996, 1.0);
        // device 2356, IC IC400, analog/basic/level_down.hpp:25
        I(CORE_DECISION14, Vlogic) <+ cpphdl_channel(V(cpphdl_n3025, Vlogic), V(CORE_DECISION14, Vlogic), 0.0050000000000000001, 0.34999999999999998, -1.0);
        // device 2357, IC IC400, analog/basic/level_down.hpp:26
        I(CORE_DECISION14, Vss) <+ cpphdl_channel(V(cpphdl_n3025, Vss), V(CORE_DECISION14, Vss), 0.01, 0.34999999999999998, 1.0);
        // device 2358, IC IC400, analog/basic/level_down.hpp:27
        I(cpphdl_n3023, Vss) <+ 5e-15 * ddt(V(cpphdl_n3023, Vss)); // Bench initial voltage = 0.0 V.
        // device 2359, IC IC400, analog/basic/level_down.hpp:28
        I(cpphdl_n3023, Vlogic) <+ 5e-15 * ddt(V(cpphdl_n3023, Vlogic)); // Bench initial voltage = 0.0 V.
        // device 2360, IC IC400, analog/basic/level_down.hpp:29
        I(cpphdl_n3023, cpphdl_n3025) <+ 2.0000000000000002e-15 * ddt(V(cpphdl_n3023, cpphdl_n3025)); // Bench initial voltage = 0.0 V.
        // device 2361, IC IC400, analog/basic/level_down.hpp:30
        I(cpphdl_n3025, Vss) <+ 8e-14 * ddt(V(cpphdl_n3025, Vss)); // Bench initial voltage = 0.0 V.
        // device 2362, IC IC400, analog/basic/level_down.hpp:31
        I(cpphdl_n3025, Vlogic) <+ 5e-15 * ddt(V(cpphdl_n3025, Vlogic)); // Bench initial voltage = 0.0 V.
        // device 2363, IC IC400, analog/basic/level_down.hpp:32
        I(cpphdl_n3025, CORE_DECISION14) <+ 2.0000000000000002e-15 * ddt(V(cpphdl_n3025, CORE_DECISION14)); // Bench initial voltage = 0.0 V.
        // device 2364, IC IC400, analog/basic/level_down.hpp:33
        I(CORE_DECISION14, Vss) <+ 1e-14 * ddt(V(CORE_DECISION14, Vss)); // Bench initial voltage = 0.0 V.
        // device 2365, IC IC401, analog/basic/level_down.hpp:23
        I(cpphdl_n3030, Vlogic) <+ cpphdl_channel(V(Vss, Vlogic), V(cpphdl_n3030, Vlogic), 0.00050000000000000001, 0.34999999999999998, -1.0);
        // device 2366, IC IC401, analog/basic/level_down.hpp:24
        I(cpphdl_n3030, Vss) <+ cpphdl_channel(V(cpphdl_n3028, Vss), V(cpphdl_n3030, Vss), 0.0040000000000000001, 0.69999999999999996, 1.0);
        // device 2367, IC IC401, analog/basic/level_down.hpp:25
        I(CORE_DECISION15, Vlogic) <+ cpphdl_channel(V(cpphdl_n3030, Vlogic), V(CORE_DECISION15, Vlogic), 0.0050000000000000001, 0.34999999999999998, -1.0);
        // device 2368, IC IC401, analog/basic/level_down.hpp:26
        I(CORE_DECISION15, Vss) <+ cpphdl_channel(V(cpphdl_n3030, Vss), V(CORE_DECISION15, Vss), 0.01, 0.34999999999999998, 1.0);
        // device 2369, IC IC401, analog/basic/level_down.hpp:27
        I(cpphdl_n3028, Vss) <+ 5e-15 * ddt(V(cpphdl_n3028, Vss)); // Bench initial voltage = 0.0 V.
        // device 2370, IC IC401, analog/basic/level_down.hpp:28
        I(cpphdl_n3028, Vlogic) <+ 5e-15 * ddt(V(cpphdl_n3028, Vlogic)); // Bench initial voltage = 0.0 V.
        // device 2371, IC IC401, analog/basic/level_down.hpp:29
        I(cpphdl_n3028, cpphdl_n3030) <+ 2.0000000000000002e-15 * ddt(V(cpphdl_n3028, cpphdl_n3030)); // Bench initial voltage = 0.0 V.
        // device 2372, IC IC401, analog/basic/level_down.hpp:30
        I(cpphdl_n3030, Vss) <+ 8e-14 * ddt(V(cpphdl_n3030, Vss)); // Bench initial voltage = 0.0 V.
        // device 2373, IC IC401, analog/basic/level_down.hpp:31
        I(cpphdl_n3030, Vlogic) <+ 5e-15 * ddt(V(cpphdl_n3030, Vlogic)); // Bench initial voltage = 0.0 V.
        // device 2374, IC IC401, analog/basic/level_down.hpp:32
        I(cpphdl_n3030, CORE_DECISION15) <+ 2.0000000000000002e-15 * ddt(V(cpphdl_n3030, CORE_DECISION15)); // Bench initial voltage = 0.0 V.
        // device 2375, IC IC401, analog/basic/level_down.hpp:33
        I(CORE_DECISION15, Vss) <+ 1e-14 * ddt(V(CORE_DECISION15, Vss)); // Bench initial voltage = 0.0 V.
    end
endmodule
