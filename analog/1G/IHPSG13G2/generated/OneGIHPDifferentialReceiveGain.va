// SIMULATION APPROXIMATION: controlled conductances are not physical MOS devices.
// Generated from elaborated C++HDL IC purposes; all contributions coexist.
// Capacitor initialization belongs to the host analysis; declared initial voltages appear below.
`include "disciplines.vams"

module OneGIHPDifferentialReceiveGain(Vdd, Vss, IN_PLUS, IN_MINUS, VREF, OUT, SELECT_N0, SELECT_N1, SELECT_N2, SELECT_N3, SELECT_N4);
    inout Vdd, Vss, IN_PLUS, IN_MINUS, VREF, OUT, SELECT_N0, SELECT_N1, SELECT_N2, SELECT_N3, SELECT_N4;
    electrical Vdd, Vss, IN_PLUS, IN_MINUS, VREF, OUT, SELECT_N0, SELECT_N1, SELECT_N2, SELECT_N3, SELECT_N4;
    electrical cpphdl_n16;
    electrical cpphdl_n17;
    electrical cpphdl_n18;
    electrical cpphdl_n19;
    electrical cpphdl_n20;
    electrical cpphdl_n21;
    electrical cpphdl_n22;
    electrical cpphdl_n23;
    electrical cpphdl_n24;
    electrical cpphdl_n25;
    electrical cpphdl_n26;
    electrical cpphdl_n27;
    electrical cpphdl_n28;
    electrical cpphdl_n29;
    electrical cpphdl_n30;
    electrical cpphdl_n31;
    electrical cpphdl_n35;
    electrical cpphdl_n39;
    electrical cpphdl_n43;
    electrical cpphdl_n47;
    electrical cpphdl_n51;
    electrical cpphdl_n52;
    electrical cpphdl_n53;
    electrical cpphdl_n54;
    electrical cpphdl_n55;
    electrical cpphdl_n58;
    electrical cpphdl_n59;
    electrical cpphdl_n61;
    electrical cpphdl_n62;
    electrical cpphdl_n63;
    electrical cpphdl_n64;
    electrical cpphdl_n65;
    electrical cpphdl_n66;
    electrical cpphdl_n67;
    electrical cpphdl_n68;
    electrical cpphdl_n69;
    electrical cpphdl_n72;

    // Square-law channel, including reverse conduction. This is not a BSIM model.
    analog function real cpphdl_channel;
        input vgs, vds, beta, threshold, polarity;
        real vgs, vds, beta, threshold, polarity;
        real gate, drain, direction, overdrive, current;
        begin
            gate = polarity * vgs;
            drain = polarity * vds;
            direction = 1.0;
            if (drain < 0.0) begin
                gate = gate - drain;
                drain = -drain;
                direction = -1.0;
            end
            overdrive = gate - threshold;
            current = 0.0;
            if (overdrive > 0.0) begin
                if (drain < overdrive)
                    current = beta * (overdrive * drain - drain * drain / 2.0);
                else
                    current = beta * overdrive * overdrive / 2.0;
            end
            cpphdl_channel = polarity * direction * current;
        end
    endfunction

    analog begin
        // device 0, IC IC1, analog/basic/inverter.hpp:11
        I(cpphdl_n35, Vdd) <+ cpphdl_channel(V(SELECT_N0, Vdd), V(cpphdl_n35, Vdd), 0.0030000000000000001, 0.69999999999999996, -1.0);
        // device 1, IC IC1, analog/basic/inverter.hpp:12
        I(cpphdl_n35, Vss) <+ cpphdl_channel(V(SELECT_N0, Vss), V(cpphdl_n35, Vss), 0.0030000000000000001, 0.69999999999999996, 1.0);
        // device 2, IC OneGIHPDifferentialReceiveGain, analog/1G/IHPSG13G2/differential_receive_gain.hpp:41
        I(cpphdl_n35, Vss) <+ 2e-14 * ddt(V(cpphdl_n35, Vss)); // Bench initial voltage = 0.0 V.
        // device 3, IC IC2, analog/basic/inverter.hpp:11
        I(cpphdl_n39, Vdd) <+ cpphdl_channel(V(SELECT_N1, Vdd), V(cpphdl_n39, Vdd), 0.0030000000000000001, 0.69999999999999996, -1.0);
        // device 4, IC IC2, analog/basic/inverter.hpp:12
        I(cpphdl_n39, Vss) <+ cpphdl_channel(V(SELECT_N1, Vss), V(cpphdl_n39, Vss), 0.0030000000000000001, 0.69999999999999996, 1.0);
        // device 5, IC OneGIHPDifferentialReceiveGain, analog/1G/IHPSG13G2/differential_receive_gain.hpp:41
        I(cpphdl_n39, Vss) <+ 2e-14 * ddt(V(cpphdl_n39, Vss)); // Bench initial voltage = 0.0 V.
        // device 6, IC IC3, analog/basic/inverter.hpp:11
        I(cpphdl_n43, Vdd) <+ cpphdl_channel(V(SELECT_N2, Vdd), V(cpphdl_n43, Vdd), 0.0030000000000000001, 0.69999999999999996, -1.0);
        // device 7, IC IC3, analog/basic/inverter.hpp:12
        I(cpphdl_n43, Vss) <+ cpphdl_channel(V(SELECT_N2, Vss), V(cpphdl_n43, Vss), 0.0030000000000000001, 0.69999999999999996, 1.0);
        // device 8, IC OneGIHPDifferentialReceiveGain, analog/1G/IHPSG13G2/differential_receive_gain.hpp:41
        I(cpphdl_n43, Vss) <+ 2e-14 * ddt(V(cpphdl_n43, Vss)); // Bench initial voltage = 0.0 V.
        // device 9, IC IC4, analog/basic/inverter.hpp:11
        I(cpphdl_n47, Vdd) <+ cpphdl_channel(V(SELECT_N3, Vdd), V(cpphdl_n47, Vdd), 0.0030000000000000001, 0.69999999999999996, -1.0);
        // device 10, IC IC4, analog/basic/inverter.hpp:12
        I(cpphdl_n47, Vss) <+ cpphdl_channel(V(SELECT_N3, Vss), V(cpphdl_n47, Vss), 0.0030000000000000001, 0.69999999999999996, 1.0);
        // device 11, IC OneGIHPDifferentialReceiveGain, analog/1G/IHPSG13G2/differential_receive_gain.hpp:41
        I(cpphdl_n47, Vss) <+ 2e-14 * ddt(V(cpphdl_n47, Vss)); // Bench initial voltage = 0.0 V.
        // device 12, IC IC5, analog/basic/inverter.hpp:11
        I(cpphdl_n51, Vdd) <+ cpphdl_channel(V(SELECT_N4, Vdd), V(cpphdl_n51, Vdd), 0.0030000000000000001, 0.69999999999999996, -1.0);
        // device 13, IC IC5, analog/basic/inverter.hpp:12
        I(cpphdl_n51, Vss) <+ cpphdl_channel(V(SELECT_N4, Vss), V(cpphdl_n51, Vss), 0.0030000000000000001, 0.69999999999999996, 1.0);
        // device 14, IC OneGIHPDifferentialReceiveGain, analog/1G/IHPSG13G2/differential_receive_gain.hpp:41
        I(cpphdl_n51, Vss) <+ 2e-14 * ddt(V(cpphdl_n51, Vss)); // Bench initial voltage = 0.0 V.
        // device 15, IC OneGIHPDifferentialReceiveGain, analog/1G/IHPSG13G2/differential_receive_gain.hpp:43
        I(VREF, cpphdl_n24) <+ V(VREF, cpphdl_n24) / 100.0;
        // device 16, IC OneGIHPDifferentialReceiveGain, analog/1G/IHPSG13G2/differential_receive_gain.hpp:45
        I(cpphdl_n24, cpphdl_n25) <+ V(cpphdl_n24, cpphdl_n25) / 100.0;
        // device 17, IC OneGIHPDifferentialReceiveGain, analog/1G/IHPSG13G2/differential_receive_gain.hpp:45
        I(cpphdl_n25, cpphdl_n26) <+ V(cpphdl_n25, cpphdl_n26) / 100.0;
        // device 18, IC OneGIHPDifferentialReceiveGain, analog/1G/IHPSG13G2/differential_receive_gain.hpp:45
        I(cpphdl_n26, cpphdl_n27) <+ V(cpphdl_n26, cpphdl_n27) / 100.0;
        // device 19, IC OneGIHPDifferentialReceiveGain, analog/1G/IHPSG13G2/differential_receive_gain.hpp:45
        I(cpphdl_n27, cpphdl_n28) <+ V(cpphdl_n27, cpphdl_n28) / 100.0;
        // device 20, IC OneGIHPDifferentialReceiveGain, analog/1G/IHPSG13G2/differential_receive_gain.hpp:45
        I(cpphdl_n28, cpphdl_n29) <+ V(cpphdl_n28, cpphdl_n29) / 100.0;
        // device 21, IC OneGIHPDifferentialReceiveGain, analog/1G/IHPSG13G2/differential_receive_gain.hpp:45
        I(cpphdl_n29, cpphdl_n30) <+ V(cpphdl_n29, cpphdl_n30) / 100.0;
        // device 22, IC OneGIHPDifferentialReceiveGain, analog/1G/IHPSG13G2/differential_receive_gain.hpp:45
        I(cpphdl_n30, cpphdl_n31) <+ V(cpphdl_n30, cpphdl_n31) / 100.0;
        // device 23, IC OneGIHPDifferentialReceiveGain, analog/1G/IHPSG13G2/differential_receive_gain.hpp:46
        I(cpphdl_n31, IN_PLUS) <+ V(cpphdl_n31, IN_PLUS) / 100.0;
        // device 24, IC OneGIHPDifferentialReceiveGain, analog/1G/IHPSG13G2/differential_receive_gain.hpp:48
        I(cpphdl_n27, cpphdl_n58) <+ cpphdl_channel(V(cpphdl_n35, cpphdl_n58), V(cpphdl_n27, cpphdl_n58), 0.029999999999999999, 0.69999999999999996, 1.0);
        // device 25, IC OneGIHPDifferentialReceiveGain, analog/1G/IHPSG13G2/differential_receive_gain.hpp:48
        I(cpphdl_n28, cpphdl_n58) <+ cpphdl_channel(V(cpphdl_n39, cpphdl_n58), V(cpphdl_n28, cpphdl_n58), 0.029999999999999999, 0.69999999999999996, 1.0);
        // device 26, IC OneGIHPDifferentialReceiveGain, analog/1G/IHPSG13G2/differential_receive_gain.hpp:48
        I(cpphdl_n29, cpphdl_n58) <+ cpphdl_channel(V(cpphdl_n43, cpphdl_n58), V(cpphdl_n29, cpphdl_n58), 0.029999999999999999, 0.69999999999999996, 1.0);
        // device 27, IC OneGIHPDifferentialReceiveGain, analog/1G/IHPSG13G2/differential_receive_gain.hpp:48
        I(cpphdl_n30, cpphdl_n58) <+ cpphdl_channel(V(cpphdl_n47, cpphdl_n58), V(cpphdl_n30, cpphdl_n58), 0.029999999999999999, 0.69999999999999996, 1.0);
        // device 28, IC OneGIHPDifferentialReceiveGain, analog/1G/IHPSG13G2/differential_receive_gain.hpp:48
        I(cpphdl_n31, cpphdl_n58) <+ cpphdl_channel(V(cpphdl_n51, cpphdl_n58), V(cpphdl_n31, cpphdl_n58), 0.029999999999999999, 0.69999999999999996, 1.0);
        // device 29, IC OneGIHPDifferentialReceiveGain, analog/1G/IHPSG13G2/differential_receive_gain.hpp:49
        I(IN_MINUS, cpphdl_n58) <+ V(IN_MINUS, cpphdl_n58) / 100000.0;
        // device 30, IC OneGIHPDifferentialReceiveGain, analog/1G/IHPSG13G2/differential_receive_gain.hpp:50
        I(cpphdl_n58, Vss) <+ 5.0000000000000002e-14 * ddt(V(cpphdl_n58, Vss)); // Bench initial voltage = 0.0 V.
        // device 31, IC IC8, analog/basic/resistor_divider.hpp:15
        I(Vdd, cpphdl_n61) <+ V(Vdd, cpphdl_n61) / 15000.0;
        // device 32, IC IC8, analog/basic/resistor_divider.hpp:16
        I(cpphdl_n61, Vss) <+ V(cpphdl_n61, Vss) / 18000.0;
        // device 33, IC IC9, analog/basic/resistor_divider.hpp:15
        I(Vdd, cpphdl_n62) <+ V(Vdd, cpphdl_n62) / 23000.0;
        // device 34, IC IC9, analog/basic/resistor_divider.hpp:16
        I(cpphdl_n62, Vss) <+ V(cpphdl_n62, Vss) / 43000.0;
        // device 35, IC OneGIHPDifferentialReceiveGain, analog/1G/IHPSG13G2/differential_receive_gain.hpp:61
        I(cpphdl_n61, Vss) <+ 9.9999999999999994e-12 * ddt(V(cpphdl_n61, Vss)); // Bench initial voltage = 0.0 V.
        // device 36, IC OneGIHPDifferentialReceiveGain, analog/1G/IHPSG13G2/differential_receive_gain.hpp:62
        I(cpphdl_n62, Vss) <+ 9.9999999999999994e-12 * ddt(V(cpphdl_n62, Vss)); // Bench initial voltage = 0.0 V.
        // device 37, IC OneGIHPDifferentialReceiveGain, analog/1G/IHPSG13G2/differential_receive_gain.hpp:63
        I(Vdd, cpphdl_n63) <+ V(Vdd, cpphdl_n63) / 2500.0;
        // device 38, IC OneGIHPDifferentialReceiveGain, analog/1G/IHPSG13G2/differential_receive_gain.hpp:64
        I(cpphdl_n63, Vss) <+ cpphdl_channel(V(cpphdl_n63, Vss), V(cpphdl_n63, Vss), 0.029999999999999999, 0.69999999999999996, 1.0);
        // device 39, IC OneGIHPDifferentialReceiveGain, analog/1G/IHPSG13G2/differential_receive_gain.hpp:65
        I(cpphdl_n63, Vss) <+ 9.9999999999999994e-12 * ddt(V(cpphdl_n63, Vss)); // Bench initial voltage = 0.0 V.
        // device 40, IC OneGIHPDifferentialReceiveGain, analog/1G/IHPSG13G2/differential_receive_gain.hpp:67
        I(OUT, cpphdl_n16) <+ V(OUT, cpphdl_n16) / 100.0;
        // device 41, IC OneGIHPDifferentialReceiveGain, analog/1G/IHPSG13G2/differential_receive_gain.hpp:69
        I(cpphdl_n16, cpphdl_n17) <+ V(cpphdl_n16, cpphdl_n17) / 100.0;
        // device 42, IC OneGIHPDifferentialReceiveGain, analog/1G/IHPSG13G2/differential_receive_gain.hpp:69
        I(cpphdl_n17, cpphdl_n18) <+ V(cpphdl_n17, cpphdl_n18) / 100.0;
        // device 43, IC OneGIHPDifferentialReceiveGain, analog/1G/IHPSG13G2/differential_receive_gain.hpp:69
        I(cpphdl_n18, cpphdl_n19) <+ V(cpphdl_n18, cpphdl_n19) / 100.0;
        // device 44, IC OneGIHPDifferentialReceiveGain, analog/1G/IHPSG13G2/differential_receive_gain.hpp:69
        I(cpphdl_n19, cpphdl_n20) <+ V(cpphdl_n19, cpphdl_n20) / 100.0;
        // device 45, IC OneGIHPDifferentialReceiveGain, analog/1G/IHPSG13G2/differential_receive_gain.hpp:69
        I(cpphdl_n20, cpphdl_n21) <+ V(cpphdl_n20, cpphdl_n21) / 100.0;
        // device 46, IC OneGIHPDifferentialReceiveGain, analog/1G/IHPSG13G2/differential_receive_gain.hpp:69
        I(cpphdl_n21, cpphdl_n22) <+ V(cpphdl_n21, cpphdl_n22) / 100.0;
        // device 47, IC OneGIHPDifferentialReceiveGain, analog/1G/IHPSG13G2/differential_receive_gain.hpp:69
        I(cpphdl_n22, cpphdl_n23) <+ V(cpphdl_n22, cpphdl_n23) / 100.0;
        // device 48, IC OneGIHPDifferentialReceiveGain, analog/1G/IHPSG13G2/differential_receive_gain.hpp:70
        I(cpphdl_n23, IN_MINUS) <+ V(cpphdl_n23, IN_MINUS) / 100.0;
        // device 49, IC OneGIHPDifferentialReceiveGain, analog/1G/IHPSG13G2/differential_receive_gain.hpp:73
        I(cpphdl_n19, cpphdl_n59) <+ cpphdl_channel(V(cpphdl_n35, cpphdl_n59), V(cpphdl_n19, cpphdl_n59), 0.029999999999999999, 0.69999999999999996, 1.0);
        // device 50, IC OneGIHPDifferentialReceiveGain, analog/1G/IHPSG13G2/differential_receive_gain.hpp:75
        I(cpphdl_n52, cpphdl_n72) <+ cpphdl_channel(V(SELECT_N0, cpphdl_n72), V(cpphdl_n52, cpphdl_n72), 0.02, 0.69999999999999996, -1.0);
        // device 51, IC OneGIHPDifferentialReceiveGain, analog/1G/IHPSG13G2/differential_receive_gain.hpp:76
        I(cpphdl_n52, Vss) <+ 9.9999999999999998e-13 * ddt(V(cpphdl_n52, Vss)); // Bench initial voltage = 0.0 V.
        // device 52, IC OneGIHPDifferentialReceiveGain, analog/1G/IHPSG13G2/differential_receive_gain.hpp:73
        I(cpphdl_n20, cpphdl_n59) <+ cpphdl_channel(V(cpphdl_n39, cpphdl_n59), V(cpphdl_n20, cpphdl_n59), 0.029999999999999999, 0.69999999999999996, 1.0);
        // device 53, IC OneGIHPDifferentialReceiveGain, analog/1G/IHPSG13G2/differential_receive_gain.hpp:75
        I(cpphdl_n53, cpphdl_n72) <+ cpphdl_channel(V(SELECT_N1, cpphdl_n72), V(cpphdl_n53, cpphdl_n72), 0.02, 0.69999999999999996, -1.0);
        // device 54, IC OneGIHPDifferentialReceiveGain, analog/1G/IHPSG13G2/differential_receive_gain.hpp:76
        I(cpphdl_n53, Vss) <+ 7.5000000000000004e-13 * ddt(V(cpphdl_n53, Vss)); // Bench initial voltage = 0.0 V.
        // device 55, IC OneGIHPDifferentialReceiveGain, analog/1G/IHPSG13G2/differential_receive_gain.hpp:73
        I(cpphdl_n21, cpphdl_n59) <+ cpphdl_channel(V(cpphdl_n43, cpphdl_n59), V(cpphdl_n21, cpphdl_n59), 0.029999999999999999, 0.69999999999999996, 1.0);
        // device 56, IC OneGIHPDifferentialReceiveGain, analog/1G/IHPSG13G2/differential_receive_gain.hpp:75
        I(cpphdl_n54, cpphdl_n72) <+ cpphdl_channel(V(SELECT_N2, cpphdl_n72), V(cpphdl_n54, cpphdl_n72), 0.02, 0.69999999999999996, -1.0);
        // device 57, IC OneGIHPDifferentialReceiveGain, analog/1G/IHPSG13G2/differential_receive_gain.hpp:76
        I(cpphdl_n54, Vss) <+ 4.9999999999999999e-13 * ddt(V(cpphdl_n54, Vss)); // Bench initial voltage = 0.0 V.
        // device 58, IC OneGIHPDifferentialReceiveGain, analog/1G/IHPSG13G2/differential_receive_gain.hpp:73
        I(cpphdl_n22, cpphdl_n59) <+ cpphdl_channel(V(cpphdl_n47, cpphdl_n59), V(cpphdl_n22, cpphdl_n59), 0.029999999999999999, 0.69999999999999996, 1.0);
        // device 59, IC OneGIHPDifferentialReceiveGain, analog/1G/IHPSG13G2/differential_receive_gain.hpp:75
        I(cpphdl_n55, cpphdl_n72) <+ cpphdl_channel(V(SELECT_N3, cpphdl_n72), V(cpphdl_n55, cpphdl_n72), 0.02, 0.69999999999999996, -1.0);
        // device 60, IC OneGIHPDifferentialReceiveGain, analog/1G/IHPSG13G2/differential_receive_gain.hpp:76
        I(cpphdl_n55, Vss) <+ 2.4999999999999999e-13 * ddt(V(cpphdl_n55, Vss)); // Bench initial voltage = 0.0 V.
        // device 61, IC OneGIHPDifferentialReceiveGain, analog/1G/IHPSG13G2/differential_receive_gain.hpp:73
        I(cpphdl_n23, cpphdl_n59) <+ cpphdl_channel(V(cpphdl_n51, cpphdl_n59), V(cpphdl_n23, cpphdl_n59), 0.029999999999999999, 0.69999999999999996, 1.0);
        // device 62, IC IC6, analog/basic/cascode_ota.hpp:29
        I(cpphdl_n64, cpphdl_n69) <+ cpphdl_channel(V(cpphdl_n58, cpphdl_n69), V(cpphdl_n64, cpphdl_n69), 0.029999999999999999, 0.69999999999999996, 1.0);
        // device 63, IC IC6, analog/basic/cascode_ota.hpp:30
        I(cpphdl_n65, cpphdl_n69) <+ cpphdl_channel(V(cpphdl_n59, cpphdl_n69), V(cpphdl_n65, cpphdl_n69), 0.029999999999999999, 0.69999999999999996, 1.0);
        // device 64, IC IC6, analog/basic/cascode_ota.hpp:31
        I(cpphdl_n66, cpphdl_n64) <+ cpphdl_channel(V(cpphdl_n61, cpphdl_n64), V(cpphdl_n66, cpphdl_n64), 0.059999999999999998, 0.69999999999999996, 1.0);
        // device 65, IC IC6, analog/basic/cascode_ota.hpp:32
        I(cpphdl_n72, cpphdl_n65) <+ cpphdl_channel(V(cpphdl_n61, cpphdl_n65), V(cpphdl_n72, cpphdl_n65), 0.059999999999999998, 0.69999999999999996, 1.0);
        // device 66, IC IC6, analog/basic/cascode_ota.hpp:33
        I(cpphdl_n67, Vdd) <+ cpphdl_channel(V(cpphdl_n66, Vdd), V(cpphdl_n67, Vdd), 0.029999999999999999, 0.69999999999999996, -1.0);
        // device 67, IC IC6, analog/basic/cascode_ota.hpp:34
        I(cpphdl_n68, Vdd) <+ cpphdl_channel(V(cpphdl_n66, Vdd), V(cpphdl_n68, Vdd), 0.029999999999999999, 0.69999999999999996, -1.0);
        // device 68, IC IC6, analog/basic/cascode_ota.hpp:35
        I(cpphdl_n66, cpphdl_n67) <+ cpphdl_channel(V(cpphdl_n62, cpphdl_n67), V(cpphdl_n66, cpphdl_n67), 0.059999999999999998, 0.69999999999999996, -1.0);
        // device 69, IC IC6, analog/basic/cascode_ota.hpp:36
        I(cpphdl_n72, cpphdl_n68) <+ cpphdl_channel(V(cpphdl_n62, cpphdl_n68), V(cpphdl_n72, cpphdl_n68), 0.059999999999999998, 0.69999999999999996, -1.0);
        // device 70, IC IC6, analog/basic/cascode_ota.hpp:37
        I(cpphdl_n69, Vss) <+ cpphdl_channel(V(cpphdl_n63, Vss), V(cpphdl_n69, Vss), 0.059999999999999998, 0.69999999999999996, 1.0);
        // device 71, IC IC6, analog/basic/cascode_ota.hpp:38
        I(cpphdl_n72, Vss) <+ 2.4999999999999999e-13 * ddt(V(cpphdl_n72, Vss)); // Bench initial voltage = 0.0 V.
        // device 72, IC IC6, analog/basic/cascode_ota.hpp:39
        I(cpphdl_n64, Vss) <+ 4e-14 * ddt(V(cpphdl_n64, Vss)); // Bench initial voltage = 0.0 V.
        // device 73, IC IC6, analog/basic/cascode_ota.hpp:40
        I(cpphdl_n65, Vss) <+ 4e-14 * ddt(V(cpphdl_n65, Vss)); // Bench initial voltage = 0.0 V.
        // device 74, IC IC6, analog/basic/cascode_ota.hpp:41
        I(cpphdl_n69, Vss) <+ 4e-14 * ddt(V(cpphdl_n69, Vss)); // Bench initial voltage = 0.0 V.
        // device 75, IC IC6, analog/basic/cascode_ota.hpp:42
        I(cpphdl_n67, Vdd) <+ 4e-14 * ddt(V(cpphdl_n67, Vdd)); // Bench initial voltage = 0.0 V.
        // device 76, IC IC6, analog/basic/cascode_ota.hpp:43
        I(cpphdl_n68, Vdd) <+ 4e-14 * ddt(V(cpphdl_n68, Vdd)); // Bench initial voltage = 0.0 V.
        // device 77, IC IC6, analog/basic/cascode_ota.hpp:44
        I(cpphdl_n66, Vss) <+ 4e-14 * ddt(V(cpphdl_n66, Vss)); // Bench initial voltage = 0.0 V.
        // device 78, IC IC6, analog/basic/cascode_ota.hpp:45
        I(cpphdl_n58, cpphdl_n69) <+ 4e-14 * ddt(V(cpphdl_n58, cpphdl_n69)); // Bench initial voltage = 0.0 V.
        // device 79, IC IC6, analog/basic/cascode_ota.hpp:46
        I(cpphdl_n59, cpphdl_n69) <+ 4e-14 * ddt(V(cpphdl_n59, cpphdl_n69)); // Bench initial voltage = 0.0 V.
        // device 80, IC IC6, analog/basic/cascode_ota.hpp:47
        I(cpphdl_n58, cpphdl_n64) <+ 1e-14 * ddt(V(cpphdl_n58, cpphdl_n64)); // Bench initial voltage = 0.0 V.
        // device 81, IC IC6, analog/basic/cascode_ota.hpp:48
        I(cpphdl_n59, cpphdl_n65) <+ 1e-14 * ddt(V(cpphdl_n59, cpphdl_n65)); // Bench initial voltage = 0.0 V.
        // device 82, IC IC7, analog/basic/nmos_source_follower.hpp:19
        I(Vdd, OUT) <+ cpphdl_channel(V(cpphdl_n72, OUT), V(Vdd, OUT), 0.20000000000000001, 0.69999999999999996, 1.0);
        // device 83, IC IC7, analog/basic/nmos_source_follower.hpp:20
        I(Vss, OUT) <+ V(Vss, OUT) / 500.0;
        // device 84, IC IC7, analog/basic/nmos_source_follower.hpp:23
        I(cpphdl_n72, OUT) <+ 8e-14 * ddt(V(cpphdl_n72, OUT)); // Bench initial voltage = 0.0 V.
        // device 85, IC IC7, analog/basic/nmos_source_follower.hpp:24
        I(cpphdl_n72, Vdd) <+ 2e-14 * ddt(V(cpphdl_n72, Vdd)); // Bench initial voltage = 0.0 V.
        // device 86, IC IC7, analog/basic/nmos_source_follower.hpp:25
        I(OUT, Vss) <+ 8e-14 * ddt(V(OUT, Vss)); // Bench initial voltage = 0.0 V.
    end
endmodule
