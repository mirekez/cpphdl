// SIMULATION APPROXIMATION: controlled conductances are not physical MOS devices.
// Generated from elaborated C++HDL IC purposes; all contributions coexist.
// Capacitor initialization belongs to the host analysis; declared initial voltages appear below.
`include "disciplines.vams"

module OneGCascodedEmphasizedPAM5Driver(Vdd, Vss, P, N, MAIN_P0, MAIN_N0, HISTORY_P0, HISTORY_N0, MAIN_P1, MAIN_N1, HISTORY_P1, HISTORY_N1, MAIN_P2, MAIN_N2, HISTORY_P2, HISTORY_N2, MAIN_P3, MAIN_N3, HISTORY_P3, HISTORY_N3, TRIM_N0, TRIM_N1, TRIM_N2, TRIM_N3, TRIM_N4, TRIM_N5);
    inout Vdd, Vss, P, N, MAIN_P0, MAIN_N0, HISTORY_P0, HISTORY_N0, MAIN_P1, MAIN_N1, HISTORY_P1, HISTORY_N1, MAIN_P2, MAIN_N2, HISTORY_P2, HISTORY_N2, MAIN_P3, MAIN_N3, HISTORY_P3, HISTORY_N3, TRIM_N0, TRIM_N1, TRIM_N2, TRIM_N3, TRIM_N4, TRIM_N5;
    electrical Vdd, Vss, P, N, MAIN_P0, MAIN_N0, HISTORY_P0, HISTORY_N0, MAIN_P1, MAIN_N1, HISTORY_P1, HISTORY_N1, MAIN_P2, MAIN_N2, HISTORY_P2, HISTORY_N2, MAIN_P3, MAIN_N3, HISTORY_P3, HISTORY_N3, TRIM_N0, TRIM_N1, TRIM_N2, TRIM_N3, TRIM_N4, TRIM_N5;
    electrical cpphdl_n28;
    electrical cpphdl_n29;
    electrical cpphdl_n30;
    electrical cpphdl_n31;
    electrical cpphdl_n32;
    electrical cpphdl_n33;
    electrical cpphdl_n34;
    electrical cpphdl_n35;
    electrical cpphdl_n36;
    electrical cpphdl_n37;
    electrical cpphdl_n38;
    electrical cpphdl_n39;
    electrical cpphdl_n40;
    electrical cpphdl_n41;
    electrical cpphdl_n42;
    electrical cpphdl_n43;
    electrical cpphdl_n44;
    electrical cpphdl_n47;
    electrical cpphdl_n54;
    electrical cpphdl_n55;
    electrical cpphdl_n56;
    electrical cpphdl_n57;
    electrical cpphdl_n58;
    electrical cpphdl_n59;

    // Square-law channel, including reverse conduction. This is not a BSIM model.
    analog function real cpphdl_channel;
        input vgs, vds, beta, threshold, polarity;
        real vgs, vds, beta, threshold, polarity;
        real gate, drain, direction, overdrive, current;
        begin
            gate = polarity * vgs;
            drain = polarity * vds;
            direction = 1.0;
            if (drain < 0.0) begin
                gate = gate - drain;
                drain = -drain;
                direction = -1.0;
            end
            overdrive = gate - threshold;
            current = 0.0;
            if (overdrive > 0.0) begin
                if (drain < overdrive)
                    current = beta * (overdrive * drain - drain * drain / 2.0);
                else
                    current = beta * overdrive * overdrive / 2.0;
            end
            cpphdl_channel = polarity * direction * current;
        end
    endfunction

    analog begin
        // device 0, IC IC1, analog/1G/IHPSG13G2/biased_driver.hpp:14
        I(Vdd, cpphdl_n47) <+ V(Vdd, cpphdl_n47) / 1800.0;
        // device 1, IC IC1, analog/1G/IHPSG13G2/biased_driver.hpp:15
        I(cpphdl_n47, Vss) <+ cpphdl_channel(V(cpphdl_n47, Vss), V(cpphdl_n47, Vss), 0.014268727705112965, 0.34999999999999998, 1.0);
        // device 2, IC IC1, analog/1G/IHPSG13G2/biased_driver.hpp:31
        I(cpphdl_n54, Vdd) <+ cpphdl_channel(V(TRIM_N0, Vdd), V(cpphdl_n54, Vdd), 0.02, 0.69999999999999996, -1.0);
        // device 3, IC IC1, analog/1G/IHPSG13G2/biased_driver.hpp:32
        I(cpphdl_n54, cpphdl_n47) <+ V(cpphdl_n54, cpphdl_n47) / 256000.0;
        // device 4, IC IC1, analog/1G/IHPSG13G2/biased_driver.hpp:31
        I(cpphdl_n55, Vdd) <+ cpphdl_channel(V(TRIM_N1, Vdd), V(cpphdl_n55, Vdd), 0.02, 0.69999999999999996, -1.0);
        // device 5, IC IC1, analog/1G/IHPSG13G2/biased_driver.hpp:32
        I(cpphdl_n55, cpphdl_n47) <+ V(cpphdl_n55, cpphdl_n47) / 128000.0;
        // device 6, IC IC1, analog/1G/IHPSG13G2/biased_driver.hpp:31
        I(cpphdl_n56, Vdd) <+ cpphdl_channel(V(TRIM_N2, Vdd), V(cpphdl_n56, Vdd), 0.02, 0.69999999999999996, -1.0);
        // device 7, IC IC1, analog/1G/IHPSG13G2/biased_driver.hpp:32
        I(cpphdl_n56, cpphdl_n47) <+ V(cpphdl_n56, cpphdl_n47) / 64000.0;
        // device 8, IC IC1, analog/1G/IHPSG13G2/biased_driver.hpp:31
        I(cpphdl_n57, Vdd) <+ cpphdl_channel(V(TRIM_N3, Vdd), V(cpphdl_n57, Vdd), 0.02, 0.69999999999999996, -1.0);
        // device 9, IC IC1, analog/1G/IHPSG13G2/biased_driver.hpp:32
        I(cpphdl_n57, cpphdl_n47) <+ V(cpphdl_n57, cpphdl_n47) / 32000.0;
        // device 10, IC IC1, analog/1G/IHPSG13G2/biased_driver.hpp:31
        I(cpphdl_n58, Vdd) <+ cpphdl_channel(V(TRIM_N4, Vdd), V(cpphdl_n58, Vdd), 0.02, 0.69999999999999996, -1.0);
        // device 11, IC IC1, analog/1G/IHPSG13G2/biased_driver.hpp:32
        I(cpphdl_n58, cpphdl_n47) <+ V(cpphdl_n58, cpphdl_n47) / 16000.0;
        // device 12, IC IC1, analog/1G/IHPSG13G2/biased_driver.hpp:31
        I(cpphdl_n59, Vdd) <+ cpphdl_channel(V(TRIM_N5, Vdd), V(cpphdl_n59, Vdd), 0.02, 0.69999999999999996, -1.0);
        // device 13, IC IC1, analog/1G/IHPSG13G2/biased_driver.hpp:32
        I(cpphdl_n59, cpphdl_n47) <+ V(cpphdl_n59, cpphdl_n47) / 8000.0;
        // device 14, IC OneGCascodedEmphasizedPAM5Driver, analog/1G/IHPSG13G2/cascoded_core_transmit_driver.hpp:32
        I(cpphdl_n47, Vss) <+ 4.0000000000000001e-10 * ddt(V(cpphdl_n47, Vss)); // Bench initial voltage = 0.0 V.
        // device 15, IC OneGCascodedEmphasizedPAM5Driver, analog/1G/IHPSG13G2/cascoded_core_transmit_driver.hpp:33
        I(Vdd, cpphdl_n28) <+ V(Vdd, cpphdl_n28) / 3000.0;
        // device 16, IC OneGCascodedEmphasizedPAM5Driver, analog/1G/IHPSG13G2/cascoded_core_transmit_driver.hpp:34
        I(cpphdl_n28, Vss) <+ V(cpphdl_n28, Vss) / 3600.0;
        // device 17, IC OneGCascodedEmphasizedPAM5Driver, analog/1G/IHPSG13G2/cascoded_core_transmit_driver.hpp:35
        I(cpphdl_n28, Vss) <+ 5.0000000000000002e-11 * ddt(V(cpphdl_n28, Vss)); // Bench initial voltage = 0.0 V.
        // device 18, IC OneGCascodedEmphasizedPAM5Driver, analog/1G/IHPSG13G2/cascoded_core_transmit_driver.hpp:36
        I(Vdd, P) <+ V(Vdd, P) / 50.0;
        // device 19, IC OneGCascodedEmphasizedPAM5Driver, analog/1G/IHPSG13G2/cascoded_core_transmit_driver.hpp:37
        I(Vdd, N) <+ V(Vdd, N) / 50.0;
        // device 20, IC OneGCascodedEmphasizedPAM5Driver, analog/1G/IHPSG13G2/cascoded_core_transmit_driver.hpp:38
        I(P, Vdd) <+ 4.9999999999999999e-13 * ddt(V(P, Vdd)); // Bench initial voltage = 0.0 V.
        // device 21, IC OneGCascodedEmphasizedPAM5Driver, analog/1G/IHPSG13G2/cascoded_core_transmit_driver.hpp:39
        I(N, Vdd) <+ 4.9999999999999999e-13 * ddt(V(N, Vdd)); // Bench initial voltage = 0.0 V.
        // device 22, IC OneGCascodedEmphasizedPAM5Driver, analog/1G/IHPSG13G2/cascoded_core_transmit_driver.hpp:53
        I(P, cpphdl_n29) <+ cpphdl_channel(V(MAIN_P0, cpphdl_n29), V(P, cpphdl_n29), 0.080000000000000002, 0.69999999999999996, 1.0);
        // device 23, IC OneGCascodedEmphasizedPAM5Driver, analog/1G/IHPSG13G2/cascoded_core_transmit_driver.hpp:54
        I(N, cpphdl_n29) <+ cpphdl_channel(V(MAIN_N0, cpphdl_n29), V(N, cpphdl_n29), 0.080000000000000002, 0.69999999999999996, 1.0);
        // device 24, IC OneGCascodedEmphasizedPAM5Driver, analog/1G/IHPSG13G2/cascoded_core_transmit_driver.hpp:55
        I(cpphdl_n29, cpphdl_n37) <+ cpphdl_channel(V(cpphdl_n28, cpphdl_n37), V(cpphdl_n29, cpphdl_n37), 0.30000000000000004, 0.69999999999999996, 1.0);
        // device 25, IC OneGCascodedEmphasizedPAM5Driver, analog/1G/IHPSG13G2/cascoded_core_transmit_driver.hpp:56
        I(cpphdl_n37, Vss) <+ cpphdl_channel(V(cpphdl_n47, Vss), V(cpphdl_n37, Vss), 0.0659862954984239, 0.34999999999999998, 1.0);
        // device 26, IC OneGCascodedEmphasizedPAM5Driver, analog/1G/IHPSG13G2/cascoded_core_transmit_driver.hpp:57
        I(cpphdl_n29, Vss) <+ 1.1e-13 * ddt(V(cpphdl_n29, Vss)); // Bench initial voltage = 0.0 V.
        // device 27, IC OneGCascodedEmphasizedPAM5Driver, analog/1G/IHPSG13G2/cascoded_core_transmit_driver.hpp:58
        I(cpphdl_n37, Vss) <+ 8.9999999999999995e-14 * ddt(V(cpphdl_n37, Vss)); // Bench initial voltage = 0.0 V.
        // device 28, IC OneGCascodedEmphasizedPAM5Driver, analog/1G/IHPSG13G2/cascoded_core_transmit_driver.hpp:59
        I(MAIN_P0, cpphdl_n29) <+ 7.1999999999999996e-13 * ddt(V(MAIN_P0, cpphdl_n29)); // Bench initial voltage = 0.0 V.
        // device 29, IC OneGCascodedEmphasizedPAM5Driver, analog/1G/IHPSG13G2/cascoded_core_transmit_driver.hpp:60
        I(MAIN_N0, cpphdl_n29) <+ 7.1999999999999996e-13 * ddt(V(MAIN_N0, cpphdl_n29)); // Bench initial voltage = 0.0 V.
        // device 30, IC OneGCascodedEmphasizedPAM5Driver, analog/1G/IHPSG13G2/cascoded_core_transmit_driver.hpp:61
        I(MAIN_P0, P) <+ 1.7999999999999999e-13 * ddt(V(MAIN_P0, P)); // Bench initial voltage = 0.0 V.
        // device 31, IC OneGCascodedEmphasizedPAM5Driver, analog/1G/IHPSG13G2/cascoded_core_transmit_driver.hpp:62
        I(MAIN_N0, N) <+ 1.7999999999999999e-13 * ddt(V(MAIN_N0, N)); // Bench initial voltage = 0.0 V.
        // device 32, IC OneGCascodedEmphasizedPAM5Driver, analog/1G/IHPSG13G2/cascoded_core_transmit_driver.hpp:63
        I(cpphdl_n47, Vss) <+ 8.0999999999999998e-13 * ddt(V(cpphdl_n47, Vss)); // Bench initial voltage = 0.0 V.
        // device 33, IC OneGCascodedEmphasizedPAM5Driver, analog/1G/IHPSG13G2/cascoded_core_transmit_driver.hpp:64
        I(cpphdl_n47, cpphdl_n37) <+ 2.025e-13 * ddt(V(cpphdl_n47, cpphdl_n37)); // Bench initial voltage = 0.0 V.
        // device 34, IC OneGCascodedEmphasizedPAM5Driver, analog/1G/IHPSG13G2/cascoded_core_transmit_driver.hpp:65
        I(cpphdl_n28, cpphdl_n37) <+ 2.7000000000000002e-12 * ddt(V(cpphdl_n28, cpphdl_n37)); // Bench initial voltage = 0.0 V.
        // device 35, IC OneGCascodedEmphasizedPAM5Driver, analog/1G/IHPSG13G2/cascoded_core_transmit_driver.hpp:66
        I(cpphdl_n28, cpphdl_n29) <+ 6.7500000000000005e-13 * ddt(V(cpphdl_n28, cpphdl_n29)); // Bench initial voltage = 0.0 V.
        // device 36, IC OneGCascodedEmphasizedPAM5Driver, analog/1G/IHPSG13G2/cascoded_core_transmit_driver.hpp:53
        I(P, cpphdl_n30) <+ cpphdl_channel(V(MAIN_P1, cpphdl_n30), V(P, cpphdl_n30), 0.080000000000000002, 0.69999999999999996, 1.0);
        // device 37, IC OneGCascodedEmphasizedPAM5Driver, analog/1G/IHPSG13G2/cascoded_core_transmit_driver.hpp:54
        I(N, cpphdl_n30) <+ cpphdl_channel(V(MAIN_N1, cpphdl_n30), V(N, cpphdl_n30), 0.080000000000000002, 0.69999999999999996, 1.0);
        // device 38, IC OneGCascodedEmphasizedPAM5Driver, analog/1G/IHPSG13G2/cascoded_core_transmit_driver.hpp:55
        I(cpphdl_n30, cpphdl_n38) <+ cpphdl_channel(V(cpphdl_n28, cpphdl_n38), V(cpphdl_n30, cpphdl_n38), 0.30000000000000004, 0.69999999999999996, 1.0);
        // device 39, IC OneGCascodedEmphasizedPAM5Driver, analog/1G/IHPSG13G2/cascoded_core_transmit_driver.hpp:56
        I(cpphdl_n38, Vss) <+ cpphdl_channel(V(cpphdl_n47, Vss), V(cpphdl_n38, Vss), 0.0659862954984239, 0.34999999999999998, 1.0);
        // device 40, IC OneGCascodedEmphasizedPAM5Driver, analog/1G/IHPSG13G2/cascoded_core_transmit_driver.hpp:57
        I(cpphdl_n30, Vss) <+ 1.1e-13 * ddt(V(cpphdl_n30, Vss)); // Bench initial voltage = 0.0 V.
        // device 41, IC OneGCascodedEmphasizedPAM5Driver, analog/1G/IHPSG13G2/cascoded_core_transmit_driver.hpp:58
        I(cpphdl_n38, Vss) <+ 8.9999999999999995e-14 * ddt(V(cpphdl_n38, Vss)); // Bench initial voltage = 0.0 V.
        // device 42, IC OneGCascodedEmphasizedPAM5Driver, analog/1G/IHPSG13G2/cascoded_core_transmit_driver.hpp:59
        I(MAIN_P1, cpphdl_n30) <+ 7.1999999999999996e-13 * ddt(V(MAIN_P1, cpphdl_n30)); // Bench initial voltage = 0.0 V.
        // device 43, IC OneGCascodedEmphasizedPAM5Driver, analog/1G/IHPSG13G2/cascoded_core_transmit_driver.hpp:60
        I(MAIN_N1, cpphdl_n30) <+ 7.1999999999999996e-13 * ddt(V(MAIN_N1, cpphdl_n30)); // Bench initial voltage = 0.0 V.
        // device 44, IC OneGCascodedEmphasizedPAM5Driver, analog/1G/IHPSG13G2/cascoded_core_transmit_driver.hpp:61
        I(MAIN_P1, P) <+ 1.7999999999999999e-13 * ddt(V(MAIN_P1, P)); // Bench initial voltage = 0.0 V.
        // device 45, IC OneGCascodedEmphasizedPAM5Driver, analog/1G/IHPSG13G2/cascoded_core_transmit_driver.hpp:62
        I(MAIN_N1, N) <+ 1.7999999999999999e-13 * ddt(V(MAIN_N1, N)); // Bench initial voltage = 0.0 V.
        // device 46, IC OneGCascodedEmphasizedPAM5Driver, analog/1G/IHPSG13G2/cascoded_core_transmit_driver.hpp:63
        I(cpphdl_n47, Vss) <+ 8.0999999999999998e-13 * ddt(V(cpphdl_n47, Vss)); // Bench initial voltage = 0.0 V.
        // device 47, IC OneGCascodedEmphasizedPAM5Driver, analog/1G/IHPSG13G2/cascoded_core_transmit_driver.hpp:64
        I(cpphdl_n47, cpphdl_n38) <+ 2.025e-13 * ddt(V(cpphdl_n47, cpphdl_n38)); // Bench initial voltage = 0.0 V.
        // device 48, IC OneGCascodedEmphasizedPAM5Driver, analog/1G/IHPSG13G2/cascoded_core_transmit_driver.hpp:65
        I(cpphdl_n28, cpphdl_n38) <+ 2.7000000000000002e-12 * ddt(V(cpphdl_n28, cpphdl_n38)); // Bench initial voltage = 0.0 V.
        // device 49, IC OneGCascodedEmphasizedPAM5Driver, analog/1G/IHPSG13G2/cascoded_core_transmit_driver.hpp:66
        I(cpphdl_n28, cpphdl_n30) <+ 6.7500000000000005e-13 * ddt(V(cpphdl_n28, cpphdl_n30)); // Bench initial voltage = 0.0 V.
        // device 50, IC OneGCascodedEmphasizedPAM5Driver, analog/1G/IHPSG13G2/cascoded_core_transmit_driver.hpp:53
        I(P, cpphdl_n31) <+ cpphdl_channel(V(MAIN_P2, cpphdl_n31), V(P, cpphdl_n31), 0.080000000000000002, 0.69999999999999996, 1.0);
        // device 51, IC OneGCascodedEmphasizedPAM5Driver, analog/1G/IHPSG13G2/cascoded_core_transmit_driver.hpp:54
        I(N, cpphdl_n31) <+ cpphdl_channel(V(MAIN_N2, cpphdl_n31), V(N, cpphdl_n31), 0.080000000000000002, 0.69999999999999996, 1.0);
        // device 52, IC OneGCascodedEmphasizedPAM5Driver, analog/1G/IHPSG13G2/cascoded_core_transmit_driver.hpp:55
        I(cpphdl_n31, cpphdl_n39) <+ cpphdl_channel(V(cpphdl_n28, cpphdl_n39), V(cpphdl_n31, cpphdl_n39), 0.30000000000000004, 0.69999999999999996, 1.0);
        // device 53, IC OneGCascodedEmphasizedPAM5Driver, analog/1G/IHPSG13G2/cascoded_core_transmit_driver.hpp:56
        I(cpphdl_n39, Vss) <+ cpphdl_channel(V(cpphdl_n47, Vss), V(cpphdl_n39, Vss), 0.0659862954984239, 0.34999999999999998, 1.0);
        // device 54, IC OneGCascodedEmphasizedPAM5Driver, analog/1G/IHPSG13G2/cascoded_core_transmit_driver.hpp:57
        I(cpphdl_n31, Vss) <+ 1.1e-13 * ddt(V(cpphdl_n31, Vss)); // Bench initial voltage = 0.0 V.
        // device 55, IC OneGCascodedEmphasizedPAM5Driver, analog/1G/IHPSG13G2/cascoded_core_transmit_driver.hpp:58
        I(cpphdl_n39, Vss) <+ 8.9999999999999995e-14 * ddt(V(cpphdl_n39, Vss)); // Bench initial voltage = 0.0 V.
        // device 56, IC OneGCascodedEmphasizedPAM5Driver, analog/1G/IHPSG13G2/cascoded_core_transmit_driver.hpp:59
        I(MAIN_P2, cpphdl_n31) <+ 7.1999999999999996e-13 * ddt(V(MAIN_P2, cpphdl_n31)); // Bench initial voltage = 0.0 V.
        // device 57, IC OneGCascodedEmphasizedPAM5Driver, analog/1G/IHPSG13G2/cascoded_core_transmit_driver.hpp:60
        I(MAIN_N2, cpphdl_n31) <+ 7.1999999999999996e-13 * ddt(V(MAIN_N2, cpphdl_n31)); // Bench initial voltage = 0.0 V.
        // device 58, IC OneGCascodedEmphasizedPAM5Driver, analog/1G/IHPSG13G2/cascoded_core_transmit_driver.hpp:61
        I(MAIN_P2, P) <+ 1.7999999999999999e-13 * ddt(V(MAIN_P2, P)); // Bench initial voltage = 0.0 V.
        // device 59, IC OneGCascodedEmphasizedPAM5Driver, analog/1G/IHPSG13G2/cascoded_core_transmit_driver.hpp:62
        I(MAIN_N2, N) <+ 1.7999999999999999e-13 * ddt(V(MAIN_N2, N)); // Bench initial voltage = 0.0 V.
        // device 60, IC OneGCascodedEmphasizedPAM5Driver, analog/1G/IHPSG13G2/cascoded_core_transmit_driver.hpp:63
        I(cpphdl_n47, Vss) <+ 8.0999999999999998e-13 * ddt(V(cpphdl_n47, Vss)); // Bench initial voltage = 0.0 V.
        // device 61, IC OneGCascodedEmphasizedPAM5Driver, analog/1G/IHPSG13G2/cascoded_core_transmit_driver.hpp:64
        I(cpphdl_n47, cpphdl_n39) <+ 2.025e-13 * ddt(V(cpphdl_n47, cpphdl_n39)); // Bench initial voltage = 0.0 V.
        // device 62, IC OneGCascodedEmphasizedPAM5Driver, analog/1G/IHPSG13G2/cascoded_core_transmit_driver.hpp:65
        I(cpphdl_n28, cpphdl_n39) <+ 2.7000000000000002e-12 * ddt(V(cpphdl_n28, cpphdl_n39)); // Bench initial voltage = 0.0 V.
        // device 63, IC OneGCascodedEmphasizedPAM5Driver, analog/1G/IHPSG13G2/cascoded_core_transmit_driver.hpp:66
        I(cpphdl_n28, cpphdl_n31) <+ 6.7500000000000005e-13 * ddt(V(cpphdl_n28, cpphdl_n31)); // Bench initial voltage = 0.0 V.
        // device 64, IC OneGCascodedEmphasizedPAM5Driver, analog/1G/IHPSG13G2/cascoded_core_transmit_driver.hpp:53
        I(P, cpphdl_n32) <+ cpphdl_channel(V(MAIN_P3, cpphdl_n32), V(P, cpphdl_n32), 0.080000000000000002, 0.69999999999999996, 1.0);
        // device 65, IC OneGCascodedEmphasizedPAM5Driver, analog/1G/IHPSG13G2/cascoded_core_transmit_driver.hpp:54
        I(N, cpphdl_n32) <+ cpphdl_channel(V(MAIN_N3, cpphdl_n32), V(N, cpphdl_n32), 0.080000000000000002, 0.69999999999999996, 1.0);
        // device 66, IC OneGCascodedEmphasizedPAM5Driver, analog/1G/IHPSG13G2/cascoded_core_transmit_driver.hpp:55
        I(cpphdl_n32, cpphdl_n40) <+ cpphdl_channel(V(cpphdl_n28, cpphdl_n40), V(cpphdl_n32, cpphdl_n40), 0.30000000000000004, 0.69999999999999996, 1.0);
        // device 67, IC OneGCascodedEmphasizedPAM5Driver, analog/1G/IHPSG13G2/cascoded_core_transmit_driver.hpp:56
        I(cpphdl_n40, Vss) <+ cpphdl_channel(V(cpphdl_n47, Vss), V(cpphdl_n40, Vss), 0.0659862954984239, 0.34999999999999998, 1.0);
        // device 68, IC OneGCascodedEmphasizedPAM5Driver, analog/1G/IHPSG13G2/cascoded_core_transmit_driver.hpp:57
        I(cpphdl_n32, Vss) <+ 1.1e-13 * ddt(V(cpphdl_n32, Vss)); // Bench initial voltage = 0.0 V.
        // device 69, IC OneGCascodedEmphasizedPAM5Driver, analog/1G/IHPSG13G2/cascoded_core_transmit_driver.hpp:58
        I(cpphdl_n40, Vss) <+ 8.9999999999999995e-14 * ddt(V(cpphdl_n40, Vss)); // Bench initial voltage = 0.0 V.
        // device 70, IC OneGCascodedEmphasizedPAM5Driver, analog/1G/IHPSG13G2/cascoded_core_transmit_driver.hpp:59
        I(MAIN_P3, cpphdl_n32) <+ 7.1999999999999996e-13 * ddt(V(MAIN_P3, cpphdl_n32)); // Bench initial voltage = 0.0 V.
        // device 71, IC OneGCascodedEmphasizedPAM5Driver, analog/1G/IHPSG13G2/cascoded_core_transmit_driver.hpp:60
        I(MAIN_N3, cpphdl_n32) <+ 7.1999999999999996e-13 * ddt(V(MAIN_N3, cpphdl_n32)); // Bench initial voltage = 0.0 V.
        // device 72, IC OneGCascodedEmphasizedPAM5Driver, analog/1G/IHPSG13G2/cascoded_core_transmit_driver.hpp:61
        I(MAIN_P3, P) <+ 1.7999999999999999e-13 * ddt(V(MAIN_P3, P)); // Bench initial voltage = 0.0 V.
        // device 73, IC OneGCascodedEmphasizedPAM5Driver, analog/1G/IHPSG13G2/cascoded_core_transmit_driver.hpp:62
        I(MAIN_N3, N) <+ 1.7999999999999999e-13 * ddt(V(MAIN_N3, N)); // Bench initial voltage = 0.0 V.
        // device 74, IC OneGCascodedEmphasizedPAM5Driver, analog/1G/IHPSG13G2/cascoded_core_transmit_driver.hpp:63
        I(cpphdl_n47, Vss) <+ 8.0999999999999998e-13 * ddt(V(cpphdl_n47, Vss)); // Bench initial voltage = 0.0 V.
        // device 75, IC OneGCascodedEmphasizedPAM5Driver, analog/1G/IHPSG13G2/cascoded_core_transmit_driver.hpp:64
        I(cpphdl_n47, cpphdl_n40) <+ 2.025e-13 * ddt(V(cpphdl_n47, cpphdl_n40)); // Bench initial voltage = 0.0 V.
        // device 76, IC OneGCascodedEmphasizedPAM5Driver, analog/1G/IHPSG13G2/cascoded_core_transmit_driver.hpp:65
        I(cpphdl_n28, cpphdl_n40) <+ 2.7000000000000002e-12 * ddt(V(cpphdl_n28, cpphdl_n40)); // Bench initial voltage = 0.0 V.
        // device 77, IC OneGCascodedEmphasizedPAM5Driver, analog/1G/IHPSG13G2/cascoded_core_transmit_driver.hpp:66
        I(cpphdl_n28, cpphdl_n32) <+ 6.7500000000000005e-13 * ddt(V(cpphdl_n28, cpphdl_n32)); // Bench initial voltage = 0.0 V.
        // device 78, IC OneGCascodedEmphasizedPAM5Driver, analog/1G/IHPSG13G2/cascoded_core_transmit_driver.hpp:53
        I(P, cpphdl_n33) <+ cpphdl_channel(V(HISTORY_P0, cpphdl_n33), V(P, cpphdl_n33), 0.040000000000000001, 0.69999999999999996, 1.0);
        // device 79, IC OneGCascodedEmphasizedPAM5Driver, analog/1G/IHPSG13G2/cascoded_core_transmit_driver.hpp:54
        I(N, cpphdl_n33) <+ cpphdl_channel(V(HISTORY_N0, cpphdl_n33), V(N, cpphdl_n33), 0.040000000000000001, 0.69999999999999996, 1.0);
        // device 80, IC OneGCascodedEmphasizedPAM5Driver, analog/1G/IHPSG13G2/cascoded_core_transmit_driver.hpp:55
        I(cpphdl_n33, cpphdl_n41) <+ cpphdl_channel(V(cpphdl_n28, cpphdl_n41), V(cpphdl_n33, cpphdl_n41), 0.10000000000000001, 0.69999999999999996, 1.0);
        // device 81, IC OneGCascodedEmphasizedPAM5Driver, analog/1G/IHPSG13G2/cascoded_core_transmit_driver.hpp:56
        I(cpphdl_n41, Vss) <+ cpphdl_channel(V(cpphdl_n47, Vss), V(cpphdl_n41, Vss), 0.021995431832807968, 0.34999999999999998, 1.0);
        // device 82, IC OneGCascodedEmphasizedPAM5Driver, analog/1G/IHPSG13G2/cascoded_core_transmit_driver.hpp:57
        I(cpphdl_n33, Vss) <+ 1.1e-13 * ddt(V(cpphdl_n33, Vss)); // Bench initial voltage = 0.0 V.
        // device 83, IC OneGCascodedEmphasizedPAM5Driver, analog/1G/IHPSG13G2/cascoded_core_transmit_driver.hpp:58
        I(cpphdl_n41, Vss) <+ 2.9999999999999998e-14 * ddt(V(cpphdl_n41, Vss)); // Bench initial voltage = 0.0 V.
        // device 84, IC OneGCascodedEmphasizedPAM5Driver, analog/1G/IHPSG13G2/cascoded_core_transmit_driver.hpp:59
        I(HISTORY_P0, cpphdl_n33) <+ 3.5999999999999998e-13 * ddt(V(HISTORY_P0, cpphdl_n33)); // Bench initial voltage = 0.0 V.
        // device 85, IC OneGCascodedEmphasizedPAM5Driver, analog/1G/IHPSG13G2/cascoded_core_transmit_driver.hpp:60
        I(HISTORY_N0, cpphdl_n33) <+ 3.5999999999999998e-13 * ddt(V(HISTORY_N0, cpphdl_n33)); // Bench initial voltage = 0.0 V.
        // device 86, IC OneGCascodedEmphasizedPAM5Driver, analog/1G/IHPSG13G2/cascoded_core_transmit_driver.hpp:61
        I(HISTORY_P0, P) <+ 8.9999999999999995e-14 * ddt(V(HISTORY_P0, P)); // Bench initial voltage = 0.0 V.
        // device 87, IC OneGCascodedEmphasizedPAM5Driver, analog/1G/IHPSG13G2/cascoded_core_transmit_driver.hpp:62
        I(HISTORY_N0, N) <+ 8.9999999999999995e-14 * ddt(V(HISTORY_N0, N)); // Bench initial voltage = 0.0 V.
        // device 88, IC OneGCascodedEmphasizedPAM5Driver, analog/1G/IHPSG13G2/cascoded_core_transmit_driver.hpp:63
        I(cpphdl_n47, Vss) <+ 2.7000000000000001e-13 * ddt(V(cpphdl_n47, Vss)); // Bench initial voltage = 0.0 V.
        // device 89, IC OneGCascodedEmphasizedPAM5Driver, analog/1G/IHPSG13G2/cascoded_core_transmit_driver.hpp:64
        I(cpphdl_n47, cpphdl_n41) <+ 6.7500000000000003e-14 * ddt(V(cpphdl_n47, cpphdl_n41)); // Bench initial voltage = 0.0 V.
        // device 90, IC OneGCascodedEmphasizedPAM5Driver, analog/1G/IHPSG13G2/cascoded_core_transmit_driver.hpp:65
        I(cpphdl_n28, cpphdl_n41) <+ 9e-13 * ddt(V(cpphdl_n28, cpphdl_n41)); // Bench initial voltage = 0.0 V.
        // device 91, IC OneGCascodedEmphasizedPAM5Driver, analog/1G/IHPSG13G2/cascoded_core_transmit_driver.hpp:66
        I(cpphdl_n28, cpphdl_n33) <+ 2.25e-13 * ddt(V(cpphdl_n28, cpphdl_n33)); // Bench initial voltage = 0.0 V.
        // device 92, IC OneGCascodedEmphasizedPAM5Driver, analog/1G/IHPSG13G2/cascoded_core_transmit_driver.hpp:53
        I(P, cpphdl_n34) <+ cpphdl_channel(V(HISTORY_P1, cpphdl_n34), V(P, cpphdl_n34), 0.040000000000000001, 0.69999999999999996, 1.0);
        // device 93, IC OneGCascodedEmphasizedPAM5Driver, analog/1G/IHPSG13G2/cascoded_core_transmit_driver.hpp:54
        I(N, cpphdl_n34) <+ cpphdl_channel(V(HISTORY_N1, cpphdl_n34), V(N, cpphdl_n34), 0.040000000000000001, 0.69999999999999996, 1.0);
        // device 94, IC OneGCascodedEmphasizedPAM5Driver, analog/1G/IHPSG13G2/cascoded_core_transmit_driver.hpp:55
        I(cpphdl_n34, cpphdl_n42) <+ cpphdl_channel(V(cpphdl_n28, cpphdl_n42), V(cpphdl_n34, cpphdl_n42), 0.10000000000000001, 0.69999999999999996, 1.0);
        // device 95, IC OneGCascodedEmphasizedPAM5Driver, analog/1G/IHPSG13G2/cascoded_core_transmit_driver.hpp:56
        I(cpphdl_n42, Vss) <+ cpphdl_channel(V(cpphdl_n47, Vss), V(cpphdl_n42, Vss), 0.021995431832807968, 0.34999999999999998, 1.0);
        // device 96, IC OneGCascodedEmphasizedPAM5Driver, analog/1G/IHPSG13G2/cascoded_core_transmit_driver.hpp:57
        I(cpphdl_n34, Vss) <+ 1.1e-13 * ddt(V(cpphdl_n34, Vss)); // Bench initial voltage = 0.0 V.
        // device 97, IC OneGCascodedEmphasizedPAM5Driver, analog/1G/IHPSG13G2/cascoded_core_transmit_driver.hpp:58
        I(cpphdl_n42, Vss) <+ 2.9999999999999998e-14 * ddt(V(cpphdl_n42, Vss)); // Bench initial voltage = 0.0 V.
        // device 98, IC OneGCascodedEmphasizedPAM5Driver, analog/1G/IHPSG13G2/cascoded_core_transmit_driver.hpp:59
        I(HISTORY_P1, cpphdl_n34) <+ 3.5999999999999998e-13 * ddt(V(HISTORY_P1, cpphdl_n34)); // Bench initial voltage = 0.0 V.
        // device 99, IC OneGCascodedEmphasizedPAM5Driver, analog/1G/IHPSG13G2/cascoded_core_transmit_driver.hpp:60
        I(HISTORY_N1, cpphdl_n34) <+ 3.5999999999999998e-13 * ddt(V(HISTORY_N1, cpphdl_n34)); // Bench initial voltage = 0.0 V.
        // device 100, IC OneGCascodedEmphasizedPAM5Driver, analog/1G/IHPSG13G2/cascoded_core_transmit_driver.hpp:61
        I(HISTORY_P1, P) <+ 8.9999999999999995e-14 * ddt(V(HISTORY_P1, P)); // Bench initial voltage = 0.0 V.
        // device 101, IC OneGCascodedEmphasizedPAM5Driver, analog/1G/IHPSG13G2/cascoded_core_transmit_driver.hpp:62
        I(HISTORY_N1, N) <+ 8.9999999999999995e-14 * ddt(V(HISTORY_N1, N)); // Bench initial voltage = 0.0 V.
        // device 102, IC OneGCascodedEmphasizedPAM5Driver, analog/1G/IHPSG13G2/cascoded_core_transmit_driver.hpp:63
        I(cpphdl_n47, Vss) <+ 2.7000000000000001e-13 * ddt(V(cpphdl_n47, Vss)); // Bench initial voltage = 0.0 V.
        // device 103, IC OneGCascodedEmphasizedPAM5Driver, analog/1G/IHPSG13G2/cascoded_core_transmit_driver.hpp:64
        I(cpphdl_n47, cpphdl_n42) <+ 6.7500000000000003e-14 * ddt(V(cpphdl_n47, cpphdl_n42)); // Bench initial voltage = 0.0 V.
        // device 104, IC OneGCascodedEmphasizedPAM5Driver, analog/1G/IHPSG13G2/cascoded_core_transmit_driver.hpp:65
        I(cpphdl_n28, cpphdl_n42) <+ 9e-13 * ddt(V(cpphdl_n28, cpphdl_n42)); // Bench initial voltage = 0.0 V.
        // device 105, IC OneGCascodedEmphasizedPAM5Driver, analog/1G/IHPSG13G2/cascoded_core_transmit_driver.hpp:66
        I(cpphdl_n28, cpphdl_n34) <+ 2.25e-13 * ddt(V(cpphdl_n28, cpphdl_n34)); // Bench initial voltage = 0.0 V.
        // device 106, IC OneGCascodedEmphasizedPAM5Driver, analog/1G/IHPSG13G2/cascoded_core_transmit_driver.hpp:53
        I(P, cpphdl_n35) <+ cpphdl_channel(V(HISTORY_P2, cpphdl_n35), V(P, cpphdl_n35), 0.040000000000000001, 0.69999999999999996, 1.0);
        // device 107, IC OneGCascodedEmphasizedPAM5Driver, analog/1G/IHPSG13G2/cascoded_core_transmit_driver.hpp:54
        I(N, cpphdl_n35) <+ cpphdl_channel(V(HISTORY_N2, cpphdl_n35), V(N, cpphdl_n35), 0.040000000000000001, 0.69999999999999996, 1.0);
        // device 108, IC OneGCascodedEmphasizedPAM5Driver, analog/1G/IHPSG13G2/cascoded_core_transmit_driver.hpp:55
        I(cpphdl_n35, cpphdl_n43) <+ cpphdl_channel(V(cpphdl_n28, cpphdl_n43), V(cpphdl_n35, cpphdl_n43), 0.10000000000000001, 0.69999999999999996, 1.0);
        // device 109, IC OneGCascodedEmphasizedPAM5Driver, analog/1G/IHPSG13G2/cascoded_core_transmit_driver.hpp:56
        I(cpphdl_n43, Vss) <+ cpphdl_channel(V(cpphdl_n47, Vss), V(cpphdl_n43, Vss), 0.021995431832807968, 0.34999999999999998, 1.0);
        // device 110, IC OneGCascodedEmphasizedPAM5Driver, analog/1G/IHPSG13G2/cascoded_core_transmit_driver.hpp:57
        I(cpphdl_n35, Vss) <+ 1.1e-13 * ddt(V(cpphdl_n35, Vss)); // Bench initial voltage = 0.0 V.
        // device 111, IC OneGCascodedEmphasizedPAM5Driver, analog/1G/IHPSG13G2/cascoded_core_transmit_driver.hpp:58
        I(cpphdl_n43, Vss) <+ 2.9999999999999998e-14 * ddt(V(cpphdl_n43, Vss)); // Bench initial voltage = 0.0 V.
        // device 112, IC OneGCascodedEmphasizedPAM5Driver, analog/1G/IHPSG13G2/cascoded_core_transmit_driver.hpp:59
        I(HISTORY_P2, cpphdl_n35) <+ 3.5999999999999998e-13 * ddt(V(HISTORY_P2, cpphdl_n35)); // Bench initial voltage = 0.0 V.
        // device 113, IC OneGCascodedEmphasizedPAM5Driver, analog/1G/IHPSG13G2/cascoded_core_transmit_driver.hpp:60
        I(HISTORY_N2, cpphdl_n35) <+ 3.5999999999999998e-13 * ddt(V(HISTORY_N2, cpphdl_n35)); // Bench initial voltage = 0.0 V.
        // device 114, IC OneGCascodedEmphasizedPAM5Driver, analog/1G/IHPSG13G2/cascoded_core_transmit_driver.hpp:61
        I(HISTORY_P2, P) <+ 8.9999999999999995e-14 * ddt(V(HISTORY_P2, P)); // Bench initial voltage = 0.0 V.
        // device 115, IC OneGCascodedEmphasizedPAM5Driver, analog/1G/IHPSG13G2/cascoded_core_transmit_driver.hpp:62
        I(HISTORY_N2, N) <+ 8.9999999999999995e-14 * ddt(V(HISTORY_N2, N)); // Bench initial voltage = 0.0 V.
        // device 116, IC OneGCascodedEmphasizedPAM5Driver, analog/1G/IHPSG13G2/cascoded_core_transmit_driver.hpp:63
        I(cpphdl_n47, Vss) <+ 2.7000000000000001e-13 * ddt(V(cpphdl_n47, Vss)); // Bench initial voltage = 0.0 V.
        // device 117, IC OneGCascodedEmphasizedPAM5Driver, analog/1G/IHPSG13G2/cascoded_core_transmit_driver.hpp:64
        I(cpphdl_n47, cpphdl_n43) <+ 6.7500000000000003e-14 * ddt(V(cpphdl_n47, cpphdl_n43)); // Bench initial voltage = 0.0 V.
        // device 118, IC OneGCascodedEmphasizedPAM5Driver, analog/1G/IHPSG13G2/cascoded_core_transmit_driver.hpp:65
        I(cpphdl_n28, cpphdl_n43) <+ 9e-13 * ddt(V(cpphdl_n28, cpphdl_n43)); // Bench initial voltage = 0.0 V.
        // device 119, IC OneGCascodedEmphasizedPAM5Driver, analog/1G/IHPSG13G2/cascoded_core_transmit_driver.hpp:66
        I(cpphdl_n28, cpphdl_n35) <+ 2.25e-13 * ddt(V(cpphdl_n28, cpphdl_n35)); // Bench initial voltage = 0.0 V.
        // device 120, IC OneGCascodedEmphasizedPAM5Driver, analog/1G/IHPSG13G2/cascoded_core_transmit_driver.hpp:53
        I(P, cpphdl_n36) <+ cpphdl_channel(V(HISTORY_P3, cpphdl_n36), V(P, cpphdl_n36), 0.040000000000000001, 0.69999999999999996, 1.0);
        // device 121, IC OneGCascodedEmphasizedPAM5Driver, analog/1G/IHPSG13G2/cascoded_core_transmit_driver.hpp:54
        I(N, cpphdl_n36) <+ cpphdl_channel(V(HISTORY_N3, cpphdl_n36), V(N, cpphdl_n36), 0.040000000000000001, 0.69999999999999996, 1.0);
        // device 122, IC OneGCascodedEmphasizedPAM5Driver, analog/1G/IHPSG13G2/cascoded_core_transmit_driver.hpp:55
        I(cpphdl_n36, cpphdl_n44) <+ cpphdl_channel(V(cpphdl_n28, cpphdl_n44), V(cpphdl_n36, cpphdl_n44), 0.10000000000000001, 0.69999999999999996, 1.0);
        // device 123, IC OneGCascodedEmphasizedPAM5Driver, analog/1G/IHPSG13G2/cascoded_core_transmit_driver.hpp:56
        I(cpphdl_n44, Vss) <+ cpphdl_channel(V(cpphdl_n47, Vss), V(cpphdl_n44, Vss), 0.021995431832807968, 0.34999999999999998, 1.0);
        // device 124, IC OneGCascodedEmphasizedPAM5Driver, analog/1G/IHPSG13G2/cascoded_core_transmit_driver.hpp:57
        I(cpphdl_n36, Vss) <+ 1.1e-13 * ddt(V(cpphdl_n36, Vss)); // Bench initial voltage = 0.0 V.
        // device 125, IC OneGCascodedEmphasizedPAM5Driver, analog/1G/IHPSG13G2/cascoded_core_transmit_driver.hpp:58
        I(cpphdl_n44, Vss) <+ 2.9999999999999998e-14 * ddt(V(cpphdl_n44, Vss)); // Bench initial voltage = 0.0 V.
        // device 126, IC OneGCascodedEmphasizedPAM5Driver, analog/1G/IHPSG13G2/cascoded_core_transmit_driver.hpp:59
        I(HISTORY_P3, cpphdl_n36) <+ 3.5999999999999998e-13 * ddt(V(HISTORY_P3, cpphdl_n36)); // Bench initial voltage = 0.0 V.
        // device 127, IC OneGCascodedEmphasizedPAM5Driver, analog/1G/IHPSG13G2/cascoded_core_transmit_driver.hpp:60
        I(HISTORY_N3, cpphdl_n36) <+ 3.5999999999999998e-13 * ddt(V(HISTORY_N3, cpphdl_n36)); // Bench initial voltage = 0.0 V.
        // device 128, IC OneGCascodedEmphasizedPAM5Driver, analog/1G/IHPSG13G2/cascoded_core_transmit_driver.hpp:61
        I(HISTORY_P3, P) <+ 8.9999999999999995e-14 * ddt(V(HISTORY_P3, P)); // Bench initial voltage = 0.0 V.
        // device 129, IC OneGCascodedEmphasizedPAM5Driver, analog/1G/IHPSG13G2/cascoded_core_transmit_driver.hpp:62
        I(HISTORY_N3, N) <+ 8.9999999999999995e-14 * ddt(V(HISTORY_N3, N)); // Bench initial voltage = 0.0 V.
        // device 130, IC OneGCascodedEmphasizedPAM5Driver, analog/1G/IHPSG13G2/cascoded_core_transmit_driver.hpp:63
        I(cpphdl_n47, Vss) <+ 2.7000000000000001e-13 * ddt(V(cpphdl_n47, Vss)); // Bench initial voltage = 0.0 V.
        // device 131, IC OneGCascodedEmphasizedPAM5Driver, analog/1G/IHPSG13G2/cascoded_core_transmit_driver.hpp:64
        I(cpphdl_n47, cpphdl_n44) <+ 6.7500000000000003e-14 * ddt(V(cpphdl_n47, cpphdl_n44)); // Bench initial voltage = 0.0 V.
        // device 132, IC OneGCascodedEmphasizedPAM5Driver, analog/1G/IHPSG13G2/cascoded_core_transmit_driver.hpp:65
        I(cpphdl_n28, cpphdl_n44) <+ 9e-13 * ddt(V(cpphdl_n28, cpphdl_n44)); // Bench initial voltage = 0.0 V.
        // device 133, IC OneGCascodedEmphasizedPAM5Driver, analog/1G/IHPSG13G2/cascoded_core_transmit_driver.hpp:66
        I(cpphdl_n28, cpphdl_n36) <+ 2.25e-13 * ddt(V(cpphdl_n28, cpphdl_n36)); // Bench initial voltage = 0.0 V.
    end
endmodule
