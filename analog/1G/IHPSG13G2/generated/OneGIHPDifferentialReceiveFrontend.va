// SIMULATION APPROXIMATION: controlled conductances are not physical MOS devices.
// Generated from elaborated C++HDL IC purposes; all contributions coexist.
// Capacitor initialization belongs to the host analysis; declared initial voltages appear below.
`include "disciplines.vams"

module OneGIHPDifferentialReceiveFrontend(Vdd, Vss, Vlogic, VREF, EVALUATE, CLEAR, PLUS, MINUS, SELECT_N0, SELECT_N1, SELECT_N2, SELECT_N3, SELECT_N4, TRACK0, CORE_DECISION0, BIT_N0_0, BIT_N0_1, BIT_N0_2, BIT_N0_3, BIT_N0_4, BIT_N0_5, BIT_N0_6, BIT_N0_7, TRACK1, CORE_DECISION1, BIT_N1_0, BIT_N1_1, BIT_N1_2, BIT_N1_3, BIT_N1_4, BIT_N1_5, BIT_N1_6, BIT_N1_7, TRACK2, CORE_DECISION2, BIT_N2_0, BIT_N2_1, BIT_N2_2, BIT_N2_3, BIT_N2_4, BIT_N2_5, BIT_N2_6, BIT_N2_7, TRACK3, CORE_DECISION3, BIT_N3_0, BIT_N3_1, BIT_N3_2, BIT_N3_3, BIT_N3_4, BIT_N3_5, BIT_N3_6, BIT_N3_7, TRACK4, CORE_DECISION4, BIT_N4_0, BIT_N4_1, BIT_N4_2, BIT_N4_3, BIT_N4_4, BIT_N4_5, BIT_N4_6, BIT_N4_7, TRACK5, CORE_DECISION5, BIT_N5_0, BIT_N5_1, BIT_N5_2, BIT_N5_3, BIT_N5_4, BIT_N5_5, BIT_N5_6, BIT_N5_7, TRACK6, CORE_DECISION6, BIT_N6_0, BIT_N6_1, BIT_N6_2, BIT_N6_3, BIT_N6_4, BIT_N6_5, BIT_N6_6, BIT_N6_7, TRACK7, CORE_DECISION7, BIT_N7_0, BIT_N7_1, BIT_N7_2, BIT_N7_3, BIT_N7_4, BIT_N7_5, BIT_N7_6, BIT_N7_7, TRACK8, CORE_DECISION8, BIT_N8_0, BIT_N8_1, BIT_N8_2, BIT_N8_3, BIT_N8_4, BIT_N8_5, BIT_N8_6, BIT_N8_7, TRACK9, CORE_DECISION9, BIT_N9_0, BIT_N9_1, BIT_N9_2, BIT_N9_3, BIT_N9_4, BIT_N9_5, BIT_N9_6, BIT_N9_7, TRACK10, CORE_DECISION10, BIT_N10_0, BIT_N10_1, BIT_N10_2, BIT_N10_3, BIT_N10_4, BIT_N10_5, BIT_N10_6, BIT_N10_7, TRACK11, CORE_DECISION11, BIT_N11_0, BIT_N11_1, BIT_N11_2, BIT_N11_3, BIT_N11_4, BIT_N11_5, BIT_N11_6, BIT_N11_7, TRACK12, CORE_DECISION12, BIT_N12_0, BIT_N12_1, BIT_N12_2, BIT_N12_3, BIT_N12_4, BIT_N12_5, BIT_N12_6, BIT_N12_7, TRACK13, CORE_DECISION13, BIT_N13_0, BIT_N13_1, BIT_N13_2, BIT_N13_3, BIT_N13_4, BIT_N13_5, BIT_N13_6, BIT_N13_7, TRACK14, CORE_DECISION14, BIT_N14_0, BIT_N14_1, BIT_N14_2, BIT_N14_3, BIT_N14_4, BIT_N14_5, BIT_N14_6, BIT_N14_7, TRACK15, CORE_DECISION15, BIT_N15_0, BIT_N15_1, BIT_N15_2, BIT_N15_3, BIT_N15_4, BIT_N15_5, BIT_N15_6, BIT_N15_7);
    inout Vdd, Vss, Vlogic, VREF, EVALUATE, CLEAR, PLUS, MINUS, SELECT_N0, SELECT_N1, SELECT_N2, SELECT_N3, SELECT_N4, TRACK0, CORE_DECISION0, BIT_N0_0, BIT_N0_1, BIT_N0_2, BIT_N0_3, BIT_N0_4, BIT_N0_5, BIT_N0_6, BIT_N0_7, TRACK1, CORE_DECISION1, BIT_N1_0, BIT_N1_1, BIT_N1_2, BIT_N1_3, BIT_N1_4, BIT_N1_5, BIT_N1_6, BIT_N1_7, TRACK2, CORE_DECISION2, BIT_N2_0, BIT_N2_1, BIT_N2_2, BIT_N2_3, BIT_N2_4, BIT_N2_5, BIT_N2_6, BIT_N2_7, TRACK3, CORE_DECISION3, BIT_N3_0, BIT_N3_1, BIT_N3_2, BIT_N3_3, BIT_N3_4, BIT_N3_5, BIT_N3_6, BIT_N3_7, TRACK4, CORE_DECISION4, BIT_N4_0, BIT_N4_1, BIT_N4_2, BIT_N4_3, BIT_N4_4, BIT_N4_5, BIT_N4_6, BIT_N4_7, TRACK5, CORE_DECISION5, BIT_N5_0, BIT_N5_1, BIT_N5_2, BIT_N5_3, BIT_N5_4, BIT_N5_5, BIT_N5_6, BIT_N5_7, TRACK6, CORE_DECISION6, BIT_N6_0, BIT_N6_1, BIT_N6_2, BIT_N6_3, BIT_N6_4, BIT_N6_5, BIT_N6_6, BIT_N6_7, TRACK7, CORE_DECISION7, BIT_N7_0, BIT_N7_1, BIT_N7_2, BIT_N7_3, BIT_N7_4, BIT_N7_5, BIT_N7_6, BIT_N7_7, TRACK8, CORE_DECISION8, BIT_N8_0, BIT_N8_1, BIT_N8_2, BIT_N8_3, BIT_N8_4, BIT_N8_5, BIT_N8_6, BIT_N8_7, TRACK9, CORE_DECISION9, BIT_N9_0, BIT_N9_1, BIT_N9_2, BIT_N9_3, BIT_N9_4, BIT_N9_5, BIT_N9_6, BIT_N9_7, TRACK10, CORE_DECISION10, BIT_N10_0, BIT_N10_1, BIT_N10_2, BIT_N10_3, BIT_N10_4, BIT_N10_5, BIT_N10_6, BIT_N10_7, TRACK11, CORE_DECISION11, BIT_N11_0, BIT_N11_1, BIT_N11_2, BIT_N11_3, BIT_N11_4, BIT_N11_5, BIT_N11_6, BIT_N11_7, TRACK12, CORE_DECISION12, BIT_N12_0, BIT_N12_1, BIT_N12_2, BIT_N12_3, BIT_N12_4, BIT_N12_5, BIT_N12_6, BIT_N12_7, TRACK13, CORE_DECISION13, BIT_N13_0, BIT_N13_1, BIT_N13_2, BIT_N13_3, BIT_N13_4, BIT_N13_5, BIT_N13_6, BIT_N13_7, TRACK14, CORE_DECISION14, BIT_N14_0, BIT_N14_1, BIT_N14_2, BIT_N14_3, BIT_N14_4, BIT_N14_5, BIT_N14_6, BIT_N14_7, TRACK15, CORE_DECISION15, BIT_N15_0, BIT_N15_1, BIT_N15_2, BIT_N15_3, BIT_N15_4, BIT_N15_5, BIT_N15_6, BIT_N15_7;
    electrical Vdd, Vss, Vlogic, VREF, EVALUATE, CLEAR, PLUS, MINUS, SELECT_N0, SELECT_N1, SELECT_N2, SELECT_N3, SELECT_N4, TRACK0, CORE_DECISION0, BIT_N0_0, BIT_N0_1, BIT_N0_2, BIT_N0_3, BIT_N0_4, BIT_N0_5, BIT_N0_6, BIT_N0_7, TRACK1, CORE_DECISION1, BIT_N1_0, BIT_N1_1, BIT_N1_2, BIT_N1_3, BIT_N1_4, BIT_N1_5, BIT_N1_6, BIT_N1_7, TRACK2, CORE_DECISION2, BIT_N2_0, BIT_N2_1, BIT_N2_2, BIT_N2_3, BIT_N2_4, BIT_N2_5, BIT_N2_6, BIT_N2_7, TRACK3, CORE_DECISION3, BIT_N3_0, BIT_N3_1, BIT_N3_2, BIT_N3_3, BIT_N3_4, BIT_N3_5, BIT_N3_6, BIT_N3_7, TRACK4, CORE_DECISION4, BIT_N4_0, BIT_N4_1, BIT_N4_2, BIT_N4_3, BIT_N4_4, BIT_N4_5, BIT_N4_6, BIT_N4_7, TRACK5, CORE_DECISION5, BIT_N5_0, BIT_N5_1, BIT_N5_2, BIT_N5_3, BIT_N5_4, BIT_N5_5, BIT_N5_6, BIT_N5_7, TRACK6, CORE_DECISION6, BIT_N6_0, BIT_N6_1, BIT_N6_2, BIT_N6_3, BIT_N6_4, BIT_N6_5, BIT_N6_6, BIT_N6_7, TRACK7, CORE_DECISION7, BIT_N7_0, BIT_N7_1, BIT_N7_2, BIT_N7_3, BIT_N7_4, BIT_N7_5, BIT_N7_6, BIT_N7_7, TRACK8, CORE_DECISION8, BIT_N8_0, BIT_N8_1, BIT_N8_2, BIT_N8_3, BIT_N8_4, BIT_N8_5, BIT_N8_6, BIT_N8_7, TRACK9, CORE_DECISION9, BIT_N9_0, BIT_N9_1, BIT_N9_2, BIT_N9_3, BIT_N9_4, BIT_N9_5, BIT_N9_6, BIT_N9_7, TRACK10, CORE_DECISION10, BIT_N10_0, BIT_N10_1, BIT_N10_2, BIT_N10_3, BIT_N10_4, BIT_N10_5, BIT_N10_6, BIT_N10_7, TRACK11, CORE_DECISION11, BIT_N11_0, BIT_N11_1, BIT_N11_2, BIT_N11_3, BIT_N11_4, BIT_N11_5, BIT_N11_6, BIT_N11_7, TRACK12, CORE_DECISION12, BIT_N12_0, BIT_N12_1, BIT_N12_2, BIT_N12_3, BIT_N12_4, BIT_N12_5, BIT_N12_6, BIT_N12_7, TRACK13, CORE_DECISION13, BIT_N13_0, BIT_N13_1, BIT_N13_2, BIT_N13_3, BIT_N13_4, BIT_N13_5, BIT_N13_6, BIT_N13_7, TRACK14, CORE_DECISION14, BIT_N14_0, BIT_N14_1, BIT_N14_2, BIT_N14_3, BIT_N14_4, BIT_N14_5, BIT_N14_6, BIT_N14_7, TRACK15, CORE_DECISION15, BIT_N15_0, BIT_N15_1, BIT_N15_2, BIT_N15_3, BIT_N15_4, BIT_N15_5, BIT_N15_6, BIT_N15_7;
    electrical cpphdl_n191;
    electrical cpphdl_n192;
    electrical cpphdl_n193;
    electrical cpphdl_n196;
    electrical cpphdl_n197;
    electrical cpphdl_n200;
    electrical cpphdl_n201;
    electrical cpphdl_n217;
    electrical cpphdl_n218;
    electrical cpphdl_n219;
    electrical cpphdl_n220;
    electrical cpphdl_n221;
    electrical cpphdl_n222;
    electrical cpphdl_n223;
    electrical cpphdl_n224;
    electrical cpphdl_n225;
    electrical cpphdl_n226;
    electrical cpphdl_n227;
    electrical cpphdl_n228;
    electrical cpphdl_n229;
    electrical cpphdl_n230;
    electrical cpphdl_n231;
    electrical cpphdl_n232;
    electrical cpphdl_n236;
    electrical cpphdl_n240;
    electrical cpphdl_n244;
    electrical cpphdl_n248;
    electrical cpphdl_n252;
    electrical cpphdl_n253;
    electrical cpphdl_n254;
    electrical cpphdl_n255;
    electrical cpphdl_n256;
    electrical cpphdl_n259;
    electrical cpphdl_n260;
    electrical cpphdl_n262;
    electrical cpphdl_n263;
    electrical cpphdl_n264;
    electrical cpphdl_n265;
    electrical cpphdl_n266;
    electrical cpphdl_n267;
    electrical cpphdl_n268;
    electrical cpphdl_n269;
    electrical cpphdl_n270;
    electrical cpphdl_n273;
    electrical cpphdl_n489;
    electrical cpphdl_n504;
    electrical cpphdl_n508;
    electrical cpphdl_n512;
    electrical cpphdl_n516;
    electrical cpphdl_n520;
    electrical cpphdl_n524;
    electrical cpphdl_n528;
    electrical cpphdl_n532;
    electrical cpphdl_n533;
    electrical cpphdl_n534;
    electrical cpphdl_n535;
    electrical cpphdl_n536;
    electrical cpphdl_n537;
    electrical cpphdl_n538;
    electrical cpphdl_n539;
    electrical cpphdl_n543;
    electrical cpphdl_n544;
    electrical cpphdl_n547;
    electrical cpphdl_n548;
    electrical cpphdl_n549;
    electrical cpphdl_n552;
    electrical cpphdl_n553;
    electrical cpphdl_n557;
    electrical cpphdl_n558;
    electrical cpphdl_n559;
    electrical cpphdl_n572;
    electrical cpphdl_n576;
    electrical cpphdl_n580;
    electrical cpphdl_n584;
    electrical cpphdl_n594;
    electrical cpphdl_n597;
    electrical cpphdl_n600;
    electrical cpphdl_n602;
    electrical cpphdl_n603;
    electrical cpphdl_n608;
    electrical cpphdl_n632;
    electrical cpphdl_n647;
    electrical cpphdl_n651;
    electrical cpphdl_n655;
    electrical cpphdl_n659;
    electrical cpphdl_n663;
    electrical cpphdl_n667;
    electrical cpphdl_n671;
    electrical cpphdl_n675;
    electrical cpphdl_n676;
    electrical cpphdl_n677;
    electrical cpphdl_n678;
    electrical cpphdl_n679;
    electrical cpphdl_n680;
    electrical cpphdl_n681;
    electrical cpphdl_n682;
    electrical cpphdl_n686;
    electrical cpphdl_n687;
    electrical cpphdl_n690;
    electrical cpphdl_n691;
    electrical cpphdl_n692;
    electrical cpphdl_n695;
    electrical cpphdl_n696;
    electrical cpphdl_n700;
    electrical cpphdl_n701;
    electrical cpphdl_n702;
    electrical cpphdl_n715;
    electrical cpphdl_n719;
    electrical cpphdl_n723;
    electrical cpphdl_n727;
    electrical cpphdl_n737;
    electrical cpphdl_n740;
    electrical cpphdl_n743;
    electrical cpphdl_n745;
    electrical cpphdl_n746;
    electrical cpphdl_n751;
    electrical cpphdl_n775;
    electrical cpphdl_n790;
    electrical cpphdl_n794;
    electrical cpphdl_n798;
    electrical cpphdl_n802;
    electrical cpphdl_n806;
    electrical cpphdl_n810;
    electrical cpphdl_n814;
    electrical cpphdl_n818;
    electrical cpphdl_n819;
    electrical cpphdl_n820;
    electrical cpphdl_n821;
    electrical cpphdl_n822;
    electrical cpphdl_n823;
    electrical cpphdl_n824;
    electrical cpphdl_n825;
    electrical cpphdl_n829;
    electrical cpphdl_n830;
    electrical cpphdl_n833;
    electrical cpphdl_n834;
    electrical cpphdl_n835;
    electrical cpphdl_n838;
    electrical cpphdl_n839;
    electrical cpphdl_n843;
    electrical cpphdl_n844;
    electrical cpphdl_n845;
    electrical cpphdl_n858;
    electrical cpphdl_n862;
    electrical cpphdl_n866;
    electrical cpphdl_n870;
    electrical cpphdl_n880;
    electrical cpphdl_n883;
    electrical cpphdl_n886;
    electrical cpphdl_n888;
    electrical cpphdl_n889;
    electrical cpphdl_n894;
    electrical cpphdl_n918;
    electrical cpphdl_n933;
    electrical cpphdl_n937;
    electrical cpphdl_n941;
    electrical cpphdl_n945;
    electrical cpphdl_n949;
    electrical cpphdl_n953;
    electrical cpphdl_n957;
    electrical cpphdl_n961;
    electrical cpphdl_n962;
    electrical cpphdl_n963;
    electrical cpphdl_n964;
    electrical cpphdl_n965;
    electrical cpphdl_n966;
    electrical cpphdl_n967;
    electrical cpphdl_n968;
    electrical cpphdl_n972;
    electrical cpphdl_n973;
    electrical cpphdl_n976;
    electrical cpphdl_n977;
    electrical cpphdl_n978;
    electrical cpphdl_n981;
    electrical cpphdl_n982;
    electrical cpphdl_n986;
    electrical cpphdl_n987;
    electrical cpphdl_n988;
    electrical cpphdl_n1001;
    electrical cpphdl_n1005;
    electrical cpphdl_n1009;
    electrical cpphdl_n1013;
    electrical cpphdl_n1023;
    electrical cpphdl_n1026;
    electrical cpphdl_n1029;
    electrical cpphdl_n1031;
    electrical cpphdl_n1032;
    electrical cpphdl_n1037;
    electrical cpphdl_n1061;
    electrical cpphdl_n1076;
    electrical cpphdl_n1080;
    electrical cpphdl_n1084;
    electrical cpphdl_n1088;
    electrical cpphdl_n1092;
    electrical cpphdl_n1096;
    electrical cpphdl_n1100;
    electrical cpphdl_n1104;
    electrical cpphdl_n1105;
    electrical cpphdl_n1106;
    electrical cpphdl_n1107;
    electrical cpphdl_n1108;
    electrical cpphdl_n1109;
    electrical cpphdl_n1110;
    electrical cpphdl_n1111;
    electrical cpphdl_n1115;
    electrical cpphdl_n1116;
    electrical cpphdl_n1119;
    electrical cpphdl_n1120;
    electrical cpphdl_n1121;
    electrical cpphdl_n1124;
    electrical cpphdl_n1125;
    electrical cpphdl_n1129;
    electrical cpphdl_n1130;
    electrical cpphdl_n1131;
    electrical cpphdl_n1144;
    electrical cpphdl_n1148;
    electrical cpphdl_n1152;
    electrical cpphdl_n1156;
    electrical cpphdl_n1166;
    electrical cpphdl_n1169;
    electrical cpphdl_n1172;
    electrical cpphdl_n1174;
    electrical cpphdl_n1175;
    electrical cpphdl_n1180;
    electrical cpphdl_n1204;
    electrical cpphdl_n1219;
    electrical cpphdl_n1223;
    electrical cpphdl_n1227;
    electrical cpphdl_n1231;
    electrical cpphdl_n1235;
    electrical cpphdl_n1239;
    electrical cpphdl_n1243;
    electrical cpphdl_n1247;
    electrical cpphdl_n1248;
    electrical cpphdl_n1249;
    electrical cpphdl_n1250;
    electrical cpphdl_n1251;
    electrical cpphdl_n1252;
    electrical cpphdl_n1253;
    electrical cpphdl_n1254;
    electrical cpphdl_n1258;
    electrical cpphdl_n1259;
    electrical cpphdl_n1262;
    electrical cpphdl_n1263;
    electrical cpphdl_n1264;
    electrical cpphdl_n1267;
    electrical cpphdl_n1268;
    electrical cpphdl_n1272;
    electrical cpphdl_n1273;
    electrical cpphdl_n1274;
    electrical cpphdl_n1287;
    electrical cpphdl_n1291;
    electrical cpphdl_n1295;
    electrical cpphdl_n1299;
    electrical cpphdl_n1309;
    electrical cpphdl_n1312;
    electrical cpphdl_n1315;
    electrical cpphdl_n1317;
    electrical cpphdl_n1318;
    electrical cpphdl_n1323;
    electrical cpphdl_n1347;
    electrical cpphdl_n1362;
    electrical cpphdl_n1366;
    electrical cpphdl_n1370;
    electrical cpphdl_n1374;
    electrical cpphdl_n1378;
    electrical cpphdl_n1382;
    electrical cpphdl_n1386;
    electrical cpphdl_n1390;
    electrical cpphdl_n1391;
    electrical cpphdl_n1392;
    electrical cpphdl_n1393;
    electrical cpphdl_n1394;
    electrical cpphdl_n1395;
    electrical cpphdl_n1396;
    electrical cpphdl_n1397;
    electrical cpphdl_n1401;
    electrical cpphdl_n1402;
    electrical cpphdl_n1405;
    electrical cpphdl_n1406;
    electrical cpphdl_n1407;
    electrical cpphdl_n1410;
    electrical cpphdl_n1411;
    electrical cpphdl_n1415;
    electrical cpphdl_n1416;
    electrical cpphdl_n1417;
    electrical cpphdl_n1430;
    electrical cpphdl_n1434;
    electrical cpphdl_n1438;
    electrical cpphdl_n1442;
    electrical cpphdl_n1452;
    electrical cpphdl_n1455;
    electrical cpphdl_n1458;
    electrical cpphdl_n1460;
    electrical cpphdl_n1461;
    electrical cpphdl_n1466;
    electrical cpphdl_n1490;
    electrical cpphdl_n1505;
    electrical cpphdl_n1509;
    electrical cpphdl_n1513;
    electrical cpphdl_n1517;
    electrical cpphdl_n1521;
    electrical cpphdl_n1525;
    electrical cpphdl_n1529;
    electrical cpphdl_n1533;
    electrical cpphdl_n1534;
    electrical cpphdl_n1535;
    electrical cpphdl_n1536;
    electrical cpphdl_n1537;
    electrical cpphdl_n1538;
    electrical cpphdl_n1539;
    electrical cpphdl_n1540;
    electrical cpphdl_n1544;
    electrical cpphdl_n1545;
    electrical cpphdl_n1548;
    electrical cpphdl_n1549;
    electrical cpphdl_n1550;
    electrical cpphdl_n1553;
    electrical cpphdl_n1554;
    electrical cpphdl_n1558;
    electrical cpphdl_n1559;
    electrical cpphdl_n1560;
    electrical cpphdl_n1573;
    electrical cpphdl_n1577;
    electrical cpphdl_n1581;
    electrical cpphdl_n1585;
    electrical cpphdl_n1595;
    electrical cpphdl_n1598;
    electrical cpphdl_n1601;
    electrical cpphdl_n1603;
    electrical cpphdl_n1604;
    electrical cpphdl_n1609;
    electrical cpphdl_n1633;
    electrical cpphdl_n1648;
    electrical cpphdl_n1652;
    electrical cpphdl_n1656;
    electrical cpphdl_n1660;
    electrical cpphdl_n1664;
    electrical cpphdl_n1668;
    electrical cpphdl_n1672;
    electrical cpphdl_n1676;
    electrical cpphdl_n1677;
    electrical cpphdl_n1678;
    electrical cpphdl_n1679;
    electrical cpphdl_n1680;
    electrical cpphdl_n1681;
    electrical cpphdl_n1682;
    electrical cpphdl_n1683;
    electrical cpphdl_n1687;
    electrical cpphdl_n1688;
    electrical cpphdl_n1691;
    electrical cpphdl_n1692;
    electrical cpphdl_n1693;
    electrical cpphdl_n1696;
    electrical cpphdl_n1697;
    electrical cpphdl_n1701;
    electrical cpphdl_n1702;
    electrical cpphdl_n1703;
    electrical cpphdl_n1716;
    electrical cpphdl_n1720;
    electrical cpphdl_n1724;
    electrical cpphdl_n1728;
    electrical cpphdl_n1738;
    electrical cpphdl_n1741;
    electrical cpphdl_n1744;
    electrical cpphdl_n1746;
    electrical cpphdl_n1747;
    electrical cpphdl_n1752;
    electrical cpphdl_n1776;
    electrical cpphdl_n1791;
    electrical cpphdl_n1795;
    electrical cpphdl_n1799;
    electrical cpphdl_n1803;
    electrical cpphdl_n1807;
    electrical cpphdl_n1811;
    electrical cpphdl_n1815;
    electrical cpphdl_n1819;
    electrical cpphdl_n1820;
    electrical cpphdl_n1821;
    electrical cpphdl_n1822;
    electrical cpphdl_n1823;
    electrical cpphdl_n1824;
    electrical cpphdl_n1825;
    electrical cpphdl_n1826;
    electrical cpphdl_n1830;
    electrical cpphdl_n1831;
    electrical cpphdl_n1834;
    electrical cpphdl_n1835;
    electrical cpphdl_n1836;
    electrical cpphdl_n1839;
    electrical cpphdl_n1840;
    electrical cpphdl_n1844;
    electrical cpphdl_n1845;
    electrical cpphdl_n1846;
    electrical cpphdl_n1859;
    electrical cpphdl_n1863;
    electrical cpphdl_n1867;
    electrical cpphdl_n1871;
    electrical cpphdl_n1881;
    electrical cpphdl_n1884;
    electrical cpphdl_n1887;
    electrical cpphdl_n1889;
    electrical cpphdl_n1890;
    electrical cpphdl_n1895;
    electrical cpphdl_n1919;
    electrical cpphdl_n1934;
    electrical cpphdl_n1938;
    electrical cpphdl_n1942;
    electrical cpphdl_n1946;
    electrical cpphdl_n1950;
    electrical cpphdl_n1954;
    electrical cpphdl_n1958;
    electrical cpphdl_n1962;
    electrical cpphdl_n1963;
    electrical cpphdl_n1964;
    electrical cpphdl_n1965;
    electrical cpphdl_n1966;
    electrical cpphdl_n1967;
    electrical cpphdl_n1968;
    electrical cpphdl_n1969;
    electrical cpphdl_n1973;
    electrical cpphdl_n1974;
    electrical cpphdl_n1977;
    electrical cpphdl_n1978;
    electrical cpphdl_n1979;
    electrical cpphdl_n1982;
    electrical cpphdl_n1983;
    electrical cpphdl_n1987;
    electrical cpphdl_n1988;
    electrical cpphdl_n1989;
    electrical cpphdl_n2002;
    electrical cpphdl_n2006;
    electrical cpphdl_n2010;
    electrical cpphdl_n2014;
    electrical cpphdl_n2024;
    electrical cpphdl_n2027;
    electrical cpphdl_n2030;
    electrical cpphdl_n2032;
    electrical cpphdl_n2033;
    electrical cpphdl_n2038;
    electrical cpphdl_n2062;
    electrical cpphdl_n2077;
    electrical cpphdl_n2081;
    electrical cpphdl_n2085;
    electrical cpphdl_n2089;
    electrical cpphdl_n2093;
    electrical cpphdl_n2097;
    electrical cpphdl_n2101;
    electrical cpphdl_n2105;
    electrical cpphdl_n2106;
    electrical cpphdl_n2107;
    electrical cpphdl_n2108;
    electrical cpphdl_n2109;
    electrical cpphdl_n2110;
    electrical cpphdl_n2111;
    electrical cpphdl_n2112;
    electrical cpphdl_n2116;
    electrical cpphdl_n2117;
    electrical cpphdl_n2120;
    electrical cpphdl_n2121;
    electrical cpphdl_n2122;
    electrical cpphdl_n2125;
    electrical cpphdl_n2126;
    electrical cpphdl_n2130;
    electrical cpphdl_n2131;
    electrical cpphdl_n2132;
    electrical cpphdl_n2145;
    electrical cpphdl_n2149;
    electrical cpphdl_n2153;
    electrical cpphdl_n2157;
    electrical cpphdl_n2167;
    electrical cpphdl_n2170;
    electrical cpphdl_n2173;
    electrical cpphdl_n2175;
    electrical cpphdl_n2176;
    electrical cpphdl_n2181;
    electrical cpphdl_n2205;
    electrical cpphdl_n2220;
    electrical cpphdl_n2224;
    electrical cpphdl_n2228;
    electrical cpphdl_n2232;
    electrical cpphdl_n2236;
    electrical cpphdl_n2240;
    electrical cpphdl_n2244;
    electrical cpphdl_n2248;
    electrical cpphdl_n2249;
    electrical cpphdl_n2250;
    electrical cpphdl_n2251;
    electrical cpphdl_n2252;
    electrical cpphdl_n2253;
    electrical cpphdl_n2254;
    electrical cpphdl_n2255;
    electrical cpphdl_n2259;
    electrical cpphdl_n2260;
    electrical cpphdl_n2263;
    electrical cpphdl_n2264;
    electrical cpphdl_n2265;
    electrical cpphdl_n2268;
    electrical cpphdl_n2269;
    electrical cpphdl_n2273;
    electrical cpphdl_n2274;
    electrical cpphdl_n2275;
    electrical cpphdl_n2288;
    electrical cpphdl_n2292;
    electrical cpphdl_n2296;
    electrical cpphdl_n2300;
    electrical cpphdl_n2310;
    electrical cpphdl_n2313;
    electrical cpphdl_n2316;
    electrical cpphdl_n2318;
    electrical cpphdl_n2319;
    electrical cpphdl_n2324;
    electrical cpphdl_n2348;
    electrical cpphdl_n2363;
    electrical cpphdl_n2367;
    electrical cpphdl_n2371;
    electrical cpphdl_n2375;
    electrical cpphdl_n2379;
    electrical cpphdl_n2383;
    electrical cpphdl_n2387;
    electrical cpphdl_n2391;
    electrical cpphdl_n2392;
    electrical cpphdl_n2393;
    electrical cpphdl_n2394;
    electrical cpphdl_n2395;
    electrical cpphdl_n2396;
    electrical cpphdl_n2397;
    electrical cpphdl_n2398;
    electrical cpphdl_n2402;
    electrical cpphdl_n2403;
    electrical cpphdl_n2406;
    electrical cpphdl_n2407;
    electrical cpphdl_n2408;
    electrical cpphdl_n2411;
    electrical cpphdl_n2412;
    electrical cpphdl_n2416;
    electrical cpphdl_n2417;
    electrical cpphdl_n2418;
    electrical cpphdl_n2431;
    electrical cpphdl_n2435;
    electrical cpphdl_n2439;
    electrical cpphdl_n2443;
    electrical cpphdl_n2453;
    electrical cpphdl_n2456;
    electrical cpphdl_n2459;
    electrical cpphdl_n2461;
    electrical cpphdl_n2462;
    electrical cpphdl_n2467;
    electrical cpphdl_n2491;
    electrical cpphdl_n2506;
    electrical cpphdl_n2510;
    electrical cpphdl_n2514;
    electrical cpphdl_n2518;
    electrical cpphdl_n2522;
    electrical cpphdl_n2526;
    electrical cpphdl_n2530;
    electrical cpphdl_n2534;
    electrical cpphdl_n2535;
    electrical cpphdl_n2536;
    electrical cpphdl_n2537;
    electrical cpphdl_n2538;
    electrical cpphdl_n2539;
    electrical cpphdl_n2540;
    electrical cpphdl_n2541;
    electrical cpphdl_n2545;
    electrical cpphdl_n2546;
    electrical cpphdl_n2549;
    electrical cpphdl_n2550;
    electrical cpphdl_n2551;
    electrical cpphdl_n2554;
    electrical cpphdl_n2555;
    electrical cpphdl_n2559;
    electrical cpphdl_n2560;
    electrical cpphdl_n2561;
    electrical cpphdl_n2574;
    electrical cpphdl_n2578;
    electrical cpphdl_n2582;
    electrical cpphdl_n2586;
    electrical cpphdl_n2596;
    electrical cpphdl_n2599;
    electrical cpphdl_n2602;
    electrical cpphdl_n2604;
    electrical cpphdl_n2605;
    electrical cpphdl_n2610;
    electrical cpphdl_n2628;
    electrical cpphdl_n2634;
    electrical cpphdl_n2649;
    electrical cpphdl_n2653;
    electrical cpphdl_n2657;
    electrical cpphdl_n2661;
    electrical cpphdl_n2665;
    electrical cpphdl_n2669;
    electrical cpphdl_n2673;
    electrical cpphdl_n2677;
    electrical cpphdl_n2678;
    electrical cpphdl_n2679;
    electrical cpphdl_n2680;
    electrical cpphdl_n2681;
    electrical cpphdl_n2682;
    electrical cpphdl_n2683;
    electrical cpphdl_n2684;
    electrical cpphdl_n2688;
    electrical cpphdl_n2689;
    electrical cpphdl_n2692;
    electrical cpphdl_n2693;
    electrical cpphdl_n2694;
    electrical cpphdl_n2697;
    electrical cpphdl_n2698;
    electrical cpphdl_n2702;
    electrical cpphdl_n2703;
    electrical cpphdl_n2704;
    electrical cpphdl_n2717;
    electrical cpphdl_n2721;
    electrical cpphdl_n2725;
    electrical cpphdl_n2729;
    electrical cpphdl_n2739;
    electrical cpphdl_n2742;
    electrical cpphdl_n2745;
    electrical cpphdl_n2747;
    electrical cpphdl_n2748;
    electrical cpphdl_n2753;
    electrical cpphdl_n2773;
    electrical cpphdl_n2775;
    electrical cpphdl_n2778;
    electrical cpphdl_n2780;
    electrical cpphdl_n2783;
    electrical cpphdl_n2785;
    electrical cpphdl_n2788;
    electrical cpphdl_n2790;
    electrical cpphdl_n2793;
    electrical cpphdl_n2795;
    electrical cpphdl_n2798;
    electrical cpphdl_n2800;
    electrical cpphdl_n2803;
    electrical cpphdl_n2805;
    electrical cpphdl_n2808;
    electrical cpphdl_n2810;
    electrical cpphdl_n2813;
    electrical cpphdl_n2815;
    electrical cpphdl_n2818;
    electrical cpphdl_n2820;
    electrical cpphdl_n2823;
    electrical cpphdl_n2825;
    electrical cpphdl_n2828;
    electrical cpphdl_n2830;
    electrical cpphdl_n2833;
    electrical cpphdl_n2835;
    electrical cpphdl_n2838;
    electrical cpphdl_n2840;
    electrical cpphdl_n2843;
    electrical cpphdl_n2845;
    electrical cpphdl_n2848;
    electrical cpphdl_n2850;

    // Square-law channel, including reverse conduction. This is not a BSIM model.
    analog function real cpphdl_channel;
        input vgs, vds, beta, threshold, polarity;
        real vgs, vds, beta, threshold, polarity;
        real gate, drain, direction, overdrive, current;
        begin
            gate = polarity * vgs;
            drain = polarity * vds;
            direction = 1.0;
            if (drain < 0.0) begin
                gate = gate - drain;
                drain = -drain;
                direction = -1.0;
            end
            overdrive = gate - threshold;
            current = 0.0;
            if (overdrive > 0.0) begin
                if (drain < overdrive)
                    current = beta * (overdrive * drain - drain * drain / 2.0);
                else
                    current = beta * overdrive * overdrive / 2.0;
            end
            cpphdl_channel = polarity * direction * current;
        end
    endfunction

    analog begin
        // device 0, IC IC1, analog/1G/IHPSG13G2/differential_receive_frontend.hpp:24
        I(PLUS, MINUS) <+ V(PLUS, MINUS) / 100.0;
        // device 1, IC IC2, analog/basic/nmos_resistor_amplifier.hpp:23
        I(Vdd, cpphdl_n200) <+ V(Vdd, cpphdl_n200) / 500.0;
        // device 2, IC IC2, analog/basic/nmos_resistor_amplifier.hpp:24
        I(Vdd, cpphdl_n196) <+ V(Vdd, cpphdl_n196) / 500.0;
        // device 3, IC IC2, analog/basic/nmos_resistor_amplifier.hpp:25
        I(cpphdl_n200, cpphdl_n191) <+ cpphdl_channel(V(PLUS, cpphdl_n191), V(cpphdl_n200, cpphdl_n191), 0.014999999999999999, 0.69999999999999996, 1.0);
        // device 4, IC IC2, analog/basic/nmos_resistor_amplifier.hpp:26
        I(cpphdl_n196, cpphdl_n192) <+ cpphdl_channel(V(MINUS, cpphdl_n192), V(cpphdl_n196, cpphdl_n192), 0.014999999999999999, 0.69999999999999996, 1.0);
        // device 5, IC IC2, analog/basic/nmos_resistor_amplifier.hpp:27
        I(cpphdl_n193, cpphdl_n191) <+ V(cpphdl_n193, cpphdl_n191) / 50.0;
        // device 6, IC IC2, analog/basic/nmos_resistor_amplifier.hpp:28
        I(cpphdl_n193, cpphdl_n192) <+ V(cpphdl_n193, cpphdl_n192) / 50.0;
        // device 7, IC IC2, analog/basic/nmos_resistor_amplifier.hpp:29
        I(Vss, cpphdl_n193) <+ V(Vss, cpphdl_n193) / 150.0;
        // device 8, IC IC2, analog/basic/nmos_resistor_amplifier.hpp:30
        I(cpphdl_n200, Vdd) <+ 1e-13 * ddt(V(cpphdl_n200, Vdd)); // Bench initial voltage = 0.0 V.
        // device 9, IC IC2, analog/basic/nmos_resistor_amplifier.hpp:31
        I(cpphdl_n196, Vdd) <+ 1e-13 * ddt(V(cpphdl_n196, Vdd)); // Bench initial voltage = 0.0 V.
        // device 10, IC IC2, analog/basic/nmos_resistor_amplifier.hpp:32
        I(cpphdl_n193, Vss) <+ 4e-14 * ddt(V(cpphdl_n193, Vss)); // Bench initial voltage = 0.0 V.
        // device 11, IC IC2, analog/basic/nmos_resistor_amplifier.hpp:34
        I(PLUS, cpphdl_n191) <+ 1.4999999999999999e-13 * ddt(V(PLUS, cpphdl_n191)); // Bench initial voltage = 0.0 V.
        // device 12, IC IC2, analog/basic/nmos_resistor_amplifier.hpp:35
        I(MINUS, cpphdl_n192) <+ 1.4999999999999999e-13 * ddt(V(MINUS, cpphdl_n192)); // Bench initial voltage = 0.0 V.
        // device 13, IC IC2, analog/basic/nmos_resistor_amplifier.hpp:36
        I(PLUS, cpphdl_n200) <+ 2e-14 * ddt(V(PLUS, cpphdl_n200)); // Bench initial voltage = 0.0 V.
        // device 14, IC IC2, analog/basic/nmos_resistor_amplifier.hpp:37
        I(MINUS, cpphdl_n196) <+ 2e-14 * ddt(V(MINUS, cpphdl_n196)); // Bench initial voltage = 0.0 V.
        // device 15, IC IC3, analog/basic/nmos_source_follower.hpp:19
        I(Vdd, cpphdl_n197) <+ cpphdl_channel(V(cpphdl_n196, cpphdl_n197), V(Vdd, cpphdl_n197), 0.10000000000000001, 0.69999999999999996, 1.0);
        // device 16, IC IC3, analog/basic/nmos_source_follower.hpp:20
        I(Vss, cpphdl_n197) <+ V(Vss, cpphdl_n197) / 250.0;
        // device 17, IC IC3, analog/basic/nmos_source_follower.hpp:23
        I(cpphdl_n196, cpphdl_n197) <+ 4e-14 * ddt(V(cpphdl_n196, cpphdl_n197)); // Bench initial voltage = 0.0 V.
        // device 18, IC IC3, analog/basic/nmos_source_follower.hpp:24
        I(cpphdl_n196, Vdd) <+ 1e-14 * ddt(V(cpphdl_n196, Vdd)); // Bench initial voltage = 0.0 V.
        // device 19, IC IC3, analog/basic/nmos_source_follower.hpp:25
        I(cpphdl_n197, Vss) <+ 4e-14 * ddt(V(cpphdl_n197, Vss)); // Bench initial voltage = 0.0 V.
        // device 20, IC IC4, analog/basic/nmos_source_follower.hpp:19
        I(Vdd, cpphdl_n201) <+ cpphdl_channel(V(cpphdl_n200, cpphdl_n201), V(Vdd, cpphdl_n201), 0.10000000000000001, 0.69999999999999996, 1.0);
        // device 21, IC IC4, analog/basic/nmos_source_follower.hpp:20
        I(Vss, cpphdl_n201) <+ V(Vss, cpphdl_n201) / 250.0;
        // device 22, IC IC4, analog/basic/nmos_source_follower.hpp:23
        I(cpphdl_n200, cpphdl_n201) <+ 4e-14 * ddt(V(cpphdl_n200, cpphdl_n201)); // Bench initial voltage = 0.0 V.
        // device 23, IC IC4, analog/basic/nmos_source_follower.hpp:24
        I(cpphdl_n200, Vdd) <+ 1e-14 * ddt(V(cpphdl_n200, Vdd)); // Bench initial voltage = 0.0 V.
        // device 24, IC IC4, analog/basic/nmos_source_follower.hpp:25
        I(cpphdl_n201, Vss) <+ 4e-14 * ddt(V(cpphdl_n201, Vss)); // Bench initial voltage = 0.0 V.
        // device 25, IC IC6, analog/basic/inverter.hpp:11
        I(cpphdl_n236, Vdd) <+ cpphdl_channel(V(SELECT_N0, Vdd), V(cpphdl_n236, Vdd), 0.0030000000000000001, 0.69999999999999996, -1.0);
        // device 26, IC IC6, analog/basic/inverter.hpp:12
        I(cpphdl_n236, Vss) <+ cpphdl_channel(V(SELECT_N0, Vss), V(cpphdl_n236, Vss), 0.0030000000000000001, 0.69999999999999996, 1.0);
        // device 27, IC IC5, analog/1G/IHPSG13G2/differential_receive_gain.hpp:41
        I(cpphdl_n236, Vss) <+ 2e-14 * ddt(V(cpphdl_n236, Vss)); // Bench initial voltage = 0.0 V.
        // device 28, IC IC7, analog/basic/inverter.hpp:11
        I(cpphdl_n240, Vdd) <+ cpphdl_channel(V(SELECT_N1, Vdd), V(cpphdl_n240, Vdd), 0.0030000000000000001, 0.69999999999999996, -1.0);
        // device 29, IC IC7, analog/basic/inverter.hpp:12
        I(cpphdl_n240, Vss) <+ cpphdl_channel(V(SELECT_N1, Vss), V(cpphdl_n240, Vss), 0.0030000000000000001, 0.69999999999999996, 1.0);
        // device 30, IC IC5, analog/1G/IHPSG13G2/differential_receive_gain.hpp:41
        I(cpphdl_n240, Vss) <+ 2e-14 * ddt(V(cpphdl_n240, Vss)); // Bench initial voltage = 0.0 V.
        // device 31, IC IC8, analog/basic/inverter.hpp:11
        I(cpphdl_n244, Vdd) <+ cpphdl_channel(V(SELECT_N2, Vdd), V(cpphdl_n244, Vdd), 0.0030000000000000001, 0.69999999999999996, -1.0);
        // device 32, IC IC8, analog/basic/inverter.hpp:12
        I(cpphdl_n244, Vss) <+ cpphdl_channel(V(SELECT_N2, Vss), V(cpphdl_n244, Vss), 0.0030000000000000001, 0.69999999999999996, 1.0);
        // device 33, IC IC5, analog/1G/IHPSG13G2/differential_receive_gain.hpp:41
        I(cpphdl_n244, Vss) <+ 2e-14 * ddt(V(cpphdl_n244, Vss)); // Bench initial voltage = 0.0 V.
        // device 34, IC IC9, analog/basic/inverter.hpp:11
        I(cpphdl_n248, Vdd) <+ cpphdl_channel(V(SELECT_N3, Vdd), V(cpphdl_n248, Vdd), 0.0030000000000000001, 0.69999999999999996, -1.0);
        // device 35, IC IC9, analog/basic/inverter.hpp:12
        I(cpphdl_n248, Vss) <+ cpphdl_channel(V(SELECT_N3, Vss), V(cpphdl_n248, Vss), 0.0030000000000000001, 0.69999999999999996, 1.0);
        // device 36, IC IC5, analog/1G/IHPSG13G2/differential_receive_gain.hpp:41
        I(cpphdl_n248, Vss) <+ 2e-14 * ddt(V(cpphdl_n248, Vss)); // Bench initial voltage = 0.0 V.
        // device 37, IC IC10, analog/basic/inverter.hpp:11
        I(cpphdl_n252, Vdd) <+ cpphdl_channel(V(SELECT_N4, Vdd), V(cpphdl_n252, Vdd), 0.0030000000000000001, 0.69999999999999996, -1.0);
        // device 38, IC IC10, analog/basic/inverter.hpp:12
        I(cpphdl_n252, Vss) <+ cpphdl_channel(V(SELECT_N4, Vss), V(cpphdl_n252, Vss), 0.0030000000000000001, 0.69999999999999996, 1.0);
        // device 39, IC IC5, analog/1G/IHPSG13G2/differential_receive_gain.hpp:41
        I(cpphdl_n252, Vss) <+ 2e-14 * ddt(V(cpphdl_n252, Vss)); // Bench initial voltage = 0.0 V.
        // device 40, IC IC5, analog/1G/IHPSG13G2/differential_receive_gain.hpp:43
        I(VREF, cpphdl_n225) <+ V(VREF, cpphdl_n225) / 100.0;
        // device 41, IC IC5, analog/1G/IHPSG13G2/differential_receive_gain.hpp:45
        I(cpphdl_n225, cpphdl_n226) <+ V(cpphdl_n225, cpphdl_n226) / 100.0;
        // device 42, IC IC5, analog/1G/IHPSG13G2/differential_receive_gain.hpp:45
        I(cpphdl_n226, cpphdl_n227) <+ V(cpphdl_n226, cpphdl_n227) / 100.0;
        // device 43, IC IC5, analog/1G/IHPSG13G2/differential_receive_gain.hpp:45
        I(cpphdl_n227, cpphdl_n228) <+ V(cpphdl_n227, cpphdl_n228) / 100.0;
        // device 44, IC IC5, analog/1G/IHPSG13G2/differential_receive_gain.hpp:45
        I(cpphdl_n228, cpphdl_n229) <+ V(cpphdl_n228, cpphdl_n229) / 100.0;
        // device 45, IC IC5, analog/1G/IHPSG13G2/differential_receive_gain.hpp:45
        I(cpphdl_n229, cpphdl_n230) <+ V(cpphdl_n229, cpphdl_n230) / 100.0;
        // device 46, IC IC5, analog/1G/IHPSG13G2/differential_receive_gain.hpp:45
        I(cpphdl_n230, cpphdl_n231) <+ V(cpphdl_n230, cpphdl_n231) / 100.0;
        // device 47, IC IC5, analog/1G/IHPSG13G2/differential_receive_gain.hpp:45
        I(cpphdl_n231, cpphdl_n232) <+ V(cpphdl_n231, cpphdl_n232) / 100.0;
        // device 48, IC IC5, analog/1G/IHPSG13G2/differential_receive_gain.hpp:46
        I(cpphdl_n232, cpphdl_n197) <+ V(cpphdl_n232, cpphdl_n197) / 100.0;
        // device 49, IC IC5, analog/1G/IHPSG13G2/differential_receive_gain.hpp:48
        I(cpphdl_n228, cpphdl_n259) <+ cpphdl_channel(V(cpphdl_n236, cpphdl_n259), V(cpphdl_n228, cpphdl_n259), 0.029999999999999999, 0.69999999999999996, 1.0);
        // device 50, IC IC5, analog/1G/IHPSG13G2/differential_receive_gain.hpp:48
        I(cpphdl_n229, cpphdl_n259) <+ cpphdl_channel(V(cpphdl_n240, cpphdl_n259), V(cpphdl_n229, cpphdl_n259), 0.029999999999999999, 0.69999999999999996, 1.0);
        // device 51, IC IC5, analog/1G/IHPSG13G2/differential_receive_gain.hpp:48
        I(cpphdl_n230, cpphdl_n259) <+ cpphdl_channel(V(cpphdl_n244, cpphdl_n259), V(cpphdl_n230, cpphdl_n259), 0.029999999999999999, 0.69999999999999996, 1.0);
        // device 52, IC IC5, analog/1G/IHPSG13G2/differential_receive_gain.hpp:48
        I(cpphdl_n231, cpphdl_n259) <+ cpphdl_channel(V(cpphdl_n248, cpphdl_n259), V(cpphdl_n231, cpphdl_n259), 0.029999999999999999, 0.69999999999999996, 1.0);
        // device 53, IC IC5, analog/1G/IHPSG13G2/differential_receive_gain.hpp:48
        I(cpphdl_n232, cpphdl_n259) <+ cpphdl_channel(V(cpphdl_n252, cpphdl_n259), V(cpphdl_n232, cpphdl_n259), 0.029999999999999999, 0.69999999999999996, 1.0);
        // device 54, IC IC5, analog/1G/IHPSG13G2/differential_receive_gain.hpp:49
        I(cpphdl_n201, cpphdl_n259) <+ V(cpphdl_n201, cpphdl_n259) / 100000.0;
        // device 55, IC IC5, analog/1G/IHPSG13G2/differential_receive_gain.hpp:50
        I(cpphdl_n259, Vss) <+ 5.0000000000000002e-14 * ddt(V(cpphdl_n259, Vss)); // Bench initial voltage = 0.0 V.
        // device 56, IC IC13, analog/basic/resistor_divider.hpp:15
        I(Vdd, cpphdl_n262) <+ V(Vdd, cpphdl_n262) / 15000.0;
        // device 57, IC IC13, analog/basic/resistor_divider.hpp:16
        I(cpphdl_n262, Vss) <+ V(cpphdl_n262, Vss) / 18000.0;
        // device 58, IC IC14, analog/basic/resistor_divider.hpp:15
        I(Vdd, cpphdl_n263) <+ V(Vdd, cpphdl_n263) / 23000.0;
        // device 59, IC IC14, analog/basic/resistor_divider.hpp:16
        I(cpphdl_n263, Vss) <+ V(cpphdl_n263, Vss) / 43000.0;
        // device 60, IC IC5, analog/1G/IHPSG13G2/differential_receive_gain.hpp:61
        I(cpphdl_n262, Vss) <+ 9.9999999999999994e-12 * ddt(V(cpphdl_n262, Vss)); // Bench initial voltage = 0.0 V.
        // device 61, IC IC5, analog/1G/IHPSG13G2/differential_receive_gain.hpp:62
        I(cpphdl_n263, Vss) <+ 9.9999999999999994e-12 * ddt(V(cpphdl_n263, Vss)); // Bench initial voltage = 0.0 V.
        // device 62, IC IC5, analog/1G/IHPSG13G2/differential_receive_gain.hpp:63
        I(Vdd, cpphdl_n264) <+ V(Vdd, cpphdl_n264) / 2500.0;
        // device 63, IC IC5, analog/1G/IHPSG13G2/differential_receive_gain.hpp:64
        I(cpphdl_n264, Vss) <+ cpphdl_channel(V(cpphdl_n264, Vss), V(cpphdl_n264, Vss), 0.029999999999999999, 0.69999999999999996, 1.0);
        // device 64, IC IC5, analog/1G/IHPSG13G2/differential_receive_gain.hpp:65
        I(cpphdl_n264, Vss) <+ 9.9999999999999994e-12 * ddt(V(cpphdl_n264, Vss)); // Bench initial voltage = 0.0 V.
        // device 65, IC IC5, analog/1G/IHPSG13G2/differential_receive_gain.hpp:67
        I(cpphdl_n2628, cpphdl_n217) <+ V(cpphdl_n2628, cpphdl_n217) / 100.0;
        // device 66, IC IC5, analog/1G/IHPSG13G2/differential_receive_gain.hpp:69
        I(cpphdl_n217, cpphdl_n218) <+ V(cpphdl_n217, cpphdl_n218) / 100.0;
        // device 67, IC IC5, analog/1G/IHPSG13G2/differential_receive_gain.hpp:69
        I(cpphdl_n218, cpphdl_n219) <+ V(cpphdl_n218, cpphdl_n219) / 100.0;
        // device 68, IC IC5, analog/1G/IHPSG13G2/differential_receive_gain.hpp:69
        I(cpphdl_n219, cpphdl_n220) <+ V(cpphdl_n219, cpphdl_n220) / 100.0;
        // device 69, IC IC5, analog/1G/IHPSG13G2/differential_receive_gain.hpp:69
        I(cpphdl_n220, cpphdl_n221) <+ V(cpphdl_n220, cpphdl_n221) / 100.0;
        // device 70, IC IC5, analog/1G/IHPSG13G2/differential_receive_gain.hpp:69
        I(cpphdl_n221, cpphdl_n222) <+ V(cpphdl_n221, cpphdl_n222) / 100.0;
        // device 71, IC IC5, analog/1G/IHPSG13G2/differential_receive_gain.hpp:69
        I(cpphdl_n222, cpphdl_n223) <+ V(cpphdl_n222, cpphdl_n223) / 100.0;
        // device 72, IC IC5, analog/1G/IHPSG13G2/differential_receive_gain.hpp:69
        I(cpphdl_n223, cpphdl_n224) <+ V(cpphdl_n223, cpphdl_n224) / 100.0;
        // device 73, IC IC5, analog/1G/IHPSG13G2/differential_receive_gain.hpp:70
        I(cpphdl_n224, cpphdl_n201) <+ V(cpphdl_n224, cpphdl_n201) / 100.0;
        // device 74, IC IC5, analog/1G/IHPSG13G2/differential_receive_gain.hpp:73
        I(cpphdl_n220, cpphdl_n260) <+ cpphdl_channel(V(cpphdl_n236, cpphdl_n260), V(cpphdl_n220, cpphdl_n260), 0.029999999999999999, 0.69999999999999996, 1.0);
        // device 75, IC IC5, analog/1G/IHPSG13G2/differential_receive_gain.hpp:75
        I(cpphdl_n253, cpphdl_n273) <+ cpphdl_channel(V(SELECT_N0, cpphdl_n273), V(cpphdl_n253, cpphdl_n273), 0.02, 0.69999999999999996, -1.0);
        // device 76, IC IC5, analog/1G/IHPSG13G2/differential_receive_gain.hpp:76
        I(cpphdl_n253, Vss) <+ 9.9999999999999998e-13 * ddt(V(cpphdl_n253, Vss)); // Bench initial voltage = 0.0 V.
        // device 77, IC IC5, analog/1G/IHPSG13G2/differential_receive_gain.hpp:73
        I(cpphdl_n221, cpphdl_n260) <+ cpphdl_channel(V(cpphdl_n240, cpphdl_n260), V(cpphdl_n221, cpphdl_n260), 0.029999999999999999, 0.69999999999999996, 1.0);
        // device 78, IC IC5, analog/1G/IHPSG13G2/differential_receive_gain.hpp:75
        I(cpphdl_n254, cpphdl_n273) <+ cpphdl_channel(V(SELECT_N1, cpphdl_n273), V(cpphdl_n254, cpphdl_n273), 0.02, 0.69999999999999996, -1.0);
        // device 79, IC IC5, analog/1G/IHPSG13G2/differential_receive_gain.hpp:76
        I(cpphdl_n254, Vss) <+ 7.5000000000000004e-13 * ddt(V(cpphdl_n254, Vss)); // Bench initial voltage = 0.0 V.
        // device 80, IC IC5, analog/1G/IHPSG13G2/differential_receive_gain.hpp:73
        I(cpphdl_n222, cpphdl_n260) <+ cpphdl_channel(V(cpphdl_n244, cpphdl_n260), V(cpphdl_n222, cpphdl_n260), 0.029999999999999999, 0.69999999999999996, 1.0);
        // device 81, IC IC5, analog/1G/IHPSG13G2/differential_receive_gain.hpp:75
        I(cpphdl_n255, cpphdl_n273) <+ cpphdl_channel(V(SELECT_N2, cpphdl_n273), V(cpphdl_n255, cpphdl_n273), 0.02, 0.69999999999999996, -1.0);
        // device 82, IC IC5, analog/1G/IHPSG13G2/differential_receive_gain.hpp:76
        I(cpphdl_n255, Vss) <+ 4.9999999999999999e-13 * ddt(V(cpphdl_n255, Vss)); // Bench initial voltage = 0.0 V.
        // device 83, IC IC5, analog/1G/IHPSG13G2/differential_receive_gain.hpp:73
        I(cpphdl_n223, cpphdl_n260) <+ cpphdl_channel(V(cpphdl_n248, cpphdl_n260), V(cpphdl_n223, cpphdl_n260), 0.029999999999999999, 0.69999999999999996, 1.0);
        // device 84, IC IC5, analog/1G/IHPSG13G2/differential_receive_gain.hpp:75
        I(cpphdl_n256, cpphdl_n273) <+ cpphdl_channel(V(SELECT_N3, cpphdl_n273), V(cpphdl_n256, cpphdl_n273), 0.02, 0.69999999999999996, -1.0);
        // device 85, IC IC5, analog/1G/IHPSG13G2/differential_receive_gain.hpp:76
        I(cpphdl_n256, Vss) <+ 2.4999999999999999e-13 * ddt(V(cpphdl_n256, Vss)); // Bench initial voltage = 0.0 V.
        // device 86, IC IC5, analog/1G/IHPSG13G2/differential_receive_gain.hpp:73
        I(cpphdl_n224, cpphdl_n260) <+ cpphdl_channel(V(cpphdl_n252, cpphdl_n260), V(cpphdl_n224, cpphdl_n260), 0.029999999999999999, 0.69999999999999996, 1.0);
        // device 87, IC IC11, analog/basic/cascode_ota.hpp:29
        I(cpphdl_n265, cpphdl_n270) <+ cpphdl_channel(V(cpphdl_n259, cpphdl_n270), V(cpphdl_n265, cpphdl_n270), 0.029999999999999999, 0.69999999999999996, 1.0);
        // device 88, IC IC11, analog/basic/cascode_ota.hpp:30
        I(cpphdl_n266, cpphdl_n270) <+ cpphdl_channel(V(cpphdl_n260, cpphdl_n270), V(cpphdl_n266, cpphdl_n270), 0.029999999999999999, 0.69999999999999996, 1.0);
        // device 89, IC IC11, analog/basic/cascode_ota.hpp:31
        I(cpphdl_n267, cpphdl_n265) <+ cpphdl_channel(V(cpphdl_n262, cpphdl_n265), V(cpphdl_n267, cpphdl_n265), 0.059999999999999998, 0.69999999999999996, 1.0);
        // device 90, IC IC11, analog/basic/cascode_ota.hpp:32
        I(cpphdl_n273, cpphdl_n266) <+ cpphdl_channel(V(cpphdl_n262, cpphdl_n266), V(cpphdl_n273, cpphdl_n266), 0.059999999999999998, 0.69999999999999996, 1.0);
        // device 91, IC IC11, analog/basic/cascode_ota.hpp:33
        I(cpphdl_n268, Vdd) <+ cpphdl_channel(V(cpphdl_n267, Vdd), V(cpphdl_n268, Vdd), 0.029999999999999999, 0.69999999999999996, -1.0);
        // device 92, IC IC11, analog/basic/cascode_ota.hpp:34
        I(cpphdl_n269, Vdd) <+ cpphdl_channel(V(cpphdl_n267, Vdd), V(cpphdl_n269, Vdd), 0.029999999999999999, 0.69999999999999996, -1.0);
        // device 93, IC IC11, analog/basic/cascode_ota.hpp:35
        I(cpphdl_n267, cpphdl_n268) <+ cpphdl_channel(V(cpphdl_n263, cpphdl_n268), V(cpphdl_n267, cpphdl_n268), 0.059999999999999998, 0.69999999999999996, -1.0);
        // device 94, IC IC11, analog/basic/cascode_ota.hpp:36
        I(cpphdl_n273, cpphdl_n269) <+ cpphdl_channel(V(cpphdl_n263, cpphdl_n269), V(cpphdl_n273, cpphdl_n269), 0.059999999999999998, 0.69999999999999996, -1.0);
        // device 95, IC IC11, analog/basic/cascode_ota.hpp:37
        I(cpphdl_n270, Vss) <+ cpphdl_channel(V(cpphdl_n264, Vss), V(cpphdl_n270, Vss), 0.059999999999999998, 0.69999999999999996, 1.0);
        // device 96, IC IC11, analog/basic/cascode_ota.hpp:38
        I(cpphdl_n273, Vss) <+ 2.4999999999999999e-13 * ddt(V(cpphdl_n273, Vss)); // Bench initial voltage = 0.0 V.
        // device 97, IC IC11, analog/basic/cascode_ota.hpp:39
        I(cpphdl_n265, Vss) <+ 4e-14 * ddt(V(cpphdl_n265, Vss)); // Bench initial voltage = 0.0 V.
        // device 98, IC IC11, analog/basic/cascode_ota.hpp:40
        I(cpphdl_n266, Vss) <+ 4e-14 * ddt(V(cpphdl_n266, Vss)); // Bench initial voltage = 0.0 V.
        // device 99, IC IC11, analog/basic/cascode_ota.hpp:41
        I(cpphdl_n270, Vss) <+ 4e-14 * ddt(V(cpphdl_n270, Vss)); // Bench initial voltage = 0.0 V.
        // device 100, IC IC11, analog/basic/cascode_ota.hpp:42
        I(cpphdl_n268, Vdd) <+ 4e-14 * ddt(V(cpphdl_n268, Vdd)); // Bench initial voltage = 0.0 V.
        // device 101, IC IC11, analog/basic/cascode_ota.hpp:43
        I(cpphdl_n269, Vdd) <+ 4e-14 * ddt(V(cpphdl_n269, Vdd)); // Bench initial voltage = 0.0 V.
        // device 102, IC IC11, analog/basic/cascode_ota.hpp:44
        I(cpphdl_n267, Vss) <+ 4e-14 * ddt(V(cpphdl_n267, Vss)); // Bench initial voltage = 0.0 V.
        // device 103, IC IC11, analog/basic/cascode_ota.hpp:45
        I(cpphdl_n259, cpphdl_n270) <+ 4e-14 * ddt(V(cpphdl_n259, cpphdl_n270)); // Bench initial voltage = 0.0 V.
        // device 104, IC IC11, analog/basic/cascode_ota.hpp:46
        I(cpphdl_n260, cpphdl_n270) <+ 4e-14 * ddt(V(cpphdl_n260, cpphdl_n270)); // Bench initial voltage = 0.0 V.
        // device 105, IC IC11, analog/basic/cascode_ota.hpp:47
        I(cpphdl_n259, cpphdl_n265) <+ 1e-14 * ddt(V(cpphdl_n259, cpphdl_n265)); // Bench initial voltage = 0.0 V.
        // device 106, IC IC11, analog/basic/cascode_ota.hpp:48
        I(cpphdl_n260, cpphdl_n266) <+ 1e-14 * ddt(V(cpphdl_n260, cpphdl_n266)); // Bench initial voltage = 0.0 V.
        // device 107, IC IC12, analog/basic/nmos_source_follower.hpp:19
        I(Vdd, cpphdl_n2628) <+ cpphdl_channel(V(cpphdl_n273, cpphdl_n2628), V(Vdd, cpphdl_n2628), 0.20000000000000001, 0.69999999999999996, 1.0);
        // device 108, IC IC12, analog/basic/nmos_source_follower.hpp:20
        I(Vss, cpphdl_n2628) <+ V(Vss, cpphdl_n2628) / 500.0;
        // device 109, IC IC12, analog/basic/nmos_source_follower.hpp:23
        I(cpphdl_n273, cpphdl_n2628) <+ 8e-14 * ddt(V(cpphdl_n273, cpphdl_n2628)); // Bench initial voltage = 0.0 V.
        // device 110, IC IC12, analog/basic/nmos_source_follower.hpp:24
        I(cpphdl_n273, Vdd) <+ 2e-14 * ddt(V(cpphdl_n273, Vdd)); // Bench initial voltage = 0.0 V.
        // device 111, IC IC12, analog/basic/nmos_source_follower.hpp:25
        I(cpphdl_n2628, Vss) <+ 8e-14 * ddt(V(cpphdl_n2628, Vss)); // Bench initial voltage = 0.0 V.
        // device 112, IC IC1, analog/1G/IHPSG13G2/differential_receive_frontend.hpp:60
        I(cpphdl_n2628, Vss) <+ 3.0000000000000001e-12 * ddt(V(cpphdl_n2628, Vss)); // Bench initial voltage = 0.0 V.
        // device 113, IC IC18, analog/basic/inverter.hpp:11
        I(cpphdl_n489, Vdd) <+ cpphdl_channel(V(TRACK0, Vdd), V(cpphdl_n489, Vdd), 0.0040000000000000001, 0.69999999999999996, -1.0);
        // device 114, IC IC18, analog/basic/inverter.hpp:12
        I(cpphdl_n489, Vss) <+ cpphdl_channel(V(TRACK0, Vss), V(cpphdl_n489, Vss), 0.0040000000000000001, 0.69999999999999996, 1.0);
        // device 115, IC IC17, analog/basic/mos_track_hold.hpp:31
        I(cpphdl_n489, Vss) <+ 2e-14 * ddt(V(cpphdl_n489, Vss)); // Bench initial voltage = 0.0 V.
        // device 116, IC IC17, analog/basic/mos_track_hold.hpp:32
        I(cpphdl_n2628, cpphdl_n543) <+ cpphdl_channel(V(TRACK0, cpphdl_n543), V(cpphdl_n2628, cpphdl_n543), 0.029999999999999999, 0.69999999999999996, 1.0);
        // device 117, IC IC17, analog/basic/mos_track_hold.hpp:33
        I(cpphdl_n543, cpphdl_n2628) <+ cpphdl_channel(V(cpphdl_n489, cpphdl_n2628), V(cpphdl_n543, cpphdl_n2628), 0.014999999999999999, 0.69999999999999996, -1.0);
        // device 118, IC IC17, analog/basic/mos_track_hold.hpp:37
        I(cpphdl_n543, cpphdl_n543) <+ cpphdl_channel(V(cpphdl_n489, cpphdl_n543), V(cpphdl_n543, cpphdl_n543), 0.016, 0.69999999999999996, 1.0);
        // device 119, IC IC17, analog/basic/mos_track_hold.hpp:38
        I(cpphdl_n543, cpphdl_n543) <+ cpphdl_channel(V(TRACK0, cpphdl_n543), V(cpphdl_n543, cpphdl_n543), 0.0083999999999999995, 0.69999999999999996, -1.0);
        // device 120, IC IC17, analog/basic/mos_track_hold.hpp:39
        I(cpphdl_n543, Vss) <+ 1.5000000000000001e-12 * ddt(V(cpphdl_n543, Vss)); // Bench initial voltage = 0.0 V.
        // device 121, IC IC17, analog/basic/mos_track_hold.hpp:42
        I(TRACK0, cpphdl_n543) <+ 2.0000000000000002e-15 * ddt(V(TRACK0, cpphdl_n543)); // Bench initial voltage = -0.0 V.
        // device 122, IC IC17, analog/basic/mos_track_hold.hpp:43
        I(cpphdl_n489, cpphdl_n543) <+ 2.0000000000000002e-15 * ddt(V(cpphdl_n489, cpphdl_n543)); // Bench initial voltage = 0.0 V.
        // device 123, IC IC17, analog/basic/mos_track_hold.hpp:44
        I(cpphdl_n2628, cpphdl_n543) <+ 1.0000000000000001e-15 * ddt(V(cpphdl_n2628, cpphdl_n543)); // Bench initial voltage = 0.0 V.
        // device 124, IC IC20, analog/basic/inverter.hpp:11
        I(cpphdl_n504, Vdd) <+ cpphdl_channel(V(BIT_N0_0, Vdd), V(cpphdl_n504, Vdd), 0.080000000000000002, 0.69999999999999996, -1.0);
        // device 125, IC IC20, analog/basic/inverter.hpp:12
        I(cpphdl_n504, Vss) <+ cpphdl_channel(V(BIT_N0_0, Vss), V(cpphdl_n504, Vss), 0.080000000000000002, 0.69999999999999996, 1.0);
        // device 126, IC IC19, analog/basic/mos_r2r_dac.hpp:27
        I(cpphdl_n504, Vss) <+ 2.9999999999999998e-15 * ddt(V(cpphdl_n504, Vss)); // Bench initial voltage = 0.0 V.
        // device 127, IC IC19, analog/basic/mos_r2r_dac.hpp:28
        I(cpphdl_n504, cpphdl_n533) <+ V(cpphdl_n504, cpphdl_n533) / 2000.0;
        // device 128, IC IC19, analog/basic/mos_r2r_dac.hpp:29
        I(cpphdl_n533, Vss) <+ 2.9999999999999998e-15 * ddt(V(cpphdl_n533, Vss)); // Bench initial voltage = 0.0 V.
        // device 129, IC IC21, analog/basic/inverter.hpp:11
        I(cpphdl_n508, Vdd) <+ cpphdl_channel(V(BIT_N0_1, Vdd), V(cpphdl_n508, Vdd), 0.080000000000000002, 0.69999999999999996, -1.0);
        // device 130, IC IC21, analog/basic/inverter.hpp:12
        I(cpphdl_n508, Vss) <+ cpphdl_channel(V(BIT_N0_1, Vss), V(cpphdl_n508, Vss), 0.080000000000000002, 0.69999999999999996, 1.0);
        // device 131, IC IC19, analog/basic/mos_r2r_dac.hpp:27
        I(cpphdl_n508, Vss) <+ 2.9999999999999998e-15 * ddt(V(cpphdl_n508, Vss)); // Bench initial voltage = 0.0 V.
        // device 132, IC IC19, analog/basic/mos_r2r_dac.hpp:28
        I(cpphdl_n508, cpphdl_n534) <+ V(cpphdl_n508, cpphdl_n534) / 2000.0;
        // device 133, IC IC19, analog/basic/mos_r2r_dac.hpp:29
        I(cpphdl_n534, Vss) <+ 2.9999999999999998e-15 * ddt(V(cpphdl_n534, Vss)); // Bench initial voltage = 0.0 V.
        // device 134, IC IC19, analog/basic/mos_r2r_dac.hpp:31
        I(cpphdl_n533, cpphdl_n534) <+ V(cpphdl_n533, cpphdl_n534) / 1000.0;
        // device 135, IC IC22, analog/basic/inverter.hpp:11
        I(cpphdl_n512, Vdd) <+ cpphdl_channel(V(BIT_N0_2, Vdd), V(cpphdl_n512, Vdd), 0.080000000000000002, 0.69999999999999996, -1.0);
        // device 136, IC IC22, analog/basic/inverter.hpp:12
        I(cpphdl_n512, Vss) <+ cpphdl_channel(V(BIT_N0_2, Vss), V(cpphdl_n512, Vss), 0.080000000000000002, 0.69999999999999996, 1.0);
        // device 137, IC IC19, analog/basic/mos_r2r_dac.hpp:27
        I(cpphdl_n512, Vss) <+ 2.9999999999999998e-15 * ddt(V(cpphdl_n512, Vss)); // Bench initial voltage = 0.0 V.
        // device 138, IC IC19, analog/basic/mos_r2r_dac.hpp:28
        I(cpphdl_n512, cpphdl_n535) <+ V(cpphdl_n512, cpphdl_n535) / 2000.0;
        // device 139, IC IC19, analog/basic/mos_r2r_dac.hpp:29
        I(cpphdl_n535, Vss) <+ 2.9999999999999998e-15 * ddt(V(cpphdl_n535, Vss)); // Bench initial voltage = 0.0 V.
        // device 140, IC IC19, analog/basic/mos_r2r_dac.hpp:31
        I(cpphdl_n534, cpphdl_n535) <+ V(cpphdl_n534, cpphdl_n535) / 1000.0;
        // device 141, IC IC23, analog/basic/inverter.hpp:11
        I(cpphdl_n516, Vdd) <+ cpphdl_channel(V(BIT_N0_3, Vdd), V(cpphdl_n516, Vdd), 0.080000000000000002, 0.69999999999999996, -1.0);
        // device 142, IC IC23, analog/basic/inverter.hpp:12
        I(cpphdl_n516, Vss) <+ cpphdl_channel(V(BIT_N0_3, Vss), V(cpphdl_n516, Vss), 0.080000000000000002, 0.69999999999999996, 1.0);
        // device 143, IC IC19, analog/basic/mos_r2r_dac.hpp:27
        I(cpphdl_n516, Vss) <+ 2.9999999999999998e-15 * ddt(V(cpphdl_n516, Vss)); // Bench initial voltage = 0.0 V.
        // device 144, IC IC19, analog/basic/mos_r2r_dac.hpp:28
        I(cpphdl_n516, cpphdl_n536) <+ V(cpphdl_n516, cpphdl_n536) / 2000.0;
        // device 145, IC IC19, analog/basic/mos_r2r_dac.hpp:29
        I(cpphdl_n536, Vss) <+ 2.9999999999999998e-15 * ddt(V(cpphdl_n536, Vss)); // Bench initial voltage = 0.0 V.
        // device 146, IC IC19, analog/basic/mos_r2r_dac.hpp:31
        I(cpphdl_n535, cpphdl_n536) <+ V(cpphdl_n535, cpphdl_n536) / 1000.0;
        // device 147, IC IC24, analog/basic/inverter.hpp:11
        I(cpphdl_n520, Vdd) <+ cpphdl_channel(V(BIT_N0_4, Vdd), V(cpphdl_n520, Vdd), 0.080000000000000002, 0.69999999999999996, -1.0);
        // device 148, IC IC24, analog/basic/inverter.hpp:12
        I(cpphdl_n520, Vss) <+ cpphdl_channel(V(BIT_N0_4, Vss), V(cpphdl_n520, Vss), 0.080000000000000002, 0.69999999999999996, 1.0);
        // device 149, IC IC19, analog/basic/mos_r2r_dac.hpp:27
        I(cpphdl_n520, Vss) <+ 2.9999999999999998e-15 * ddt(V(cpphdl_n520, Vss)); // Bench initial voltage = 0.0 V.
        // device 150, IC IC19, analog/basic/mos_r2r_dac.hpp:28
        I(cpphdl_n520, cpphdl_n537) <+ V(cpphdl_n520, cpphdl_n537) / 2000.0;
        // device 151, IC IC19, analog/basic/mos_r2r_dac.hpp:29
        I(cpphdl_n537, Vss) <+ 2.9999999999999998e-15 * ddt(V(cpphdl_n537, Vss)); // Bench initial voltage = 0.0 V.
        // device 152, IC IC19, analog/basic/mos_r2r_dac.hpp:31
        I(cpphdl_n536, cpphdl_n537) <+ V(cpphdl_n536, cpphdl_n537) / 1000.0;
        // device 153, IC IC25, analog/basic/inverter.hpp:11
        I(cpphdl_n524, Vdd) <+ cpphdl_channel(V(BIT_N0_5, Vdd), V(cpphdl_n524, Vdd), 0.080000000000000002, 0.69999999999999996, -1.0);
        // device 154, IC IC25, analog/basic/inverter.hpp:12
        I(cpphdl_n524, Vss) <+ cpphdl_channel(V(BIT_N0_5, Vss), V(cpphdl_n524, Vss), 0.080000000000000002, 0.69999999999999996, 1.0);
        // device 155, IC IC19, analog/basic/mos_r2r_dac.hpp:27
        I(cpphdl_n524, Vss) <+ 2.9999999999999998e-15 * ddt(V(cpphdl_n524, Vss)); // Bench initial voltage = 0.0 V.
        // device 156, IC IC19, analog/basic/mos_r2r_dac.hpp:28
        I(cpphdl_n524, cpphdl_n538) <+ V(cpphdl_n524, cpphdl_n538) / 2000.0;
        // device 157, IC IC19, analog/basic/mos_r2r_dac.hpp:29
        I(cpphdl_n538, Vss) <+ 2.9999999999999998e-15 * ddt(V(cpphdl_n538, Vss)); // Bench initial voltage = 0.0 V.
        // device 158, IC IC19, analog/basic/mos_r2r_dac.hpp:31
        I(cpphdl_n537, cpphdl_n538) <+ V(cpphdl_n537, cpphdl_n538) / 1000.0;
        // device 159, IC IC26, analog/basic/inverter.hpp:11
        I(cpphdl_n528, Vdd) <+ cpphdl_channel(V(BIT_N0_6, Vdd), V(cpphdl_n528, Vdd), 0.080000000000000002, 0.69999999999999996, -1.0);
        // device 160, IC IC26, analog/basic/inverter.hpp:12
        I(cpphdl_n528, Vss) <+ cpphdl_channel(V(BIT_N0_6, Vss), V(cpphdl_n528, Vss), 0.080000000000000002, 0.69999999999999996, 1.0);
        // device 161, IC IC19, analog/basic/mos_r2r_dac.hpp:27
        I(cpphdl_n528, Vss) <+ 2.9999999999999998e-15 * ddt(V(cpphdl_n528, Vss)); // Bench initial voltage = 0.0 V.
        // device 162, IC IC19, analog/basic/mos_r2r_dac.hpp:28
        I(cpphdl_n528, cpphdl_n539) <+ V(cpphdl_n528, cpphdl_n539) / 2000.0;
        // device 163, IC IC19, analog/basic/mos_r2r_dac.hpp:29
        I(cpphdl_n539, Vss) <+ 2.9999999999999998e-15 * ddt(V(cpphdl_n539, Vss)); // Bench initial voltage = 0.0 V.
        // device 164, IC IC19, analog/basic/mos_r2r_dac.hpp:31
        I(cpphdl_n538, cpphdl_n539) <+ V(cpphdl_n538, cpphdl_n539) / 1000.0;
        // device 165, IC IC27, analog/basic/inverter.hpp:11
        I(cpphdl_n532, Vdd) <+ cpphdl_channel(V(BIT_N0_7, Vdd), V(cpphdl_n532, Vdd), 0.080000000000000002, 0.69999999999999996, -1.0);
        // device 166, IC IC27, analog/basic/inverter.hpp:12
        I(cpphdl_n532, Vss) <+ cpphdl_channel(V(BIT_N0_7, Vss), V(cpphdl_n532, Vss), 0.080000000000000002, 0.69999999999999996, 1.0);
        // device 167, IC IC19, analog/basic/mos_r2r_dac.hpp:27
        I(cpphdl_n532, Vss) <+ 2.9999999999999998e-15 * ddt(V(cpphdl_n532, Vss)); // Bench initial voltage = 0.0 V.
        // device 168, IC IC19, analog/basic/mos_r2r_dac.hpp:28
        I(cpphdl_n532, cpphdl_n544) <+ V(cpphdl_n532, cpphdl_n544) / 2000.0;
        // device 169, IC IC19, analog/basic/mos_r2r_dac.hpp:29
        I(cpphdl_n544, Vss) <+ 2.9999999999999998e-15 * ddt(V(cpphdl_n544, Vss)); // Bench initial voltage = 0.0 V.
        // device 170, IC IC19, analog/basic/mos_r2r_dac.hpp:31
        I(cpphdl_n539, cpphdl_n544) <+ V(cpphdl_n539, cpphdl_n544) / 1000.0;
        // device 171, IC IC19, analog/basic/mos_r2r_dac.hpp:33
        I(Vss, cpphdl_n533) <+ V(Vss, cpphdl_n533) / 2000.0;
        // device 172, IC IC28, analog/basic/nmos_resistor_amplifier.hpp:23
        I(Vdd, cpphdl_n553) <+ V(Vdd, cpphdl_n553) / 1000.0;
        // device 173, IC IC28, analog/basic/nmos_resistor_amplifier.hpp:24
        I(Vdd, cpphdl_n552) <+ V(Vdd, cpphdl_n552) / 1000.0;
        // device 174, IC IC28, analog/basic/nmos_resistor_amplifier.hpp:25
        I(cpphdl_n553, cpphdl_n547) <+ cpphdl_channel(V(cpphdl_n543, cpphdl_n547), V(cpphdl_n553, cpphdl_n547), 0.0074999999999999997, 0.69999999999999996, 1.0);
        // device 175, IC IC28, analog/basic/nmos_resistor_amplifier.hpp:26
        I(cpphdl_n552, cpphdl_n548) <+ cpphdl_channel(V(cpphdl_n544, cpphdl_n548), V(cpphdl_n552, cpphdl_n548), 0.0074999999999999997, 0.69999999999999996, 1.0);
        // device 176, IC IC28, analog/basic/nmos_resistor_amplifier.hpp:27
        I(cpphdl_n549, cpphdl_n547) <+ V(cpphdl_n549, cpphdl_n547) / 100.0;
        // device 177, IC IC28, analog/basic/nmos_resistor_amplifier.hpp:28
        I(cpphdl_n549, cpphdl_n548) <+ V(cpphdl_n549, cpphdl_n548) / 100.0;
        // device 178, IC IC28, analog/basic/nmos_resistor_amplifier.hpp:29
        I(Vss, cpphdl_n549) <+ V(Vss, cpphdl_n549) / 300.0;
        // device 179, IC IC28, analog/basic/nmos_resistor_amplifier.hpp:30
        I(cpphdl_n553, Vdd) <+ 2.9999999999999998e-13 * ddt(V(cpphdl_n553, Vdd)); // Bench initial voltage = 0.0 V.
        // device 180, IC IC28, analog/basic/nmos_resistor_amplifier.hpp:31
        I(cpphdl_n552, Vdd) <+ 2.9999999999999998e-13 * ddt(V(cpphdl_n552, Vdd)); // Bench initial voltage = 0.0 V.
        // device 181, IC IC28, analog/basic/nmos_resistor_amplifier.hpp:32
        I(cpphdl_n549, Vss) <+ 4e-14 * ddt(V(cpphdl_n549, Vss)); // Bench initial voltage = 0.0 V.
        // device 182, IC IC28, analog/basic/nmos_resistor_amplifier.hpp:34
        I(cpphdl_n543, cpphdl_n547) <+ 2e-14 * ddt(V(cpphdl_n543, cpphdl_n547)); // Bench initial voltage = 0.0 V.
        // device 183, IC IC28, analog/basic/nmos_resistor_amplifier.hpp:35
        I(cpphdl_n544, cpphdl_n548) <+ 2e-14 * ddt(V(cpphdl_n544, cpphdl_n548)); // Bench initial voltage = 0.0 V.
        // device 184, IC IC28, analog/basic/nmos_resistor_amplifier.hpp:36
        I(cpphdl_n543, cpphdl_n553) <+ 2.9999999999999998e-15 * ddt(V(cpphdl_n543, cpphdl_n553)); // Bench initial voltage = 0.0 V.
        // device 185, IC IC28, analog/basic/nmos_resistor_amplifier.hpp:37
        I(cpphdl_n544, cpphdl_n552) <+ 2.9999999999999998e-15 * ddt(V(cpphdl_n544, cpphdl_n552)); // Bench initial voltage = 0.0 V.
        // device 186, IC IC29, analog/basic/strongarm_comparator.hpp:28
        I(cpphdl_n557, cpphdl_n559) <+ cpphdl_channel(V(cpphdl_n552, cpphdl_n559), V(cpphdl_n557, cpphdl_n559), 0.0080000000000000002, 0.69999999999999996, 1.0);
        // device 187, IC IC29, analog/basic/strongarm_comparator.hpp:29
        I(cpphdl_n558, cpphdl_n559) <+ cpphdl_channel(V(cpphdl_n553, cpphdl_n559), V(cpphdl_n558, cpphdl_n559), 0.0080000000000000002, 0.69999999999999996, 1.0);
        // device 188, IC IC29, analog/basic/strongarm_comparator.hpp:30
        I(cpphdl_n559, Vss) <+ cpphdl_channel(V(EVALUATE, Vss), V(cpphdl_n559, Vss), 0.0080000000000000002, 0.69999999999999996, 1.0);
        // device 189, IC IC29, analog/basic/strongarm_comparator.hpp:33
        I(cpphdl_n572, cpphdl_n557) <+ cpphdl_channel(V(cpphdl_n576, cpphdl_n557), V(cpphdl_n572, cpphdl_n557), 0.0040000000000000001, 0.69999999999999996, 1.0);
        // device 190, IC IC29, analog/basic/strongarm_comparator.hpp:34
        I(cpphdl_n576, cpphdl_n558) <+ cpphdl_channel(V(cpphdl_n572, cpphdl_n558), V(cpphdl_n576, cpphdl_n558), 0.0040000000000000001, 0.69999999999999996, 1.0);
        // device 191, IC IC29, analog/basic/strongarm_comparator.hpp:35
        I(cpphdl_n576, Vdd) <+ cpphdl_channel(V(cpphdl_n572, Vdd), V(cpphdl_n576, Vdd), 0.002, 0.69999999999999996, -1.0);
        // device 192, IC IC29, analog/basic/strongarm_comparator.hpp:36
        I(cpphdl_n572, Vdd) <+ cpphdl_channel(V(cpphdl_n576, Vdd), V(cpphdl_n572, Vdd), 0.002, 0.69999999999999996, -1.0);
        // device 193, IC IC29, analog/basic/strongarm_comparator.hpp:38
        I(cpphdl_n557, Vdd) <+ cpphdl_channel(V(EVALUATE, Vdd), V(cpphdl_n557, Vdd), 0.002, 0.69999999999999996, -1.0);
        // device 194, IC IC29, analog/basic/strongarm_comparator.hpp:39
        I(cpphdl_n558, Vdd) <+ cpphdl_channel(V(EVALUATE, Vdd), V(cpphdl_n558, Vdd), 0.002, 0.69999999999999996, -1.0);
        // device 195, IC IC29, analog/basic/strongarm_comparator.hpp:40
        I(cpphdl_n576, Vdd) <+ cpphdl_channel(V(EVALUATE, Vdd), V(cpphdl_n576, Vdd), 0.002, 0.69999999999999996, -1.0);
        // device 196, IC IC29, analog/basic/strongarm_comparator.hpp:41
        I(cpphdl_n572, Vdd) <+ cpphdl_channel(V(EVALUATE, Vdd), V(cpphdl_n572, Vdd), 0.002, 0.69999999999999996, -1.0);
        // device 197, IC IC29, analog/basic/strongarm_comparator.hpp:42
        I(cpphdl_n557, Vss) <+ 2.9999999999999998e-14 * ddt(V(cpphdl_n557, Vss)); // Bench initial voltage = 0.0 V.
        // device 198, IC IC29, analog/basic/strongarm_comparator.hpp:43
        I(cpphdl_n558, Vss) <+ 2.9999999999999998e-14 * ddt(V(cpphdl_n558, Vss)); // Bench initial voltage = 0.0 V.
        // device 199, IC IC29, analog/basic/strongarm_comparator.hpp:44
        I(cpphdl_n559, Vss) <+ 2.9999999999999998e-14 * ddt(V(cpphdl_n559, Vss)); // Bench initial voltage = 0.0 V.
        // device 200, IC IC29, analog/basic/strongarm_comparator.hpp:45
        I(cpphdl_n576, Vss) <+ 5.0000000000000002e-14 * ddt(V(cpphdl_n576, Vss)); // Bench initial voltage = 0.0 V.
        // device 201, IC IC29, analog/basic/strongarm_comparator.hpp:46
        I(cpphdl_n572, Vss) <+ 5.0000000000000002e-14 * ddt(V(cpphdl_n572, Vss)); // Bench initial voltage = 0.0 V.
        // device 202, IC IC29, analog/basic/strongarm_comparator.hpp:47
        I(cpphdl_n552, cpphdl_n559) <+ 2e-14 * ddt(V(cpphdl_n552, cpphdl_n559)); // Bench initial voltage = 0.0 V.
        // device 203, IC IC29, analog/basic/strongarm_comparator.hpp:48
        I(cpphdl_n553, cpphdl_n559) <+ 2e-14 * ddt(V(cpphdl_n553, cpphdl_n559)); // Bench initial voltage = 0.0 V.
        // device 204, IC IC29, analog/basic/strongarm_comparator.hpp:49
        I(cpphdl_n552, cpphdl_n557) <+ 2.9999999999999998e-15 * ddt(V(cpphdl_n552, cpphdl_n557)); // Bench initial voltage = 0.0 V.
        // device 205, IC IC29, analog/basic/strongarm_comparator.hpp:50
        I(cpphdl_n553, cpphdl_n558) <+ 2.9999999999999998e-15 * ddt(V(cpphdl_n553, cpphdl_n558)); // Bench initial voltage = 0.0 V.
        // device 206, IC IC31, analog/basic/inverter.hpp:11
        I(cpphdl_n580, Vdd) <+ cpphdl_channel(V(cpphdl_n572, Vdd), V(cpphdl_n580, Vdd), 0.001, 0.69999999999999996, -1.0);
        // device 207, IC IC31, analog/basic/inverter.hpp:12
        I(cpphdl_n580, Vss) <+ cpphdl_channel(V(cpphdl_n572, Vss), V(cpphdl_n580, Vss), 0.001, 0.69999999999999996, 1.0);
        // device 208, IC IC33, analog/basic/inverter.hpp:11
        I(cpphdl_n594, Vdd) <+ cpphdl_channel(V(cpphdl_n580, Vdd), V(cpphdl_n594, Vdd), 0.0040000000000000001, 0.69999999999999996, -1.0);
        // device 209, IC IC33, analog/basic/inverter.hpp:12
        I(cpphdl_n594, Vss) <+ cpphdl_channel(V(cpphdl_n580, Vss), V(cpphdl_n594, Vss), 0.0040000000000000001, 0.69999999999999996, 1.0);
        // device 210, IC IC30, analog/basic/buffered_nand_latch.hpp:34
        I(cpphdl_n572, Vss) <+ 2.0000000000000002e-15 * ddt(V(cpphdl_n572, Vss)); // Bench initial voltage = 0.0 V.
        // device 211, IC IC30, analog/basic/buffered_nand_latch.hpp:35
        I(cpphdl_n572, cpphdl_n580) <+ 1.0000000000000001e-15 * ddt(V(cpphdl_n572, cpphdl_n580)); // Bench initial voltage = 0.0 V.
        // device 212, IC IC30, analog/basic/buffered_nand_latch.hpp:36
        I(cpphdl_n580, Vss) <+ 5e-15 * ddt(V(cpphdl_n580, Vss)); // Bench initial voltage = 0.0 V.
        // device 213, IC IC30, analog/basic/buffered_nand_latch.hpp:37
        I(cpphdl_n580, Vss) <+ 8.0000000000000006e-15 * ddt(V(cpphdl_n580, Vss)); // Bench initial voltage = 0.0 V.
        // device 214, IC IC30, analog/basic/buffered_nand_latch.hpp:38
        I(cpphdl_n594, Vss) <+ 1e-14 * ddt(V(cpphdl_n594, Vss)); // Bench initial voltage = 0.0 V.
        // device 215, IC IC32, analog/basic/inverter.hpp:11
        I(cpphdl_n584, Vdd) <+ cpphdl_channel(V(cpphdl_n576, Vdd), V(cpphdl_n584, Vdd), 0.001, 0.69999999999999996, -1.0);
        // device 216, IC IC32, analog/basic/inverter.hpp:12
        I(cpphdl_n584, Vss) <+ cpphdl_channel(V(cpphdl_n576, Vss), V(cpphdl_n584, Vss), 0.001, 0.69999999999999996, 1.0);
        // device 217, IC IC34, analog/basic/inverter.hpp:11
        I(cpphdl_n600, Vdd) <+ cpphdl_channel(V(cpphdl_n584, Vdd), V(cpphdl_n600, Vdd), 0.0040000000000000001, 0.69999999999999996, -1.0);
        // device 218, IC IC34, analog/basic/inverter.hpp:12
        I(cpphdl_n600, Vss) <+ cpphdl_channel(V(cpphdl_n584, Vss), V(cpphdl_n600, Vss), 0.0040000000000000001, 0.69999999999999996, 1.0);
        // device 219, IC IC30, analog/basic/buffered_nand_latch.hpp:34
        I(cpphdl_n576, Vss) <+ 2.0000000000000002e-15 * ddt(V(cpphdl_n576, Vss)); // Bench initial voltage = 0.0 V.
        // device 220, IC IC30, analog/basic/buffered_nand_latch.hpp:35
        I(cpphdl_n576, cpphdl_n584) <+ 1.0000000000000001e-15 * ddt(V(cpphdl_n576, cpphdl_n584)); // Bench initial voltage = 0.0 V.
        // device 221, IC IC30, analog/basic/buffered_nand_latch.hpp:36
        I(cpphdl_n584, Vss) <+ 5e-15 * ddt(V(cpphdl_n584, Vss)); // Bench initial voltage = 0.0 V.
        // device 222, IC IC30, analog/basic/buffered_nand_latch.hpp:37
        I(cpphdl_n584, Vss) <+ 8.0000000000000006e-15 * ddt(V(cpphdl_n584, Vss)); // Bench initial voltage = 0.0 V.
        // device 223, IC IC30, analog/basic/buffered_nand_latch.hpp:38
        I(cpphdl_n600, Vss) <+ 1e-14 * ddt(V(cpphdl_n600, Vss)); // Bench initial voltage = 0.0 V.
        // device 224, IC IC36, analog/basic/cmos_logic.hpp:17
        I(cpphdl_n2773, Vss) <+ 5.0000000000000002e-14 * ddt(V(cpphdl_n2773, Vss)); // Bench initial voltage = 0.0 V.
        // device 225, IC IC36, analog/basic/cmos_logic.hpp:18
        I(cpphdl_n2773, Vdd) <+ cpphdl_channel(V(cpphdl_n594, Vdd), V(cpphdl_n2773, Vdd), 0.01, 0.69999999999999996, -1.0);
        // device 226, IC IC36, analog/basic/cmos_logic.hpp:19
        I(cpphdl_n2773, Vdd) <+ cpphdl_channel(V(cpphdl_n602, Vdd), V(cpphdl_n2773, Vdd), 0.01, 0.69999999999999996, -1.0);
        // device 227, IC IC36, analog/basic/cmos_logic.hpp:20
        I(cpphdl_n2773, cpphdl_n597) <+ cpphdl_channel(V(cpphdl_n594, cpphdl_n597), V(cpphdl_n2773, cpphdl_n597), 0.01, 0.69999999999999996, 1.0);
        // device 228, IC IC36, analog/basic/cmos_logic.hpp:21
        I(cpphdl_n597, Vss) <+ cpphdl_channel(V(cpphdl_n602, Vss), V(cpphdl_n597, Vss), 0.01, 0.69999999999999996, 1.0);
        // device 229, IC IC36, analog/basic/cmos_logic.hpp:27
        I(cpphdl_n597, Vss) <+ 1e-14 * ddt(V(cpphdl_n597, Vss)); // Bench initial voltage = 0.0 V.
        // device 230, IC IC37, analog/basic/cmos_logic.hpp:17
        I(cpphdl_n602, Vss) <+ 5.0000000000000002e-14 * ddt(V(cpphdl_n602, Vss)); // Bench initial voltage = 0.0 V.
        // device 231, IC IC37, analog/basic/cmos_logic.hpp:18
        I(cpphdl_n602, Vdd) <+ cpphdl_channel(V(cpphdl_n600, Vdd), V(cpphdl_n602, Vdd), 0.01, 0.69999999999999996, -1.0);
        // device 232, IC IC37, analog/basic/cmos_logic.hpp:19
        I(cpphdl_n602, Vdd) <+ cpphdl_channel(V(cpphdl_n2773, Vdd), V(cpphdl_n602, Vdd), 0.01, 0.69999999999999996, -1.0);
        // device 233, IC IC37, analog/basic/cmos_logic.hpp:20
        I(cpphdl_n602, cpphdl_n603) <+ cpphdl_channel(V(cpphdl_n600, cpphdl_n603), V(cpphdl_n602, cpphdl_n603), 0.01, 0.69999999999999996, 1.0);
        // device 234, IC IC37, analog/basic/cmos_logic.hpp:21
        I(cpphdl_n603, Vss) <+ cpphdl_channel(V(cpphdl_n2773, Vss), V(cpphdl_n603, Vss), 0.01, 0.69999999999999996, 1.0);
        // device 235, IC IC37, analog/basic/cmos_logic.hpp:27
        I(cpphdl_n603, Vss) <+ 1e-14 * ddt(V(cpphdl_n603, Vss)); // Bench initial voltage = 0.0 V.
        // device 236, IC IC35, analog/basic/nand_latch.hpp:36
        I(cpphdl_n594, Vss) <+ 2.9999999999999998e-15 * ddt(V(cpphdl_n594, Vss)); // Bench initial voltage = 0.0 V.
        // device 237, IC IC35, analog/basic/nand_latch.hpp:37
        I(cpphdl_n600, Vss) <+ 2.9999999999999998e-15 * ddt(V(cpphdl_n600, Vss)); // Bench initial voltage = 0.0 V.
        // device 238, IC IC38, analog/basic/inverter.hpp:11
        I(cpphdl_n608, Vdd) <+ cpphdl_channel(V(CLEAR, Vdd), V(cpphdl_n608, Vdd), 0.01, 0.69999999999999996, -1.0);
        // device 239, IC IC38, analog/basic/inverter.hpp:12
        I(cpphdl_n608, Vss) <+ cpphdl_channel(V(CLEAR, Vss), V(cpphdl_n608, Vss), 0.01, 0.69999999999999996, 1.0);
        // device 240, IC IC35, analog/basic/nand_latch.hpp:58
        I(cpphdl_n608, Vss) <+ 2.9999999999999998e-15 * ddt(V(cpphdl_n608, Vss)); // Bench initial voltage = 0.0 V.
        // device 241, IC IC35, analog/basic/nand_latch.hpp:59
        I(cpphdl_n2773, Vss) <+ cpphdl_channel(V(CLEAR, Vss), V(cpphdl_n2773, Vss), 0.050000000000000003, 0.69999999999999996, 1.0);
        // device 242, IC IC35, analog/basic/nand_latch.hpp:60
        I(cpphdl_n602, Vdd) <+ cpphdl_channel(V(cpphdl_n608, Vdd), V(cpphdl_n602, Vdd), 0.050000000000000003, 0.69999999999999996, -1.0);
        // device 243, IC IC41, analog/basic/inverter.hpp:11
        I(cpphdl_n632, Vdd) <+ cpphdl_channel(V(TRACK1, Vdd), V(cpphdl_n632, Vdd), 0.0040000000000000001, 0.69999999999999996, -1.0);
        // device 244, IC IC41, analog/basic/inverter.hpp:12
        I(cpphdl_n632, Vss) <+ cpphdl_channel(V(TRACK1, Vss), V(cpphdl_n632, Vss), 0.0040000000000000001, 0.69999999999999996, 1.0);
        // device 245, IC IC40, analog/basic/mos_track_hold.hpp:31
        I(cpphdl_n632, Vss) <+ 2e-14 * ddt(V(cpphdl_n632, Vss)); // Bench initial voltage = 0.0 V.
        // device 246, IC IC40, analog/basic/mos_track_hold.hpp:32
        I(cpphdl_n2628, cpphdl_n686) <+ cpphdl_channel(V(TRACK1, cpphdl_n686), V(cpphdl_n2628, cpphdl_n686), 0.029999999999999999, 0.69999999999999996, 1.0);
        // device 247, IC IC40, analog/basic/mos_track_hold.hpp:33
        I(cpphdl_n686, cpphdl_n2628) <+ cpphdl_channel(V(cpphdl_n632, cpphdl_n2628), V(cpphdl_n686, cpphdl_n2628), 0.014999999999999999, 0.69999999999999996, -1.0);
        // device 248, IC IC40, analog/basic/mos_track_hold.hpp:37
        I(cpphdl_n686, cpphdl_n686) <+ cpphdl_channel(V(cpphdl_n632, cpphdl_n686), V(cpphdl_n686, cpphdl_n686), 0.016, 0.69999999999999996, 1.0);
        // device 249, IC IC40, analog/basic/mos_track_hold.hpp:38
        I(cpphdl_n686, cpphdl_n686) <+ cpphdl_channel(V(TRACK1, cpphdl_n686), V(cpphdl_n686, cpphdl_n686), 0.0083999999999999995, 0.69999999999999996, -1.0);
        // device 250, IC IC40, analog/basic/mos_track_hold.hpp:39
        I(cpphdl_n686, Vss) <+ 1.5000000000000001e-12 * ddt(V(cpphdl_n686, Vss)); // Bench initial voltage = 0.0 V.
        // device 251, IC IC40, analog/basic/mos_track_hold.hpp:42
        I(TRACK1, cpphdl_n686) <+ 2.0000000000000002e-15 * ddt(V(TRACK1, cpphdl_n686)); // Bench initial voltage = -0.0 V.
        // device 252, IC IC40, analog/basic/mos_track_hold.hpp:43
        I(cpphdl_n632, cpphdl_n686) <+ 2.0000000000000002e-15 * ddt(V(cpphdl_n632, cpphdl_n686)); // Bench initial voltage = 0.0 V.
        // device 253, IC IC40, analog/basic/mos_track_hold.hpp:44
        I(cpphdl_n2628, cpphdl_n686) <+ 1.0000000000000001e-15 * ddt(V(cpphdl_n2628, cpphdl_n686)); // Bench initial voltage = 0.0 V.
        // device 254, IC IC43, analog/basic/inverter.hpp:11
        I(cpphdl_n647, Vdd) <+ cpphdl_channel(V(BIT_N1_0, Vdd), V(cpphdl_n647, Vdd), 0.080000000000000002, 0.69999999999999996, -1.0);
        // device 255, IC IC43, analog/basic/inverter.hpp:12
        I(cpphdl_n647, Vss) <+ cpphdl_channel(V(BIT_N1_0, Vss), V(cpphdl_n647, Vss), 0.080000000000000002, 0.69999999999999996, 1.0);
        // device 256, IC IC42, analog/basic/mos_r2r_dac.hpp:27
        I(cpphdl_n647, Vss) <+ 2.9999999999999998e-15 * ddt(V(cpphdl_n647, Vss)); // Bench initial voltage = 0.0 V.
        // device 257, IC IC42, analog/basic/mos_r2r_dac.hpp:28
        I(cpphdl_n647, cpphdl_n676) <+ V(cpphdl_n647, cpphdl_n676) / 2000.0;
        // device 258, IC IC42, analog/basic/mos_r2r_dac.hpp:29
        I(cpphdl_n676, Vss) <+ 2.9999999999999998e-15 * ddt(V(cpphdl_n676, Vss)); // Bench initial voltage = 0.0 V.
        // device 259, IC IC44, analog/basic/inverter.hpp:11
        I(cpphdl_n651, Vdd) <+ cpphdl_channel(V(BIT_N1_1, Vdd), V(cpphdl_n651, Vdd), 0.080000000000000002, 0.69999999999999996, -1.0);
        // device 260, IC IC44, analog/basic/inverter.hpp:12
        I(cpphdl_n651, Vss) <+ cpphdl_channel(V(BIT_N1_1, Vss), V(cpphdl_n651, Vss), 0.080000000000000002, 0.69999999999999996, 1.0);
        // device 261, IC IC42, analog/basic/mos_r2r_dac.hpp:27
        I(cpphdl_n651, Vss) <+ 2.9999999999999998e-15 * ddt(V(cpphdl_n651, Vss)); // Bench initial voltage = 0.0 V.
        // device 262, IC IC42, analog/basic/mos_r2r_dac.hpp:28
        I(cpphdl_n651, cpphdl_n677) <+ V(cpphdl_n651, cpphdl_n677) / 2000.0;
        // device 263, IC IC42, analog/basic/mos_r2r_dac.hpp:29
        I(cpphdl_n677, Vss) <+ 2.9999999999999998e-15 * ddt(V(cpphdl_n677, Vss)); // Bench initial voltage = 0.0 V.
        // device 264, IC IC42, analog/basic/mos_r2r_dac.hpp:31
        I(cpphdl_n676, cpphdl_n677) <+ V(cpphdl_n676, cpphdl_n677) / 1000.0;
        // device 265, IC IC45, analog/basic/inverter.hpp:11
        I(cpphdl_n655, Vdd) <+ cpphdl_channel(V(BIT_N1_2, Vdd), V(cpphdl_n655, Vdd), 0.080000000000000002, 0.69999999999999996, -1.0);
        // device 266, IC IC45, analog/basic/inverter.hpp:12
        I(cpphdl_n655, Vss) <+ cpphdl_channel(V(BIT_N1_2, Vss), V(cpphdl_n655, Vss), 0.080000000000000002, 0.69999999999999996, 1.0);
        // device 267, IC IC42, analog/basic/mos_r2r_dac.hpp:27
        I(cpphdl_n655, Vss) <+ 2.9999999999999998e-15 * ddt(V(cpphdl_n655, Vss)); // Bench initial voltage = 0.0 V.
        // device 268, IC IC42, analog/basic/mos_r2r_dac.hpp:28
        I(cpphdl_n655, cpphdl_n678) <+ V(cpphdl_n655, cpphdl_n678) / 2000.0;
        // device 269, IC IC42, analog/basic/mos_r2r_dac.hpp:29
        I(cpphdl_n678, Vss) <+ 2.9999999999999998e-15 * ddt(V(cpphdl_n678, Vss)); // Bench initial voltage = 0.0 V.
        // device 270, IC IC42, analog/basic/mos_r2r_dac.hpp:31
        I(cpphdl_n677, cpphdl_n678) <+ V(cpphdl_n677, cpphdl_n678) / 1000.0;
        // device 271, IC IC46, analog/basic/inverter.hpp:11
        I(cpphdl_n659, Vdd) <+ cpphdl_channel(V(BIT_N1_3, Vdd), V(cpphdl_n659, Vdd), 0.080000000000000002, 0.69999999999999996, -1.0);
        // device 272, IC IC46, analog/basic/inverter.hpp:12
        I(cpphdl_n659, Vss) <+ cpphdl_channel(V(BIT_N1_3, Vss), V(cpphdl_n659, Vss), 0.080000000000000002, 0.69999999999999996, 1.0);
        // device 273, IC IC42, analog/basic/mos_r2r_dac.hpp:27
        I(cpphdl_n659, Vss) <+ 2.9999999999999998e-15 * ddt(V(cpphdl_n659, Vss)); // Bench initial voltage = 0.0 V.
        // device 274, IC IC42, analog/basic/mos_r2r_dac.hpp:28
        I(cpphdl_n659, cpphdl_n679) <+ V(cpphdl_n659, cpphdl_n679) / 2000.0;
        // device 275, IC IC42, analog/basic/mos_r2r_dac.hpp:29
        I(cpphdl_n679, Vss) <+ 2.9999999999999998e-15 * ddt(V(cpphdl_n679, Vss)); // Bench initial voltage = 0.0 V.
        // device 276, IC IC42, analog/basic/mos_r2r_dac.hpp:31
        I(cpphdl_n678, cpphdl_n679) <+ V(cpphdl_n678, cpphdl_n679) / 1000.0;
        // device 277, IC IC47, analog/basic/inverter.hpp:11
        I(cpphdl_n663, Vdd) <+ cpphdl_channel(V(BIT_N1_4, Vdd), V(cpphdl_n663, Vdd), 0.080000000000000002, 0.69999999999999996, -1.0);
        // device 278, IC IC47, analog/basic/inverter.hpp:12
        I(cpphdl_n663, Vss) <+ cpphdl_channel(V(BIT_N1_4, Vss), V(cpphdl_n663, Vss), 0.080000000000000002, 0.69999999999999996, 1.0);
        // device 279, IC IC42, analog/basic/mos_r2r_dac.hpp:27
        I(cpphdl_n663, Vss) <+ 2.9999999999999998e-15 * ddt(V(cpphdl_n663, Vss)); // Bench initial voltage = 0.0 V.
        // device 280, IC IC42, analog/basic/mos_r2r_dac.hpp:28
        I(cpphdl_n663, cpphdl_n680) <+ V(cpphdl_n663, cpphdl_n680) / 2000.0;
        // device 281, IC IC42, analog/basic/mos_r2r_dac.hpp:29
        I(cpphdl_n680, Vss) <+ 2.9999999999999998e-15 * ddt(V(cpphdl_n680, Vss)); // Bench initial voltage = 0.0 V.
        // device 282, IC IC42, analog/basic/mos_r2r_dac.hpp:31
        I(cpphdl_n679, cpphdl_n680) <+ V(cpphdl_n679, cpphdl_n680) / 1000.0;
        // device 283, IC IC48, analog/basic/inverter.hpp:11
        I(cpphdl_n667, Vdd) <+ cpphdl_channel(V(BIT_N1_5, Vdd), V(cpphdl_n667, Vdd), 0.080000000000000002, 0.69999999999999996, -1.0);
        // device 284, IC IC48, analog/basic/inverter.hpp:12
        I(cpphdl_n667, Vss) <+ cpphdl_channel(V(BIT_N1_5, Vss), V(cpphdl_n667, Vss), 0.080000000000000002, 0.69999999999999996, 1.0);
        // device 285, IC IC42, analog/basic/mos_r2r_dac.hpp:27
        I(cpphdl_n667, Vss) <+ 2.9999999999999998e-15 * ddt(V(cpphdl_n667, Vss)); // Bench initial voltage = 0.0 V.
        // device 286, IC IC42, analog/basic/mos_r2r_dac.hpp:28
        I(cpphdl_n667, cpphdl_n681) <+ V(cpphdl_n667, cpphdl_n681) / 2000.0;
        // device 287, IC IC42, analog/basic/mos_r2r_dac.hpp:29
        I(cpphdl_n681, Vss) <+ 2.9999999999999998e-15 * ddt(V(cpphdl_n681, Vss)); // Bench initial voltage = 0.0 V.
        // device 288, IC IC42, analog/basic/mos_r2r_dac.hpp:31
        I(cpphdl_n680, cpphdl_n681) <+ V(cpphdl_n680, cpphdl_n681) / 1000.0;
        // device 289, IC IC49, analog/basic/inverter.hpp:11
        I(cpphdl_n671, Vdd) <+ cpphdl_channel(V(BIT_N1_6, Vdd), V(cpphdl_n671, Vdd), 0.080000000000000002, 0.69999999999999996, -1.0);
        // device 290, IC IC49, analog/basic/inverter.hpp:12
        I(cpphdl_n671, Vss) <+ cpphdl_channel(V(BIT_N1_6, Vss), V(cpphdl_n671, Vss), 0.080000000000000002, 0.69999999999999996, 1.0);
        // device 291, IC IC42, analog/basic/mos_r2r_dac.hpp:27
        I(cpphdl_n671, Vss) <+ 2.9999999999999998e-15 * ddt(V(cpphdl_n671, Vss)); // Bench initial voltage = 0.0 V.
        // device 292, IC IC42, analog/basic/mos_r2r_dac.hpp:28
        I(cpphdl_n671, cpphdl_n682) <+ V(cpphdl_n671, cpphdl_n682) / 2000.0;
        // device 293, IC IC42, analog/basic/mos_r2r_dac.hpp:29
        I(cpphdl_n682, Vss) <+ 2.9999999999999998e-15 * ddt(V(cpphdl_n682, Vss)); // Bench initial voltage = 0.0 V.
        // device 294, IC IC42, analog/basic/mos_r2r_dac.hpp:31
        I(cpphdl_n681, cpphdl_n682) <+ V(cpphdl_n681, cpphdl_n682) / 1000.0;
        // device 295, IC IC50, analog/basic/inverter.hpp:11
        I(cpphdl_n675, Vdd) <+ cpphdl_channel(V(BIT_N1_7, Vdd), V(cpphdl_n675, Vdd), 0.080000000000000002, 0.69999999999999996, -1.0);
        // device 296, IC IC50, analog/basic/inverter.hpp:12
        I(cpphdl_n675, Vss) <+ cpphdl_channel(V(BIT_N1_7, Vss), V(cpphdl_n675, Vss), 0.080000000000000002, 0.69999999999999996, 1.0);
        // device 297, IC IC42, analog/basic/mos_r2r_dac.hpp:27
        I(cpphdl_n675, Vss) <+ 2.9999999999999998e-15 * ddt(V(cpphdl_n675, Vss)); // Bench initial voltage = 0.0 V.
        // device 298, IC IC42, analog/basic/mos_r2r_dac.hpp:28
        I(cpphdl_n675, cpphdl_n687) <+ V(cpphdl_n675, cpphdl_n687) / 2000.0;
        // device 299, IC IC42, analog/basic/mos_r2r_dac.hpp:29
        I(cpphdl_n687, Vss) <+ 2.9999999999999998e-15 * ddt(V(cpphdl_n687, Vss)); // Bench initial voltage = 0.0 V.
        // device 300, IC IC42, analog/basic/mos_r2r_dac.hpp:31
        I(cpphdl_n682, cpphdl_n687) <+ V(cpphdl_n682, cpphdl_n687) / 1000.0;
        // device 301, IC IC42, analog/basic/mos_r2r_dac.hpp:33
        I(Vss, cpphdl_n676) <+ V(Vss, cpphdl_n676) / 2000.0;
        // device 302, IC IC51, analog/basic/nmos_resistor_amplifier.hpp:23
        I(Vdd, cpphdl_n696) <+ V(Vdd, cpphdl_n696) / 1000.0;
        // device 303, IC IC51, analog/basic/nmos_resistor_amplifier.hpp:24
        I(Vdd, cpphdl_n695) <+ V(Vdd, cpphdl_n695) / 1000.0;
        // device 304, IC IC51, analog/basic/nmos_resistor_amplifier.hpp:25
        I(cpphdl_n696, cpphdl_n690) <+ cpphdl_channel(V(cpphdl_n686, cpphdl_n690), V(cpphdl_n696, cpphdl_n690), 0.0074999999999999997, 0.69999999999999996, 1.0);
        // device 305, IC IC51, analog/basic/nmos_resistor_amplifier.hpp:26
        I(cpphdl_n695, cpphdl_n691) <+ cpphdl_channel(V(cpphdl_n687, cpphdl_n691), V(cpphdl_n695, cpphdl_n691), 0.0074999999999999997, 0.69999999999999996, 1.0);
        // device 306, IC IC51, analog/basic/nmos_resistor_amplifier.hpp:27
        I(cpphdl_n692, cpphdl_n690) <+ V(cpphdl_n692, cpphdl_n690) / 100.0;
        // device 307, IC IC51, analog/basic/nmos_resistor_amplifier.hpp:28
        I(cpphdl_n692, cpphdl_n691) <+ V(cpphdl_n692, cpphdl_n691) / 100.0;
        // device 308, IC IC51, analog/basic/nmos_resistor_amplifier.hpp:29
        I(Vss, cpphdl_n692) <+ V(Vss, cpphdl_n692) / 300.0;
        // device 309, IC IC51, analog/basic/nmos_resistor_amplifier.hpp:30
        I(cpphdl_n696, Vdd) <+ 2.9999999999999998e-13 * ddt(V(cpphdl_n696, Vdd)); // Bench initial voltage = 0.0 V.
        // device 310, IC IC51, analog/basic/nmos_resistor_amplifier.hpp:31
        I(cpphdl_n695, Vdd) <+ 2.9999999999999998e-13 * ddt(V(cpphdl_n695, Vdd)); // Bench initial voltage = 0.0 V.
        // device 311, IC IC51, analog/basic/nmos_resistor_amplifier.hpp:32
        I(cpphdl_n692, Vss) <+ 4e-14 * ddt(V(cpphdl_n692, Vss)); // Bench initial voltage = 0.0 V.
        // device 312, IC IC51, analog/basic/nmos_resistor_amplifier.hpp:34
        I(cpphdl_n686, cpphdl_n690) <+ 2e-14 * ddt(V(cpphdl_n686, cpphdl_n690)); // Bench initial voltage = 0.0 V.
        // device 313, IC IC51, analog/basic/nmos_resistor_amplifier.hpp:35
        I(cpphdl_n687, cpphdl_n691) <+ 2e-14 * ddt(V(cpphdl_n687, cpphdl_n691)); // Bench initial voltage = 0.0 V.
        // device 314, IC IC51, analog/basic/nmos_resistor_amplifier.hpp:36
        I(cpphdl_n686, cpphdl_n696) <+ 2.9999999999999998e-15 * ddt(V(cpphdl_n686, cpphdl_n696)); // Bench initial voltage = 0.0 V.
        // device 315, IC IC51, analog/basic/nmos_resistor_amplifier.hpp:37
        I(cpphdl_n687, cpphdl_n695) <+ 2.9999999999999998e-15 * ddt(V(cpphdl_n687, cpphdl_n695)); // Bench initial voltage = 0.0 V.
        // device 316, IC IC52, analog/basic/strongarm_comparator.hpp:28
        I(cpphdl_n700, cpphdl_n702) <+ cpphdl_channel(V(cpphdl_n695, cpphdl_n702), V(cpphdl_n700, cpphdl_n702), 0.0080000000000000002, 0.69999999999999996, 1.0);
        // device 317, IC IC52, analog/basic/strongarm_comparator.hpp:29
        I(cpphdl_n701, cpphdl_n702) <+ cpphdl_channel(V(cpphdl_n696, cpphdl_n702), V(cpphdl_n701, cpphdl_n702), 0.0080000000000000002, 0.69999999999999996, 1.0);
        // device 318, IC IC52, analog/basic/strongarm_comparator.hpp:30
        I(cpphdl_n702, Vss) <+ cpphdl_channel(V(EVALUATE, Vss), V(cpphdl_n702, Vss), 0.0080000000000000002, 0.69999999999999996, 1.0);
        // device 319, IC IC52, analog/basic/strongarm_comparator.hpp:33
        I(cpphdl_n715, cpphdl_n700) <+ cpphdl_channel(V(cpphdl_n719, cpphdl_n700), V(cpphdl_n715, cpphdl_n700), 0.0040000000000000001, 0.69999999999999996, 1.0);
        // device 320, IC IC52, analog/basic/strongarm_comparator.hpp:34
        I(cpphdl_n719, cpphdl_n701) <+ cpphdl_channel(V(cpphdl_n715, cpphdl_n701), V(cpphdl_n719, cpphdl_n701), 0.0040000000000000001, 0.69999999999999996, 1.0);
        // device 321, IC IC52, analog/basic/strongarm_comparator.hpp:35
        I(cpphdl_n719, Vdd) <+ cpphdl_channel(V(cpphdl_n715, Vdd), V(cpphdl_n719, Vdd), 0.002, 0.69999999999999996, -1.0);
        // device 322, IC IC52, analog/basic/strongarm_comparator.hpp:36
        I(cpphdl_n715, Vdd) <+ cpphdl_channel(V(cpphdl_n719, Vdd), V(cpphdl_n715, Vdd), 0.002, 0.69999999999999996, -1.0);
        // device 323, IC IC52, analog/basic/strongarm_comparator.hpp:38
        I(cpphdl_n700, Vdd) <+ cpphdl_channel(V(EVALUATE, Vdd), V(cpphdl_n700, Vdd), 0.002, 0.69999999999999996, -1.0);
        // device 324, IC IC52, analog/basic/strongarm_comparator.hpp:39
        I(cpphdl_n701, Vdd) <+ cpphdl_channel(V(EVALUATE, Vdd), V(cpphdl_n701, Vdd), 0.002, 0.69999999999999996, -1.0);
        // device 325, IC IC52, analog/basic/strongarm_comparator.hpp:40
        I(cpphdl_n719, Vdd) <+ cpphdl_channel(V(EVALUATE, Vdd), V(cpphdl_n719, Vdd), 0.002, 0.69999999999999996, -1.0);
        // device 326, IC IC52, analog/basic/strongarm_comparator.hpp:41
        I(cpphdl_n715, Vdd) <+ cpphdl_channel(V(EVALUATE, Vdd), V(cpphdl_n715, Vdd), 0.002, 0.69999999999999996, -1.0);
        // device 327, IC IC52, analog/basic/strongarm_comparator.hpp:42
        I(cpphdl_n700, Vss) <+ 2.9999999999999998e-14 * ddt(V(cpphdl_n700, Vss)); // Bench initial voltage = 0.0 V.
        // device 328, IC IC52, analog/basic/strongarm_comparator.hpp:43
        I(cpphdl_n701, Vss) <+ 2.9999999999999998e-14 * ddt(V(cpphdl_n701, Vss)); // Bench initial voltage = 0.0 V.
        // device 329, IC IC52, analog/basic/strongarm_comparator.hpp:44
        I(cpphdl_n702, Vss) <+ 2.9999999999999998e-14 * ddt(V(cpphdl_n702, Vss)); // Bench initial voltage = 0.0 V.
        // device 330, IC IC52, analog/basic/strongarm_comparator.hpp:45
        I(cpphdl_n719, Vss) <+ 5.0000000000000002e-14 * ddt(V(cpphdl_n719, Vss)); // Bench initial voltage = 0.0 V.
        // device 331, IC IC52, analog/basic/strongarm_comparator.hpp:46
        I(cpphdl_n715, Vss) <+ 5.0000000000000002e-14 * ddt(V(cpphdl_n715, Vss)); // Bench initial voltage = 0.0 V.
        // device 332, IC IC52, analog/basic/strongarm_comparator.hpp:47
        I(cpphdl_n695, cpphdl_n702) <+ 2e-14 * ddt(V(cpphdl_n695, cpphdl_n702)); // Bench initial voltage = 0.0 V.
        // device 333, IC IC52, analog/basic/strongarm_comparator.hpp:48
        I(cpphdl_n696, cpphdl_n702) <+ 2e-14 * ddt(V(cpphdl_n696, cpphdl_n702)); // Bench initial voltage = 0.0 V.
        // device 334, IC IC52, analog/basic/strongarm_comparator.hpp:49
        I(cpphdl_n695, cpphdl_n700) <+ 2.9999999999999998e-15 * ddt(V(cpphdl_n695, cpphdl_n700)); // Bench initial voltage = 0.0 V.
        // device 335, IC IC52, analog/basic/strongarm_comparator.hpp:50
        I(cpphdl_n696, cpphdl_n701) <+ 2.9999999999999998e-15 * ddt(V(cpphdl_n696, cpphdl_n701)); // Bench initial voltage = 0.0 V.
        // device 336, IC IC54, analog/basic/inverter.hpp:11
        I(cpphdl_n723, Vdd) <+ cpphdl_channel(V(cpphdl_n715, Vdd), V(cpphdl_n723, Vdd), 0.001, 0.69999999999999996, -1.0);
        // device 337, IC IC54, analog/basic/inverter.hpp:12
        I(cpphdl_n723, Vss) <+ cpphdl_channel(V(cpphdl_n715, Vss), V(cpphdl_n723, Vss), 0.001, 0.69999999999999996, 1.0);
        // device 338, IC IC56, analog/basic/inverter.hpp:11
        I(cpphdl_n737, Vdd) <+ cpphdl_channel(V(cpphdl_n723, Vdd), V(cpphdl_n737, Vdd), 0.0040000000000000001, 0.69999999999999996, -1.0);
        // device 339, IC IC56, analog/basic/inverter.hpp:12
        I(cpphdl_n737, Vss) <+ cpphdl_channel(V(cpphdl_n723, Vss), V(cpphdl_n737, Vss), 0.0040000000000000001, 0.69999999999999996, 1.0);
        // device 340, IC IC53, analog/basic/buffered_nand_latch.hpp:34
        I(cpphdl_n715, Vss) <+ 2.0000000000000002e-15 * ddt(V(cpphdl_n715, Vss)); // Bench initial voltage = 0.0 V.
        // device 341, IC IC53, analog/basic/buffered_nand_latch.hpp:35
        I(cpphdl_n715, cpphdl_n723) <+ 1.0000000000000001e-15 * ddt(V(cpphdl_n715, cpphdl_n723)); // Bench initial voltage = 0.0 V.
        // device 342, IC IC53, analog/basic/buffered_nand_latch.hpp:36
        I(cpphdl_n723, Vss) <+ 5e-15 * ddt(V(cpphdl_n723, Vss)); // Bench initial voltage = 0.0 V.
        // device 343, IC IC53, analog/basic/buffered_nand_latch.hpp:37
        I(cpphdl_n723, Vss) <+ 8.0000000000000006e-15 * ddt(V(cpphdl_n723, Vss)); // Bench initial voltage = 0.0 V.
        // device 344, IC IC53, analog/basic/buffered_nand_latch.hpp:38
        I(cpphdl_n737, Vss) <+ 1e-14 * ddt(V(cpphdl_n737, Vss)); // Bench initial voltage = 0.0 V.
        // device 345, IC IC55, analog/basic/inverter.hpp:11
        I(cpphdl_n727, Vdd) <+ cpphdl_channel(V(cpphdl_n719, Vdd), V(cpphdl_n727, Vdd), 0.001, 0.69999999999999996, -1.0);
        // device 346, IC IC55, analog/basic/inverter.hpp:12
        I(cpphdl_n727, Vss) <+ cpphdl_channel(V(cpphdl_n719, Vss), V(cpphdl_n727, Vss), 0.001, 0.69999999999999996, 1.0);
        // device 347, IC IC57, analog/basic/inverter.hpp:11
        I(cpphdl_n743, Vdd) <+ cpphdl_channel(V(cpphdl_n727, Vdd), V(cpphdl_n743, Vdd), 0.0040000000000000001, 0.69999999999999996, -1.0);
        // device 348, IC IC57, analog/basic/inverter.hpp:12
        I(cpphdl_n743, Vss) <+ cpphdl_channel(V(cpphdl_n727, Vss), V(cpphdl_n743, Vss), 0.0040000000000000001, 0.69999999999999996, 1.0);
        // device 349, IC IC53, analog/basic/buffered_nand_latch.hpp:34
        I(cpphdl_n719, Vss) <+ 2.0000000000000002e-15 * ddt(V(cpphdl_n719, Vss)); // Bench initial voltage = 0.0 V.
        // device 350, IC IC53, analog/basic/buffered_nand_latch.hpp:35
        I(cpphdl_n719, cpphdl_n727) <+ 1.0000000000000001e-15 * ddt(V(cpphdl_n719, cpphdl_n727)); // Bench initial voltage = 0.0 V.
        // device 351, IC IC53, analog/basic/buffered_nand_latch.hpp:36
        I(cpphdl_n727, Vss) <+ 5e-15 * ddt(V(cpphdl_n727, Vss)); // Bench initial voltage = 0.0 V.
        // device 352, IC IC53, analog/basic/buffered_nand_latch.hpp:37
        I(cpphdl_n727, Vss) <+ 8.0000000000000006e-15 * ddt(V(cpphdl_n727, Vss)); // Bench initial voltage = 0.0 V.
        // device 353, IC IC53, analog/basic/buffered_nand_latch.hpp:38
        I(cpphdl_n743, Vss) <+ 1e-14 * ddt(V(cpphdl_n743, Vss)); // Bench initial voltage = 0.0 V.
        // device 354, IC IC59, analog/basic/cmos_logic.hpp:17
        I(cpphdl_n2778, Vss) <+ 5.0000000000000002e-14 * ddt(V(cpphdl_n2778, Vss)); // Bench initial voltage = 0.0 V.
        // device 355, IC IC59, analog/basic/cmos_logic.hpp:18
        I(cpphdl_n2778, Vdd) <+ cpphdl_channel(V(cpphdl_n737, Vdd), V(cpphdl_n2778, Vdd), 0.01, 0.69999999999999996, -1.0);
        // device 356, IC IC59, analog/basic/cmos_logic.hpp:19
        I(cpphdl_n2778, Vdd) <+ cpphdl_channel(V(cpphdl_n745, Vdd), V(cpphdl_n2778, Vdd), 0.01, 0.69999999999999996, -1.0);
        // device 357, IC IC59, analog/basic/cmos_logic.hpp:20
        I(cpphdl_n2778, cpphdl_n740) <+ cpphdl_channel(V(cpphdl_n737, cpphdl_n740), V(cpphdl_n2778, cpphdl_n740), 0.01, 0.69999999999999996, 1.0);
        // device 358, IC IC59, analog/basic/cmos_logic.hpp:21
        I(cpphdl_n740, Vss) <+ cpphdl_channel(V(cpphdl_n745, Vss), V(cpphdl_n740, Vss), 0.01, 0.69999999999999996, 1.0);
        // device 359, IC IC59, analog/basic/cmos_logic.hpp:27
        I(cpphdl_n740, Vss) <+ 1e-14 * ddt(V(cpphdl_n740, Vss)); // Bench initial voltage = 0.0 V.
        // device 360, IC IC60, analog/basic/cmos_logic.hpp:17
        I(cpphdl_n745, Vss) <+ 5.0000000000000002e-14 * ddt(V(cpphdl_n745, Vss)); // Bench initial voltage = 0.0 V.
        // device 361, IC IC60, analog/basic/cmos_logic.hpp:18
        I(cpphdl_n745, Vdd) <+ cpphdl_channel(V(cpphdl_n743, Vdd), V(cpphdl_n745, Vdd), 0.01, 0.69999999999999996, -1.0);
        // device 362, IC IC60, analog/basic/cmos_logic.hpp:19
        I(cpphdl_n745, Vdd) <+ cpphdl_channel(V(cpphdl_n2778, Vdd), V(cpphdl_n745, Vdd), 0.01, 0.69999999999999996, -1.0);
        // device 363, IC IC60, analog/basic/cmos_logic.hpp:20
        I(cpphdl_n745, cpphdl_n746) <+ cpphdl_channel(V(cpphdl_n743, cpphdl_n746), V(cpphdl_n745, cpphdl_n746), 0.01, 0.69999999999999996, 1.0);
        // device 364, IC IC60, analog/basic/cmos_logic.hpp:21
        I(cpphdl_n746, Vss) <+ cpphdl_channel(V(cpphdl_n2778, Vss), V(cpphdl_n746, Vss), 0.01, 0.69999999999999996, 1.0);
        // device 365, IC IC60, analog/basic/cmos_logic.hpp:27
        I(cpphdl_n746, Vss) <+ 1e-14 * ddt(V(cpphdl_n746, Vss)); // Bench initial voltage = 0.0 V.
        // device 366, IC IC58, analog/basic/nand_latch.hpp:36
        I(cpphdl_n737, Vss) <+ 2.9999999999999998e-15 * ddt(V(cpphdl_n737, Vss)); // Bench initial voltage = 0.0 V.
        // device 367, IC IC58, analog/basic/nand_latch.hpp:37
        I(cpphdl_n743, Vss) <+ 2.9999999999999998e-15 * ddt(V(cpphdl_n743, Vss)); // Bench initial voltage = 0.0 V.
        // device 368, IC IC61, analog/basic/inverter.hpp:11
        I(cpphdl_n751, Vdd) <+ cpphdl_channel(V(CLEAR, Vdd), V(cpphdl_n751, Vdd), 0.01, 0.69999999999999996, -1.0);
        // device 369, IC IC61, analog/basic/inverter.hpp:12
        I(cpphdl_n751, Vss) <+ cpphdl_channel(V(CLEAR, Vss), V(cpphdl_n751, Vss), 0.01, 0.69999999999999996, 1.0);
        // device 370, IC IC58, analog/basic/nand_latch.hpp:58
        I(cpphdl_n751, Vss) <+ 2.9999999999999998e-15 * ddt(V(cpphdl_n751, Vss)); // Bench initial voltage = 0.0 V.
        // device 371, IC IC58, analog/basic/nand_latch.hpp:59
        I(cpphdl_n2778, Vss) <+ cpphdl_channel(V(CLEAR, Vss), V(cpphdl_n2778, Vss), 0.050000000000000003, 0.69999999999999996, 1.0);
        // device 372, IC IC58, analog/basic/nand_latch.hpp:60
        I(cpphdl_n745, Vdd) <+ cpphdl_channel(V(cpphdl_n751, Vdd), V(cpphdl_n745, Vdd), 0.050000000000000003, 0.69999999999999996, -1.0);
        // device 373, IC IC64, analog/basic/inverter.hpp:11
        I(cpphdl_n775, Vdd) <+ cpphdl_channel(V(TRACK2, Vdd), V(cpphdl_n775, Vdd), 0.0040000000000000001, 0.69999999999999996, -1.0);
        // device 374, IC IC64, analog/basic/inverter.hpp:12
        I(cpphdl_n775, Vss) <+ cpphdl_channel(V(TRACK2, Vss), V(cpphdl_n775, Vss), 0.0040000000000000001, 0.69999999999999996, 1.0);
        // device 375, IC IC63, analog/basic/mos_track_hold.hpp:31
        I(cpphdl_n775, Vss) <+ 2e-14 * ddt(V(cpphdl_n775, Vss)); // Bench initial voltage = 0.0 V.
        // device 376, IC IC63, analog/basic/mos_track_hold.hpp:32
        I(cpphdl_n2628, cpphdl_n829) <+ cpphdl_channel(V(TRACK2, cpphdl_n829), V(cpphdl_n2628, cpphdl_n829), 0.029999999999999999, 0.69999999999999996, 1.0);
        // device 377, IC IC63, analog/basic/mos_track_hold.hpp:33
        I(cpphdl_n829, cpphdl_n2628) <+ cpphdl_channel(V(cpphdl_n775, cpphdl_n2628), V(cpphdl_n829, cpphdl_n2628), 0.014999999999999999, 0.69999999999999996, -1.0);
        // device 378, IC IC63, analog/basic/mos_track_hold.hpp:37
        I(cpphdl_n829, cpphdl_n829) <+ cpphdl_channel(V(cpphdl_n775, cpphdl_n829), V(cpphdl_n829, cpphdl_n829), 0.016, 0.69999999999999996, 1.0);
        // device 379, IC IC63, analog/basic/mos_track_hold.hpp:38
        I(cpphdl_n829, cpphdl_n829) <+ cpphdl_channel(V(TRACK2, cpphdl_n829), V(cpphdl_n829, cpphdl_n829), 0.0083999999999999995, 0.69999999999999996, -1.0);
        // device 380, IC IC63, analog/basic/mos_track_hold.hpp:39
        I(cpphdl_n829, Vss) <+ 1.5000000000000001e-12 * ddt(V(cpphdl_n829, Vss)); // Bench initial voltage = 0.0 V.
        // device 381, IC IC63, analog/basic/mos_track_hold.hpp:42
        I(TRACK2, cpphdl_n829) <+ 2.0000000000000002e-15 * ddt(V(TRACK2, cpphdl_n829)); // Bench initial voltage = -0.0 V.
        // device 382, IC IC63, analog/basic/mos_track_hold.hpp:43
        I(cpphdl_n775, cpphdl_n829) <+ 2.0000000000000002e-15 * ddt(V(cpphdl_n775, cpphdl_n829)); // Bench initial voltage = 0.0 V.
        // device 383, IC IC63, analog/basic/mos_track_hold.hpp:44
        I(cpphdl_n2628, cpphdl_n829) <+ 1.0000000000000001e-15 * ddt(V(cpphdl_n2628, cpphdl_n829)); // Bench initial voltage = 0.0 V.
        // device 384, IC IC66, analog/basic/inverter.hpp:11
        I(cpphdl_n790, Vdd) <+ cpphdl_channel(V(BIT_N2_0, Vdd), V(cpphdl_n790, Vdd), 0.080000000000000002, 0.69999999999999996, -1.0);
        // device 385, IC IC66, analog/basic/inverter.hpp:12
        I(cpphdl_n790, Vss) <+ cpphdl_channel(V(BIT_N2_0, Vss), V(cpphdl_n790, Vss), 0.080000000000000002, 0.69999999999999996, 1.0);
        // device 386, IC IC65, analog/basic/mos_r2r_dac.hpp:27
        I(cpphdl_n790, Vss) <+ 2.9999999999999998e-15 * ddt(V(cpphdl_n790, Vss)); // Bench initial voltage = 0.0 V.
        // device 387, IC IC65, analog/basic/mos_r2r_dac.hpp:28
        I(cpphdl_n790, cpphdl_n819) <+ V(cpphdl_n790, cpphdl_n819) / 2000.0;
        // device 388, IC IC65, analog/basic/mos_r2r_dac.hpp:29
        I(cpphdl_n819, Vss) <+ 2.9999999999999998e-15 * ddt(V(cpphdl_n819, Vss)); // Bench initial voltage = 0.0 V.
        // device 389, IC IC67, analog/basic/inverter.hpp:11
        I(cpphdl_n794, Vdd) <+ cpphdl_channel(V(BIT_N2_1, Vdd), V(cpphdl_n794, Vdd), 0.080000000000000002, 0.69999999999999996, -1.0);
        // device 390, IC IC67, analog/basic/inverter.hpp:12
        I(cpphdl_n794, Vss) <+ cpphdl_channel(V(BIT_N2_1, Vss), V(cpphdl_n794, Vss), 0.080000000000000002, 0.69999999999999996, 1.0);
        // device 391, IC IC65, analog/basic/mos_r2r_dac.hpp:27
        I(cpphdl_n794, Vss) <+ 2.9999999999999998e-15 * ddt(V(cpphdl_n794, Vss)); // Bench initial voltage = 0.0 V.
        // device 392, IC IC65, analog/basic/mos_r2r_dac.hpp:28
        I(cpphdl_n794, cpphdl_n820) <+ V(cpphdl_n794, cpphdl_n820) / 2000.0;
        // device 393, IC IC65, analog/basic/mos_r2r_dac.hpp:29
        I(cpphdl_n820, Vss) <+ 2.9999999999999998e-15 * ddt(V(cpphdl_n820, Vss)); // Bench initial voltage = 0.0 V.
        // device 394, IC IC65, analog/basic/mos_r2r_dac.hpp:31
        I(cpphdl_n819, cpphdl_n820) <+ V(cpphdl_n819, cpphdl_n820) / 1000.0;
        // device 395, IC IC68, analog/basic/inverter.hpp:11
        I(cpphdl_n798, Vdd) <+ cpphdl_channel(V(BIT_N2_2, Vdd), V(cpphdl_n798, Vdd), 0.080000000000000002, 0.69999999999999996, -1.0);
        // device 396, IC IC68, analog/basic/inverter.hpp:12
        I(cpphdl_n798, Vss) <+ cpphdl_channel(V(BIT_N2_2, Vss), V(cpphdl_n798, Vss), 0.080000000000000002, 0.69999999999999996, 1.0);
        // device 397, IC IC65, analog/basic/mos_r2r_dac.hpp:27
        I(cpphdl_n798, Vss) <+ 2.9999999999999998e-15 * ddt(V(cpphdl_n798, Vss)); // Bench initial voltage = 0.0 V.
        // device 398, IC IC65, analog/basic/mos_r2r_dac.hpp:28
        I(cpphdl_n798, cpphdl_n821) <+ V(cpphdl_n798, cpphdl_n821) / 2000.0;
        // device 399, IC IC65, analog/basic/mos_r2r_dac.hpp:29
        I(cpphdl_n821, Vss) <+ 2.9999999999999998e-15 * ddt(V(cpphdl_n821, Vss)); // Bench initial voltage = 0.0 V.
        // device 400, IC IC65, analog/basic/mos_r2r_dac.hpp:31
        I(cpphdl_n820, cpphdl_n821) <+ V(cpphdl_n820, cpphdl_n821) / 1000.0;
        // device 401, IC IC69, analog/basic/inverter.hpp:11
        I(cpphdl_n802, Vdd) <+ cpphdl_channel(V(BIT_N2_3, Vdd), V(cpphdl_n802, Vdd), 0.080000000000000002, 0.69999999999999996, -1.0);
        // device 402, IC IC69, analog/basic/inverter.hpp:12
        I(cpphdl_n802, Vss) <+ cpphdl_channel(V(BIT_N2_3, Vss), V(cpphdl_n802, Vss), 0.080000000000000002, 0.69999999999999996, 1.0);
        // device 403, IC IC65, analog/basic/mos_r2r_dac.hpp:27
        I(cpphdl_n802, Vss) <+ 2.9999999999999998e-15 * ddt(V(cpphdl_n802, Vss)); // Bench initial voltage = 0.0 V.
        // device 404, IC IC65, analog/basic/mos_r2r_dac.hpp:28
        I(cpphdl_n802, cpphdl_n822) <+ V(cpphdl_n802, cpphdl_n822) / 2000.0;
        // device 405, IC IC65, analog/basic/mos_r2r_dac.hpp:29
        I(cpphdl_n822, Vss) <+ 2.9999999999999998e-15 * ddt(V(cpphdl_n822, Vss)); // Bench initial voltage = 0.0 V.
        // device 406, IC IC65, analog/basic/mos_r2r_dac.hpp:31
        I(cpphdl_n821, cpphdl_n822) <+ V(cpphdl_n821, cpphdl_n822) / 1000.0;
        // device 407, IC IC70, analog/basic/inverter.hpp:11
        I(cpphdl_n806, Vdd) <+ cpphdl_channel(V(BIT_N2_4, Vdd), V(cpphdl_n806, Vdd), 0.080000000000000002, 0.69999999999999996, -1.0);
        // device 408, IC IC70, analog/basic/inverter.hpp:12
        I(cpphdl_n806, Vss) <+ cpphdl_channel(V(BIT_N2_4, Vss), V(cpphdl_n806, Vss), 0.080000000000000002, 0.69999999999999996, 1.0);
        // device 409, IC IC65, analog/basic/mos_r2r_dac.hpp:27
        I(cpphdl_n806, Vss) <+ 2.9999999999999998e-15 * ddt(V(cpphdl_n806, Vss)); // Bench initial voltage = 0.0 V.
        // device 410, IC IC65, analog/basic/mos_r2r_dac.hpp:28
        I(cpphdl_n806, cpphdl_n823) <+ V(cpphdl_n806, cpphdl_n823) / 2000.0;
        // device 411, IC IC65, analog/basic/mos_r2r_dac.hpp:29
        I(cpphdl_n823, Vss) <+ 2.9999999999999998e-15 * ddt(V(cpphdl_n823, Vss)); // Bench initial voltage = 0.0 V.
        // device 412, IC IC65, analog/basic/mos_r2r_dac.hpp:31
        I(cpphdl_n822, cpphdl_n823) <+ V(cpphdl_n822, cpphdl_n823) / 1000.0;
        // device 413, IC IC71, analog/basic/inverter.hpp:11
        I(cpphdl_n810, Vdd) <+ cpphdl_channel(V(BIT_N2_5, Vdd), V(cpphdl_n810, Vdd), 0.080000000000000002, 0.69999999999999996, -1.0);
        // device 414, IC IC71, analog/basic/inverter.hpp:12
        I(cpphdl_n810, Vss) <+ cpphdl_channel(V(BIT_N2_5, Vss), V(cpphdl_n810, Vss), 0.080000000000000002, 0.69999999999999996, 1.0);
        // device 415, IC IC65, analog/basic/mos_r2r_dac.hpp:27
        I(cpphdl_n810, Vss) <+ 2.9999999999999998e-15 * ddt(V(cpphdl_n810, Vss)); // Bench initial voltage = 0.0 V.
        // device 416, IC IC65, analog/basic/mos_r2r_dac.hpp:28
        I(cpphdl_n810, cpphdl_n824) <+ V(cpphdl_n810, cpphdl_n824) / 2000.0;
        // device 417, IC IC65, analog/basic/mos_r2r_dac.hpp:29
        I(cpphdl_n824, Vss) <+ 2.9999999999999998e-15 * ddt(V(cpphdl_n824, Vss)); // Bench initial voltage = 0.0 V.
        // device 418, IC IC65, analog/basic/mos_r2r_dac.hpp:31
        I(cpphdl_n823, cpphdl_n824) <+ V(cpphdl_n823, cpphdl_n824) / 1000.0;
        // device 419, IC IC72, analog/basic/inverter.hpp:11
        I(cpphdl_n814, Vdd) <+ cpphdl_channel(V(BIT_N2_6, Vdd), V(cpphdl_n814, Vdd), 0.080000000000000002, 0.69999999999999996, -1.0);
        // device 420, IC IC72, analog/basic/inverter.hpp:12
        I(cpphdl_n814, Vss) <+ cpphdl_channel(V(BIT_N2_6, Vss), V(cpphdl_n814, Vss), 0.080000000000000002, 0.69999999999999996, 1.0);
        // device 421, IC IC65, analog/basic/mos_r2r_dac.hpp:27
        I(cpphdl_n814, Vss) <+ 2.9999999999999998e-15 * ddt(V(cpphdl_n814, Vss)); // Bench initial voltage = 0.0 V.
        // device 422, IC IC65, analog/basic/mos_r2r_dac.hpp:28
        I(cpphdl_n814, cpphdl_n825) <+ V(cpphdl_n814, cpphdl_n825) / 2000.0;
        // device 423, IC IC65, analog/basic/mos_r2r_dac.hpp:29
        I(cpphdl_n825, Vss) <+ 2.9999999999999998e-15 * ddt(V(cpphdl_n825, Vss)); // Bench initial voltage = 0.0 V.
        // device 424, IC IC65, analog/basic/mos_r2r_dac.hpp:31
        I(cpphdl_n824, cpphdl_n825) <+ V(cpphdl_n824, cpphdl_n825) / 1000.0;
        // device 425, IC IC73, analog/basic/inverter.hpp:11
        I(cpphdl_n818, Vdd) <+ cpphdl_channel(V(BIT_N2_7, Vdd), V(cpphdl_n818, Vdd), 0.080000000000000002, 0.69999999999999996, -1.0);
        // device 426, IC IC73, analog/basic/inverter.hpp:12
        I(cpphdl_n818, Vss) <+ cpphdl_channel(V(BIT_N2_7, Vss), V(cpphdl_n818, Vss), 0.080000000000000002, 0.69999999999999996, 1.0);
        // device 427, IC IC65, analog/basic/mos_r2r_dac.hpp:27
        I(cpphdl_n818, Vss) <+ 2.9999999999999998e-15 * ddt(V(cpphdl_n818, Vss)); // Bench initial voltage = 0.0 V.
        // device 428, IC IC65, analog/basic/mos_r2r_dac.hpp:28
        I(cpphdl_n818, cpphdl_n830) <+ V(cpphdl_n818, cpphdl_n830) / 2000.0;
        // device 429, IC IC65, analog/basic/mos_r2r_dac.hpp:29
        I(cpphdl_n830, Vss) <+ 2.9999999999999998e-15 * ddt(V(cpphdl_n830, Vss)); // Bench initial voltage = 0.0 V.
        // device 430, IC IC65, analog/basic/mos_r2r_dac.hpp:31
        I(cpphdl_n825, cpphdl_n830) <+ V(cpphdl_n825, cpphdl_n830) / 1000.0;
        // device 431, IC IC65, analog/basic/mos_r2r_dac.hpp:33
        I(Vss, cpphdl_n819) <+ V(Vss, cpphdl_n819) / 2000.0;
        // device 432, IC IC74, analog/basic/nmos_resistor_amplifier.hpp:23
        I(Vdd, cpphdl_n839) <+ V(Vdd, cpphdl_n839) / 1000.0;
        // device 433, IC IC74, analog/basic/nmos_resistor_amplifier.hpp:24
        I(Vdd, cpphdl_n838) <+ V(Vdd, cpphdl_n838) / 1000.0;
        // device 434, IC IC74, analog/basic/nmos_resistor_amplifier.hpp:25
        I(cpphdl_n839, cpphdl_n833) <+ cpphdl_channel(V(cpphdl_n829, cpphdl_n833), V(cpphdl_n839, cpphdl_n833), 0.0074999999999999997, 0.69999999999999996, 1.0);
        // device 435, IC IC74, analog/basic/nmos_resistor_amplifier.hpp:26
        I(cpphdl_n838, cpphdl_n834) <+ cpphdl_channel(V(cpphdl_n830, cpphdl_n834), V(cpphdl_n838, cpphdl_n834), 0.0074999999999999997, 0.69999999999999996, 1.0);
        // device 436, IC IC74, analog/basic/nmos_resistor_amplifier.hpp:27
        I(cpphdl_n835, cpphdl_n833) <+ V(cpphdl_n835, cpphdl_n833) / 100.0;
        // device 437, IC IC74, analog/basic/nmos_resistor_amplifier.hpp:28
        I(cpphdl_n835, cpphdl_n834) <+ V(cpphdl_n835, cpphdl_n834) / 100.0;
        // device 438, IC IC74, analog/basic/nmos_resistor_amplifier.hpp:29
        I(Vss, cpphdl_n835) <+ V(Vss, cpphdl_n835) / 300.0;
        // device 439, IC IC74, analog/basic/nmos_resistor_amplifier.hpp:30
        I(cpphdl_n839, Vdd) <+ 2.9999999999999998e-13 * ddt(V(cpphdl_n839, Vdd)); // Bench initial voltage = 0.0 V.
        // device 440, IC IC74, analog/basic/nmos_resistor_amplifier.hpp:31
        I(cpphdl_n838, Vdd) <+ 2.9999999999999998e-13 * ddt(V(cpphdl_n838, Vdd)); // Bench initial voltage = 0.0 V.
        // device 441, IC IC74, analog/basic/nmos_resistor_amplifier.hpp:32
        I(cpphdl_n835, Vss) <+ 4e-14 * ddt(V(cpphdl_n835, Vss)); // Bench initial voltage = 0.0 V.
        // device 442, IC IC74, analog/basic/nmos_resistor_amplifier.hpp:34
        I(cpphdl_n829, cpphdl_n833) <+ 2e-14 * ddt(V(cpphdl_n829, cpphdl_n833)); // Bench initial voltage = 0.0 V.
        // device 443, IC IC74, analog/basic/nmos_resistor_amplifier.hpp:35
        I(cpphdl_n830, cpphdl_n834) <+ 2e-14 * ddt(V(cpphdl_n830, cpphdl_n834)); // Bench initial voltage = 0.0 V.
        // device 444, IC IC74, analog/basic/nmos_resistor_amplifier.hpp:36
        I(cpphdl_n829, cpphdl_n839) <+ 2.9999999999999998e-15 * ddt(V(cpphdl_n829, cpphdl_n839)); // Bench initial voltage = 0.0 V.
        // device 445, IC IC74, analog/basic/nmos_resistor_amplifier.hpp:37
        I(cpphdl_n830, cpphdl_n838) <+ 2.9999999999999998e-15 * ddt(V(cpphdl_n830, cpphdl_n838)); // Bench initial voltage = 0.0 V.
        // device 446, IC IC75, analog/basic/strongarm_comparator.hpp:28
        I(cpphdl_n843, cpphdl_n845) <+ cpphdl_channel(V(cpphdl_n838, cpphdl_n845), V(cpphdl_n843, cpphdl_n845), 0.0080000000000000002, 0.69999999999999996, 1.0);
        // device 447, IC IC75, analog/basic/strongarm_comparator.hpp:29
        I(cpphdl_n844, cpphdl_n845) <+ cpphdl_channel(V(cpphdl_n839, cpphdl_n845), V(cpphdl_n844, cpphdl_n845), 0.0080000000000000002, 0.69999999999999996, 1.0);
        // device 448, IC IC75, analog/basic/strongarm_comparator.hpp:30
        I(cpphdl_n845, Vss) <+ cpphdl_channel(V(EVALUATE, Vss), V(cpphdl_n845, Vss), 0.0080000000000000002, 0.69999999999999996, 1.0);
        // device 449, IC IC75, analog/basic/strongarm_comparator.hpp:33
        I(cpphdl_n858, cpphdl_n843) <+ cpphdl_channel(V(cpphdl_n862, cpphdl_n843), V(cpphdl_n858, cpphdl_n843), 0.0040000000000000001, 0.69999999999999996, 1.0);
        // device 450, IC IC75, analog/basic/strongarm_comparator.hpp:34
        I(cpphdl_n862, cpphdl_n844) <+ cpphdl_channel(V(cpphdl_n858, cpphdl_n844), V(cpphdl_n862, cpphdl_n844), 0.0040000000000000001, 0.69999999999999996, 1.0);
        // device 451, IC IC75, analog/basic/strongarm_comparator.hpp:35
        I(cpphdl_n862, Vdd) <+ cpphdl_channel(V(cpphdl_n858, Vdd), V(cpphdl_n862, Vdd), 0.002, 0.69999999999999996, -1.0);
        // device 452, IC IC75, analog/basic/strongarm_comparator.hpp:36
        I(cpphdl_n858, Vdd) <+ cpphdl_channel(V(cpphdl_n862, Vdd), V(cpphdl_n858, Vdd), 0.002, 0.69999999999999996, -1.0);
        // device 453, IC IC75, analog/basic/strongarm_comparator.hpp:38
        I(cpphdl_n843, Vdd) <+ cpphdl_channel(V(EVALUATE, Vdd), V(cpphdl_n843, Vdd), 0.002, 0.69999999999999996, -1.0);
        // device 454, IC IC75, analog/basic/strongarm_comparator.hpp:39
        I(cpphdl_n844, Vdd) <+ cpphdl_channel(V(EVALUATE, Vdd), V(cpphdl_n844, Vdd), 0.002, 0.69999999999999996, -1.0);
        // device 455, IC IC75, analog/basic/strongarm_comparator.hpp:40
        I(cpphdl_n862, Vdd) <+ cpphdl_channel(V(EVALUATE, Vdd), V(cpphdl_n862, Vdd), 0.002, 0.69999999999999996, -1.0);
        // device 456, IC IC75, analog/basic/strongarm_comparator.hpp:41
        I(cpphdl_n858, Vdd) <+ cpphdl_channel(V(EVALUATE, Vdd), V(cpphdl_n858, Vdd), 0.002, 0.69999999999999996, -1.0);
        // device 457, IC IC75, analog/basic/strongarm_comparator.hpp:42
        I(cpphdl_n843, Vss) <+ 2.9999999999999998e-14 * ddt(V(cpphdl_n843, Vss)); // Bench initial voltage = 0.0 V.
        // device 458, IC IC75, analog/basic/strongarm_comparator.hpp:43
        I(cpphdl_n844, Vss) <+ 2.9999999999999998e-14 * ddt(V(cpphdl_n844, Vss)); // Bench initial voltage = 0.0 V.
        // device 459, IC IC75, analog/basic/strongarm_comparator.hpp:44
        I(cpphdl_n845, Vss) <+ 2.9999999999999998e-14 * ddt(V(cpphdl_n845, Vss)); // Bench initial voltage = 0.0 V.
        // device 460, IC IC75, analog/basic/strongarm_comparator.hpp:45
        I(cpphdl_n862, Vss) <+ 5.0000000000000002e-14 * ddt(V(cpphdl_n862, Vss)); // Bench initial voltage = 0.0 V.
        // device 461, IC IC75, analog/basic/strongarm_comparator.hpp:46
        I(cpphdl_n858, Vss) <+ 5.0000000000000002e-14 * ddt(V(cpphdl_n858, Vss)); // Bench initial voltage = 0.0 V.
        // device 462, IC IC75, analog/basic/strongarm_comparator.hpp:47
        I(cpphdl_n838, cpphdl_n845) <+ 2e-14 * ddt(V(cpphdl_n838, cpphdl_n845)); // Bench initial voltage = 0.0 V.
        // device 463, IC IC75, analog/basic/strongarm_comparator.hpp:48
        I(cpphdl_n839, cpphdl_n845) <+ 2e-14 * ddt(V(cpphdl_n839, cpphdl_n845)); // Bench initial voltage = 0.0 V.
        // device 464, IC IC75, analog/basic/strongarm_comparator.hpp:49
        I(cpphdl_n838, cpphdl_n843) <+ 2.9999999999999998e-15 * ddt(V(cpphdl_n838, cpphdl_n843)); // Bench initial voltage = 0.0 V.
        // device 465, IC IC75, analog/basic/strongarm_comparator.hpp:50
        I(cpphdl_n839, cpphdl_n844) <+ 2.9999999999999998e-15 * ddt(V(cpphdl_n839, cpphdl_n844)); // Bench initial voltage = 0.0 V.
        // device 466, IC IC77, analog/basic/inverter.hpp:11
        I(cpphdl_n866, Vdd) <+ cpphdl_channel(V(cpphdl_n858, Vdd), V(cpphdl_n866, Vdd), 0.001, 0.69999999999999996, -1.0);
        // device 467, IC IC77, analog/basic/inverter.hpp:12
        I(cpphdl_n866, Vss) <+ cpphdl_channel(V(cpphdl_n858, Vss), V(cpphdl_n866, Vss), 0.001, 0.69999999999999996, 1.0);
        // device 468, IC IC79, analog/basic/inverter.hpp:11
        I(cpphdl_n880, Vdd) <+ cpphdl_channel(V(cpphdl_n866, Vdd), V(cpphdl_n880, Vdd), 0.0040000000000000001, 0.69999999999999996, -1.0);
        // device 469, IC IC79, analog/basic/inverter.hpp:12
        I(cpphdl_n880, Vss) <+ cpphdl_channel(V(cpphdl_n866, Vss), V(cpphdl_n880, Vss), 0.0040000000000000001, 0.69999999999999996, 1.0);
        // device 470, IC IC76, analog/basic/buffered_nand_latch.hpp:34
        I(cpphdl_n858, Vss) <+ 2.0000000000000002e-15 * ddt(V(cpphdl_n858, Vss)); // Bench initial voltage = 0.0 V.
        // device 471, IC IC76, analog/basic/buffered_nand_latch.hpp:35
        I(cpphdl_n858, cpphdl_n866) <+ 1.0000000000000001e-15 * ddt(V(cpphdl_n858, cpphdl_n866)); // Bench initial voltage = 0.0 V.
        // device 472, IC IC76, analog/basic/buffered_nand_latch.hpp:36
        I(cpphdl_n866, Vss) <+ 5e-15 * ddt(V(cpphdl_n866, Vss)); // Bench initial voltage = 0.0 V.
        // device 473, IC IC76, analog/basic/buffered_nand_latch.hpp:37
        I(cpphdl_n866, Vss) <+ 8.0000000000000006e-15 * ddt(V(cpphdl_n866, Vss)); // Bench initial voltage = 0.0 V.
        // device 474, IC IC76, analog/basic/buffered_nand_latch.hpp:38
        I(cpphdl_n880, Vss) <+ 1e-14 * ddt(V(cpphdl_n880, Vss)); // Bench initial voltage = 0.0 V.
        // device 475, IC IC78, analog/basic/inverter.hpp:11
        I(cpphdl_n870, Vdd) <+ cpphdl_channel(V(cpphdl_n862, Vdd), V(cpphdl_n870, Vdd), 0.001, 0.69999999999999996, -1.0);
        // device 476, IC IC78, analog/basic/inverter.hpp:12
        I(cpphdl_n870, Vss) <+ cpphdl_channel(V(cpphdl_n862, Vss), V(cpphdl_n870, Vss), 0.001, 0.69999999999999996, 1.0);
        // device 477, IC IC80, analog/basic/inverter.hpp:11
        I(cpphdl_n886, Vdd) <+ cpphdl_channel(V(cpphdl_n870, Vdd), V(cpphdl_n886, Vdd), 0.0040000000000000001, 0.69999999999999996, -1.0);
        // device 478, IC IC80, analog/basic/inverter.hpp:12
        I(cpphdl_n886, Vss) <+ cpphdl_channel(V(cpphdl_n870, Vss), V(cpphdl_n886, Vss), 0.0040000000000000001, 0.69999999999999996, 1.0);
        // device 479, IC IC76, analog/basic/buffered_nand_latch.hpp:34
        I(cpphdl_n862, Vss) <+ 2.0000000000000002e-15 * ddt(V(cpphdl_n862, Vss)); // Bench initial voltage = 0.0 V.
        // device 480, IC IC76, analog/basic/buffered_nand_latch.hpp:35
        I(cpphdl_n862, cpphdl_n870) <+ 1.0000000000000001e-15 * ddt(V(cpphdl_n862, cpphdl_n870)); // Bench initial voltage = 0.0 V.
        // device 481, IC IC76, analog/basic/buffered_nand_latch.hpp:36
        I(cpphdl_n870, Vss) <+ 5e-15 * ddt(V(cpphdl_n870, Vss)); // Bench initial voltage = 0.0 V.
        // device 482, IC IC76, analog/basic/buffered_nand_latch.hpp:37
        I(cpphdl_n870, Vss) <+ 8.0000000000000006e-15 * ddt(V(cpphdl_n870, Vss)); // Bench initial voltage = 0.0 V.
        // device 483, IC IC76, analog/basic/buffered_nand_latch.hpp:38
        I(cpphdl_n886, Vss) <+ 1e-14 * ddt(V(cpphdl_n886, Vss)); // Bench initial voltage = 0.0 V.
        // device 484, IC IC82, analog/basic/cmos_logic.hpp:17
        I(cpphdl_n2783, Vss) <+ 5.0000000000000002e-14 * ddt(V(cpphdl_n2783, Vss)); // Bench initial voltage = 0.0 V.
        // device 485, IC IC82, analog/basic/cmos_logic.hpp:18
        I(cpphdl_n2783, Vdd) <+ cpphdl_channel(V(cpphdl_n880, Vdd), V(cpphdl_n2783, Vdd), 0.01, 0.69999999999999996, -1.0);
        // device 486, IC IC82, analog/basic/cmos_logic.hpp:19
        I(cpphdl_n2783, Vdd) <+ cpphdl_channel(V(cpphdl_n888, Vdd), V(cpphdl_n2783, Vdd), 0.01, 0.69999999999999996, -1.0);
        // device 487, IC IC82, analog/basic/cmos_logic.hpp:20
        I(cpphdl_n2783, cpphdl_n883) <+ cpphdl_channel(V(cpphdl_n880, cpphdl_n883), V(cpphdl_n2783, cpphdl_n883), 0.01, 0.69999999999999996, 1.0);
        // device 488, IC IC82, analog/basic/cmos_logic.hpp:21
        I(cpphdl_n883, Vss) <+ cpphdl_channel(V(cpphdl_n888, Vss), V(cpphdl_n883, Vss), 0.01, 0.69999999999999996, 1.0);
        // device 489, IC IC82, analog/basic/cmos_logic.hpp:27
        I(cpphdl_n883, Vss) <+ 1e-14 * ddt(V(cpphdl_n883, Vss)); // Bench initial voltage = 0.0 V.
        // device 490, IC IC83, analog/basic/cmos_logic.hpp:17
        I(cpphdl_n888, Vss) <+ 5.0000000000000002e-14 * ddt(V(cpphdl_n888, Vss)); // Bench initial voltage = 0.0 V.
        // device 491, IC IC83, analog/basic/cmos_logic.hpp:18
        I(cpphdl_n888, Vdd) <+ cpphdl_channel(V(cpphdl_n886, Vdd), V(cpphdl_n888, Vdd), 0.01, 0.69999999999999996, -1.0);
        // device 492, IC IC83, analog/basic/cmos_logic.hpp:19
        I(cpphdl_n888, Vdd) <+ cpphdl_channel(V(cpphdl_n2783, Vdd), V(cpphdl_n888, Vdd), 0.01, 0.69999999999999996, -1.0);
        // device 493, IC IC83, analog/basic/cmos_logic.hpp:20
        I(cpphdl_n888, cpphdl_n889) <+ cpphdl_channel(V(cpphdl_n886, cpphdl_n889), V(cpphdl_n888, cpphdl_n889), 0.01, 0.69999999999999996, 1.0);
        // device 494, IC IC83, analog/basic/cmos_logic.hpp:21
        I(cpphdl_n889, Vss) <+ cpphdl_channel(V(cpphdl_n2783, Vss), V(cpphdl_n889, Vss), 0.01, 0.69999999999999996, 1.0);
        // device 495, IC IC83, analog/basic/cmos_logic.hpp:27
        I(cpphdl_n889, Vss) <+ 1e-14 * ddt(V(cpphdl_n889, Vss)); // Bench initial voltage = 0.0 V.
        // device 496, IC IC81, analog/basic/nand_latch.hpp:36
        I(cpphdl_n880, Vss) <+ 2.9999999999999998e-15 * ddt(V(cpphdl_n880, Vss)); // Bench initial voltage = 0.0 V.
        // device 497, IC IC81, analog/basic/nand_latch.hpp:37
        I(cpphdl_n886, Vss) <+ 2.9999999999999998e-15 * ddt(V(cpphdl_n886, Vss)); // Bench initial voltage = 0.0 V.
        // device 498, IC IC84, analog/basic/inverter.hpp:11
        I(cpphdl_n894, Vdd) <+ cpphdl_channel(V(CLEAR, Vdd), V(cpphdl_n894, Vdd), 0.01, 0.69999999999999996, -1.0);
        // device 499, IC IC84, analog/basic/inverter.hpp:12
        I(cpphdl_n894, Vss) <+ cpphdl_channel(V(CLEAR, Vss), V(cpphdl_n894, Vss), 0.01, 0.69999999999999996, 1.0);
        // device 500, IC IC81, analog/basic/nand_latch.hpp:58
        I(cpphdl_n894, Vss) <+ 2.9999999999999998e-15 * ddt(V(cpphdl_n894, Vss)); // Bench initial voltage = 0.0 V.
        // device 501, IC IC81, analog/basic/nand_latch.hpp:59
        I(cpphdl_n2783, Vss) <+ cpphdl_channel(V(CLEAR, Vss), V(cpphdl_n2783, Vss), 0.050000000000000003, 0.69999999999999996, 1.0);
        // device 502, IC IC81, analog/basic/nand_latch.hpp:60
        I(cpphdl_n888, Vdd) <+ cpphdl_channel(V(cpphdl_n894, Vdd), V(cpphdl_n888, Vdd), 0.050000000000000003, 0.69999999999999996, -1.0);
        // device 503, IC IC87, analog/basic/inverter.hpp:11
        I(cpphdl_n918, Vdd) <+ cpphdl_channel(V(TRACK3, Vdd), V(cpphdl_n918, Vdd), 0.0040000000000000001, 0.69999999999999996, -1.0);
        // device 504, IC IC87, analog/basic/inverter.hpp:12
        I(cpphdl_n918, Vss) <+ cpphdl_channel(V(TRACK3, Vss), V(cpphdl_n918, Vss), 0.0040000000000000001, 0.69999999999999996, 1.0);
        // device 505, IC IC86, analog/basic/mos_track_hold.hpp:31
        I(cpphdl_n918, Vss) <+ 2e-14 * ddt(V(cpphdl_n918, Vss)); // Bench initial voltage = 0.0 V.
        // device 506, IC IC86, analog/basic/mos_track_hold.hpp:32
        I(cpphdl_n2628, cpphdl_n972) <+ cpphdl_channel(V(TRACK3, cpphdl_n972), V(cpphdl_n2628, cpphdl_n972), 0.029999999999999999, 0.69999999999999996, 1.0);
        // device 507, IC IC86, analog/basic/mos_track_hold.hpp:33
        I(cpphdl_n972, cpphdl_n2628) <+ cpphdl_channel(V(cpphdl_n918, cpphdl_n2628), V(cpphdl_n972, cpphdl_n2628), 0.014999999999999999, 0.69999999999999996, -1.0);
        // device 508, IC IC86, analog/basic/mos_track_hold.hpp:37
        I(cpphdl_n972, cpphdl_n972) <+ cpphdl_channel(V(cpphdl_n918, cpphdl_n972), V(cpphdl_n972, cpphdl_n972), 0.016, 0.69999999999999996, 1.0);
        // device 509, IC IC86, analog/basic/mos_track_hold.hpp:38
        I(cpphdl_n972, cpphdl_n972) <+ cpphdl_channel(V(TRACK3, cpphdl_n972), V(cpphdl_n972, cpphdl_n972), 0.0083999999999999995, 0.69999999999999996, -1.0);
        // device 510, IC IC86, analog/basic/mos_track_hold.hpp:39
        I(cpphdl_n972, Vss) <+ 1.5000000000000001e-12 * ddt(V(cpphdl_n972, Vss)); // Bench initial voltage = 0.0 V.
        // device 511, IC IC86, analog/basic/mos_track_hold.hpp:42
        I(TRACK3, cpphdl_n972) <+ 2.0000000000000002e-15 * ddt(V(TRACK3, cpphdl_n972)); // Bench initial voltage = -0.0 V.
        // device 512, IC IC86, analog/basic/mos_track_hold.hpp:43
        I(cpphdl_n918, cpphdl_n972) <+ 2.0000000000000002e-15 * ddt(V(cpphdl_n918, cpphdl_n972)); // Bench initial voltage = 0.0 V.
        // device 513, IC IC86, analog/basic/mos_track_hold.hpp:44
        I(cpphdl_n2628, cpphdl_n972) <+ 1.0000000000000001e-15 * ddt(V(cpphdl_n2628, cpphdl_n972)); // Bench initial voltage = 0.0 V.
        // device 514, IC IC89, analog/basic/inverter.hpp:11
        I(cpphdl_n933, Vdd) <+ cpphdl_channel(V(BIT_N3_0, Vdd), V(cpphdl_n933, Vdd), 0.080000000000000002, 0.69999999999999996, -1.0);
        // device 515, IC IC89, analog/basic/inverter.hpp:12
        I(cpphdl_n933, Vss) <+ cpphdl_channel(V(BIT_N3_0, Vss), V(cpphdl_n933, Vss), 0.080000000000000002, 0.69999999999999996, 1.0);
        // device 516, IC IC88, analog/basic/mos_r2r_dac.hpp:27
        I(cpphdl_n933, Vss) <+ 2.9999999999999998e-15 * ddt(V(cpphdl_n933, Vss)); // Bench initial voltage = 0.0 V.
        // device 517, IC IC88, analog/basic/mos_r2r_dac.hpp:28
        I(cpphdl_n933, cpphdl_n962) <+ V(cpphdl_n933, cpphdl_n962) / 2000.0;
        // device 518, IC IC88, analog/basic/mos_r2r_dac.hpp:29
        I(cpphdl_n962, Vss) <+ 2.9999999999999998e-15 * ddt(V(cpphdl_n962, Vss)); // Bench initial voltage = 0.0 V.
        // device 519, IC IC90, analog/basic/inverter.hpp:11
        I(cpphdl_n937, Vdd) <+ cpphdl_channel(V(BIT_N3_1, Vdd), V(cpphdl_n937, Vdd), 0.080000000000000002, 0.69999999999999996, -1.0);
        // device 520, IC IC90, analog/basic/inverter.hpp:12
        I(cpphdl_n937, Vss) <+ cpphdl_channel(V(BIT_N3_1, Vss), V(cpphdl_n937, Vss), 0.080000000000000002, 0.69999999999999996, 1.0);
        // device 521, IC IC88, analog/basic/mos_r2r_dac.hpp:27
        I(cpphdl_n937, Vss) <+ 2.9999999999999998e-15 * ddt(V(cpphdl_n937, Vss)); // Bench initial voltage = 0.0 V.
        // device 522, IC IC88, analog/basic/mos_r2r_dac.hpp:28
        I(cpphdl_n937, cpphdl_n963) <+ V(cpphdl_n937, cpphdl_n963) / 2000.0;
        // device 523, IC IC88, analog/basic/mos_r2r_dac.hpp:29
        I(cpphdl_n963, Vss) <+ 2.9999999999999998e-15 * ddt(V(cpphdl_n963, Vss)); // Bench initial voltage = 0.0 V.
        // device 524, IC IC88, analog/basic/mos_r2r_dac.hpp:31
        I(cpphdl_n962, cpphdl_n963) <+ V(cpphdl_n962, cpphdl_n963) / 1000.0;
        // device 525, IC IC91, analog/basic/inverter.hpp:11
        I(cpphdl_n941, Vdd) <+ cpphdl_channel(V(BIT_N3_2, Vdd), V(cpphdl_n941, Vdd), 0.080000000000000002, 0.69999999999999996, -1.0);
        // device 526, IC IC91, analog/basic/inverter.hpp:12
        I(cpphdl_n941, Vss) <+ cpphdl_channel(V(BIT_N3_2, Vss), V(cpphdl_n941, Vss), 0.080000000000000002, 0.69999999999999996, 1.0);
        // device 527, IC IC88, analog/basic/mos_r2r_dac.hpp:27
        I(cpphdl_n941, Vss) <+ 2.9999999999999998e-15 * ddt(V(cpphdl_n941, Vss)); // Bench initial voltage = 0.0 V.
        // device 528, IC IC88, analog/basic/mos_r2r_dac.hpp:28
        I(cpphdl_n941, cpphdl_n964) <+ V(cpphdl_n941, cpphdl_n964) / 2000.0;
        // device 529, IC IC88, analog/basic/mos_r2r_dac.hpp:29
        I(cpphdl_n964, Vss) <+ 2.9999999999999998e-15 * ddt(V(cpphdl_n964, Vss)); // Bench initial voltage = 0.0 V.
        // device 530, IC IC88, analog/basic/mos_r2r_dac.hpp:31
        I(cpphdl_n963, cpphdl_n964) <+ V(cpphdl_n963, cpphdl_n964) / 1000.0;
        // device 531, IC IC92, analog/basic/inverter.hpp:11
        I(cpphdl_n945, Vdd) <+ cpphdl_channel(V(BIT_N3_3, Vdd), V(cpphdl_n945, Vdd), 0.080000000000000002, 0.69999999999999996, -1.0);
        // device 532, IC IC92, analog/basic/inverter.hpp:12
        I(cpphdl_n945, Vss) <+ cpphdl_channel(V(BIT_N3_3, Vss), V(cpphdl_n945, Vss), 0.080000000000000002, 0.69999999999999996, 1.0);
        // device 533, IC IC88, analog/basic/mos_r2r_dac.hpp:27
        I(cpphdl_n945, Vss) <+ 2.9999999999999998e-15 * ddt(V(cpphdl_n945, Vss)); // Bench initial voltage = 0.0 V.
        // device 534, IC IC88, analog/basic/mos_r2r_dac.hpp:28
        I(cpphdl_n945, cpphdl_n965) <+ V(cpphdl_n945, cpphdl_n965) / 2000.0;
        // device 535, IC IC88, analog/basic/mos_r2r_dac.hpp:29
        I(cpphdl_n965, Vss) <+ 2.9999999999999998e-15 * ddt(V(cpphdl_n965, Vss)); // Bench initial voltage = 0.0 V.
        // device 536, IC IC88, analog/basic/mos_r2r_dac.hpp:31
        I(cpphdl_n964, cpphdl_n965) <+ V(cpphdl_n964, cpphdl_n965) / 1000.0;
        // device 537, IC IC93, analog/basic/inverter.hpp:11
        I(cpphdl_n949, Vdd) <+ cpphdl_channel(V(BIT_N3_4, Vdd), V(cpphdl_n949, Vdd), 0.080000000000000002, 0.69999999999999996, -1.0);
        // device 538, IC IC93, analog/basic/inverter.hpp:12
        I(cpphdl_n949, Vss) <+ cpphdl_channel(V(BIT_N3_4, Vss), V(cpphdl_n949, Vss), 0.080000000000000002, 0.69999999999999996, 1.0);
        // device 539, IC IC88, analog/basic/mos_r2r_dac.hpp:27
        I(cpphdl_n949, Vss) <+ 2.9999999999999998e-15 * ddt(V(cpphdl_n949, Vss)); // Bench initial voltage = 0.0 V.
        // device 540, IC IC88, analog/basic/mos_r2r_dac.hpp:28
        I(cpphdl_n949, cpphdl_n966) <+ V(cpphdl_n949, cpphdl_n966) / 2000.0;
        // device 541, IC IC88, analog/basic/mos_r2r_dac.hpp:29
        I(cpphdl_n966, Vss) <+ 2.9999999999999998e-15 * ddt(V(cpphdl_n966, Vss)); // Bench initial voltage = 0.0 V.
        // device 542, IC IC88, analog/basic/mos_r2r_dac.hpp:31
        I(cpphdl_n965, cpphdl_n966) <+ V(cpphdl_n965, cpphdl_n966) / 1000.0;
        // device 543, IC IC94, analog/basic/inverter.hpp:11
        I(cpphdl_n953, Vdd) <+ cpphdl_channel(V(BIT_N3_5, Vdd), V(cpphdl_n953, Vdd), 0.080000000000000002, 0.69999999999999996, -1.0);
        // device 544, IC IC94, analog/basic/inverter.hpp:12
        I(cpphdl_n953, Vss) <+ cpphdl_channel(V(BIT_N3_5, Vss), V(cpphdl_n953, Vss), 0.080000000000000002, 0.69999999999999996, 1.0);
        // device 545, IC IC88, analog/basic/mos_r2r_dac.hpp:27
        I(cpphdl_n953, Vss) <+ 2.9999999999999998e-15 * ddt(V(cpphdl_n953, Vss)); // Bench initial voltage = 0.0 V.
        // device 546, IC IC88, analog/basic/mos_r2r_dac.hpp:28
        I(cpphdl_n953, cpphdl_n967) <+ V(cpphdl_n953, cpphdl_n967) / 2000.0;
        // device 547, IC IC88, analog/basic/mos_r2r_dac.hpp:29
        I(cpphdl_n967, Vss) <+ 2.9999999999999998e-15 * ddt(V(cpphdl_n967, Vss)); // Bench initial voltage = 0.0 V.
        // device 548, IC IC88, analog/basic/mos_r2r_dac.hpp:31
        I(cpphdl_n966, cpphdl_n967) <+ V(cpphdl_n966, cpphdl_n967) / 1000.0;
        // device 549, IC IC95, analog/basic/inverter.hpp:11
        I(cpphdl_n957, Vdd) <+ cpphdl_channel(V(BIT_N3_6, Vdd), V(cpphdl_n957, Vdd), 0.080000000000000002, 0.69999999999999996, -1.0);
        // device 550, IC IC95, analog/basic/inverter.hpp:12
        I(cpphdl_n957, Vss) <+ cpphdl_channel(V(BIT_N3_6, Vss), V(cpphdl_n957, Vss), 0.080000000000000002, 0.69999999999999996, 1.0);
        // device 551, IC IC88, analog/basic/mos_r2r_dac.hpp:27
        I(cpphdl_n957, Vss) <+ 2.9999999999999998e-15 * ddt(V(cpphdl_n957, Vss)); // Bench initial voltage = 0.0 V.
        // device 552, IC IC88, analog/basic/mos_r2r_dac.hpp:28
        I(cpphdl_n957, cpphdl_n968) <+ V(cpphdl_n957, cpphdl_n968) / 2000.0;
        // device 553, IC IC88, analog/basic/mos_r2r_dac.hpp:29
        I(cpphdl_n968, Vss) <+ 2.9999999999999998e-15 * ddt(V(cpphdl_n968, Vss)); // Bench initial voltage = 0.0 V.
        // device 554, IC IC88, analog/basic/mos_r2r_dac.hpp:31
        I(cpphdl_n967, cpphdl_n968) <+ V(cpphdl_n967, cpphdl_n968) / 1000.0;
        // device 555, IC IC96, analog/basic/inverter.hpp:11
        I(cpphdl_n961, Vdd) <+ cpphdl_channel(V(BIT_N3_7, Vdd), V(cpphdl_n961, Vdd), 0.080000000000000002, 0.69999999999999996, -1.0);
        // device 556, IC IC96, analog/basic/inverter.hpp:12
        I(cpphdl_n961, Vss) <+ cpphdl_channel(V(BIT_N3_7, Vss), V(cpphdl_n961, Vss), 0.080000000000000002, 0.69999999999999996, 1.0);
        // device 557, IC IC88, analog/basic/mos_r2r_dac.hpp:27
        I(cpphdl_n961, Vss) <+ 2.9999999999999998e-15 * ddt(V(cpphdl_n961, Vss)); // Bench initial voltage = 0.0 V.
        // device 558, IC IC88, analog/basic/mos_r2r_dac.hpp:28
        I(cpphdl_n961, cpphdl_n973) <+ V(cpphdl_n961, cpphdl_n973) / 2000.0;
        // device 559, IC IC88, analog/basic/mos_r2r_dac.hpp:29
        I(cpphdl_n973, Vss) <+ 2.9999999999999998e-15 * ddt(V(cpphdl_n973, Vss)); // Bench initial voltage = 0.0 V.
        // device 560, IC IC88, analog/basic/mos_r2r_dac.hpp:31
        I(cpphdl_n968, cpphdl_n973) <+ V(cpphdl_n968, cpphdl_n973) / 1000.0;
        // device 561, IC IC88, analog/basic/mos_r2r_dac.hpp:33
        I(Vss, cpphdl_n962) <+ V(Vss, cpphdl_n962) / 2000.0;
        // device 562, IC IC97, analog/basic/nmos_resistor_amplifier.hpp:23
        I(Vdd, cpphdl_n982) <+ V(Vdd, cpphdl_n982) / 1000.0;
        // device 563, IC IC97, analog/basic/nmos_resistor_amplifier.hpp:24
        I(Vdd, cpphdl_n981) <+ V(Vdd, cpphdl_n981) / 1000.0;
        // device 564, IC IC97, analog/basic/nmos_resistor_amplifier.hpp:25
        I(cpphdl_n982, cpphdl_n976) <+ cpphdl_channel(V(cpphdl_n972, cpphdl_n976), V(cpphdl_n982, cpphdl_n976), 0.0074999999999999997, 0.69999999999999996, 1.0);
        // device 565, IC IC97, analog/basic/nmos_resistor_amplifier.hpp:26
        I(cpphdl_n981, cpphdl_n977) <+ cpphdl_channel(V(cpphdl_n973, cpphdl_n977), V(cpphdl_n981, cpphdl_n977), 0.0074999999999999997, 0.69999999999999996, 1.0);
        // device 566, IC IC97, analog/basic/nmos_resistor_amplifier.hpp:27
        I(cpphdl_n978, cpphdl_n976) <+ V(cpphdl_n978, cpphdl_n976) / 100.0;
        // device 567, IC IC97, analog/basic/nmos_resistor_amplifier.hpp:28
        I(cpphdl_n978, cpphdl_n977) <+ V(cpphdl_n978, cpphdl_n977) / 100.0;
        // device 568, IC IC97, analog/basic/nmos_resistor_amplifier.hpp:29
        I(Vss, cpphdl_n978) <+ V(Vss, cpphdl_n978) / 300.0;
        // device 569, IC IC97, analog/basic/nmos_resistor_amplifier.hpp:30
        I(cpphdl_n982, Vdd) <+ 2.9999999999999998e-13 * ddt(V(cpphdl_n982, Vdd)); // Bench initial voltage = 0.0 V.
        // device 570, IC IC97, analog/basic/nmos_resistor_amplifier.hpp:31
        I(cpphdl_n981, Vdd) <+ 2.9999999999999998e-13 * ddt(V(cpphdl_n981, Vdd)); // Bench initial voltage = 0.0 V.
        // device 571, IC IC97, analog/basic/nmos_resistor_amplifier.hpp:32
        I(cpphdl_n978, Vss) <+ 4e-14 * ddt(V(cpphdl_n978, Vss)); // Bench initial voltage = 0.0 V.
        // device 572, IC IC97, analog/basic/nmos_resistor_amplifier.hpp:34
        I(cpphdl_n972, cpphdl_n976) <+ 2e-14 * ddt(V(cpphdl_n972, cpphdl_n976)); // Bench initial voltage = 0.0 V.
        // device 573, IC IC97, analog/basic/nmos_resistor_amplifier.hpp:35
        I(cpphdl_n973, cpphdl_n977) <+ 2e-14 * ddt(V(cpphdl_n973, cpphdl_n977)); // Bench initial voltage = 0.0 V.
        // device 574, IC IC97, analog/basic/nmos_resistor_amplifier.hpp:36
        I(cpphdl_n972, cpphdl_n982) <+ 2.9999999999999998e-15 * ddt(V(cpphdl_n972, cpphdl_n982)); // Bench initial voltage = 0.0 V.
        // device 575, IC IC97, analog/basic/nmos_resistor_amplifier.hpp:37
        I(cpphdl_n973, cpphdl_n981) <+ 2.9999999999999998e-15 * ddt(V(cpphdl_n973, cpphdl_n981)); // Bench initial voltage = 0.0 V.
        // device 576, IC IC98, analog/basic/strongarm_comparator.hpp:28
        I(cpphdl_n986, cpphdl_n988) <+ cpphdl_channel(V(cpphdl_n981, cpphdl_n988), V(cpphdl_n986, cpphdl_n988), 0.0080000000000000002, 0.69999999999999996, 1.0);
        // device 577, IC IC98, analog/basic/strongarm_comparator.hpp:29
        I(cpphdl_n987, cpphdl_n988) <+ cpphdl_channel(V(cpphdl_n982, cpphdl_n988), V(cpphdl_n987, cpphdl_n988), 0.0080000000000000002, 0.69999999999999996, 1.0);
        // device 578, IC IC98, analog/basic/strongarm_comparator.hpp:30
        I(cpphdl_n988, Vss) <+ cpphdl_channel(V(EVALUATE, Vss), V(cpphdl_n988, Vss), 0.0080000000000000002, 0.69999999999999996, 1.0);
        // device 579, IC IC98, analog/basic/strongarm_comparator.hpp:33
        I(cpphdl_n1001, cpphdl_n986) <+ cpphdl_channel(V(cpphdl_n1005, cpphdl_n986), V(cpphdl_n1001, cpphdl_n986), 0.0040000000000000001, 0.69999999999999996, 1.0);
        // device 580, IC IC98, analog/basic/strongarm_comparator.hpp:34
        I(cpphdl_n1005, cpphdl_n987) <+ cpphdl_channel(V(cpphdl_n1001, cpphdl_n987), V(cpphdl_n1005, cpphdl_n987), 0.0040000000000000001, 0.69999999999999996, 1.0);
        // device 581, IC IC98, analog/basic/strongarm_comparator.hpp:35
        I(cpphdl_n1005, Vdd) <+ cpphdl_channel(V(cpphdl_n1001, Vdd), V(cpphdl_n1005, Vdd), 0.002, 0.69999999999999996, -1.0);
        // device 582, IC IC98, analog/basic/strongarm_comparator.hpp:36
        I(cpphdl_n1001, Vdd) <+ cpphdl_channel(V(cpphdl_n1005, Vdd), V(cpphdl_n1001, Vdd), 0.002, 0.69999999999999996, -1.0);
        // device 583, IC IC98, analog/basic/strongarm_comparator.hpp:38
        I(cpphdl_n986, Vdd) <+ cpphdl_channel(V(EVALUATE, Vdd), V(cpphdl_n986, Vdd), 0.002, 0.69999999999999996, -1.0);
        // device 584, IC IC98, analog/basic/strongarm_comparator.hpp:39
        I(cpphdl_n987, Vdd) <+ cpphdl_channel(V(EVALUATE, Vdd), V(cpphdl_n987, Vdd), 0.002, 0.69999999999999996, -1.0);
        // device 585, IC IC98, analog/basic/strongarm_comparator.hpp:40
        I(cpphdl_n1005, Vdd) <+ cpphdl_channel(V(EVALUATE, Vdd), V(cpphdl_n1005, Vdd), 0.002, 0.69999999999999996, -1.0);
        // device 586, IC IC98, analog/basic/strongarm_comparator.hpp:41
        I(cpphdl_n1001, Vdd) <+ cpphdl_channel(V(EVALUATE, Vdd), V(cpphdl_n1001, Vdd), 0.002, 0.69999999999999996, -1.0);
        // device 587, IC IC98, analog/basic/strongarm_comparator.hpp:42
        I(cpphdl_n986, Vss) <+ 2.9999999999999998e-14 * ddt(V(cpphdl_n986, Vss)); // Bench initial voltage = 0.0 V.
        // device 588, IC IC98, analog/basic/strongarm_comparator.hpp:43
        I(cpphdl_n987, Vss) <+ 2.9999999999999998e-14 * ddt(V(cpphdl_n987, Vss)); // Bench initial voltage = 0.0 V.
        // device 589, IC IC98, analog/basic/strongarm_comparator.hpp:44
        I(cpphdl_n988, Vss) <+ 2.9999999999999998e-14 * ddt(V(cpphdl_n988, Vss)); // Bench initial voltage = 0.0 V.
        // device 590, IC IC98, analog/basic/strongarm_comparator.hpp:45
        I(cpphdl_n1005, Vss) <+ 5.0000000000000002e-14 * ddt(V(cpphdl_n1005, Vss)); // Bench initial voltage = 0.0 V.
        // device 591, IC IC98, analog/basic/strongarm_comparator.hpp:46
        I(cpphdl_n1001, Vss) <+ 5.0000000000000002e-14 * ddt(V(cpphdl_n1001, Vss)); // Bench initial voltage = 0.0 V.
        // device 592, IC IC98, analog/basic/strongarm_comparator.hpp:47
        I(cpphdl_n981, cpphdl_n988) <+ 2e-14 * ddt(V(cpphdl_n981, cpphdl_n988)); // Bench initial voltage = 0.0 V.
        // device 593, IC IC98, analog/basic/strongarm_comparator.hpp:48
        I(cpphdl_n982, cpphdl_n988) <+ 2e-14 * ddt(V(cpphdl_n982, cpphdl_n988)); // Bench initial voltage = 0.0 V.
        // device 594, IC IC98, analog/basic/strongarm_comparator.hpp:49
        I(cpphdl_n981, cpphdl_n986) <+ 2.9999999999999998e-15 * ddt(V(cpphdl_n981, cpphdl_n986)); // Bench initial voltage = 0.0 V.
        // device 595, IC IC98, analog/basic/strongarm_comparator.hpp:50
        I(cpphdl_n982, cpphdl_n987) <+ 2.9999999999999998e-15 * ddt(V(cpphdl_n982, cpphdl_n987)); // Bench initial voltage = 0.0 V.
        // device 596, IC IC100, analog/basic/inverter.hpp:11
        I(cpphdl_n1009, Vdd) <+ cpphdl_channel(V(cpphdl_n1001, Vdd), V(cpphdl_n1009, Vdd), 0.001, 0.69999999999999996, -1.0);
        // device 597, IC IC100, analog/basic/inverter.hpp:12
        I(cpphdl_n1009, Vss) <+ cpphdl_channel(V(cpphdl_n1001, Vss), V(cpphdl_n1009, Vss), 0.001, 0.69999999999999996, 1.0);
        // device 598, IC IC102, analog/basic/inverter.hpp:11
        I(cpphdl_n1023, Vdd) <+ cpphdl_channel(V(cpphdl_n1009, Vdd), V(cpphdl_n1023, Vdd), 0.0040000000000000001, 0.69999999999999996, -1.0);
        // device 599, IC IC102, analog/basic/inverter.hpp:12
        I(cpphdl_n1023, Vss) <+ cpphdl_channel(V(cpphdl_n1009, Vss), V(cpphdl_n1023, Vss), 0.0040000000000000001, 0.69999999999999996, 1.0);
        // device 600, IC IC99, analog/basic/buffered_nand_latch.hpp:34
        I(cpphdl_n1001, Vss) <+ 2.0000000000000002e-15 * ddt(V(cpphdl_n1001, Vss)); // Bench initial voltage = 0.0 V.
        // device 601, IC IC99, analog/basic/buffered_nand_latch.hpp:35
        I(cpphdl_n1001, cpphdl_n1009) <+ 1.0000000000000001e-15 * ddt(V(cpphdl_n1001, cpphdl_n1009)); // Bench initial voltage = 0.0 V.
        // device 602, IC IC99, analog/basic/buffered_nand_latch.hpp:36
        I(cpphdl_n1009, Vss) <+ 5e-15 * ddt(V(cpphdl_n1009, Vss)); // Bench initial voltage = 0.0 V.
        // device 603, IC IC99, analog/basic/buffered_nand_latch.hpp:37
        I(cpphdl_n1009, Vss) <+ 8.0000000000000006e-15 * ddt(V(cpphdl_n1009, Vss)); // Bench initial voltage = 0.0 V.
        // device 604, IC IC99, analog/basic/buffered_nand_latch.hpp:38
        I(cpphdl_n1023, Vss) <+ 1e-14 * ddt(V(cpphdl_n1023, Vss)); // Bench initial voltage = 0.0 V.
        // device 605, IC IC101, analog/basic/inverter.hpp:11
        I(cpphdl_n1013, Vdd) <+ cpphdl_channel(V(cpphdl_n1005, Vdd), V(cpphdl_n1013, Vdd), 0.001, 0.69999999999999996, -1.0);
        // device 606, IC IC101, analog/basic/inverter.hpp:12
        I(cpphdl_n1013, Vss) <+ cpphdl_channel(V(cpphdl_n1005, Vss), V(cpphdl_n1013, Vss), 0.001, 0.69999999999999996, 1.0);
        // device 607, IC IC103, analog/basic/inverter.hpp:11
        I(cpphdl_n1029, Vdd) <+ cpphdl_channel(V(cpphdl_n1013, Vdd), V(cpphdl_n1029, Vdd), 0.0040000000000000001, 0.69999999999999996, -1.0);
        // device 608, IC IC103, analog/basic/inverter.hpp:12
        I(cpphdl_n1029, Vss) <+ cpphdl_channel(V(cpphdl_n1013, Vss), V(cpphdl_n1029, Vss), 0.0040000000000000001, 0.69999999999999996, 1.0);
        // device 609, IC IC99, analog/basic/buffered_nand_latch.hpp:34
        I(cpphdl_n1005, Vss) <+ 2.0000000000000002e-15 * ddt(V(cpphdl_n1005, Vss)); // Bench initial voltage = 0.0 V.
        // device 610, IC IC99, analog/basic/buffered_nand_latch.hpp:35
        I(cpphdl_n1005, cpphdl_n1013) <+ 1.0000000000000001e-15 * ddt(V(cpphdl_n1005, cpphdl_n1013)); // Bench initial voltage = 0.0 V.
        // device 611, IC IC99, analog/basic/buffered_nand_latch.hpp:36
        I(cpphdl_n1013, Vss) <+ 5e-15 * ddt(V(cpphdl_n1013, Vss)); // Bench initial voltage = 0.0 V.
        // device 612, IC IC99, analog/basic/buffered_nand_latch.hpp:37
        I(cpphdl_n1013, Vss) <+ 8.0000000000000006e-15 * ddt(V(cpphdl_n1013, Vss)); // Bench initial voltage = 0.0 V.
        // device 613, IC IC99, analog/basic/buffered_nand_latch.hpp:38
        I(cpphdl_n1029, Vss) <+ 1e-14 * ddt(V(cpphdl_n1029, Vss)); // Bench initial voltage = 0.0 V.
        // device 614, IC IC105, analog/basic/cmos_logic.hpp:17
        I(cpphdl_n2788, Vss) <+ 5.0000000000000002e-14 * ddt(V(cpphdl_n2788, Vss)); // Bench initial voltage = 0.0 V.
        // device 615, IC IC105, analog/basic/cmos_logic.hpp:18
        I(cpphdl_n2788, Vdd) <+ cpphdl_channel(V(cpphdl_n1023, Vdd), V(cpphdl_n2788, Vdd), 0.01, 0.69999999999999996, -1.0);
        // device 616, IC IC105, analog/basic/cmos_logic.hpp:19
        I(cpphdl_n2788, Vdd) <+ cpphdl_channel(V(cpphdl_n1031, Vdd), V(cpphdl_n2788, Vdd), 0.01, 0.69999999999999996, -1.0);
        // device 617, IC IC105, analog/basic/cmos_logic.hpp:20
        I(cpphdl_n2788, cpphdl_n1026) <+ cpphdl_channel(V(cpphdl_n1023, cpphdl_n1026), V(cpphdl_n2788, cpphdl_n1026), 0.01, 0.69999999999999996, 1.0);
        // device 618, IC IC105, analog/basic/cmos_logic.hpp:21
        I(cpphdl_n1026, Vss) <+ cpphdl_channel(V(cpphdl_n1031, Vss), V(cpphdl_n1026, Vss), 0.01, 0.69999999999999996, 1.0);
        // device 619, IC IC105, analog/basic/cmos_logic.hpp:27
        I(cpphdl_n1026, Vss) <+ 1e-14 * ddt(V(cpphdl_n1026, Vss)); // Bench initial voltage = 0.0 V.
        // device 620, IC IC106, analog/basic/cmos_logic.hpp:17
        I(cpphdl_n1031, Vss) <+ 5.0000000000000002e-14 * ddt(V(cpphdl_n1031, Vss)); // Bench initial voltage = 0.0 V.
        // device 621, IC IC106, analog/basic/cmos_logic.hpp:18
        I(cpphdl_n1031, Vdd) <+ cpphdl_channel(V(cpphdl_n1029, Vdd), V(cpphdl_n1031, Vdd), 0.01, 0.69999999999999996, -1.0);
        // device 622, IC IC106, analog/basic/cmos_logic.hpp:19
        I(cpphdl_n1031, Vdd) <+ cpphdl_channel(V(cpphdl_n2788, Vdd), V(cpphdl_n1031, Vdd), 0.01, 0.69999999999999996, -1.0);
        // device 623, IC IC106, analog/basic/cmos_logic.hpp:20
        I(cpphdl_n1031, cpphdl_n1032) <+ cpphdl_channel(V(cpphdl_n1029, cpphdl_n1032), V(cpphdl_n1031, cpphdl_n1032), 0.01, 0.69999999999999996, 1.0);
        // device 624, IC IC106, analog/basic/cmos_logic.hpp:21
        I(cpphdl_n1032, Vss) <+ cpphdl_channel(V(cpphdl_n2788, Vss), V(cpphdl_n1032, Vss), 0.01, 0.69999999999999996, 1.0);
        // device 625, IC IC106, analog/basic/cmos_logic.hpp:27
        I(cpphdl_n1032, Vss) <+ 1e-14 * ddt(V(cpphdl_n1032, Vss)); // Bench initial voltage = 0.0 V.
        // device 626, IC IC104, analog/basic/nand_latch.hpp:36
        I(cpphdl_n1023, Vss) <+ 2.9999999999999998e-15 * ddt(V(cpphdl_n1023, Vss)); // Bench initial voltage = 0.0 V.
        // device 627, IC IC104, analog/basic/nand_latch.hpp:37
        I(cpphdl_n1029, Vss) <+ 2.9999999999999998e-15 * ddt(V(cpphdl_n1029, Vss)); // Bench initial voltage = 0.0 V.
        // device 628, IC IC107, analog/basic/inverter.hpp:11
        I(cpphdl_n1037, Vdd) <+ cpphdl_channel(V(CLEAR, Vdd), V(cpphdl_n1037, Vdd), 0.01, 0.69999999999999996, -1.0);
        // device 629, IC IC107, analog/basic/inverter.hpp:12
        I(cpphdl_n1037, Vss) <+ cpphdl_channel(V(CLEAR, Vss), V(cpphdl_n1037, Vss), 0.01, 0.69999999999999996, 1.0);
        // device 630, IC IC104, analog/basic/nand_latch.hpp:58
        I(cpphdl_n1037, Vss) <+ 2.9999999999999998e-15 * ddt(V(cpphdl_n1037, Vss)); // Bench initial voltage = 0.0 V.
        // device 631, IC IC104, analog/basic/nand_latch.hpp:59
        I(cpphdl_n2788, Vss) <+ cpphdl_channel(V(CLEAR, Vss), V(cpphdl_n2788, Vss), 0.050000000000000003, 0.69999999999999996, 1.0);
        // device 632, IC IC104, analog/basic/nand_latch.hpp:60
        I(cpphdl_n1031, Vdd) <+ cpphdl_channel(V(cpphdl_n1037, Vdd), V(cpphdl_n1031, Vdd), 0.050000000000000003, 0.69999999999999996, -1.0);
        // device 633, IC IC110, analog/basic/inverter.hpp:11
        I(cpphdl_n1061, Vdd) <+ cpphdl_channel(V(TRACK4, Vdd), V(cpphdl_n1061, Vdd), 0.0040000000000000001, 0.69999999999999996, -1.0);
        // device 634, IC IC110, analog/basic/inverter.hpp:12
        I(cpphdl_n1061, Vss) <+ cpphdl_channel(V(TRACK4, Vss), V(cpphdl_n1061, Vss), 0.0040000000000000001, 0.69999999999999996, 1.0);
        // device 635, IC IC109, analog/basic/mos_track_hold.hpp:31
        I(cpphdl_n1061, Vss) <+ 2e-14 * ddt(V(cpphdl_n1061, Vss)); // Bench initial voltage = 0.0 V.
        // device 636, IC IC109, analog/basic/mos_track_hold.hpp:32
        I(cpphdl_n2628, cpphdl_n1115) <+ cpphdl_channel(V(TRACK4, cpphdl_n1115), V(cpphdl_n2628, cpphdl_n1115), 0.029999999999999999, 0.69999999999999996, 1.0);
        // device 637, IC IC109, analog/basic/mos_track_hold.hpp:33
        I(cpphdl_n1115, cpphdl_n2628) <+ cpphdl_channel(V(cpphdl_n1061, cpphdl_n2628), V(cpphdl_n1115, cpphdl_n2628), 0.014999999999999999, 0.69999999999999996, -1.0);
        // device 638, IC IC109, analog/basic/mos_track_hold.hpp:37
        I(cpphdl_n1115, cpphdl_n1115) <+ cpphdl_channel(V(cpphdl_n1061, cpphdl_n1115), V(cpphdl_n1115, cpphdl_n1115), 0.016, 0.69999999999999996, 1.0);
        // device 639, IC IC109, analog/basic/mos_track_hold.hpp:38
        I(cpphdl_n1115, cpphdl_n1115) <+ cpphdl_channel(V(TRACK4, cpphdl_n1115), V(cpphdl_n1115, cpphdl_n1115), 0.0083999999999999995, 0.69999999999999996, -1.0);
        // device 640, IC IC109, analog/basic/mos_track_hold.hpp:39
        I(cpphdl_n1115, Vss) <+ 1.5000000000000001e-12 * ddt(V(cpphdl_n1115, Vss)); // Bench initial voltage = 0.0 V.
        // device 641, IC IC109, analog/basic/mos_track_hold.hpp:42
        I(TRACK4, cpphdl_n1115) <+ 2.0000000000000002e-15 * ddt(V(TRACK4, cpphdl_n1115)); // Bench initial voltage = -0.0 V.
        // device 642, IC IC109, analog/basic/mos_track_hold.hpp:43
        I(cpphdl_n1061, cpphdl_n1115) <+ 2.0000000000000002e-15 * ddt(V(cpphdl_n1061, cpphdl_n1115)); // Bench initial voltage = 0.0 V.
        // device 643, IC IC109, analog/basic/mos_track_hold.hpp:44
        I(cpphdl_n2628, cpphdl_n1115) <+ 1.0000000000000001e-15 * ddt(V(cpphdl_n2628, cpphdl_n1115)); // Bench initial voltage = 0.0 V.
        // device 644, IC IC112, analog/basic/inverter.hpp:11
        I(cpphdl_n1076, Vdd) <+ cpphdl_channel(V(BIT_N4_0, Vdd), V(cpphdl_n1076, Vdd), 0.080000000000000002, 0.69999999999999996, -1.0);
        // device 645, IC IC112, analog/basic/inverter.hpp:12
        I(cpphdl_n1076, Vss) <+ cpphdl_channel(V(BIT_N4_0, Vss), V(cpphdl_n1076, Vss), 0.080000000000000002, 0.69999999999999996, 1.0);
        // device 646, IC IC111, analog/basic/mos_r2r_dac.hpp:27
        I(cpphdl_n1076, Vss) <+ 2.9999999999999998e-15 * ddt(V(cpphdl_n1076, Vss)); // Bench initial voltage = 0.0 V.
        // device 647, IC IC111, analog/basic/mos_r2r_dac.hpp:28
        I(cpphdl_n1076, cpphdl_n1105) <+ V(cpphdl_n1076, cpphdl_n1105) / 2000.0;
        // device 648, IC IC111, analog/basic/mos_r2r_dac.hpp:29
        I(cpphdl_n1105, Vss) <+ 2.9999999999999998e-15 * ddt(V(cpphdl_n1105, Vss)); // Bench initial voltage = 0.0 V.
        // device 649, IC IC113, analog/basic/inverter.hpp:11
        I(cpphdl_n1080, Vdd) <+ cpphdl_channel(V(BIT_N4_1, Vdd), V(cpphdl_n1080, Vdd), 0.080000000000000002, 0.69999999999999996, -1.0);
        // device 650, IC IC113, analog/basic/inverter.hpp:12
        I(cpphdl_n1080, Vss) <+ cpphdl_channel(V(BIT_N4_1, Vss), V(cpphdl_n1080, Vss), 0.080000000000000002, 0.69999999999999996, 1.0);
        // device 651, IC IC111, analog/basic/mos_r2r_dac.hpp:27
        I(cpphdl_n1080, Vss) <+ 2.9999999999999998e-15 * ddt(V(cpphdl_n1080, Vss)); // Bench initial voltage = 0.0 V.
        // device 652, IC IC111, analog/basic/mos_r2r_dac.hpp:28
        I(cpphdl_n1080, cpphdl_n1106) <+ V(cpphdl_n1080, cpphdl_n1106) / 2000.0;
        // device 653, IC IC111, analog/basic/mos_r2r_dac.hpp:29
        I(cpphdl_n1106, Vss) <+ 2.9999999999999998e-15 * ddt(V(cpphdl_n1106, Vss)); // Bench initial voltage = 0.0 V.
        // device 654, IC IC111, analog/basic/mos_r2r_dac.hpp:31
        I(cpphdl_n1105, cpphdl_n1106) <+ V(cpphdl_n1105, cpphdl_n1106) / 1000.0;
        // device 655, IC IC114, analog/basic/inverter.hpp:11
        I(cpphdl_n1084, Vdd) <+ cpphdl_channel(V(BIT_N4_2, Vdd), V(cpphdl_n1084, Vdd), 0.080000000000000002, 0.69999999999999996, -1.0);
        // device 656, IC IC114, analog/basic/inverter.hpp:12
        I(cpphdl_n1084, Vss) <+ cpphdl_channel(V(BIT_N4_2, Vss), V(cpphdl_n1084, Vss), 0.080000000000000002, 0.69999999999999996, 1.0);
        // device 657, IC IC111, analog/basic/mos_r2r_dac.hpp:27
        I(cpphdl_n1084, Vss) <+ 2.9999999999999998e-15 * ddt(V(cpphdl_n1084, Vss)); // Bench initial voltage = 0.0 V.
        // device 658, IC IC111, analog/basic/mos_r2r_dac.hpp:28
        I(cpphdl_n1084, cpphdl_n1107) <+ V(cpphdl_n1084, cpphdl_n1107) / 2000.0;
        // device 659, IC IC111, analog/basic/mos_r2r_dac.hpp:29
        I(cpphdl_n1107, Vss) <+ 2.9999999999999998e-15 * ddt(V(cpphdl_n1107, Vss)); // Bench initial voltage = 0.0 V.
        // device 660, IC IC111, analog/basic/mos_r2r_dac.hpp:31
        I(cpphdl_n1106, cpphdl_n1107) <+ V(cpphdl_n1106, cpphdl_n1107) / 1000.0;
        // device 661, IC IC115, analog/basic/inverter.hpp:11
        I(cpphdl_n1088, Vdd) <+ cpphdl_channel(V(BIT_N4_3, Vdd), V(cpphdl_n1088, Vdd), 0.080000000000000002, 0.69999999999999996, -1.0);
        // device 662, IC IC115, analog/basic/inverter.hpp:12
        I(cpphdl_n1088, Vss) <+ cpphdl_channel(V(BIT_N4_3, Vss), V(cpphdl_n1088, Vss), 0.080000000000000002, 0.69999999999999996, 1.0);
        // device 663, IC IC111, analog/basic/mos_r2r_dac.hpp:27
        I(cpphdl_n1088, Vss) <+ 2.9999999999999998e-15 * ddt(V(cpphdl_n1088, Vss)); // Bench initial voltage = 0.0 V.
        // device 664, IC IC111, analog/basic/mos_r2r_dac.hpp:28
        I(cpphdl_n1088, cpphdl_n1108) <+ V(cpphdl_n1088, cpphdl_n1108) / 2000.0;
        // device 665, IC IC111, analog/basic/mos_r2r_dac.hpp:29
        I(cpphdl_n1108, Vss) <+ 2.9999999999999998e-15 * ddt(V(cpphdl_n1108, Vss)); // Bench initial voltage = 0.0 V.
        // device 666, IC IC111, analog/basic/mos_r2r_dac.hpp:31
        I(cpphdl_n1107, cpphdl_n1108) <+ V(cpphdl_n1107, cpphdl_n1108) / 1000.0;
        // device 667, IC IC116, analog/basic/inverter.hpp:11
        I(cpphdl_n1092, Vdd) <+ cpphdl_channel(V(BIT_N4_4, Vdd), V(cpphdl_n1092, Vdd), 0.080000000000000002, 0.69999999999999996, -1.0);
        // device 668, IC IC116, analog/basic/inverter.hpp:12
        I(cpphdl_n1092, Vss) <+ cpphdl_channel(V(BIT_N4_4, Vss), V(cpphdl_n1092, Vss), 0.080000000000000002, 0.69999999999999996, 1.0);
        // device 669, IC IC111, analog/basic/mos_r2r_dac.hpp:27
        I(cpphdl_n1092, Vss) <+ 2.9999999999999998e-15 * ddt(V(cpphdl_n1092, Vss)); // Bench initial voltage = 0.0 V.
        // device 670, IC IC111, analog/basic/mos_r2r_dac.hpp:28
        I(cpphdl_n1092, cpphdl_n1109) <+ V(cpphdl_n1092, cpphdl_n1109) / 2000.0;
        // device 671, IC IC111, analog/basic/mos_r2r_dac.hpp:29
        I(cpphdl_n1109, Vss) <+ 2.9999999999999998e-15 * ddt(V(cpphdl_n1109, Vss)); // Bench initial voltage = 0.0 V.
        // device 672, IC IC111, analog/basic/mos_r2r_dac.hpp:31
        I(cpphdl_n1108, cpphdl_n1109) <+ V(cpphdl_n1108, cpphdl_n1109) / 1000.0;
        // device 673, IC IC117, analog/basic/inverter.hpp:11
        I(cpphdl_n1096, Vdd) <+ cpphdl_channel(V(BIT_N4_5, Vdd), V(cpphdl_n1096, Vdd), 0.080000000000000002, 0.69999999999999996, -1.0);
        // device 674, IC IC117, analog/basic/inverter.hpp:12
        I(cpphdl_n1096, Vss) <+ cpphdl_channel(V(BIT_N4_5, Vss), V(cpphdl_n1096, Vss), 0.080000000000000002, 0.69999999999999996, 1.0);
        // device 675, IC IC111, analog/basic/mos_r2r_dac.hpp:27
        I(cpphdl_n1096, Vss) <+ 2.9999999999999998e-15 * ddt(V(cpphdl_n1096, Vss)); // Bench initial voltage = 0.0 V.
        // device 676, IC IC111, analog/basic/mos_r2r_dac.hpp:28
        I(cpphdl_n1096, cpphdl_n1110) <+ V(cpphdl_n1096, cpphdl_n1110) / 2000.0;
        // device 677, IC IC111, analog/basic/mos_r2r_dac.hpp:29
        I(cpphdl_n1110, Vss) <+ 2.9999999999999998e-15 * ddt(V(cpphdl_n1110, Vss)); // Bench initial voltage = 0.0 V.
        // device 678, IC IC111, analog/basic/mos_r2r_dac.hpp:31
        I(cpphdl_n1109, cpphdl_n1110) <+ V(cpphdl_n1109, cpphdl_n1110) / 1000.0;
        // device 679, IC IC118, analog/basic/inverter.hpp:11
        I(cpphdl_n1100, Vdd) <+ cpphdl_channel(V(BIT_N4_6, Vdd), V(cpphdl_n1100, Vdd), 0.080000000000000002, 0.69999999999999996, -1.0);
        // device 680, IC IC118, analog/basic/inverter.hpp:12
        I(cpphdl_n1100, Vss) <+ cpphdl_channel(V(BIT_N4_6, Vss), V(cpphdl_n1100, Vss), 0.080000000000000002, 0.69999999999999996, 1.0);
        // device 681, IC IC111, analog/basic/mos_r2r_dac.hpp:27
        I(cpphdl_n1100, Vss) <+ 2.9999999999999998e-15 * ddt(V(cpphdl_n1100, Vss)); // Bench initial voltage = 0.0 V.
        // device 682, IC IC111, analog/basic/mos_r2r_dac.hpp:28
        I(cpphdl_n1100, cpphdl_n1111) <+ V(cpphdl_n1100, cpphdl_n1111) / 2000.0;
        // device 683, IC IC111, analog/basic/mos_r2r_dac.hpp:29
        I(cpphdl_n1111, Vss) <+ 2.9999999999999998e-15 * ddt(V(cpphdl_n1111, Vss)); // Bench initial voltage = 0.0 V.
        // device 684, IC IC111, analog/basic/mos_r2r_dac.hpp:31
        I(cpphdl_n1110, cpphdl_n1111) <+ V(cpphdl_n1110, cpphdl_n1111) / 1000.0;
        // device 685, IC IC119, analog/basic/inverter.hpp:11
        I(cpphdl_n1104, Vdd) <+ cpphdl_channel(V(BIT_N4_7, Vdd), V(cpphdl_n1104, Vdd), 0.080000000000000002, 0.69999999999999996, -1.0);
        // device 686, IC IC119, analog/basic/inverter.hpp:12
        I(cpphdl_n1104, Vss) <+ cpphdl_channel(V(BIT_N4_7, Vss), V(cpphdl_n1104, Vss), 0.080000000000000002, 0.69999999999999996, 1.0);
        // device 687, IC IC111, analog/basic/mos_r2r_dac.hpp:27
        I(cpphdl_n1104, Vss) <+ 2.9999999999999998e-15 * ddt(V(cpphdl_n1104, Vss)); // Bench initial voltage = 0.0 V.
        // device 688, IC IC111, analog/basic/mos_r2r_dac.hpp:28
        I(cpphdl_n1104, cpphdl_n1116) <+ V(cpphdl_n1104, cpphdl_n1116) / 2000.0;
        // device 689, IC IC111, analog/basic/mos_r2r_dac.hpp:29
        I(cpphdl_n1116, Vss) <+ 2.9999999999999998e-15 * ddt(V(cpphdl_n1116, Vss)); // Bench initial voltage = 0.0 V.
        // device 690, IC IC111, analog/basic/mos_r2r_dac.hpp:31
        I(cpphdl_n1111, cpphdl_n1116) <+ V(cpphdl_n1111, cpphdl_n1116) / 1000.0;
        // device 691, IC IC111, analog/basic/mos_r2r_dac.hpp:33
        I(Vss, cpphdl_n1105) <+ V(Vss, cpphdl_n1105) / 2000.0;
        // device 692, IC IC120, analog/basic/nmos_resistor_amplifier.hpp:23
        I(Vdd, cpphdl_n1125) <+ V(Vdd, cpphdl_n1125) / 1000.0;
        // device 693, IC IC120, analog/basic/nmos_resistor_amplifier.hpp:24
        I(Vdd, cpphdl_n1124) <+ V(Vdd, cpphdl_n1124) / 1000.0;
        // device 694, IC IC120, analog/basic/nmos_resistor_amplifier.hpp:25
        I(cpphdl_n1125, cpphdl_n1119) <+ cpphdl_channel(V(cpphdl_n1115, cpphdl_n1119), V(cpphdl_n1125, cpphdl_n1119), 0.0074999999999999997, 0.69999999999999996, 1.0);
        // device 695, IC IC120, analog/basic/nmos_resistor_amplifier.hpp:26
        I(cpphdl_n1124, cpphdl_n1120) <+ cpphdl_channel(V(cpphdl_n1116, cpphdl_n1120), V(cpphdl_n1124, cpphdl_n1120), 0.0074999999999999997, 0.69999999999999996, 1.0);
        // device 696, IC IC120, analog/basic/nmos_resistor_amplifier.hpp:27
        I(cpphdl_n1121, cpphdl_n1119) <+ V(cpphdl_n1121, cpphdl_n1119) / 100.0;
        // device 697, IC IC120, analog/basic/nmos_resistor_amplifier.hpp:28
        I(cpphdl_n1121, cpphdl_n1120) <+ V(cpphdl_n1121, cpphdl_n1120) / 100.0;
        // device 698, IC IC120, analog/basic/nmos_resistor_amplifier.hpp:29
        I(Vss, cpphdl_n1121) <+ V(Vss, cpphdl_n1121) / 300.0;
        // device 699, IC IC120, analog/basic/nmos_resistor_amplifier.hpp:30
        I(cpphdl_n1125, Vdd) <+ 2.9999999999999998e-13 * ddt(V(cpphdl_n1125, Vdd)); // Bench initial voltage = 0.0 V.
        // device 700, IC IC120, analog/basic/nmos_resistor_amplifier.hpp:31
        I(cpphdl_n1124, Vdd) <+ 2.9999999999999998e-13 * ddt(V(cpphdl_n1124, Vdd)); // Bench initial voltage = 0.0 V.
        // device 701, IC IC120, analog/basic/nmos_resistor_amplifier.hpp:32
        I(cpphdl_n1121, Vss) <+ 4e-14 * ddt(V(cpphdl_n1121, Vss)); // Bench initial voltage = 0.0 V.
        // device 702, IC IC120, analog/basic/nmos_resistor_amplifier.hpp:34
        I(cpphdl_n1115, cpphdl_n1119) <+ 2e-14 * ddt(V(cpphdl_n1115, cpphdl_n1119)); // Bench initial voltage = 0.0 V.
        // device 703, IC IC120, analog/basic/nmos_resistor_amplifier.hpp:35
        I(cpphdl_n1116, cpphdl_n1120) <+ 2e-14 * ddt(V(cpphdl_n1116, cpphdl_n1120)); // Bench initial voltage = 0.0 V.
        // device 704, IC IC120, analog/basic/nmos_resistor_amplifier.hpp:36
        I(cpphdl_n1115, cpphdl_n1125) <+ 2.9999999999999998e-15 * ddt(V(cpphdl_n1115, cpphdl_n1125)); // Bench initial voltage = 0.0 V.
        // device 705, IC IC120, analog/basic/nmos_resistor_amplifier.hpp:37
        I(cpphdl_n1116, cpphdl_n1124) <+ 2.9999999999999998e-15 * ddt(V(cpphdl_n1116, cpphdl_n1124)); // Bench initial voltage = 0.0 V.
        // device 706, IC IC121, analog/basic/strongarm_comparator.hpp:28
        I(cpphdl_n1129, cpphdl_n1131) <+ cpphdl_channel(V(cpphdl_n1124, cpphdl_n1131), V(cpphdl_n1129, cpphdl_n1131), 0.0080000000000000002, 0.69999999999999996, 1.0);
        // device 707, IC IC121, analog/basic/strongarm_comparator.hpp:29
        I(cpphdl_n1130, cpphdl_n1131) <+ cpphdl_channel(V(cpphdl_n1125, cpphdl_n1131), V(cpphdl_n1130, cpphdl_n1131), 0.0080000000000000002, 0.69999999999999996, 1.0);
        // device 708, IC IC121, analog/basic/strongarm_comparator.hpp:30
        I(cpphdl_n1131, Vss) <+ cpphdl_channel(V(EVALUATE, Vss), V(cpphdl_n1131, Vss), 0.0080000000000000002, 0.69999999999999996, 1.0);
        // device 709, IC IC121, analog/basic/strongarm_comparator.hpp:33
        I(cpphdl_n1144, cpphdl_n1129) <+ cpphdl_channel(V(cpphdl_n1148, cpphdl_n1129), V(cpphdl_n1144, cpphdl_n1129), 0.0040000000000000001, 0.69999999999999996, 1.0);
        // device 710, IC IC121, analog/basic/strongarm_comparator.hpp:34
        I(cpphdl_n1148, cpphdl_n1130) <+ cpphdl_channel(V(cpphdl_n1144, cpphdl_n1130), V(cpphdl_n1148, cpphdl_n1130), 0.0040000000000000001, 0.69999999999999996, 1.0);
        // device 711, IC IC121, analog/basic/strongarm_comparator.hpp:35
        I(cpphdl_n1148, Vdd) <+ cpphdl_channel(V(cpphdl_n1144, Vdd), V(cpphdl_n1148, Vdd), 0.002, 0.69999999999999996, -1.0);
        // device 712, IC IC121, analog/basic/strongarm_comparator.hpp:36
        I(cpphdl_n1144, Vdd) <+ cpphdl_channel(V(cpphdl_n1148, Vdd), V(cpphdl_n1144, Vdd), 0.002, 0.69999999999999996, -1.0);
        // device 713, IC IC121, analog/basic/strongarm_comparator.hpp:38
        I(cpphdl_n1129, Vdd) <+ cpphdl_channel(V(EVALUATE, Vdd), V(cpphdl_n1129, Vdd), 0.002, 0.69999999999999996, -1.0);
        // device 714, IC IC121, analog/basic/strongarm_comparator.hpp:39
        I(cpphdl_n1130, Vdd) <+ cpphdl_channel(V(EVALUATE, Vdd), V(cpphdl_n1130, Vdd), 0.002, 0.69999999999999996, -1.0);
        // device 715, IC IC121, analog/basic/strongarm_comparator.hpp:40
        I(cpphdl_n1148, Vdd) <+ cpphdl_channel(V(EVALUATE, Vdd), V(cpphdl_n1148, Vdd), 0.002, 0.69999999999999996, -1.0);
        // device 716, IC IC121, analog/basic/strongarm_comparator.hpp:41
        I(cpphdl_n1144, Vdd) <+ cpphdl_channel(V(EVALUATE, Vdd), V(cpphdl_n1144, Vdd), 0.002, 0.69999999999999996, -1.0);
        // device 717, IC IC121, analog/basic/strongarm_comparator.hpp:42
        I(cpphdl_n1129, Vss) <+ 2.9999999999999998e-14 * ddt(V(cpphdl_n1129, Vss)); // Bench initial voltage = 0.0 V.
        // device 718, IC IC121, analog/basic/strongarm_comparator.hpp:43
        I(cpphdl_n1130, Vss) <+ 2.9999999999999998e-14 * ddt(V(cpphdl_n1130, Vss)); // Bench initial voltage = 0.0 V.
        // device 719, IC IC121, analog/basic/strongarm_comparator.hpp:44
        I(cpphdl_n1131, Vss) <+ 2.9999999999999998e-14 * ddt(V(cpphdl_n1131, Vss)); // Bench initial voltage = 0.0 V.
        // device 720, IC IC121, analog/basic/strongarm_comparator.hpp:45
        I(cpphdl_n1148, Vss) <+ 5.0000000000000002e-14 * ddt(V(cpphdl_n1148, Vss)); // Bench initial voltage = 0.0 V.
        // device 721, IC IC121, analog/basic/strongarm_comparator.hpp:46
        I(cpphdl_n1144, Vss) <+ 5.0000000000000002e-14 * ddt(V(cpphdl_n1144, Vss)); // Bench initial voltage = 0.0 V.
        // device 722, IC IC121, analog/basic/strongarm_comparator.hpp:47
        I(cpphdl_n1124, cpphdl_n1131) <+ 2e-14 * ddt(V(cpphdl_n1124, cpphdl_n1131)); // Bench initial voltage = 0.0 V.
        // device 723, IC IC121, analog/basic/strongarm_comparator.hpp:48
        I(cpphdl_n1125, cpphdl_n1131) <+ 2e-14 * ddt(V(cpphdl_n1125, cpphdl_n1131)); // Bench initial voltage = 0.0 V.
        // device 724, IC IC121, analog/basic/strongarm_comparator.hpp:49
        I(cpphdl_n1124, cpphdl_n1129) <+ 2.9999999999999998e-15 * ddt(V(cpphdl_n1124, cpphdl_n1129)); // Bench initial voltage = 0.0 V.
        // device 725, IC IC121, analog/basic/strongarm_comparator.hpp:50
        I(cpphdl_n1125, cpphdl_n1130) <+ 2.9999999999999998e-15 * ddt(V(cpphdl_n1125, cpphdl_n1130)); // Bench initial voltage = 0.0 V.
        // device 726, IC IC123, analog/basic/inverter.hpp:11
        I(cpphdl_n1152, Vdd) <+ cpphdl_channel(V(cpphdl_n1144, Vdd), V(cpphdl_n1152, Vdd), 0.001, 0.69999999999999996, -1.0);
        // device 727, IC IC123, analog/basic/inverter.hpp:12
        I(cpphdl_n1152, Vss) <+ cpphdl_channel(V(cpphdl_n1144, Vss), V(cpphdl_n1152, Vss), 0.001, 0.69999999999999996, 1.0);
        // device 728, IC IC125, analog/basic/inverter.hpp:11
        I(cpphdl_n1166, Vdd) <+ cpphdl_channel(V(cpphdl_n1152, Vdd), V(cpphdl_n1166, Vdd), 0.0040000000000000001, 0.69999999999999996, -1.0);
        // device 729, IC IC125, analog/basic/inverter.hpp:12
        I(cpphdl_n1166, Vss) <+ cpphdl_channel(V(cpphdl_n1152, Vss), V(cpphdl_n1166, Vss), 0.0040000000000000001, 0.69999999999999996, 1.0);
        // device 730, IC IC122, analog/basic/buffered_nand_latch.hpp:34
        I(cpphdl_n1144, Vss) <+ 2.0000000000000002e-15 * ddt(V(cpphdl_n1144, Vss)); // Bench initial voltage = 0.0 V.
        // device 731, IC IC122, analog/basic/buffered_nand_latch.hpp:35
        I(cpphdl_n1144, cpphdl_n1152) <+ 1.0000000000000001e-15 * ddt(V(cpphdl_n1144, cpphdl_n1152)); // Bench initial voltage = 0.0 V.
        // device 732, IC IC122, analog/basic/buffered_nand_latch.hpp:36
        I(cpphdl_n1152, Vss) <+ 5e-15 * ddt(V(cpphdl_n1152, Vss)); // Bench initial voltage = 0.0 V.
        // device 733, IC IC122, analog/basic/buffered_nand_latch.hpp:37
        I(cpphdl_n1152, Vss) <+ 8.0000000000000006e-15 * ddt(V(cpphdl_n1152, Vss)); // Bench initial voltage = 0.0 V.
        // device 734, IC IC122, analog/basic/buffered_nand_latch.hpp:38
        I(cpphdl_n1166, Vss) <+ 1e-14 * ddt(V(cpphdl_n1166, Vss)); // Bench initial voltage = 0.0 V.
        // device 735, IC IC124, analog/basic/inverter.hpp:11
        I(cpphdl_n1156, Vdd) <+ cpphdl_channel(V(cpphdl_n1148, Vdd), V(cpphdl_n1156, Vdd), 0.001, 0.69999999999999996, -1.0);
        // device 736, IC IC124, analog/basic/inverter.hpp:12
        I(cpphdl_n1156, Vss) <+ cpphdl_channel(V(cpphdl_n1148, Vss), V(cpphdl_n1156, Vss), 0.001, 0.69999999999999996, 1.0);
        // device 737, IC IC126, analog/basic/inverter.hpp:11
        I(cpphdl_n1172, Vdd) <+ cpphdl_channel(V(cpphdl_n1156, Vdd), V(cpphdl_n1172, Vdd), 0.0040000000000000001, 0.69999999999999996, -1.0);
        // device 738, IC IC126, analog/basic/inverter.hpp:12
        I(cpphdl_n1172, Vss) <+ cpphdl_channel(V(cpphdl_n1156, Vss), V(cpphdl_n1172, Vss), 0.0040000000000000001, 0.69999999999999996, 1.0);
        // device 739, IC IC122, analog/basic/buffered_nand_latch.hpp:34
        I(cpphdl_n1148, Vss) <+ 2.0000000000000002e-15 * ddt(V(cpphdl_n1148, Vss)); // Bench initial voltage = 0.0 V.
        // device 740, IC IC122, analog/basic/buffered_nand_latch.hpp:35
        I(cpphdl_n1148, cpphdl_n1156) <+ 1.0000000000000001e-15 * ddt(V(cpphdl_n1148, cpphdl_n1156)); // Bench initial voltage = 0.0 V.
        // device 741, IC IC122, analog/basic/buffered_nand_latch.hpp:36
        I(cpphdl_n1156, Vss) <+ 5e-15 * ddt(V(cpphdl_n1156, Vss)); // Bench initial voltage = 0.0 V.
        // device 742, IC IC122, analog/basic/buffered_nand_latch.hpp:37
        I(cpphdl_n1156, Vss) <+ 8.0000000000000006e-15 * ddt(V(cpphdl_n1156, Vss)); // Bench initial voltage = 0.0 V.
        // device 743, IC IC122, analog/basic/buffered_nand_latch.hpp:38
        I(cpphdl_n1172, Vss) <+ 1e-14 * ddt(V(cpphdl_n1172, Vss)); // Bench initial voltage = 0.0 V.
        // device 744, IC IC128, analog/basic/cmos_logic.hpp:17
        I(cpphdl_n2793, Vss) <+ 5.0000000000000002e-14 * ddt(V(cpphdl_n2793, Vss)); // Bench initial voltage = 0.0 V.
        // device 745, IC IC128, analog/basic/cmos_logic.hpp:18
        I(cpphdl_n2793, Vdd) <+ cpphdl_channel(V(cpphdl_n1166, Vdd), V(cpphdl_n2793, Vdd), 0.01, 0.69999999999999996, -1.0);
        // device 746, IC IC128, analog/basic/cmos_logic.hpp:19
        I(cpphdl_n2793, Vdd) <+ cpphdl_channel(V(cpphdl_n1174, Vdd), V(cpphdl_n2793, Vdd), 0.01, 0.69999999999999996, -1.0);
        // device 747, IC IC128, analog/basic/cmos_logic.hpp:20
        I(cpphdl_n2793, cpphdl_n1169) <+ cpphdl_channel(V(cpphdl_n1166, cpphdl_n1169), V(cpphdl_n2793, cpphdl_n1169), 0.01, 0.69999999999999996, 1.0);
        // device 748, IC IC128, analog/basic/cmos_logic.hpp:21
        I(cpphdl_n1169, Vss) <+ cpphdl_channel(V(cpphdl_n1174, Vss), V(cpphdl_n1169, Vss), 0.01, 0.69999999999999996, 1.0);
        // device 749, IC IC128, analog/basic/cmos_logic.hpp:27
        I(cpphdl_n1169, Vss) <+ 1e-14 * ddt(V(cpphdl_n1169, Vss)); // Bench initial voltage = 0.0 V.
        // device 750, IC IC129, analog/basic/cmos_logic.hpp:17
        I(cpphdl_n1174, Vss) <+ 5.0000000000000002e-14 * ddt(V(cpphdl_n1174, Vss)); // Bench initial voltage = 0.0 V.
        // device 751, IC IC129, analog/basic/cmos_logic.hpp:18
        I(cpphdl_n1174, Vdd) <+ cpphdl_channel(V(cpphdl_n1172, Vdd), V(cpphdl_n1174, Vdd), 0.01, 0.69999999999999996, -1.0);
        // device 752, IC IC129, analog/basic/cmos_logic.hpp:19
        I(cpphdl_n1174, Vdd) <+ cpphdl_channel(V(cpphdl_n2793, Vdd), V(cpphdl_n1174, Vdd), 0.01, 0.69999999999999996, -1.0);
        // device 753, IC IC129, analog/basic/cmos_logic.hpp:20
        I(cpphdl_n1174, cpphdl_n1175) <+ cpphdl_channel(V(cpphdl_n1172, cpphdl_n1175), V(cpphdl_n1174, cpphdl_n1175), 0.01, 0.69999999999999996, 1.0);
        // device 754, IC IC129, analog/basic/cmos_logic.hpp:21
        I(cpphdl_n1175, Vss) <+ cpphdl_channel(V(cpphdl_n2793, Vss), V(cpphdl_n1175, Vss), 0.01, 0.69999999999999996, 1.0);
        // device 755, IC IC129, analog/basic/cmos_logic.hpp:27
        I(cpphdl_n1175, Vss) <+ 1e-14 * ddt(V(cpphdl_n1175, Vss)); // Bench initial voltage = 0.0 V.
        // device 756, IC IC127, analog/basic/nand_latch.hpp:36
        I(cpphdl_n1166, Vss) <+ 2.9999999999999998e-15 * ddt(V(cpphdl_n1166, Vss)); // Bench initial voltage = 0.0 V.
        // device 757, IC IC127, analog/basic/nand_latch.hpp:37
        I(cpphdl_n1172, Vss) <+ 2.9999999999999998e-15 * ddt(V(cpphdl_n1172, Vss)); // Bench initial voltage = 0.0 V.
        // device 758, IC IC130, analog/basic/inverter.hpp:11
        I(cpphdl_n1180, Vdd) <+ cpphdl_channel(V(CLEAR, Vdd), V(cpphdl_n1180, Vdd), 0.01, 0.69999999999999996, -1.0);
        // device 759, IC IC130, analog/basic/inverter.hpp:12
        I(cpphdl_n1180, Vss) <+ cpphdl_channel(V(CLEAR, Vss), V(cpphdl_n1180, Vss), 0.01, 0.69999999999999996, 1.0);
        // device 760, IC IC127, analog/basic/nand_latch.hpp:58
        I(cpphdl_n1180, Vss) <+ 2.9999999999999998e-15 * ddt(V(cpphdl_n1180, Vss)); // Bench initial voltage = 0.0 V.
        // device 761, IC IC127, analog/basic/nand_latch.hpp:59
        I(cpphdl_n2793, Vss) <+ cpphdl_channel(V(CLEAR, Vss), V(cpphdl_n2793, Vss), 0.050000000000000003, 0.69999999999999996, 1.0);
        // device 762, IC IC127, analog/basic/nand_latch.hpp:60
        I(cpphdl_n1174, Vdd) <+ cpphdl_channel(V(cpphdl_n1180, Vdd), V(cpphdl_n1174, Vdd), 0.050000000000000003, 0.69999999999999996, -1.0);
        // device 763, IC IC133, analog/basic/inverter.hpp:11
        I(cpphdl_n1204, Vdd) <+ cpphdl_channel(V(TRACK5, Vdd), V(cpphdl_n1204, Vdd), 0.0040000000000000001, 0.69999999999999996, -1.0);
        // device 764, IC IC133, analog/basic/inverter.hpp:12
        I(cpphdl_n1204, Vss) <+ cpphdl_channel(V(TRACK5, Vss), V(cpphdl_n1204, Vss), 0.0040000000000000001, 0.69999999999999996, 1.0);
        // device 765, IC IC132, analog/basic/mos_track_hold.hpp:31
        I(cpphdl_n1204, Vss) <+ 2e-14 * ddt(V(cpphdl_n1204, Vss)); // Bench initial voltage = 0.0 V.
        // device 766, IC IC132, analog/basic/mos_track_hold.hpp:32
        I(cpphdl_n2628, cpphdl_n1258) <+ cpphdl_channel(V(TRACK5, cpphdl_n1258), V(cpphdl_n2628, cpphdl_n1258), 0.029999999999999999, 0.69999999999999996, 1.0);
        // device 767, IC IC132, analog/basic/mos_track_hold.hpp:33
        I(cpphdl_n1258, cpphdl_n2628) <+ cpphdl_channel(V(cpphdl_n1204, cpphdl_n2628), V(cpphdl_n1258, cpphdl_n2628), 0.014999999999999999, 0.69999999999999996, -1.0);
        // device 768, IC IC132, analog/basic/mos_track_hold.hpp:37
        I(cpphdl_n1258, cpphdl_n1258) <+ cpphdl_channel(V(cpphdl_n1204, cpphdl_n1258), V(cpphdl_n1258, cpphdl_n1258), 0.016, 0.69999999999999996, 1.0);
        // device 769, IC IC132, analog/basic/mos_track_hold.hpp:38
        I(cpphdl_n1258, cpphdl_n1258) <+ cpphdl_channel(V(TRACK5, cpphdl_n1258), V(cpphdl_n1258, cpphdl_n1258), 0.0083999999999999995, 0.69999999999999996, -1.0);
        // device 770, IC IC132, analog/basic/mos_track_hold.hpp:39
        I(cpphdl_n1258, Vss) <+ 1.5000000000000001e-12 * ddt(V(cpphdl_n1258, Vss)); // Bench initial voltage = 0.0 V.
        // device 771, IC IC132, analog/basic/mos_track_hold.hpp:42
        I(TRACK5, cpphdl_n1258) <+ 2.0000000000000002e-15 * ddt(V(TRACK5, cpphdl_n1258)); // Bench initial voltage = -0.0 V.
        // device 772, IC IC132, analog/basic/mos_track_hold.hpp:43
        I(cpphdl_n1204, cpphdl_n1258) <+ 2.0000000000000002e-15 * ddt(V(cpphdl_n1204, cpphdl_n1258)); // Bench initial voltage = 0.0 V.
        // device 773, IC IC132, analog/basic/mos_track_hold.hpp:44
        I(cpphdl_n2628, cpphdl_n1258) <+ 1.0000000000000001e-15 * ddt(V(cpphdl_n2628, cpphdl_n1258)); // Bench initial voltage = 0.0 V.
        // device 774, IC IC135, analog/basic/inverter.hpp:11
        I(cpphdl_n1219, Vdd) <+ cpphdl_channel(V(BIT_N5_0, Vdd), V(cpphdl_n1219, Vdd), 0.080000000000000002, 0.69999999999999996, -1.0);
        // device 775, IC IC135, analog/basic/inverter.hpp:12
        I(cpphdl_n1219, Vss) <+ cpphdl_channel(V(BIT_N5_0, Vss), V(cpphdl_n1219, Vss), 0.080000000000000002, 0.69999999999999996, 1.0);
        // device 776, IC IC134, analog/basic/mos_r2r_dac.hpp:27
        I(cpphdl_n1219, Vss) <+ 2.9999999999999998e-15 * ddt(V(cpphdl_n1219, Vss)); // Bench initial voltage = 0.0 V.
        // device 777, IC IC134, analog/basic/mos_r2r_dac.hpp:28
        I(cpphdl_n1219, cpphdl_n1248) <+ V(cpphdl_n1219, cpphdl_n1248) / 2000.0;
        // device 778, IC IC134, analog/basic/mos_r2r_dac.hpp:29
        I(cpphdl_n1248, Vss) <+ 2.9999999999999998e-15 * ddt(V(cpphdl_n1248, Vss)); // Bench initial voltage = 0.0 V.
        // device 779, IC IC136, analog/basic/inverter.hpp:11
        I(cpphdl_n1223, Vdd) <+ cpphdl_channel(V(BIT_N5_1, Vdd), V(cpphdl_n1223, Vdd), 0.080000000000000002, 0.69999999999999996, -1.0);
        // device 780, IC IC136, analog/basic/inverter.hpp:12
        I(cpphdl_n1223, Vss) <+ cpphdl_channel(V(BIT_N5_1, Vss), V(cpphdl_n1223, Vss), 0.080000000000000002, 0.69999999999999996, 1.0);
        // device 781, IC IC134, analog/basic/mos_r2r_dac.hpp:27
        I(cpphdl_n1223, Vss) <+ 2.9999999999999998e-15 * ddt(V(cpphdl_n1223, Vss)); // Bench initial voltage = 0.0 V.
        // device 782, IC IC134, analog/basic/mos_r2r_dac.hpp:28
        I(cpphdl_n1223, cpphdl_n1249) <+ V(cpphdl_n1223, cpphdl_n1249) / 2000.0;
        // device 783, IC IC134, analog/basic/mos_r2r_dac.hpp:29
        I(cpphdl_n1249, Vss) <+ 2.9999999999999998e-15 * ddt(V(cpphdl_n1249, Vss)); // Bench initial voltage = 0.0 V.
        // device 784, IC IC134, analog/basic/mos_r2r_dac.hpp:31
        I(cpphdl_n1248, cpphdl_n1249) <+ V(cpphdl_n1248, cpphdl_n1249) / 1000.0;
        // device 785, IC IC137, analog/basic/inverter.hpp:11
        I(cpphdl_n1227, Vdd) <+ cpphdl_channel(V(BIT_N5_2, Vdd), V(cpphdl_n1227, Vdd), 0.080000000000000002, 0.69999999999999996, -1.0);
        // device 786, IC IC137, analog/basic/inverter.hpp:12
        I(cpphdl_n1227, Vss) <+ cpphdl_channel(V(BIT_N5_2, Vss), V(cpphdl_n1227, Vss), 0.080000000000000002, 0.69999999999999996, 1.0);
        // device 787, IC IC134, analog/basic/mos_r2r_dac.hpp:27
        I(cpphdl_n1227, Vss) <+ 2.9999999999999998e-15 * ddt(V(cpphdl_n1227, Vss)); // Bench initial voltage = 0.0 V.
        // device 788, IC IC134, analog/basic/mos_r2r_dac.hpp:28
        I(cpphdl_n1227, cpphdl_n1250) <+ V(cpphdl_n1227, cpphdl_n1250) / 2000.0;
        // device 789, IC IC134, analog/basic/mos_r2r_dac.hpp:29
        I(cpphdl_n1250, Vss) <+ 2.9999999999999998e-15 * ddt(V(cpphdl_n1250, Vss)); // Bench initial voltage = 0.0 V.
        // device 790, IC IC134, analog/basic/mos_r2r_dac.hpp:31
        I(cpphdl_n1249, cpphdl_n1250) <+ V(cpphdl_n1249, cpphdl_n1250) / 1000.0;
        // device 791, IC IC138, analog/basic/inverter.hpp:11
        I(cpphdl_n1231, Vdd) <+ cpphdl_channel(V(BIT_N5_3, Vdd), V(cpphdl_n1231, Vdd), 0.080000000000000002, 0.69999999999999996, -1.0);
        // device 792, IC IC138, analog/basic/inverter.hpp:12
        I(cpphdl_n1231, Vss) <+ cpphdl_channel(V(BIT_N5_3, Vss), V(cpphdl_n1231, Vss), 0.080000000000000002, 0.69999999999999996, 1.0);
        // device 793, IC IC134, analog/basic/mos_r2r_dac.hpp:27
        I(cpphdl_n1231, Vss) <+ 2.9999999999999998e-15 * ddt(V(cpphdl_n1231, Vss)); // Bench initial voltage = 0.0 V.
        // device 794, IC IC134, analog/basic/mos_r2r_dac.hpp:28
        I(cpphdl_n1231, cpphdl_n1251) <+ V(cpphdl_n1231, cpphdl_n1251) / 2000.0;
        // device 795, IC IC134, analog/basic/mos_r2r_dac.hpp:29
        I(cpphdl_n1251, Vss) <+ 2.9999999999999998e-15 * ddt(V(cpphdl_n1251, Vss)); // Bench initial voltage = 0.0 V.
        // device 796, IC IC134, analog/basic/mos_r2r_dac.hpp:31
        I(cpphdl_n1250, cpphdl_n1251) <+ V(cpphdl_n1250, cpphdl_n1251) / 1000.0;
        // device 797, IC IC139, analog/basic/inverter.hpp:11
        I(cpphdl_n1235, Vdd) <+ cpphdl_channel(V(BIT_N5_4, Vdd), V(cpphdl_n1235, Vdd), 0.080000000000000002, 0.69999999999999996, -1.0);
        // device 798, IC IC139, analog/basic/inverter.hpp:12
        I(cpphdl_n1235, Vss) <+ cpphdl_channel(V(BIT_N5_4, Vss), V(cpphdl_n1235, Vss), 0.080000000000000002, 0.69999999999999996, 1.0);
        // device 799, IC IC134, analog/basic/mos_r2r_dac.hpp:27
        I(cpphdl_n1235, Vss) <+ 2.9999999999999998e-15 * ddt(V(cpphdl_n1235, Vss)); // Bench initial voltage = 0.0 V.
        // device 800, IC IC134, analog/basic/mos_r2r_dac.hpp:28
        I(cpphdl_n1235, cpphdl_n1252) <+ V(cpphdl_n1235, cpphdl_n1252) / 2000.0;
        // device 801, IC IC134, analog/basic/mos_r2r_dac.hpp:29
        I(cpphdl_n1252, Vss) <+ 2.9999999999999998e-15 * ddt(V(cpphdl_n1252, Vss)); // Bench initial voltage = 0.0 V.
        // device 802, IC IC134, analog/basic/mos_r2r_dac.hpp:31
        I(cpphdl_n1251, cpphdl_n1252) <+ V(cpphdl_n1251, cpphdl_n1252) / 1000.0;
        // device 803, IC IC140, analog/basic/inverter.hpp:11
        I(cpphdl_n1239, Vdd) <+ cpphdl_channel(V(BIT_N5_5, Vdd), V(cpphdl_n1239, Vdd), 0.080000000000000002, 0.69999999999999996, -1.0);
        // device 804, IC IC140, analog/basic/inverter.hpp:12
        I(cpphdl_n1239, Vss) <+ cpphdl_channel(V(BIT_N5_5, Vss), V(cpphdl_n1239, Vss), 0.080000000000000002, 0.69999999999999996, 1.0);
        // device 805, IC IC134, analog/basic/mos_r2r_dac.hpp:27
        I(cpphdl_n1239, Vss) <+ 2.9999999999999998e-15 * ddt(V(cpphdl_n1239, Vss)); // Bench initial voltage = 0.0 V.
        // device 806, IC IC134, analog/basic/mos_r2r_dac.hpp:28
        I(cpphdl_n1239, cpphdl_n1253) <+ V(cpphdl_n1239, cpphdl_n1253) / 2000.0;
        // device 807, IC IC134, analog/basic/mos_r2r_dac.hpp:29
        I(cpphdl_n1253, Vss) <+ 2.9999999999999998e-15 * ddt(V(cpphdl_n1253, Vss)); // Bench initial voltage = 0.0 V.
        // device 808, IC IC134, analog/basic/mos_r2r_dac.hpp:31
        I(cpphdl_n1252, cpphdl_n1253) <+ V(cpphdl_n1252, cpphdl_n1253) / 1000.0;
        // device 809, IC IC141, analog/basic/inverter.hpp:11
        I(cpphdl_n1243, Vdd) <+ cpphdl_channel(V(BIT_N5_6, Vdd), V(cpphdl_n1243, Vdd), 0.080000000000000002, 0.69999999999999996, -1.0);
        // device 810, IC IC141, analog/basic/inverter.hpp:12
        I(cpphdl_n1243, Vss) <+ cpphdl_channel(V(BIT_N5_6, Vss), V(cpphdl_n1243, Vss), 0.080000000000000002, 0.69999999999999996, 1.0);
        // device 811, IC IC134, analog/basic/mos_r2r_dac.hpp:27
        I(cpphdl_n1243, Vss) <+ 2.9999999999999998e-15 * ddt(V(cpphdl_n1243, Vss)); // Bench initial voltage = 0.0 V.
        // device 812, IC IC134, analog/basic/mos_r2r_dac.hpp:28
        I(cpphdl_n1243, cpphdl_n1254) <+ V(cpphdl_n1243, cpphdl_n1254) / 2000.0;
        // device 813, IC IC134, analog/basic/mos_r2r_dac.hpp:29
        I(cpphdl_n1254, Vss) <+ 2.9999999999999998e-15 * ddt(V(cpphdl_n1254, Vss)); // Bench initial voltage = 0.0 V.
        // device 814, IC IC134, analog/basic/mos_r2r_dac.hpp:31
        I(cpphdl_n1253, cpphdl_n1254) <+ V(cpphdl_n1253, cpphdl_n1254) / 1000.0;
        // device 815, IC IC142, analog/basic/inverter.hpp:11
        I(cpphdl_n1247, Vdd) <+ cpphdl_channel(V(BIT_N5_7, Vdd), V(cpphdl_n1247, Vdd), 0.080000000000000002, 0.69999999999999996, -1.0);
        // device 816, IC IC142, analog/basic/inverter.hpp:12
        I(cpphdl_n1247, Vss) <+ cpphdl_channel(V(BIT_N5_7, Vss), V(cpphdl_n1247, Vss), 0.080000000000000002, 0.69999999999999996, 1.0);
        // device 817, IC IC134, analog/basic/mos_r2r_dac.hpp:27
        I(cpphdl_n1247, Vss) <+ 2.9999999999999998e-15 * ddt(V(cpphdl_n1247, Vss)); // Bench initial voltage = 0.0 V.
        // device 818, IC IC134, analog/basic/mos_r2r_dac.hpp:28
        I(cpphdl_n1247, cpphdl_n1259) <+ V(cpphdl_n1247, cpphdl_n1259) / 2000.0;
        // device 819, IC IC134, analog/basic/mos_r2r_dac.hpp:29
        I(cpphdl_n1259, Vss) <+ 2.9999999999999998e-15 * ddt(V(cpphdl_n1259, Vss)); // Bench initial voltage = 0.0 V.
        // device 820, IC IC134, analog/basic/mos_r2r_dac.hpp:31
        I(cpphdl_n1254, cpphdl_n1259) <+ V(cpphdl_n1254, cpphdl_n1259) / 1000.0;
        // device 821, IC IC134, analog/basic/mos_r2r_dac.hpp:33
        I(Vss, cpphdl_n1248) <+ V(Vss, cpphdl_n1248) / 2000.0;
        // device 822, IC IC143, analog/basic/nmos_resistor_amplifier.hpp:23
        I(Vdd, cpphdl_n1268) <+ V(Vdd, cpphdl_n1268) / 1000.0;
        // device 823, IC IC143, analog/basic/nmos_resistor_amplifier.hpp:24
        I(Vdd, cpphdl_n1267) <+ V(Vdd, cpphdl_n1267) / 1000.0;
        // device 824, IC IC143, analog/basic/nmos_resistor_amplifier.hpp:25
        I(cpphdl_n1268, cpphdl_n1262) <+ cpphdl_channel(V(cpphdl_n1258, cpphdl_n1262), V(cpphdl_n1268, cpphdl_n1262), 0.0074999999999999997, 0.69999999999999996, 1.0);
        // device 825, IC IC143, analog/basic/nmos_resistor_amplifier.hpp:26
        I(cpphdl_n1267, cpphdl_n1263) <+ cpphdl_channel(V(cpphdl_n1259, cpphdl_n1263), V(cpphdl_n1267, cpphdl_n1263), 0.0074999999999999997, 0.69999999999999996, 1.0);
        // device 826, IC IC143, analog/basic/nmos_resistor_amplifier.hpp:27
        I(cpphdl_n1264, cpphdl_n1262) <+ V(cpphdl_n1264, cpphdl_n1262) / 100.0;
        // device 827, IC IC143, analog/basic/nmos_resistor_amplifier.hpp:28
        I(cpphdl_n1264, cpphdl_n1263) <+ V(cpphdl_n1264, cpphdl_n1263) / 100.0;
        // device 828, IC IC143, analog/basic/nmos_resistor_amplifier.hpp:29
        I(Vss, cpphdl_n1264) <+ V(Vss, cpphdl_n1264) / 300.0;
        // device 829, IC IC143, analog/basic/nmos_resistor_amplifier.hpp:30
        I(cpphdl_n1268, Vdd) <+ 2.9999999999999998e-13 * ddt(V(cpphdl_n1268, Vdd)); // Bench initial voltage = 0.0 V.
        // device 830, IC IC143, analog/basic/nmos_resistor_amplifier.hpp:31
        I(cpphdl_n1267, Vdd) <+ 2.9999999999999998e-13 * ddt(V(cpphdl_n1267, Vdd)); // Bench initial voltage = 0.0 V.
        // device 831, IC IC143, analog/basic/nmos_resistor_amplifier.hpp:32
        I(cpphdl_n1264, Vss) <+ 4e-14 * ddt(V(cpphdl_n1264, Vss)); // Bench initial voltage = 0.0 V.
        // device 832, IC IC143, analog/basic/nmos_resistor_amplifier.hpp:34
        I(cpphdl_n1258, cpphdl_n1262) <+ 2e-14 * ddt(V(cpphdl_n1258, cpphdl_n1262)); // Bench initial voltage = 0.0 V.
        // device 833, IC IC143, analog/basic/nmos_resistor_amplifier.hpp:35
        I(cpphdl_n1259, cpphdl_n1263) <+ 2e-14 * ddt(V(cpphdl_n1259, cpphdl_n1263)); // Bench initial voltage = 0.0 V.
        // device 834, IC IC143, analog/basic/nmos_resistor_amplifier.hpp:36
        I(cpphdl_n1258, cpphdl_n1268) <+ 2.9999999999999998e-15 * ddt(V(cpphdl_n1258, cpphdl_n1268)); // Bench initial voltage = 0.0 V.
        // device 835, IC IC143, analog/basic/nmos_resistor_amplifier.hpp:37
        I(cpphdl_n1259, cpphdl_n1267) <+ 2.9999999999999998e-15 * ddt(V(cpphdl_n1259, cpphdl_n1267)); // Bench initial voltage = 0.0 V.
        // device 836, IC IC144, analog/basic/strongarm_comparator.hpp:28
        I(cpphdl_n1272, cpphdl_n1274) <+ cpphdl_channel(V(cpphdl_n1267, cpphdl_n1274), V(cpphdl_n1272, cpphdl_n1274), 0.0080000000000000002, 0.69999999999999996, 1.0);
        // device 837, IC IC144, analog/basic/strongarm_comparator.hpp:29
        I(cpphdl_n1273, cpphdl_n1274) <+ cpphdl_channel(V(cpphdl_n1268, cpphdl_n1274), V(cpphdl_n1273, cpphdl_n1274), 0.0080000000000000002, 0.69999999999999996, 1.0);
        // device 838, IC IC144, analog/basic/strongarm_comparator.hpp:30
        I(cpphdl_n1274, Vss) <+ cpphdl_channel(V(EVALUATE, Vss), V(cpphdl_n1274, Vss), 0.0080000000000000002, 0.69999999999999996, 1.0);
        // device 839, IC IC144, analog/basic/strongarm_comparator.hpp:33
        I(cpphdl_n1287, cpphdl_n1272) <+ cpphdl_channel(V(cpphdl_n1291, cpphdl_n1272), V(cpphdl_n1287, cpphdl_n1272), 0.0040000000000000001, 0.69999999999999996, 1.0);
        // device 840, IC IC144, analog/basic/strongarm_comparator.hpp:34
        I(cpphdl_n1291, cpphdl_n1273) <+ cpphdl_channel(V(cpphdl_n1287, cpphdl_n1273), V(cpphdl_n1291, cpphdl_n1273), 0.0040000000000000001, 0.69999999999999996, 1.0);
        // device 841, IC IC144, analog/basic/strongarm_comparator.hpp:35
        I(cpphdl_n1291, Vdd) <+ cpphdl_channel(V(cpphdl_n1287, Vdd), V(cpphdl_n1291, Vdd), 0.002, 0.69999999999999996, -1.0);
        // device 842, IC IC144, analog/basic/strongarm_comparator.hpp:36
        I(cpphdl_n1287, Vdd) <+ cpphdl_channel(V(cpphdl_n1291, Vdd), V(cpphdl_n1287, Vdd), 0.002, 0.69999999999999996, -1.0);
        // device 843, IC IC144, analog/basic/strongarm_comparator.hpp:38
        I(cpphdl_n1272, Vdd) <+ cpphdl_channel(V(EVALUATE, Vdd), V(cpphdl_n1272, Vdd), 0.002, 0.69999999999999996, -1.0);
        // device 844, IC IC144, analog/basic/strongarm_comparator.hpp:39
        I(cpphdl_n1273, Vdd) <+ cpphdl_channel(V(EVALUATE, Vdd), V(cpphdl_n1273, Vdd), 0.002, 0.69999999999999996, -1.0);
        // device 845, IC IC144, analog/basic/strongarm_comparator.hpp:40
        I(cpphdl_n1291, Vdd) <+ cpphdl_channel(V(EVALUATE, Vdd), V(cpphdl_n1291, Vdd), 0.002, 0.69999999999999996, -1.0);
        // device 846, IC IC144, analog/basic/strongarm_comparator.hpp:41
        I(cpphdl_n1287, Vdd) <+ cpphdl_channel(V(EVALUATE, Vdd), V(cpphdl_n1287, Vdd), 0.002, 0.69999999999999996, -1.0);
        // device 847, IC IC144, analog/basic/strongarm_comparator.hpp:42
        I(cpphdl_n1272, Vss) <+ 2.9999999999999998e-14 * ddt(V(cpphdl_n1272, Vss)); // Bench initial voltage = 0.0 V.
        // device 848, IC IC144, analog/basic/strongarm_comparator.hpp:43
        I(cpphdl_n1273, Vss) <+ 2.9999999999999998e-14 * ddt(V(cpphdl_n1273, Vss)); // Bench initial voltage = 0.0 V.
        // device 849, IC IC144, analog/basic/strongarm_comparator.hpp:44
        I(cpphdl_n1274, Vss) <+ 2.9999999999999998e-14 * ddt(V(cpphdl_n1274, Vss)); // Bench initial voltage = 0.0 V.
        // device 850, IC IC144, analog/basic/strongarm_comparator.hpp:45
        I(cpphdl_n1291, Vss) <+ 5.0000000000000002e-14 * ddt(V(cpphdl_n1291, Vss)); // Bench initial voltage = 0.0 V.
        // device 851, IC IC144, analog/basic/strongarm_comparator.hpp:46
        I(cpphdl_n1287, Vss) <+ 5.0000000000000002e-14 * ddt(V(cpphdl_n1287, Vss)); // Bench initial voltage = 0.0 V.
        // device 852, IC IC144, analog/basic/strongarm_comparator.hpp:47
        I(cpphdl_n1267, cpphdl_n1274) <+ 2e-14 * ddt(V(cpphdl_n1267, cpphdl_n1274)); // Bench initial voltage = 0.0 V.
        // device 853, IC IC144, analog/basic/strongarm_comparator.hpp:48
        I(cpphdl_n1268, cpphdl_n1274) <+ 2e-14 * ddt(V(cpphdl_n1268, cpphdl_n1274)); // Bench initial voltage = 0.0 V.
        // device 854, IC IC144, analog/basic/strongarm_comparator.hpp:49
        I(cpphdl_n1267, cpphdl_n1272) <+ 2.9999999999999998e-15 * ddt(V(cpphdl_n1267, cpphdl_n1272)); // Bench initial voltage = 0.0 V.
        // device 855, IC IC144, analog/basic/strongarm_comparator.hpp:50
        I(cpphdl_n1268, cpphdl_n1273) <+ 2.9999999999999998e-15 * ddt(V(cpphdl_n1268, cpphdl_n1273)); // Bench initial voltage = 0.0 V.
        // device 856, IC IC146, analog/basic/inverter.hpp:11
        I(cpphdl_n1295, Vdd) <+ cpphdl_channel(V(cpphdl_n1287, Vdd), V(cpphdl_n1295, Vdd), 0.001, 0.69999999999999996, -1.0);
        // device 857, IC IC146, analog/basic/inverter.hpp:12
        I(cpphdl_n1295, Vss) <+ cpphdl_channel(V(cpphdl_n1287, Vss), V(cpphdl_n1295, Vss), 0.001, 0.69999999999999996, 1.0);
        // device 858, IC IC148, analog/basic/inverter.hpp:11
        I(cpphdl_n1309, Vdd) <+ cpphdl_channel(V(cpphdl_n1295, Vdd), V(cpphdl_n1309, Vdd), 0.0040000000000000001, 0.69999999999999996, -1.0);
        // device 859, IC IC148, analog/basic/inverter.hpp:12
        I(cpphdl_n1309, Vss) <+ cpphdl_channel(V(cpphdl_n1295, Vss), V(cpphdl_n1309, Vss), 0.0040000000000000001, 0.69999999999999996, 1.0);
        // device 860, IC IC145, analog/basic/buffered_nand_latch.hpp:34
        I(cpphdl_n1287, Vss) <+ 2.0000000000000002e-15 * ddt(V(cpphdl_n1287, Vss)); // Bench initial voltage = 0.0 V.
        // device 861, IC IC145, analog/basic/buffered_nand_latch.hpp:35
        I(cpphdl_n1287, cpphdl_n1295) <+ 1.0000000000000001e-15 * ddt(V(cpphdl_n1287, cpphdl_n1295)); // Bench initial voltage = 0.0 V.
        // device 862, IC IC145, analog/basic/buffered_nand_latch.hpp:36
        I(cpphdl_n1295, Vss) <+ 5e-15 * ddt(V(cpphdl_n1295, Vss)); // Bench initial voltage = 0.0 V.
        // device 863, IC IC145, analog/basic/buffered_nand_latch.hpp:37
        I(cpphdl_n1295, Vss) <+ 8.0000000000000006e-15 * ddt(V(cpphdl_n1295, Vss)); // Bench initial voltage = 0.0 V.
        // device 864, IC IC145, analog/basic/buffered_nand_latch.hpp:38
        I(cpphdl_n1309, Vss) <+ 1e-14 * ddt(V(cpphdl_n1309, Vss)); // Bench initial voltage = 0.0 V.
        // device 865, IC IC147, analog/basic/inverter.hpp:11
        I(cpphdl_n1299, Vdd) <+ cpphdl_channel(V(cpphdl_n1291, Vdd), V(cpphdl_n1299, Vdd), 0.001, 0.69999999999999996, -1.0);
        // device 866, IC IC147, analog/basic/inverter.hpp:12
        I(cpphdl_n1299, Vss) <+ cpphdl_channel(V(cpphdl_n1291, Vss), V(cpphdl_n1299, Vss), 0.001, 0.69999999999999996, 1.0);
        // device 867, IC IC149, analog/basic/inverter.hpp:11
        I(cpphdl_n1315, Vdd) <+ cpphdl_channel(V(cpphdl_n1299, Vdd), V(cpphdl_n1315, Vdd), 0.0040000000000000001, 0.69999999999999996, -1.0);
        // device 868, IC IC149, analog/basic/inverter.hpp:12
        I(cpphdl_n1315, Vss) <+ cpphdl_channel(V(cpphdl_n1299, Vss), V(cpphdl_n1315, Vss), 0.0040000000000000001, 0.69999999999999996, 1.0);
        // device 869, IC IC145, analog/basic/buffered_nand_latch.hpp:34
        I(cpphdl_n1291, Vss) <+ 2.0000000000000002e-15 * ddt(V(cpphdl_n1291, Vss)); // Bench initial voltage = 0.0 V.
        // device 870, IC IC145, analog/basic/buffered_nand_latch.hpp:35
        I(cpphdl_n1291, cpphdl_n1299) <+ 1.0000000000000001e-15 * ddt(V(cpphdl_n1291, cpphdl_n1299)); // Bench initial voltage = 0.0 V.
        // device 871, IC IC145, analog/basic/buffered_nand_latch.hpp:36
        I(cpphdl_n1299, Vss) <+ 5e-15 * ddt(V(cpphdl_n1299, Vss)); // Bench initial voltage = 0.0 V.
        // device 872, IC IC145, analog/basic/buffered_nand_latch.hpp:37
        I(cpphdl_n1299, Vss) <+ 8.0000000000000006e-15 * ddt(V(cpphdl_n1299, Vss)); // Bench initial voltage = 0.0 V.
        // device 873, IC IC145, analog/basic/buffered_nand_latch.hpp:38
        I(cpphdl_n1315, Vss) <+ 1e-14 * ddt(V(cpphdl_n1315, Vss)); // Bench initial voltage = 0.0 V.
        // device 874, IC IC151, analog/basic/cmos_logic.hpp:17
        I(cpphdl_n2798, Vss) <+ 5.0000000000000002e-14 * ddt(V(cpphdl_n2798, Vss)); // Bench initial voltage = 0.0 V.
        // device 875, IC IC151, analog/basic/cmos_logic.hpp:18
        I(cpphdl_n2798, Vdd) <+ cpphdl_channel(V(cpphdl_n1309, Vdd), V(cpphdl_n2798, Vdd), 0.01, 0.69999999999999996, -1.0);
        // device 876, IC IC151, analog/basic/cmos_logic.hpp:19
        I(cpphdl_n2798, Vdd) <+ cpphdl_channel(V(cpphdl_n1317, Vdd), V(cpphdl_n2798, Vdd), 0.01, 0.69999999999999996, -1.0);
        // device 877, IC IC151, analog/basic/cmos_logic.hpp:20
        I(cpphdl_n2798, cpphdl_n1312) <+ cpphdl_channel(V(cpphdl_n1309, cpphdl_n1312), V(cpphdl_n2798, cpphdl_n1312), 0.01, 0.69999999999999996, 1.0);
        // device 878, IC IC151, analog/basic/cmos_logic.hpp:21
        I(cpphdl_n1312, Vss) <+ cpphdl_channel(V(cpphdl_n1317, Vss), V(cpphdl_n1312, Vss), 0.01, 0.69999999999999996, 1.0);
        // device 879, IC IC151, analog/basic/cmos_logic.hpp:27
        I(cpphdl_n1312, Vss) <+ 1e-14 * ddt(V(cpphdl_n1312, Vss)); // Bench initial voltage = 0.0 V.
        // device 880, IC IC152, analog/basic/cmos_logic.hpp:17
        I(cpphdl_n1317, Vss) <+ 5.0000000000000002e-14 * ddt(V(cpphdl_n1317, Vss)); // Bench initial voltage = 0.0 V.
        // device 881, IC IC152, analog/basic/cmos_logic.hpp:18
        I(cpphdl_n1317, Vdd) <+ cpphdl_channel(V(cpphdl_n1315, Vdd), V(cpphdl_n1317, Vdd), 0.01, 0.69999999999999996, -1.0);
        // device 882, IC IC152, analog/basic/cmos_logic.hpp:19
        I(cpphdl_n1317, Vdd) <+ cpphdl_channel(V(cpphdl_n2798, Vdd), V(cpphdl_n1317, Vdd), 0.01, 0.69999999999999996, -1.0);
        // device 883, IC IC152, analog/basic/cmos_logic.hpp:20
        I(cpphdl_n1317, cpphdl_n1318) <+ cpphdl_channel(V(cpphdl_n1315, cpphdl_n1318), V(cpphdl_n1317, cpphdl_n1318), 0.01, 0.69999999999999996, 1.0);
        // device 884, IC IC152, analog/basic/cmos_logic.hpp:21
        I(cpphdl_n1318, Vss) <+ cpphdl_channel(V(cpphdl_n2798, Vss), V(cpphdl_n1318, Vss), 0.01, 0.69999999999999996, 1.0);
        // device 885, IC IC152, analog/basic/cmos_logic.hpp:27
        I(cpphdl_n1318, Vss) <+ 1e-14 * ddt(V(cpphdl_n1318, Vss)); // Bench initial voltage = 0.0 V.
        // device 886, IC IC150, analog/basic/nand_latch.hpp:36
        I(cpphdl_n1309, Vss) <+ 2.9999999999999998e-15 * ddt(V(cpphdl_n1309, Vss)); // Bench initial voltage = 0.0 V.
        // device 887, IC IC150, analog/basic/nand_latch.hpp:37
        I(cpphdl_n1315, Vss) <+ 2.9999999999999998e-15 * ddt(V(cpphdl_n1315, Vss)); // Bench initial voltage = 0.0 V.
        // device 888, IC IC153, analog/basic/inverter.hpp:11
        I(cpphdl_n1323, Vdd) <+ cpphdl_channel(V(CLEAR, Vdd), V(cpphdl_n1323, Vdd), 0.01, 0.69999999999999996, -1.0);
        // device 889, IC IC153, analog/basic/inverter.hpp:12
        I(cpphdl_n1323, Vss) <+ cpphdl_channel(V(CLEAR, Vss), V(cpphdl_n1323, Vss), 0.01, 0.69999999999999996, 1.0);
        // device 890, IC IC150, analog/basic/nand_latch.hpp:58
        I(cpphdl_n1323, Vss) <+ 2.9999999999999998e-15 * ddt(V(cpphdl_n1323, Vss)); // Bench initial voltage = 0.0 V.
        // device 891, IC IC150, analog/basic/nand_latch.hpp:59
        I(cpphdl_n2798, Vss) <+ cpphdl_channel(V(CLEAR, Vss), V(cpphdl_n2798, Vss), 0.050000000000000003, 0.69999999999999996, 1.0);
        // device 892, IC IC150, analog/basic/nand_latch.hpp:60
        I(cpphdl_n1317, Vdd) <+ cpphdl_channel(V(cpphdl_n1323, Vdd), V(cpphdl_n1317, Vdd), 0.050000000000000003, 0.69999999999999996, -1.0);
        // device 893, IC IC156, analog/basic/inverter.hpp:11
        I(cpphdl_n1347, Vdd) <+ cpphdl_channel(V(TRACK6, Vdd), V(cpphdl_n1347, Vdd), 0.0040000000000000001, 0.69999999999999996, -1.0);
        // device 894, IC IC156, analog/basic/inverter.hpp:12
        I(cpphdl_n1347, Vss) <+ cpphdl_channel(V(TRACK6, Vss), V(cpphdl_n1347, Vss), 0.0040000000000000001, 0.69999999999999996, 1.0);
        // device 895, IC IC155, analog/basic/mos_track_hold.hpp:31
        I(cpphdl_n1347, Vss) <+ 2e-14 * ddt(V(cpphdl_n1347, Vss)); // Bench initial voltage = 0.0 V.
        // device 896, IC IC155, analog/basic/mos_track_hold.hpp:32
        I(cpphdl_n2628, cpphdl_n1401) <+ cpphdl_channel(V(TRACK6, cpphdl_n1401), V(cpphdl_n2628, cpphdl_n1401), 0.029999999999999999, 0.69999999999999996, 1.0);
        // device 897, IC IC155, analog/basic/mos_track_hold.hpp:33
        I(cpphdl_n1401, cpphdl_n2628) <+ cpphdl_channel(V(cpphdl_n1347, cpphdl_n2628), V(cpphdl_n1401, cpphdl_n2628), 0.014999999999999999, 0.69999999999999996, -1.0);
        // device 898, IC IC155, analog/basic/mos_track_hold.hpp:37
        I(cpphdl_n1401, cpphdl_n1401) <+ cpphdl_channel(V(cpphdl_n1347, cpphdl_n1401), V(cpphdl_n1401, cpphdl_n1401), 0.016, 0.69999999999999996, 1.0);
        // device 899, IC IC155, analog/basic/mos_track_hold.hpp:38
        I(cpphdl_n1401, cpphdl_n1401) <+ cpphdl_channel(V(TRACK6, cpphdl_n1401), V(cpphdl_n1401, cpphdl_n1401), 0.0083999999999999995, 0.69999999999999996, -1.0);
        // device 900, IC IC155, analog/basic/mos_track_hold.hpp:39
        I(cpphdl_n1401, Vss) <+ 1.5000000000000001e-12 * ddt(V(cpphdl_n1401, Vss)); // Bench initial voltage = 0.0 V.
        // device 901, IC IC155, analog/basic/mos_track_hold.hpp:42
        I(TRACK6, cpphdl_n1401) <+ 2.0000000000000002e-15 * ddt(V(TRACK6, cpphdl_n1401)); // Bench initial voltage = -0.0 V.
        // device 902, IC IC155, analog/basic/mos_track_hold.hpp:43
        I(cpphdl_n1347, cpphdl_n1401) <+ 2.0000000000000002e-15 * ddt(V(cpphdl_n1347, cpphdl_n1401)); // Bench initial voltage = 0.0 V.
        // device 903, IC IC155, analog/basic/mos_track_hold.hpp:44
        I(cpphdl_n2628, cpphdl_n1401) <+ 1.0000000000000001e-15 * ddt(V(cpphdl_n2628, cpphdl_n1401)); // Bench initial voltage = 0.0 V.
        // device 904, IC IC158, analog/basic/inverter.hpp:11
        I(cpphdl_n1362, Vdd) <+ cpphdl_channel(V(BIT_N6_0, Vdd), V(cpphdl_n1362, Vdd), 0.080000000000000002, 0.69999999999999996, -1.0);
        // device 905, IC IC158, analog/basic/inverter.hpp:12
        I(cpphdl_n1362, Vss) <+ cpphdl_channel(V(BIT_N6_0, Vss), V(cpphdl_n1362, Vss), 0.080000000000000002, 0.69999999999999996, 1.0);
        // device 906, IC IC157, analog/basic/mos_r2r_dac.hpp:27
        I(cpphdl_n1362, Vss) <+ 2.9999999999999998e-15 * ddt(V(cpphdl_n1362, Vss)); // Bench initial voltage = 0.0 V.
        // device 907, IC IC157, analog/basic/mos_r2r_dac.hpp:28
        I(cpphdl_n1362, cpphdl_n1391) <+ V(cpphdl_n1362, cpphdl_n1391) / 2000.0;
        // device 908, IC IC157, analog/basic/mos_r2r_dac.hpp:29
        I(cpphdl_n1391, Vss) <+ 2.9999999999999998e-15 * ddt(V(cpphdl_n1391, Vss)); // Bench initial voltage = 0.0 V.
        // device 909, IC IC159, analog/basic/inverter.hpp:11
        I(cpphdl_n1366, Vdd) <+ cpphdl_channel(V(BIT_N6_1, Vdd), V(cpphdl_n1366, Vdd), 0.080000000000000002, 0.69999999999999996, -1.0);
        // device 910, IC IC159, analog/basic/inverter.hpp:12
        I(cpphdl_n1366, Vss) <+ cpphdl_channel(V(BIT_N6_1, Vss), V(cpphdl_n1366, Vss), 0.080000000000000002, 0.69999999999999996, 1.0);
        // device 911, IC IC157, analog/basic/mos_r2r_dac.hpp:27
        I(cpphdl_n1366, Vss) <+ 2.9999999999999998e-15 * ddt(V(cpphdl_n1366, Vss)); // Bench initial voltage = 0.0 V.
        // device 912, IC IC157, analog/basic/mos_r2r_dac.hpp:28
        I(cpphdl_n1366, cpphdl_n1392) <+ V(cpphdl_n1366, cpphdl_n1392) / 2000.0;
        // device 913, IC IC157, analog/basic/mos_r2r_dac.hpp:29
        I(cpphdl_n1392, Vss) <+ 2.9999999999999998e-15 * ddt(V(cpphdl_n1392, Vss)); // Bench initial voltage = 0.0 V.
        // device 914, IC IC157, analog/basic/mos_r2r_dac.hpp:31
        I(cpphdl_n1391, cpphdl_n1392) <+ V(cpphdl_n1391, cpphdl_n1392) / 1000.0;
        // device 915, IC IC160, analog/basic/inverter.hpp:11
        I(cpphdl_n1370, Vdd) <+ cpphdl_channel(V(BIT_N6_2, Vdd), V(cpphdl_n1370, Vdd), 0.080000000000000002, 0.69999999999999996, -1.0);
        // device 916, IC IC160, analog/basic/inverter.hpp:12
        I(cpphdl_n1370, Vss) <+ cpphdl_channel(V(BIT_N6_2, Vss), V(cpphdl_n1370, Vss), 0.080000000000000002, 0.69999999999999996, 1.0);
        // device 917, IC IC157, analog/basic/mos_r2r_dac.hpp:27
        I(cpphdl_n1370, Vss) <+ 2.9999999999999998e-15 * ddt(V(cpphdl_n1370, Vss)); // Bench initial voltage = 0.0 V.
        // device 918, IC IC157, analog/basic/mos_r2r_dac.hpp:28
        I(cpphdl_n1370, cpphdl_n1393) <+ V(cpphdl_n1370, cpphdl_n1393) / 2000.0;
        // device 919, IC IC157, analog/basic/mos_r2r_dac.hpp:29
        I(cpphdl_n1393, Vss) <+ 2.9999999999999998e-15 * ddt(V(cpphdl_n1393, Vss)); // Bench initial voltage = 0.0 V.
        // device 920, IC IC157, analog/basic/mos_r2r_dac.hpp:31
        I(cpphdl_n1392, cpphdl_n1393) <+ V(cpphdl_n1392, cpphdl_n1393) / 1000.0;
        // device 921, IC IC161, analog/basic/inverter.hpp:11
        I(cpphdl_n1374, Vdd) <+ cpphdl_channel(V(BIT_N6_3, Vdd), V(cpphdl_n1374, Vdd), 0.080000000000000002, 0.69999999999999996, -1.0);
        // device 922, IC IC161, analog/basic/inverter.hpp:12
        I(cpphdl_n1374, Vss) <+ cpphdl_channel(V(BIT_N6_3, Vss), V(cpphdl_n1374, Vss), 0.080000000000000002, 0.69999999999999996, 1.0);
        // device 923, IC IC157, analog/basic/mos_r2r_dac.hpp:27
        I(cpphdl_n1374, Vss) <+ 2.9999999999999998e-15 * ddt(V(cpphdl_n1374, Vss)); // Bench initial voltage = 0.0 V.
        // device 924, IC IC157, analog/basic/mos_r2r_dac.hpp:28
        I(cpphdl_n1374, cpphdl_n1394) <+ V(cpphdl_n1374, cpphdl_n1394) / 2000.0;
        // device 925, IC IC157, analog/basic/mos_r2r_dac.hpp:29
        I(cpphdl_n1394, Vss) <+ 2.9999999999999998e-15 * ddt(V(cpphdl_n1394, Vss)); // Bench initial voltage = 0.0 V.
        // device 926, IC IC157, analog/basic/mos_r2r_dac.hpp:31
        I(cpphdl_n1393, cpphdl_n1394) <+ V(cpphdl_n1393, cpphdl_n1394) / 1000.0;
        // device 927, IC IC162, analog/basic/inverter.hpp:11
        I(cpphdl_n1378, Vdd) <+ cpphdl_channel(V(BIT_N6_4, Vdd), V(cpphdl_n1378, Vdd), 0.080000000000000002, 0.69999999999999996, -1.0);
        // device 928, IC IC162, analog/basic/inverter.hpp:12
        I(cpphdl_n1378, Vss) <+ cpphdl_channel(V(BIT_N6_4, Vss), V(cpphdl_n1378, Vss), 0.080000000000000002, 0.69999999999999996, 1.0);
        // device 929, IC IC157, analog/basic/mos_r2r_dac.hpp:27
        I(cpphdl_n1378, Vss) <+ 2.9999999999999998e-15 * ddt(V(cpphdl_n1378, Vss)); // Bench initial voltage = 0.0 V.
        // device 930, IC IC157, analog/basic/mos_r2r_dac.hpp:28
        I(cpphdl_n1378, cpphdl_n1395) <+ V(cpphdl_n1378, cpphdl_n1395) / 2000.0;
        // device 931, IC IC157, analog/basic/mos_r2r_dac.hpp:29
        I(cpphdl_n1395, Vss) <+ 2.9999999999999998e-15 * ddt(V(cpphdl_n1395, Vss)); // Bench initial voltage = 0.0 V.
        // device 932, IC IC157, analog/basic/mos_r2r_dac.hpp:31
        I(cpphdl_n1394, cpphdl_n1395) <+ V(cpphdl_n1394, cpphdl_n1395) / 1000.0;
        // device 933, IC IC163, analog/basic/inverter.hpp:11
        I(cpphdl_n1382, Vdd) <+ cpphdl_channel(V(BIT_N6_5, Vdd), V(cpphdl_n1382, Vdd), 0.080000000000000002, 0.69999999999999996, -1.0);
        // device 934, IC IC163, analog/basic/inverter.hpp:12
        I(cpphdl_n1382, Vss) <+ cpphdl_channel(V(BIT_N6_5, Vss), V(cpphdl_n1382, Vss), 0.080000000000000002, 0.69999999999999996, 1.0);
        // device 935, IC IC157, analog/basic/mos_r2r_dac.hpp:27
        I(cpphdl_n1382, Vss) <+ 2.9999999999999998e-15 * ddt(V(cpphdl_n1382, Vss)); // Bench initial voltage = 0.0 V.
        // device 936, IC IC157, analog/basic/mos_r2r_dac.hpp:28
        I(cpphdl_n1382, cpphdl_n1396) <+ V(cpphdl_n1382, cpphdl_n1396) / 2000.0;
        // device 937, IC IC157, analog/basic/mos_r2r_dac.hpp:29
        I(cpphdl_n1396, Vss) <+ 2.9999999999999998e-15 * ddt(V(cpphdl_n1396, Vss)); // Bench initial voltage = 0.0 V.
        // device 938, IC IC157, analog/basic/mos_r2r_dac.hpp:31
        I(cpphdl_n1395, cpphdl_n1396) <+ V(cpphdl_n1395, cpphdl_n1396) / 1000.0;
        // device 939, IC IC164, analog/basic/inverter.hpp:11
        I(cpphdl_n1386, Vdd) <+ cpphdl_channel(V(BIT_N6_6, Vdd), V(cpphdl_n1386, Vdd), 0.080000000000000002, 0.69999999999999996, -1.0);
        // device 940, IC IC164, analog/basic/inverter.hpp:12
        I(cpphdl_n1386, Vss) <+ cpphdl_channel(V(BIT_N6_6, Vss), V(cpphdl_n1386, Vss), 0.080000000000000002, 0.69999999999999996, 1.0);
        // device 941, IC IC157, analog/basic/mos_r2r_dac.hpp:27
        I(cpphdl_n1386, Vss) <+ 2.9999999999999998e-15 * ddt(V(cpphdl_n1386, Vss)); // Bench initial voltage = 0.0 V.
        // device 942, IC IC157, analog/basic/mos_r2r_dac.hpp:28
        I(cpphdl_n1386, cpphdl_n1397) <+ V(cpphdl_n1386, cpphdl_n1397) / 2000.0;
        // device 943, IC IC157, analog/basic/mos_r2r_dac.hpp:29
        I(cpphdl_n1397, Vss) <+ 2.9999999999999998e-15 * ddt(V(cpphdl_n1397, Vss)); // Bench initial voltage = 0.0 V.
        // device 944, IC IC157, analog/basic/mos_r2r_dac.hpp:31
        I(cpphdl_n1396, cpphdl_n1397) <+ V(cpphdl_n1396, cpphdl_n1397) / 1000.0;
        // device 945, IC IC165, analog/basic/inverter.hpp:11
        I(cpphdl_n1390, Vdd) <+ cpphdl_channel(V(BIT_N6_7, Vdd), V(cpphdl_n1390, Vdd), 0.080000000000000002, 0.69999999999999996, -1.0);
        // device 946, IC IC165, analog/basic/inverter.hpp:12
        I(cpphdl_n1390, Vss) <+ cpphdl_channel(V(BIT_N6_7, Vss), V(cpphdl_n1390, Vss), 0.080000000000000002, 0.69999999999999996, 1.0);
        // device 947, IC IC157, analog/basic/mos_r2r_dac.hpp:27
        I(cpphdl_n1390, Vss) <+ 2.9999999999999998e-15 * ddt(V(cpphdl_n1390, Vss)); // Bench initial voltage = 0.0 V.
        // device 948, IC IC157, analog/basic/mos_r2r_dac.hpp:28
        I(cpphdl_n1390, cpphdl_n1402) <+ V(cpphdl_n1390, cpphdl_n1402) / 2000.0;
        // device 949, IC IC157, analog/basic/mos_r2r_dac.hpp:29
        I(cpphdl_n1402, Vss) <+ 2.9999999999999998e-15 * ddt(V(cpphdl_n1402, Vss)); // Bench initial voltage = 0.0 V.
        // device 950, IC IC157, analog/basic/mos_r2r_dac.hpp:31
        I(cpphdl_n1397, cpphdl_n1402) <+ V(cpphdl_n1397, cpphdl_n1402) / 1000.0;
        // device 951, IC IC157, analog/basic/mos_r2r_dac.hpp:33
        I(Vss, cpphdl_n1391) <+ V(Vss, cpphdl_n1391) / 2000.0;
        // device 952, IC IC166, analog/basic/nmos_resistor_amplifier.hpp:23
        I(Vdd, cpphdl_n1411) <+ V(Vdd, cpphdl_n1411) / 1000.0;
        // device 953, IC IC166, analog/basic/nmos_resistor_amplifier.hpp:24
        I(Vdd, cpphdl_n1410) <+ V(Vdd, cpphdl_n1410) / 1000.0;
        // device 954, IC IC166, analog/basic/nmos_resistor_amplifier.hpp:25
        I(cpphdl_n1411, cpphdl_n1405) <+ cpphdl_channel(V(cpphdl_n1401, cpphdl_n1405), V(cpphdl_n1411, cpphdl_n1405), 0.0074999999999999997, 0.69999999999999996, 1.0);
        // device 955, IC IC166, analog/basic/nmos_resistor_amplifier.hpp:26
        I(cpphdl_n1410, cpphdl_n1406) <+ cpphdl_channel(V(cpphdl_n1402, cpphdl_n1406), V(cpphdl_n1410, cpphdl_n1406), 0.0074999999999999997, 0.69999999999999996, 1.0);
        // device 956, IC IC166, analog/basic/nmos_resistor_amplifier.hpp:27
        I(cpphdl_n1407, cpphdl_n1405) <+ V(cpphdl_n1407, cpphdl_n1405) / 100.0;
        // device 957, IC IC166, analog/basic/nmos_resistor_amplifier.hpp:28
        I(cpphdl_n1407, cpphdl_n1406) <+ V(cpphdl_n1407, cpphdl_n1406) / 100.0;
        // device 958, IC IC166, analog/basic/nmos_resistor_amplifier.hpp:29
        I(Vss, cpphdl_n1407) <+ V(Vss, cpphdl_n1407) / 300.0;
        // device 959, IC IC166, analog/basic/nmos_resistor_amplifier.hpp:30
        I(cpphdl_n1411, Vdd) <+ 2.9999999999999998e-13 * ddt(V(cpphdl_n1411, Vdd)); // Bench initial voltage = 0.0 V.
        // device 960, IC IC166, analog/basic/nmos_resistor_amplifier.hpp:31
        I(cpphdl_n1410, Vdd) <+ 2.9999999999999998e-13 * ddt(V(cpphdl_n1410, Vdd)); // Bench initial voltage = 0.0 V.
        // device 961, IC IC166, analog/basic/nmos_resistor_amplifier.hpp:32
        I(cpphdl_n1407, Vss) <+ 4e-14 * ddt(V(cpphdl_n1407, Vss)); // Bench initial voltage = 0.0 V.
        // device 962, IC IC166, analog/basic/nmos_resistor_amplifier.hpp:34
        I(cpphdl_n1401, cpphdl_n1405) <+ 2e-14 * ddt(V(cpphdl_n1401, cpphdl_n1405)); // Bench initial voltage = 0.0 V.
        // device 963, IC IC166, analog/basic/nmos_resistor_amplifier.hpp:35
        I(cpphdl_n1402, cpphdl_n1406) <+ 2e-14 * ddt(V(cpphdl_n1402, cpphdl_n1406)); // Bench initial voltage = 0.0 V.
        // device 964, IC IC166, analog/basic/nmos_resistor_amplifier.hpp:36
        I(cpphdl_n1401, cpphdl_n1411) <+ 2.9999999999999998e-15 * ddt(V(cpphdl_n1401, cpphdl_n1411)); // Bench initial voltage = 0.0 V.
        // device 965, IC IC166, analog/basic/nmos_resistor_amplifier.hpp:37
        I(cpphdl_n1402, cpphdl_n1410) <+ 2.9999999999999998e-15 * ddt(V(cpphdl_n1402, cpphdl_n1410)); // Bench initial voltage = 0.0 V.
        // device 966, IC IC167, analog/basic/strongarm_comparator.hpp:28
        I(cpphdl_n1415, cpphdl_n1417) <+ cpphdl_channel(V(cpphdl_n1410, cpphdl_n1417), V(cpphdl_n1415, cpphdl_n1417), 0.0080000000000000002, 0.69999999999999996, 1.0);
        // device 967, IC IC167, analog/basic/strongarm_comparator.hpp:29
        I(cpphdl_n1416, cpphdl_n1417) <+ cpphdl_channel(V(cpphdl_n1411, cpphdl_n1417), V(cpphdl_n1416, cpphdl_n1417), 0.0080000000000000002, 0.69999999999999996, 1.0);
        // device 968, IC IC167, analog/basic/strongarm_comparator.hpp:30
        I(cpphdl_n1417, Vss) <+ cpphdl_channel(V(EVALUATE, Vss), V(cpphdl_n1417, Vss), 0.0080000000000000002, 0.69999999999999996, 1.0);
        // device 969, IC IC167, analog/basic/strongarm_comparator.hpp:33
        I(cpphdl_n1430, cpphdl_n1415) <+ cpphdl_channel(V(cpphdl_n1434, cpphdl_n1415), V(cpphdl_n1430, cpphdl_n1415), 0.0040000000000000001, 0.69999999999999996, 1.0);
        // device 970, IC IC167, analog/basic/strongarm_comparator.hpp:34
        I(cpphdl_n1434, cpphdl_n1416) <+ cpphdl_channel(V(cpphdl_n1430, cpphdl_n1416), V(cpphdl_n1434, cpphdl_n1416), 0.0040000000000000001, 0.69999999999999996, 1.0);
        // device 971, IC IC167, analog/basic/strongarm_comparator.hpp:35
        I(cpphdl_n1434, Vdd) <+ cpphdl_channel(V(cpphdl_n1430, Vdd), V(cpphdl_n1434, Vdd), 0.002, 0.69999999999999996, -1.0);
        // device 972, IC IC167, analog/basic/strongarm_comparator.hpp:36
        I(cpphdl_n1430, Vdd) <+ cpphdl_channel(V(cpphdl_n1434, Vdd), V(cpphdl_n1430, Vdd), 0.002, 0.69999999999999996, -1.0);
        // device 973, IC IC167, analog/basic/strongarm_comparator.hpp:38
        I(cpphdl_n1415, Vdd) <+ cpphdl_channel(V(EVALUATE, Vdd), V(cpphdl_n1415, Vdd), 0.002, 0.69999999999999996, -1.0);
        // device 974, IC IC167, analog/basic/strongarm_comparator.hpp:39
        I(cpphdl_n1416, Vdd) <+ cpphdl_channel(V(EVALUATE, Vdd), V(cpphdl_n1416, Vdd), 0.002, 0.69999999999999996, -1.0);
        // device 975, IC IC167, analog/basic/strongarm_comparator.hpp:40
        I(cpphdl_n1434, Vdd) <+ cpphdl_channel(V(EVALUATE, Vdd), V(cpphdl_n1434, Vdd), 0.002, 0.69999999999999996, -1.0);
        // device 976, IC IC167, analog/basic/strongarm_comparator.hpp:41
        I(cpphdl_n1430, Vdd) <+ cpphdl_channel(V(EVALUATE, Vdd), V(cpphdl_n1430, Vdd), 0.002, 0.69999999999999996, -1.0);
        // device 977, IC IC167, analog/basic/strongarm_comparator.hpp:42
        I(cpphdl_n1415, Vss) <+ 2.9999999999999998e-14 * ddt(V(cpphdl_n1415, Vss)); // Bench initial voltage = 0.0 V.
        // device 978, IC IC167, analog/basic/strongarm_comparator.hpp:43
        I(cpphdl_n1416, Vss) <+ 2.9999999999999998e-14 * ddt(V(cpphdl_n1416, Vss)); // Bench initial voltage = 0.0 V.
        // device 979, IC IC167, analog/basic/strongarm_comparator.hpp:44
        I(cpphdl_n1417, Vss) <+ 2.9999999999999998e-14 * ddt(V(cpphdl_n1417, Vss)); // Bench initial voltage = 0.0 V.
        // device 980, IC IC167, analog/basic/strongarm_comparator.hpp:45
        I(cpphdl_n1434, Vss) <+ 5.0000000000000002e-14 * ddt(V(cpphdl_n1434, Vss)); // Bench initial voltage = 0.0 V.
        // device 981, IC IC167, analog/basic/strongarm_comparator.hpp:46
        I(cpphdl_n1430, Vss) <+ 5.0000000000000002e-14 * ddt(V(cpphdl_n1430, Vss)); // Bench initial voltage = 0.0 V.
        // device 982, IC IC167, analog/basic/strongarm_comparator.hpp:47
        I(cpphdl_n1410, cpphdl_n1417) <+ 2e-14 * ddt(V(cpphdl_n1410, cpphdl_n1417)); // Bench initial voltage = 0.0 V.
        // device 983, IC IC167, analog/basic/strongarm_comparator.hpp:48
        I(cpphdl_n1411, cpphdl_n1417) <+ 2e-14 * ddt(V(cpphdl_n1411, cpphdl_n1417)); // Bench initial voltage = 0.0 V.
        // device 984, IC IC167, analog/basic/strongarm_comparator.hpp:49
        I(cpphdl_n1410, cpphdl_n1415) <+ 2.9999999999999998e-15 * ddt(V(cpphdl_n1410, cpphdl_n1415)); // Bench initial voltage = 0.0 V.
        // device 985, IC IC167, analog/basic/strongarm_comparator.hpp:50
        I(cpphdl_n1411, cpphdl_n1416) <+ 2.9999999999999998e-15 * ddt(V(cpphdl_n1411, cpphdl_n1416)); // Bench initial voltage = 0.0 V.
        // device 986, IC IC169, analog/basic/inverter.hpp:11
        I(cpphdl_n1438, Vdd) <+ cpphdl_channel(V(cpphdl_n1430, Vdd), V(cpphdl_n1438, Vdd), 0.001, 0.69999999999999996, -1.0);
        // device 987, IC IC169, analog/basic/inverter.hpp:12
        I(cpphdl_n1438, Vss) <+ cpphdl_channel(V(cpphdl_n1430, Vss), V(cpphdl_n1438, Vss), 0.001, 0.69999999999999996, 1.0);
        // device 988, IC IC171, analog/basic/inverter.hpp:11
        I(cpphdl_n1452, Vdd) <+ cpphdl_channel(V(cpphdl_n1438, Vdd), V(cpphdl_n1452, Vdd), 0.0040000000000000001, 0.69999999999999996, -1.0);
        // device 989, IC IC171, analog/basic/inverter.hpp:12
        I(cpphdl_n1452, Vss) <+ cpphdl_channel(V(cpphdl_n1438, Vss), V(cpphdl_n1452, Vss), 0.0040000000000000001, 0.69999999999999996, 1.0);
        // device 990, IC IC168, analog/basic/buffered_nand_latch.hpp:34
        I(cpphdl_n1430, Vss) <+ 2.0000000000000002e-15 * ddt(V(cpphdl_n1430, Vss)); // Bench initial voltage = 0.0 V.
        // device 991, IC IC168, analog/basic/buffered_nand_latch.hpp:35
        I(cpphdl_n1430, cpphdl_n1438) <+ 1.0000000000000001e-15 * ddt(V(cpphdl_n1430, cpphdl_n1438)); // Bench initial voltage = 0.0 V.
        // device 992, IC IC168, analog/basic/buffered_nand_latch.hpp:36
        I(cpphdl_n1438, Vss) <+ 5e-15 * ddt(V(cpphdl_n1438, Vss)); // Bench initial voltage = 0.0 V.
        // device 993, IC IC168, analog/basic/buffered_nand_latch.hpp:37
        I(cpphdl_n1438, Vss) <+ 8.0000000000000006e-15 * ddt(V(cpphdl_n1438, Vss)); // Bench initial voltage = 0.0 V.
        // device 994, IC IC168, analog/basic/buffered_nand_latch.hpp:38
        I(cpphdl_n1452, Vss) <+ 1e-14 * ddt(V(cpphdl_n1452, Vss)); // Bench initial voltage = 0.0 V.
        // device 995, IC IC170, analog/basic/inverter.hpp:11
        I(cpphdl_n1442, Vdd) <+ cpphdl_channel(V(cpphdl_n1434, Vdd), V(cpphdl_n1442, Vdd), 0.001, 0.69999999999999996, -1.0);
        // device 996, IC IC170, analog/basic/inverter.hpp:12
        I(cpphdl_n1442, Vss) <+ cpphdl_channel(V(cpphdl_n1434, Vss), V(cpphdl_n1442, Vss), 0.001, 0.69999999999999996, 1.0);
        // device 997, IC IC172, analog/basic/inverter.hpp:11
        I(cpphdl_n1458, Vdd) <+ cpphdl_channel(V(cpphdl_n1442, Vdd), V(cpphdl_n1458, Vdd), 0.0040000000000000001, 0.69999999999999996, -1.0);
        // device 998, IC IC172, analog/basic/inverter.hpp:12
        I(cpphdl_n1458, Vss) <+ cpphdl_channel(V(cpphdl_n1442, Vss), V(cpphdl_n1458, Vss), 0.0040000000000000001, 0.69999999999999996, 1.0);
        // device 999, IC IC168, analog/basic/buffered_nand_latch.hpp:34
        I(cpphdl_n1434, Vss) <+ 2.0000000000000002e-15 * ddt(V(cpphdl_n1434, Vss)); // Bench initial voltage = 0.0 V.
        // device 1000, IC IC168, analog/basic/buffered_nand_latch.hpp:35
        I(cpphdl_n1434, cpphdl_n1442) <+ 1.0000000000000001e-15 * ddt(V(cpphdl_n1434, cpphdl_n1442)); // Bench initial voltage = 0.0 V.
        // device 1001, IC IC168, analog/basic/buffered_nand_latch.hpp:36
        I(cpphdl_n1442, Vss) <+ 5e-15 * ddt(V(cpphdl_n1442, Vss)); // Bench initial voltage = 0.0 V.
        // device 1002, IC IC168, analog/basic/buffered_nand_latch.hpp:37
        I(cpphdl_n1442, Vss) <+ 8.0000000000000006e-15 * ddt(V(cpphdl_n1442, Vss)); // Bench initial voltage = 0.0 V.
        // device 1003, IC IC168, analog/basic/buffered_nand_latch.hpp:38
        I(cpphdl_n1458, Vss) <+ 1e-14 * ddt(V(cpphdl_n1458, Vss)); // Bench initial voltage = 0.0 V.
        // device 1004, IC IC174, analog/basic/cmos_logic.hpp:17
        I(cpphdl_n2803, Vss) <+ 5.0000000000000002e-14 * ddt(V(cpphdl_n2803, Vss)); // Bench initial voltage = 0.0 V.
        // device 1005, IC IC174, analog/basic/cmos_logic.hpp:18
        I(cpphdl_n2803, Vdd) <+ cpphdl_channel(V(cpphdl_n1452, Vdd), V(cpphdl_n2803, Vdd), 0.01, 0.69999999999999996, -1.0);
        // device 1006, IC IC174, analog/basic/cmos_logic.hpp:19
        I(cpphdl_n2803, Vdd) <+ cpphdl_channel(V(cpphdl_n1460, Vdd), V(cpphdl_n2803, Vdd), 0.01, 0.69999999999999996, -1.0);
        // device 1007, IC IC174, analog/basic/cmos_logic.hpp:20
        I(cpphdl_n2803, cpphdl_n1455) <+ cpphdl_channel(V(cpphdl_n1452, cpphdl_n1455), V(cpphdl_n2803, cpphdl_n1455), 0.01, 0.69999999999999996, 1.0);
        // device 1008, IC IC174, analog/basic/cmos_logic.hpp:21
        I(cpphdl_n1455, Vss) <+ cpphdl_channel(V(cpphdl_n1460, Vss), V(cpphdl_n1455, Vss), 0.01, 0.69999999999999996, 1.0);
        // device 1009, IC IC174, analog/basic/cmos_logic.hpp:27
        I(cpphdl_n1455, Vss) <+ 1e-14 * ddt(V(cpphdl_n1455, Vss)); // Bench initial voltage = 0.0 V.
        // device 1010, IC IC175, analog/basic/cmos_logic.hpp:17
        I(cpphdl_n1460, Vss) <+ 5.0000000000000002e-14 * ddt(V(cpphdl_n1460, Vss)); // Bench initial voltage = 0.0 V.
        // device 1011, IC IC175, analog/basic/cmos_logic.hpp:18
        I(cpphdl_n1460, Vdd) <+ cpphdl_channel(V(cpphdl_n1458, Vdd), V(cpphdl_n1460, Vdd), 0.01, 0.69999999999999996, -1.0);
        // device 1012, IC IC175, analog/basic/cmos_logic.hpp:19
        I(cpphdl_n1460, Vdd) <+ cpphdl_channel(V(cpphdl_n2803, Vdd), V(cpphdl_n1460, Vdd), 0.01, 0.69999999999999996, -1.0);
        // device 1013, IC IC175, analog/basic/cmos_logic.hpp:20
        I(cpphdl_n1460, cpphdl_n1461) <+ cpphdl_channel(V(cpphdl_n1458, cpphdl_n1461), V(cpphdl_n1460, cpphdl_n1461), 0.01, 0.69999999999999996, 1.0);
        // device 1014, IC IC175, analog/basic/cmos_logic.hpp:21
        I(cpphdl_n1461, Vss) <+ cpphdl_channel(V(cpphdl_n2803, Vss), V(cpphdl_n1461, Vss), 0.01, 0.69999999999999996, 1.0);
        // device 1015, IC IC175, analog/basic/cmos_logic.hpp:27
        I(cpphdl_n1461, Vss) <+ 1e-14 * ddt(V(cpphdl_n1461, Vss)); // Bench initial voltage = 0.0 V.
        // device 1016, IC IC173, analog/basic/nand_latch.hpp:36
        I(cpphdl_n1452, Vss) <+ 2.9999999999999998e-15 * ddt(V(cpphdl_n1452, Vss)); // Bench initial voltage = 0.0 V.
        // device 1017, IC IC173, analog/basic/nand_latch.hpp:37
        I(cpphdl_n1458, Vss) <+ 2.9999999999999998e-15 * ddt(V(cpphdl_n1458, Vss)); // Bench initial voltage = 0.0 V.
        // device 1018, IC IC176, analog/basic/inverter.hpp:11
        I(cpphdl_n1466, Vdd) <+ cpphdl_channel(V(CLEAR, Vdd), V(cpphdl_n1466, Vdd), 0.01, 0.69999999999999996, -1.0);
        // device 1019, IC IC176, analog/basic/inverter.hpp:12
        I(cpphdl_n1466, Vss) <+ cpphdl_channel(V(CLEAR, Vss), V(cpphdl_n1466, Vss), 0.01, 0.69999999999999996, 1.0);
        // device 1020, IC IC173, analog/basic/nand_latch.hpp:58
        I(cpphdl_n1466, Vss) <+ 2.9999999999999998e-15 * ddt(V(cpphdl_n1466, Vss)); // Bench initial voltage = 0.0 V.
        // device 1021, IC IC173, analog/basic/nand_latch.hpp:59
        I(cpphdl_n2803, Vss) <+ cpphdl_channel(V(CLEAR, Vss), V(cpphdl_n2803, Vss), 0.050000000000000003, 0.69999999999999996, 1.0);
        // device 1022, IC IC173, analog/basic/nand_latch.hpp:60
        I(cpphdl_n1460, Vdd) <+ cpphdl_channel(V(cpphdl_n1466, Vdd), V(cpphdl_n1460, Vdd), 0.050000000000000003, 0.69999999999999996, -1.0);
        // device 1023, IC IC179, analog/basic/inverter.hpp:11
        I(cpphdl_n1490, Vdd) <+ cpphdl_channel(V(TRACK7, Vdd), V(cpphdl_n1490, Vdd), 0.0040000000000000001, 0.69999999999999996, -1.0);
        // device 1024, IC IC179, analog/basic/inverter.hpp:12
        I(cpphdl_n1490, Vss) <+ cpphdl_channel(V(TRACK7, Vss), V(cpphdl_n1490, Vss), 0.0040000000000000001, 0.69999999999999996, 1.0);
        // device 1025, IC IC178, analog/basic/mos_track_hold.hpp:31
        I(cpphdl_n1490, Vss) <+ 2e-14 * ddt(V(cpphdl_n1490, Vss)); // Bench initial voltage = 0.0 V.
        // device 1026, IC IC178, analog/basic/mos_track_hold.hpp:32
        I(cpphdl_n2628, cpphdl_n1544) <+ cpphdl_channel(V(TRACK7, cpphdl_n1544), V(cpphdl_n2628, cpphdl_n1544), 0.029999999999999999, 0.69999999999999996, 1.0);
        // device 1027, IC IC178, analog/basic/mos_track_hold.hpp:33
        I(cpphdl_n1544, cpphdl_n2628) <+ cpphdl_channel(V(cpphdl_n1490, cpphdl_n2628), V(cpphdl_n1544, cpphdl_n2628), 0.014999999999999999, 0.69999999999999996, -1.0);
        // device 1028, IC IC178, analog/basic/mos_track_hold.hpp:37
        I(cpphdl_n1544, cpphdl_n1544) <+ cpphdl_channel(V(cpphdl_n1490, cpphdl_n1544), V(cpphdl_n1544, cpphdl_n1544), 0.016, 0.69999999999999996, 1.0);
        // device 1029, IC IC178, analog/basic/mos_track_hold.hpp:38
        I(cpphdl_n1544, cpphdl_n1544) <+ cpphdl_channel(V(TRACK7, cpphdl_n1544), V(cpphdl_n1544, cpphdl_n1544), 0.0083999999999999995, 0.69999999999999996, -1.0);
        // device 1030, IC IC178, analog/basic/mos_track_hold.hpp:39
        I(cpphdl_n1544, Vss) <+ 1.5000000000000001e-12 * ddt(V(cpphdl_n1544, Vss)); // Bench initial voltage = 0.0 V.
        // device 1031, IC IC178, analog/basic/mos_track_hold.hpp:42
        I(TRACK7, cpphdl_n1544) <+ 2.0000000000000002e-15 * ddt(V(TRACK7, cpphdl_n1544)); // Bench initial voltage = -0.0 V.
        // device 1032, IC IC178, analog/basic/mos_track_hold.hpp:43
        I(cpphdl_n1490, cpphdl_n1544) <+ 2.0000000000000002e-15 * ddt(V(cpphdl_n1490, cpphdl_n1544)); // Bench initial voltage = 0.0 V.
        // device 1033, IC IC178, analog/basic/mos_track_hold.hpp:44
        I(cpphdl_n2628, cpphdl_n1544) <+ 1.0000000000000001e-15 * ddt(V(cpphdl_n2628, cpphdl_n1544)); // Bench initial voltage = 0.0 V.
        // device 1034, IC IC181, analog/basic/inverter.hpp:11
        I(cpphdl_n1505, Vdd) <+ cpphdl_channel(V(BIT_N7_0, Vdd), V(cpphdl_n1505, Vdd), 0.080000000000000002, 0.69999999999999996, -1.0);
        // device 1035, IC IC181, analog/basic/inverter.hpp:12
        I(cpphdl_n1505, Vss) <+ cpphdl_channel(V(BIT_N7_0, Vss), V(cpphdl_n1505, Vss), 0.080000000000000002, 0.69999999999999996, 1.0);
        // device 1036, IC IC180, analog/basic/mos_r2r_dac.hpp:27
        I(cpphdl_n1505, Vss) <+ 2.9999999999999998e-15 * ddt(V(cpphdl_n1505, Vss)); // Bench initial voltage = 0.0 V.
        // device 1037, IC IC180, analog/basic/mos_r2r_dac.hpp:28
        I(cpphdl_n1505, cpphdl_n1534) <+ V(cpphdl_n1505, cpphdl_n1534) / 2000.0;
        // device 1038, IC IC180, analog/basic/mos_r2r_dac.hpp:29
        I(cpphdl_n1534, Vss) <+ 2.9999999999999998e-15 * ddt(V(cpphdl_n1534, Vss)); // Bench initial voltage = 0.0 V.
        // device 1039, IC IC182, analog/basic/inverter.hpp:11
        I(cpphdl_n1509, Vdd) <+ cpphdl_channel(V(BIT_N7_1, Vdd), V(cpphdl_n1509, Vdd), 0.080000000000000002, 0.69999999999999996, -1.0);
        // device 1040, IC IC182, analog/basic/inverter.hpp:12
        I(cpphdl_n1509, Vss) <+ cpphdl_channel(V(BIT_N7_1, Vss), V(cpphdl_n1509, Vss), 0.080000000000000002, 0.69999999999999996, 1.0);
        // device 1041, IC IC180, analog/basic/mos_r2r_dac.hpp:27
        I(cpphdl_n1509, Vss) <+ 2.9999999999999998e-15 * ddt(V(cpphdl_n1509, Vss)); // Bench initial voltage = 0.0 V.
        // device 1042, IC IC180, analog/basic/mos_r2r_dac.hpp:28
        I(cpphdl_n1509, cpphdl_n1535) <+ V(cpphdl_n1509, cpphdl_n1535) / 2000.0;
        // device 1043, IC IC180, analog/basic/mos_r2r_dac.hpp:29
        I(cpphdl_n1535, Vss) <+ 2.9999999999999998e-15 * ddt(V(cpphdl_n1535, Vss)); // Bench initial voltage = 0.0 V.
        // device 1044, IC IC180, analog/basic/mos_r2r_dac.hpp:31
        I(cpphdl_n1534, cpphdl_n1535) <+ V(cpphdl_n1534, cpphdl_n1535) / 1000.0;
        // device 1045, IC IC183, analog/basic/inverter.hpp:11
        I(cpphdl_n1513, Vdd) <+ cpphdl_channel(V(BIT_N7_2, Vdd), V(cpphdl_n1513, Vdd), 0.080000000000000002, 0.69999999999999996, -1.0);
        // device 1046, IC IC183, analog/basic/inverter.hpp:12
        I(cpphdl_n1513, Vss) <+ cpphdl_channel(V(BIT_N7_2, Vss), V(cpphdl_n1513, Vss), 0.080000000000000002, 0.69999999999999996, 1.0);
        // device 1047, IC IC180, analog/basic/mos_r2r_dac.hpp:27
        I(cpphdl_n1513, Vss) <+ 2.9999999999999998e-15 * ddt(V(cpphdl_n1513, Vss)); // Bench initial voltage = 0.0 V.
        // device 1048, IC IC180, analog/basic/mos_r2r_dac.hpp:28
        I(cpphdl_n1513, cpphdl_n1536) <+ V(cpphdl_n1513, cpphdl_n1536) / 2000.0;
        // device 1049, IC IC180, analog/basic/mos_r2r_dac.hpp:29
        I(cpphdl_n1536, Vss) <+ 2.9999999999999998e-15 * ddt(V(cpphdl_n1536, Vss)); // Bench initial voltage = 0.0 V.
        // device 1050, IC IC180, analog/basic/mos_r2r_dac.hpp:31
        I(cpphdl_n1535, cpphdl_n1536) <+ V(cpphdl_n1535, cpphdl_n1536) / 1000.0;
        // device 1051, IC IC184, analog/basic/inverter.hpp:11
        I(cpphdl_n1517, Vdd) <+ cpphdl_channel(V(BIT_N7_3, Vdd), V(cpphdl_n1517, Vdd), 0.080000000000000002, 0.69999999999999996, -1.0);
        // device 1052, IC IC184, analog/basic/inverter.hpp:12
        I(cpphdl_n1517, Vss) <+ cpphdl_channel(V(BIT_N7_3, Vss), V(cpphdl_n1517, Vss), 0.080000000000000002, 0.69999999999999996, 1.0);
        // device 1053, IC IC180, analog/basic/mos_r2r_dac.hpp:27
        I(cpphdl_n1517, Vss) <+ 2.9999999999999998e-15 * ddt(V(cpphdl_n1517, Vss)); // Bench initial voltage = 0.0 V.
        // device 1054, IC IC180, analog/basic/mos_r2r_dac.hpp:28
        I(cpphdl_n1517, cpphdl_n1537) <+ V(cpphdl_n1517, cpphdl_n1537) / 2000.0;
        // device 1055, IC IC180, analog/basic/mos_r2r_dac.hpp:29
        I(cpphdl_n1537, Vss) <+ 2.9999999999999998e-15 * ddt(V(cpphdl_n1537, Vss)); // Bench initial voltage = 0.0 V.
        // device 1056, IC IC180, analog/basic/mos_r2r_dac.hpp:31
        I(cpphdl_n1536, cpphdl_n1537) <+ V(cpphdl_n1536, cpphdl_n1537) / 1000.0;
        // device 1057, IC IC185, analog/basic/inverter.hpp:11
        I(cpphdl_n1521, Vdd) <+ cpphdl_channel(V(BIT_N7_4, Vdd), V(cpphdl_n1521, Vdd), 0.080000000000000002, 0.69999999999999996, -1.0);
        // device 1058, IC IC185, analog/basic/inverter.hpp:12
        I(cpphdl_n1521, Vss) <+ cpphdl_channel(V(BIT_N7_4, Vss), V(cpphdl_n1521, Vss), 0.080000000000000002, 0.69999999999999996, 1.0);
        // device 1059, IC IC180, analog/basic/mos_r2r_dac.hpp:27
        I(cpphdl_n1521, Vss) <+ 2.9999999999999998e-15 * ddt(V(cpphdl_n1521, Vss)); // Bench initial voltage = 0.0 V.
        // device 1060, IC IC180, analog/basic/mos_r2r_dac.hpp:28
        I(cpphdl_n1521, cpphdl_n1538) <+ V(cpphdl_n1521, cpphdl_n1538) / 2000.0;
        // device 1061, IC IC180, analog/basic/mos_r2r_dac.hpp:29
        I(cpphdl_n1538, Vss) <+ 2.9999999999999998e-15 * ddt(V(cpphdl_n1538, Vss)); // Bench initial voltage = 0.0 V.
        // device 1062, IC IC180, analog/basic/mos_r2r_dac.hpp:31
        I(cpphdl_n1537, cpphdl_n1538) <+ V(cpphdl_n1537, cpphdl_n1538) / 1000.0;
        // device 1063, IC IC186, analog/basic/inverter.hpp:11
        I(cpphdl_n1525, Vdd) <+ cpphdl_channel(V(BIT_N7_5, Vdd), V(cpphdl_n1525, Vdd), 0.080000000000000002, 0.69999999999999996, -1.0);
        // device 1064, IC IC186, analog/basic/inverter.hpp:12
        I(cpphdl_n1525, Vss) <+ cpphdl_channel(V(BIT_N7_5, Vss), V(cpphdl_n1525, Vss), 0.080000000000000002, 0.69999999999999996, 1.0);
        // device 1065, IC IC180, analog/basic/mos_r2r_dac.hpp:27
        I(cpphdl_n1525, Vss) <+ 2.9999999999999998e-15 * ddt(V(cpphdl_n1525, Vss)); // Bench initial voltage = 0.0 V.
        // device 1066, IC IC180, analog/basic/mos_r2r_dac.hpp:28
        I(cpphdl_n1525, cpphdl_n1539) <+ V(cpphdl_n1525, cpphdl_n1539) / 2000.0;
        // device 1067, IC IC180, analog/basic/mos_r2r_dac.hpp:29
        I(cpphdl_n1539, Vss) <+ 2.9999999999999998e-15 * ddt(V(cpphdl_n1539, Vss)); // Bench initial voltage = 0.0 V.
        // device 1068, IC IC180, analog/basic/mos_r2r_dac.hpp:31
        I(cpphdl_n1538, cpphdl_n1539) <+ V(cpphdl_n1538, cpphdl_n1539) / 1000.0;
        // device 1069, IC IC187, analog/basic/inverter.hpp:11
        I(cpphdl_n1529, Vdd) <+ cpphdl_channel(V(BIT_N7_6, Vdd), V(cpphdl_n1529, Vdd), 0.080000000000000002, 0.69999999999999996, -1.0);
        // device 1070, IC IC187, analog/basic/inverter.hpp:12
        I(cpphdl_n1529, Vss) <+ cpphdl_channel(V(BIT_N7_6, Vss), V(cpphdl_n1529, Vss), 0.080000000000000002, 0.69999999999999996, 1.0);
        // device 1071, IC IC180, analog/basic/mos_r2r_dac.hpp:27
        I(cpphdl_n1529, Vss) <+ 2.9999999999999998e-15 * ddt(V(cpphdl_n1529, Vss)); // Bench initial voltage = 0.0 V.
        // device 1072, IC IC180, analog/basic/mos_r2r_dac.hpp:28
        I(cpphdl_n1529, cpphdl_n1540) <+ V(cpphdl_n1529, cpphdl_n1540) / 2000.0;
        // device 1073, IC IC180, analog/basic/mos_r2r_dac.hpp:29
        I(cpphdl_n1540, Vss) <+ 2.9999999999999998e-15 * ddt(V(cpphdl_n1540, Vss)); // Bench initial voltage = 0.0 V.
        // device 1074, IC IC180, analog/basic/mos_r2r_dac.hpp:31
        I(cpphdl_n1539, cpphdl_n1540) <+ V(cpphdl_n1539, cpphdl_n1540) / 1000.0;
        // device 1075, IC IC188, analog/basic/inverter.hpp:11
        I(cpphdl_n1533, Vdd) <+ cpphdl_channel(V(BIT_N7_7, Vdd), V(cpphdl_n1533, Vdd), 0.080000000000000002, 0.69999999999999996, -1.0);
        // device 1076, IC IC188, analog/basic/inverter.hpp:12
        I(cpphdl_n1533, Vss) <+ cpphdl_channel(V(BIT_N7_7, Vss), V(cpphdl_n1533, Vss), 0.080000000000000002, 0.69999999999999996, 1.0);
        // device 1077, IC IC180, analog/basic/mos_r2r_dac.hpp:27
        I(cpphdl_n1533, Vss) <+ 2.9999999999999998e-15 * ddt(V(cpphdl_n1533, Vss)); // Bench initial voltage = 0.0 V.
        // device 1078, IC IC180, analog/basic/mos_r2r_dac.hpp:28
        I(cpphdl_n1533, cpphdl_n1545) <+ V(cpphdl_n1533, cpphdl_n1545) / 2000.0;
        // device 1079, IC IC180, analog/basic/mos_r2r_dac.hpp:29
        I(cpphdl_n1545, Vss) <+ 2.9999999999999998e-15 * ddt(V(cpphdl_n1545, Vss)); // Bench initial voltage = 0.0 V.
        // device 1080, IC IC180, analog/basic/mos_r2r_dac.hpp:31
        I(cpphdl_n1540, cpphdl_n1545) <+ V(cpphdl_n1540, cpphdl_n1545) / 1000.0;
        // device 1081, IC IC180, analog/basic/mos_r2r_dac.hpp:33
        I(Vss, cpphdl_n1534) <+ V(Vss, cpphdl_n1534) / 2000.0;
        // device 1082, IC IC189, analog/basic/nmos_resistor_amplifier.hpp:23
        I(Vdd, cpphdl_n1554) <+ V(Vdd, cpphdl_n1554) / 1000.0;
        // device 1083, IC IC189, analog/basic/nmos_resistor_amplifier.hpp:24
        I(Vdd, cpphdl_n1553) <+ V(Vdd, cpphdl_n1553) / 1000.0;
        // device 1084, IC IC189, analog/basic/nmos_resistor_amplifier.hpp:25
        I(cpphdl_n1554, cpphdl_n1548) <+ cpphdl_channel(V(cpphdl_n1544, cpphdl_n1548), V(cpphdl_n1554, cpphdl_n1548), 0.0074999999999999997, 0.69999999999999996, 1.0);
        // device 1085, IC IC189, analog/basic/nmos_resistor_amplifier.hpp:26
        I(cpphdl_n1553, cpphdl_n1549) <+ cpphdl_channel(V(cpphdl_n1545, cpphdl_n1549), V(cpphdl_n1553, cpphdl_n1549), 0.0074999999999999997, 0.69999999999999996, 1.0);
        // device 1086, IC IC189, analog/basic/nmos_resistor_amplifier.hpp:27
        I(cpphdl_n1550, cpphdl_n1548) <+ V(cpphdl_n1550, cpphdl_n1548) / 100.0;
        // device 1087, IC IC189, analog/basic/nmos_resistor_amplifier.hpp:28
        I(cpphdl_n1550, cpphdl_n1549) <+ V(cpphdl_n1550, cpphdl_n1549) / 100.0;
        // device 1088, IC IC189, analog/basic/nmos_resistor_amplifier.hpp:29
        I(Vss, cpphdl_n1550) <+ V(Vss, cpphdl_n1550) / 300.0;
        // device 1089, IC IC189, analog/basic/nmos_resistor_amplifier.hpp:30
        I(cpphdl_n1554, Vdd) <+ 2.9999999999999998e-13 * ddt(V(cpphdl_n1554, Vdd)); // Bench initial voltage = 0.0 V.
        // device 1090, IC IC189, analog/basic/nmos_resistor_amplifier.hpp:31
        I(cpphdl_n1553, Vdd) <+ 2.9999999999999998e-13 * ddt(V(cpphdl_n1553, Vdd)); // Bench initial voltage = 0.0 V.
        // device 1091, IC IC189, analog/basic/nmos_resistor_amplifier.hpp:32
        I(cpphdl_n1550, Vss) <+ 4e-14 * ddt(V(cpphdl_n1550, Vss)); // Bench initial voltage = 0.0 V.
        // device 1092, IC IC189, analog/basic/nmos_resistor_amplifier.hpp:34
        I(cpphdl_n1544, cpphdl_n1548) <+ 2e-14 * ddt(V(cpphdl_n1544, cpphdl_n1548)); // Bench initial voltage = 0.0 V.
        // device 1093, IC IC189, analog/basic/nmos_resistor_amplifier.hpp:35
        I(cpphdl_n1545, cpphdl_n1549) <+ 2e-14 * ddt(V(cpphdl_n1545, cpphdl_n1549)); // Bench initial voltage = 0.0 V.
        // device 1094, IC IC189, analog/basic/nmos_resistor_amplifier.hpp:36
        I(cpphdl_n1544, cpphdl_n1554) <+ 2.9999999999999998e-15 * ddt(V(cpphdl_n1544, cpphdl_n1554)); // Bench initial voltage = 0.0 V.
        // device 1095, IC IC189, analog/basic/nmos_resistor_amplifier.hpp:37
        I(cpphdl_n1545, cpphdl_n1553) <+ 2.9999999999999998e-15 * ddt(V(cpphdl_n1545, cpphdl_n1553)); // Bench initial voltage = 0.0 V.
        // device 1096, IC IC190, analog/basic/strongarm_comparator.hpp:28
        I(cpphdl_n1558, cpphdl_n1560) <+ cpphdl_channel(V(cpphdl_n1553, cpphdl_n1560), V(cpphdl_n1558, cpphdl_n1560), 0.0080000000000000002, 0.69999999999999996, 1.0);
        // device 1097, IC IC190, analog/basic/strongarm_comparator.hpp:29
        I(cpphdl_n1559, cpphdl_n1560) <+ cpphdl_channel(V(cpphdl_n1554, cpphdl_n1560), V(cpphdl_n1559, cpphdl_n1560), 0.0080000000000000002, 0.69999999999999996, 1.0);
        // device 1098, IC IC190, analog/basic/strongarm_comparator.hpp:30
        I(cpphdl_n1560, Vss) <+ cpphdl_channel(V(EVALUATE, Vss), V(cpphdl_n1560, Vss), 0.0080000000000000002, 0.69999999999999996, 1.0);
        // device 1099, IC IC190, analog/basic/strongarm_comparator.hpp:33
        I(cpphdl_n1573, cpphdl_n1558) <+ cpphdl_channel(V(cpphdl_n1577, cpphdl_n1558), V(cpphdl_n1573, cpphdl_n1558), 0.0040000000000000001, 0.69999999999999996, 1.0);
        // device 1100, IC IC190, analog/basic/strongarm_comparator.hpp:34
        I(cpphdl_n1577, cpphdl_n1559) <+ cpphdl_channel(V(cpphdl_n1573, cpphdl_n1559), V(cpphdl_n1577, cpphdl_n1559), 0.0040000000000000001, 0.69999999999999996, 1.0);
        // device 1101, IC IC190, analog/basic/strongarm_comparator.hpp:35
        I(cpphdl_n1577, Vdd) <+ cpphdl_channel(V(cpphdl_n1573, Vdd), V(cpphdl_n1577, Vdd), 0.002, 0.69999999999999996, -1.0);
        // device 1102, IC IC190, analog/basic/strongarm_comparator.hpp:36
        I(cpphdl_n1573, Vdd) <+ cpphdl_channel(V(cpphdl_n1577, Vdd), V(cpphdl_n1573, Vdd), 0.002, 0.69999999999999996, -1.0);
        // device 1103, IC IC190, analog/basic/strongarm_comparator.hpp:38
        I(cpphdl_n1558, Vdd) <+ cpphdl_channel(V(EVALUATE, Vdd), V(cpphdl_n1558, Vdd), 0.002, 0.69999999999999996, -1.0);
        // device 1104, IC IC190, analog/basic/strongarm_comparator.hpp:39
        I(cpphdl_n1559, Vdd) <+ cpphdl_channel(V(EVALUATE, Vdd), V(cpphdl_n1559, Vdd), 0.002, 0.69999999999999996, -1.0);
        // device 1105, IC IC190, analog/basic/strongarm_comparator.hpp:40
        I(cpphdl_n1577, Vdd) <+ cpphdl_channel(V(EVALUATE, Vdd), V(cpphdl_n1577, Vdd), 0.002, 0.69999999999999996, -1.0);
        // device 1106, IC IC190, analog/basic/strongarm_comparator.hpp:41
        I(cpphdl_n1573, Vdd) <+ cpphdl_channel(V(EVALUATE, Vdd), V(cpphdl_n1573, Vdd), 0.002, 0.69999999999999996, -1.0);
        // device 1107, IC IC190, analog/basic/strongarm_comparator.hpp:42
        I(cpphdl_n1558, Vss) <+ 2.9999999999999998e-14 * ddt(V(cpphdl_n1558, Vss)); // Bench initial voltage = 0.0 V.
        // device 1108, IC IC190, analog/basic/strongarm_comparator.hpp:43
        I(cpphdl_n1559, Vss) <+ 2.9999999999999998e-14 * ddt(V(cpphdl_n1559, Vss)); // Bench initial voltage = 0.0 V.
        // device 1109, IC IC190, analog/basic/strongarm_comparator.hpp:44
        I(cpphdl_n1560, Vss) <+ 2.9999999999999998e-14 * ddt(V(cpphdl_n1560, Vss)); // Bench initial voltage = 0.0 V.
        // device 1110, IC IC190, analog/basic/strongarm_comparator.hpp:45
        I(cpphdl_n1577, Vss) <+ 5.0000000000000002e-14 * ddt(V(cpphdl_n1577, Vss)); // Bench initial voltage = 0.0 V.
        // device 1111, IC IC190, analog/basic/strongarm_comparator.hpp:46
        I(cpphdl_n1573, Vss) <+ 5.0000000000000002e-14 * ddt(V(cpphdl_n1573, Vss)); // Bench initial voltage = 0.0 V.
        // device 1112, IC IC190, analog/basic/strongarm_comparator.hpp:47
        I(cpphdl_n1553, cpphdl_n1560) <+ 2e-14 * ddt(V(cpphdl_n1553, cpphdl_n1560)); // Bench initial voltage = 0.0 V.
        // device 1113, IC IC190, analog/basic/strongarm_comparator.hpp:48
        I(cpphdl_n1554, cpphdl_n1560) <+ 2e-14 * ddt(V(cpphdl_n1554, cpphdl_n1560)); // Bench initial voltage = 0.0 V.
        // device 1114, IC IC190, analog/basic/strongarm_comparator.hpp:49
        I(cpphdl_n1553, cpphdl_n1558) <+ 2.9999999999999998e-15 * ddt(V(cpphdl_n1553, cpphdl_n1558)); // Bench initial voltage = 0.0 V.
        // device 1115, IC IC190, analog/basic/strongarm_comparator.hpp:50
        I(cpphdl_n1554, cpphdl_n1559) <+ 2.9999999999999998e-15 * ddt(V(cpphdl_n1554, cpphdl_n1559)); // Bench initial voltage = 0.0 V.
        // device 1116, IC IC192, analog/basic/inverter.hpp:11
        I(cpphdl_n1581, Vdd) <+ cpphdl_channel(V(cpphdl_n1573, Vdd), V(cpphdl_n1581, Vdd), 0.001, 0.69999999999999996, -1.0);
        // device 1117, IC IC192, analog/basic/inverter.hpp:12
        I(cpphdl_n1581, Vss) <+ cpphdl_channel(V(cpphdl_n1573, Vss), V(cpphdl_n1581, Vss), 0.001, 0.69999999999999996, 1.0);
        // device 1118, IC IC194, analog/basic/inverter.hpp:11
        I(cpphdl_n1595, Vdd) <+ cpphdl_channel(V(cpphdl_n1581, Vdd), V(cpphdl_n1595, Vdd), 0.0040000000000000001, 0.69999999999999996, -1.0);
        // device 1119, IC IC194, analog/basic/inverter.hpp:12
        I(cpphdl_n1595, Vss) <+ cpphdl_channel(V(cpphdl_n1581, Vss), V(cpphdl_n1595, Vss), 0.0040000000000000001, 0.69999999999999996, 1.0);
        // device 1120, IC IC191, analog/basic/buffered_nand_latch.hpp:34
        I(cpphdl_n1573, Vss) <+ 2.0000000000000002e-15 * ddt(V(cpphdl_n1573, Vss)); // Bench initial voltage = 0.0 V.
        // device 1121, IC IC191, analog/basic/buffered_nand_latch.hpp:35
        I(cpphdl_n1573, cpphdl_n1581) <+ 1.0000000000000001e-15 * ddt(V(cpphdl_n1573, cpphdl_n1581)); // Bench initial voltage = 0.0 V.
        // device 1122, IC IC191, analog/basic/buffered_nand_latch.hpp:36
        I(cpphdl_n1581, Vss) <+ 5e-15 * ddt(V(cpphdl_n1581, Vss)); // Bench initial voltage = 0.0 V.
        // device 1123, IC IC191, analog/basic/buffered_nand_latch.hpp:37
        I(cpphdl_n1581, Vss) <+ 8.0000000000000006e-15 * ddt(V(cpphdl_n1581, Vss)); // Bench initial voltage = 0.0 V.
        // device 1124, IC IC191, analog/basic/buffered_nand_latch.hpp:38
        I(cpphdl_n1595, Vss) <+ 1e-14 * ddt(V(cpphdl_n1595, Vss)); // Bench initial voltage = 0.0 V.
        // device 1125, IC IC193, analog/basic/inverter.hpp:11
        I(cpphdl_n1585, Vdd) <+ cpphdl_channel(V(cpphdl_n1577, Vdd), V(cpphdl_n1585, Vdd), 0.001, 0.69999999999999996, -1.0);
        // device 1126, IC IC193, analog/basic/inverter.hpp:12
        I(cpphdl_n1585, Vss) <+ cpphdl_channel(V(cpphdl_n1577, Vss), V(cpphdl_n1585, Vss), 0.001, 0.69999999999999996, 1.0);
        // device 1127, IC IC195, analog/basic/inverter.hpp:11
        I(cpphdl_n1601, Vdd) <+ cpphdl_channel(V(cpphdl_n1585, Vdd), V(cpphdl_n1601, Vdd), 0.0040000000000000001, 0.69999999999999996, -1.0);
        // device 1128, IC IC195, analog/basic/inverter.hpp:12
        I(cpphdl_n1601, Vss) <+ cpphdl_channel(V(cpphdl_n1585, Vss), V(cpphdl_n1601, Vss), 0.0040000000000000001, 0.69999999999999996, 1.0);
        // device 1129, IC IC191, analog/basic/buffered_nand_latch.hpp:34
        I(cpphdl_n1577, Vss) <+ 2.0000000000000002e-15 * ddt(V(cpphdl_n1577, Vss)); // Bench initial voltage = 0.0 V.
        // device 1130, IC IC191, analog/basic/buffered_nand_latch.hpp:35
        I(cpphdl_n1577, cpphdl_n1585) <+ 1.0000000000000001e-15 * ddt(V(cpphdl_n1577, cpphdl_n1585)); // Bench initial voltage = 0.0 V.
        // device 1131, IC IC191, analog/basic/buffered_nand_latch.hpp:36
        I(cpphdl_n1585, Vss) <+ 5e-15 * ddt(V(cpphdl_n1585, Vss)); // Bench initial voltage = 0.0 V.
        // device 1132, IC IC191, analog/basic/buffered_nand_latch.hpp:37
        I(cpphdl_n1585, Vss) <+ 8.0000000000000006e-15 * ddt(V(cpphdl_n1585, Vss)); // Bench initial voltage = 0.0 V.
        // device 1133, IC IC191, analog/basic/buffered_nand_latch.hpp:38
        I(cpphdl_n1601, Vss) <+ 1e-14 * ddt(V(cpphdl_n1601, Vss)); // Bench initial voltage = 0.0 V.
        // device 1134, IC IC197, analog/basic/cmos_logic.hpp:17
        I(cpphdl_n2808, Vss) <+ 5.0000000000000002e-14 * ddt(V(cpphdl_n2808, Vss)); // Bench initial voltage = 0.0 V.
        // device 1135, IC IC197, analog/basic/cmos_logic.hpp:18
        I(cpphdl_n2808, Vdd) <+ cpphdl_channel(V(cpphdl_n1595, Vdd), V(cpphdl_n2808, Vdd), 0.01, 0.69999999999999996, -1.0);
        // device 1136, IC IC197, analog/basic/cmos_logic.hpp:19
        I(cpphdl_n2808, Vdd) <+ cpphdl_channel(V(cpphdl_n1603, Vdd), V(cpphdl_n2808, Vdd), 0.01, 0.69999999999999996, -1.0);
        // device 1137, IC IC197, analog/basic/cmos_logic.hpp:20
        I(cpphdl_n2808, cpphdl_n1598) <+ cpphdl_channel(V(cpphdl_n1595, cpphdl_n1598), V(cpphdl_n2808, cpphdl_n1598), 0.01, 0.69999999999999996, 1.0);
        // device 1138, IC IC197, analog/basic/cmos_logic.hpp:21
        I(cpphdl_n1598, Vss) <+ cpphdl_channel(V(cpphdl_n1603, Vss), V(cpphdl_n1598, Vss), 0.01, 0.69999999999999996, 1.0);
        // device 1139, IC IC197, analog/basic/cmos_logic.hpp:27
        I(cpphdl_n1598, Vss) <+ 1e-14 * ddt(V(cpphdl_n1598, Vss)); // Bench initial voltage = 0.0 V.
        // device 1140, IC IC198, analog/basic/cmos_logic.hpp:17
        I(cpphdl_n1603, Vss) <+ 5.0000000000000002e-14 * ddt(V(cpphdl_n1603, Vss)); // Bench initial voltage = 0.0 V.
        // device 1141, IC IC198, analog/basic/cmos_logic.hpp:18
        I(cpphdl_n1603, Vdd) <+ cpphdl_channel(V(cpphdl_n1601, Vdd), V(cpphdl_n1603, Vdd), 0.01, 0.69999999999999996, -1.0);
        // device 1142, IC IC198, analog/basic/cmos_logic.hpp:19
        I(cpphdl_n1603, Vdd) <+ cpphdl_channel(V(cpphdl_n2808, Vdd), V(cpphdl_n1603, Vdd), 0.01, 0.69999999999999996, -1.0);
        // device 1143, IC IC198, analog/basic/cmos_logic.hpp:20
        I(cpphdl_n1603, cpphdl_n1604) <+ cpphdl_channel(V(cpphdl_n1601, cpphdl_n1604), V(cpphdl_n1603, cpphdl_n1604), 0.01, 0.69999999999999996, 1.0);
        // device 1144, IC IC198, analog/basic/cmos_logic.hpp:21
        I(cpphdl_n1604, Vss) <+ cpphdl_channel(V(cpphdl_n2808, Vss), V(cpphdl_n1604, Vss), 0.01, 0.69999999999999996, 1.0);
        // device 1145, IC IC198, analog/basic/cmos_logic.hpp:27
        I(cpphdl_n1604, Vss) <+ 1e-14 * ddt(V(cpphdl_n1604, Vss)); // Bench initial voltage = 0.0 V.
        // device 1146, IC IC196, analog/basic/nand_latch.hpp:36
        I(cpphdl_n1595, Vss) <+ 2.9999999999999998e-15 * ddt(V(cpphdl_n1595, Vss)); // Bench initial voltage = 0.0 V.
        // device 1147, IC IC196, analog/basic/nand_latch.hpp:37
        I(cpphdl_n1601, Vss) <+ 2.9999999999999998e-15 * ddt(V(cpphdl_n1601, Vss)); // Bench initial voltage = 0.0 V.
        // device 1148, IC IC199, analog/basic/inverter.hpp:11
        I(cpphdl_n1609, Vdd) <+ cpphdl_channel(V(CLEAR, Vdd), V(cpphdl_n1609, Vdd), 0.01, 0.69999999999999996, -1.0);
        // device 1149, IC IC199, analog/basic/inverter.hpp:12
        I(cpphdl_n1609, Vss) <+ cpphdl_channel(V(CLEAR, Vss), V(cpphdl_n1609, Vss), 0.01, 0.69999999999999996, 1.0);
        // device 1150, IC IC196, analog/basic/nand_latch.hpp:58
        I(cpphdl_n1609, Vss) <+ 2.9999999999999998e-15 * ddt(V(cpphdl_n1609, Vss)); // Bench initial voltage = 0.0 V.
        // device 1151, IC IC196, analog/basic/nand_latch.hpp:59
        I(cpphdl_n2808, Vss) <+ cpphdl_channel(V(CLEAR, Vss), V(cpphdl_n2808, Vss), 0.050000000000000003, 0.69999999999999996, 1.0);
        // device 1152, IC IC196, analog/basic/nand_latch.hpp:60
        I(cpphdl_n1603, Vdd) <+ cpphdl_channel(V(cpphdl_n1609, Vdd), V(cpphdl_n1603, Vdd), 0.050000000000000003, 0.69999999999999996, -1.0);
        // device 1153, IC IC202, analog/basic/inverter.hpp:11
        I(cpphdl_n1633, Vdd) <+ cpphdl_channel(V(TRACK8, Vdd), V(cpphdl_n1633, Vdd), 0.0040000000000000001, 0.69999999999999996, -1.0);
        // device 1154, IC IC202, analog/basic/inverter.hpp:12
        I(cpphdl_n1633, Vss) <+ cpphdl_channel(V(TRACK8, Vss), V(cpphdl_n1633, Vss), 0.0040000000000000001, 0.69999999999999996, 1.0);
        // device 1155, IC IC201, analog/basic/mos_track_hold.hpp:31
        I(cpphdl_n1633, Vss) <+ 2e-14 * ddt(V(cpphdl_n1633, Vss)); // Bench initial voltage = 0.0 V.
        // device 1156, IC IC201, analog/basic/mos_track_hold.hpp:32
        I(cpphdl_n2628, cpphdl_n1687) <+ cpphdl_channel(V(TRACK8, cpphdl_n1687), V(cpphdl_n2628, cpphdl_n1687), 0.029999999999999999, 0.69999999999999996, 1.0);
        // device 1157, IC IC201, analog/basic/mos_track_hold.hpp:33
        I(cpphdl_n1687, cpphdl_n2628) <+ cpphdl_channel(V(cpphdl_n1633, cpphdl_n2628), V(cpphdl_n1687, cpphdl_n2628), 0.014999999999999999, 0.69999999999999996, -1.0);
        // device 1158, IC IC201, analog/basic/mos_track_hold.hpp:37
        I(cpphdl_n1687, cpphdl_n1687) <+ cpphdl_channel(V(cpphdl_n1633, cpphdl_n1687), V(cpphdl_n1687, cpphdl_n1687), 0.016, 0.69999999999999996, 1.0);
        // device 1159, IC IC201, analog/basic/mos_track_hold.hpp:38
        I(cpphdl_n1687, cpphdl_n1687) <+ cpphdl_channel(V(TRACK8, cpphdl_n1687), V(cpphdl_n1687, cpphdl_n1687), 0.0083999999999999995, 0.69999999999999996, -1.0);
        // device 1160, IC IC201, analog/basic/mos_track_hold.hpp:39
        I(cpphdl_n1687, Vss) <+ 1.5000000000000001e-12 * ddt(V(cpphdl_n1687, Vss)); // Bench initial voltage = 0.0 V.
        // device 1161, IC IC201, analog/basic/mos_track_hold.hpp:42
        I(TRACK8, cpphdl_n1687) <+ 2.0000000000000002e-15 * ddt(V(TRACK8, cpphdl_n1687)); // Bench initial voltage = -0.0 V.
        // device 1162, IC IC201, analog/basic/mos_track_hold.hpp:43
        I(cpphdl_n1633, cpphdl_n1687) <+ 2.0000000000000002e-15 * ddt(V(cpphdl_n1633, cpphdl_n1687)); // Bench initial voltage = 0.0 V.
        // device 1163, IC IC201, analog/basic/mos_track_hold.hpp:44
        I(cpphdl_n2628, cpphdl_n1687) <+ 1.0000000000000001e-15 * ddt(V(cpphdl_n2628, cpphdl_n1687)); // Bench initial voltage = 0.0 V.
        // device 1164, IC IC204, analog/basic/inverter.hpp:11
        I(cpphdl_n1648, Vdd) <+ cpphdl_channel(V(BIT_N8_0, Vdd), V(cpphdl_n1648, Vdd), 0.080000000000000002, 0.69999999999999996, -1.0);
        // device 1165, IC IC204, analog/basic/inverter.hpp:12
        I(cpphdl_n1648, Vss) <+ cpphdl_channel(V(BIT_N8_0, Vss), V(cpphdl_n1648, Vss), 0.080000000000000002, 0.69999999999999996, 1.0);
        // device 1166, IC IC203, analog/basic/mos_r2r_dac.hpp:27
        I(cpphdl_n1648, Vss) <+ 2.9999999999999998e-15 * ddt(V(cpphdl_n1648, Vss)); // Bench initial voltage = 0.0 V.
        // device 1167, IC IC203, analog/basic/mos_r2r_dac.hpp:28
        I(cpphdl_n1648, cpphdl_n1677) <+ V(cpphdl_n1648, cpphdl_n1677) / 2000.0;
        // device 1168, IC IC203, analog/basic/mos_r2r_dac.hpp:29
        I(cpphdl_n1677, Vss) <+ 2.9999999999999998e-15 * ddt(V(cpphdl_n1677, Vss)); // Bench initial voltage = 0.0 V.
        // device 1169, IC IC205, analog/basic/inverter.hpp:11
        I(cpphdl_n1652, Vdd) <+ cpphdl_channel(V(BIT_N8_1, Vdd), V(cpphdl_n1652, Vdd), 0.080000000000000002, 0.69999999999999996, -1.0);
        // device 1170, IC IC205, analog/basic/inverter.hpp:12
        I(cpphdl_n1652, Vss) <+ cpphdl_channel(V(BIT_N8_1, Vss), V(cpphdl_n1652, Vss), 0.080000000000000002, 0.69999999999999996, 1.0);
        // device 1171, IC IC203, analog/basic/mos_r2r_dac.hpp:27
        I(cpphdl_n1652, Vss) <+ 2.9999999999999998e-15 * ddt(V(cpphdl_n1652, Vss)); // Bench initial voltage = 0.0 V.
        // device 1172, IC IC203, analog/basic/mos_r2r_dac.hpp:28
        I(cpphdl_n1652, cpphdl_n1678) <+ V(cpphdl_n1652, cpphdl_n1678) / 2000.0;
        // device 1173, IC IC203, analog/basic/mos_r2r_dac.hpp:29
        I(cpphdl_n1678, Vss) <+ 2.9999999999999998e-15 * ddt(V(cpphdl_n1678, Vss)); // Bench initial voltage = 0.0 V.
        // device 1174, IC IC203, analog/basic/mos_r2r_dac.hpp:31
        I(cpphdl_n1677, cpphdl_n1678) <+ V(cpphdl_n1677, cpphdl_n1678) / 1000.0;
        // device 1175, IC IC206, analog/basic/inverter.hpp:11
        I(cpphdl_n1656, Vdd) <+ cpphdl_channel(V(BIT_N8_2, Vdd), V(cpphdl_n1656, Vdd), 0.080000000000000002, 0.69999999999999996, -1.0);
        // device 1176, IC IC206, analog/basic/inverter.hpp:12
        I(cpphdl_n1656, Vss) <+ cpphdl_channel(V(BIT_N8_2, Vss), V(cpphdl_n1656, Vss), 0.080000000000000002, 0.69999999999999996, 1.0);
        // device 1177, IC IC203, analog/basic/mos_r2r_dac.hpp:27
        I(cpphdl_n1656, Vss) <+ 2.9999999999999998e-15 * ddt(V(cpphdl_n1656, Vss)); // Bench initial voltage = 0.0 V.
        // device 1178, IC IC203, analog/basic/mos_r2r_dac.hpp:28
        I(cpphdl_n1656, cpphdl_n1679) <+ V(cpphdl_n1656, cpphdl_n1679) / 2000.0;
        // device 1179, IC IC203, analog/basic/mos_r2r_dac.hpp:29
        I(cpphdl_n1679, Vss) <+ 2.9999999999999998e-15 * ddt(V(cpphdl_n1679, Vss)); // Bench initial voltage = 0.0 V.
        // device 1180, IC IC203, analog/basic/mos_r2r_dac.hpp:31
        I(cpphdl_n1678, cpphdl_n1679) <+ V(cpphdl_n1678, cpphdl_n1679) / 1000.0;
        // device 1181, IC IC207, analog/basic/inverter.hpp:11
        I(cpphdl_n1660, Vdd) <+ cpphdl_channel(V(BIT_N8_3, Vdd), V(cpphdl_n1660, Vdd), 0.080000000000000002, 0.69999999999999996, -1.0);
        // device 1182, IC IC207, analog/basic/inverter.hpp:12
        I(cpphdl_n1660, Vss) <+ cpphdl_channel(V(BIT_N8_3, Vss), V(cpphdl_n1660, Vss), 0.080000000000000002, 0.69999999999999996, 1.0);
        // device 1183, IC IC203, analog/basic/mos_r2r_dac.hpp:27
        I(cpphdl_n1660, Vss) <+ 2.9999999999999998e-15 * ddt(V(cpphdl_n1660, Vss)); // Bench initial voltage = 0.0 V.
        // device 1184, IC IC203, analog/basic/mos_r2r_dac.hpp:28
        I(cpphdl_n1660, cpphdl_n1680) <+ V(cpphdl_n1660, cpphdl_n1680) / 2000.0;
        // device 1185, IC IC203, analog/basic/mos_r2r_dac.hpp:29
        I(cpphdl_n1680, Vss) <+ 2.9999999999999998e-15 * ddt(V(cpphdl_n1680, Vss)); // Bench initial voltage = 0.0 V.
        // device 1186, IC IC203, analog/basic/mos_r2r_dac.hpp:31
        I(cpphdl_n1679, cpphdl_n1680) <+ V(cpphdl_n1679, cpphdl_n1680) / 1000.0;
        // device 1187, IC IC208, analog/basic/inverter.hpp:11
        I(cpphdl_n1664, Vdd) <+ cpphdl_channel(V(BIT_N8_4, Vdd), V(cpphdl_n1664, Vdd), 0.080000000000000002, 0.69999999999999996, -1.0);
        // device 1188, IC IC208, analog/basic/inverter.hpp:12
        I(cpphdl_n1664, Vss) <+ cpphdl_channel(V(BIT_N8_4, Vss), V(cpphdl_n1664, Vss), 0.080000000000000002, 0.69999999999999996, 1.0);
        // device 1189, IC IC203, analog/basic/mos_r2r_dac.hpp:27
        I(cpphdl_n1664, Vss) <+ 2.9999999999999998e-15 * ddt(V(cpphdl_n1664, Vss)); // Bench initial voltage = 0.0 V.
        // device 1190, IC IC203, analog/basic/mos_r2r_dac.hpp:28
        I(cpphdl_n1664, cpphdl_n1681) <+ V(cpphdl_n1664, cpphdl_n1681) / 2000.0;
        // device 1191, IC IC203, analog/basic/mos_r2r_dac.hpp:29
        I(cpphdl_n1681, Vss) <+ 2.9999999999999998e-15 * ddt(V(cpphdl_n1681, Vss)); // Bench initial voltage = 0.0 V.
        // device 1192, IC IC203, analog/basic/mos_r2r_dac.hpp:31
        I(cpphdl_n1680, cpphdl_n1681) <+ V(cpphdl_n1680, cpphdl_n1681) / 1000.0;
        // device 1193, IC IC209, analog/basic/inverter.hpp:11
        I(cpphdl_n1668, Vdd) <+ cpphdl_channel(V(BIT_N8_5, Vdd), V(cpphdl_n1668, Vdd), 0.080000000000000002, 0.69999999999999996, -1.0);
        // device 1194, IC IC209, analog/basic/inverter.hpp:12
        I(cpphdl_n1668, Vss) <+ cpphdl_channel(V(BIT_N8_5, Vss), V(cpphdl_n1668, Vss), 0.080000000000000002, 0.69999999999999996, 1.0);
        // device 1195, IC IC203, analog/basic/mos_r2r_dac.hpp:27
        I(cpphdl_n1668, Vss) <+ 2.9999999999999998e-15 * ddt(V(cpphdl_n1668, Vss)); // Bench initial voltage = 0.0 V.
        // device 1196, IC IC203, analog/basic/mos_r2r_dac.hpp:28
        I(cpphdl_n1668, cpphdl_n1682) <+ V(cpphdl_n1668, cpphdl_n1682) / 2000.0;
        // device 1197, IC IC203, analog/basic/mos_r2r_dac.hpp:29
        I(cpphdl_n1682, Vss) <+ 2.9999999999999998e-15 * ddt(V(cpphdl_n1682, Vss)); // Bench initial voltage = 0.0 V.
        // device 1198, IC IC203, analog/basic/mos_r2r_dac.hpp:31
        I(cpphdl_n1681, cpphdl_n1682) <+ V(cpphdl_n1681, cpphdl_n1682) / 1000.0;
        // device 1199, IC IC210, analog/basic/inverter.hpp:11
        I(cpphdl_n1672, Vdd) <+ cpphdl_channel(V(BIT_N8_6, Vdd), V(cpphdl_n1672, Vdd), 0.080000000000000002, 0.69999999999999996, -1.0);
        // device 1200, IC IC210, analog/basic/inverter.hpp:12
        I(cpphdl_n1672, Vss) <+ cpphdl_channel(V(BIT_N8_6, Vss), V(cpphdl_n1672, Vss), 0.080000000000000002, 0.69999999999999996, 1.0);
        // device 1201, IC IC203, analog/basic/mos_r2r_dac.hpp:27
        I(cpphdl_n1672, Vss) <+ 2.9999999999999998e-15 * ddt(V(cpphdl_n1672, Vss)); // Bench initial voltage = 0.0 V.
        // device 1202, IC IC203, analog/basic/mos_r2r_dac.hpp:28
        I(cpphdl_n1672, cpphdl_n1683) <+ V(cpphdl_n1672, cpphdl_n1683) / 2000.0;
        // device 1203, IC IC203, analog/basic/mos_r2r_dac.hpp:29
        I(cpphdl_n1683, Vss) <+ 2.9999999999999998e-15 * ddt(V(cpphdl_n1683, Vss)); // Bench initial voltage = 0.0 V.
        // device 1204, IC IC203, analog/basic/mos_r2r_dac.hpp:31
        I(cpphdl_n1682, cpphdl_n1683) <+ V(cpphdl_n1682, cpphdl_n1683) / 1000.0;
        // device 1205, IC IC211, analog/basic/inverter.hpp:11
        I(cpphdl_n1676, Vdd) <+ cpphdl_channel(V(BIT_N8_7, Vdd), V(cpphdl_n1676, Vdd), 0.080000000000000002, 0.69999999999999996, -1.0);
        // device 1206, IC IC211, analog/basic/inverter.hpp:12
        I(cpphdl_n1676, Vss) <+ cpphdl_channel(V(BIT_N8_7, Vss), V(cpphdl_n1676, Vss), 0.080000000000000002, 0.69999999999999996, 1.0);
        // device 1207, IC IC203, analog/basic/mos_r2r_dac.hpp:27
        I(cpphdl_n1676, Vss) <+ 2.9999999999999998e-15 * ddt(V(cpphdl_n1676, Vss)); // Bench initial voltage = 0.0 V.
        // device 1208, IC IC203, analog/basic/mos_r2r_dac.hpp:28
        I(cpphdl_n1676, cpphdl_n1688) <+ V(cpphdl_n1676, cpphdl_n1688) / 2000.0;
        // device 1209, IC IC203, analog/basic/mos_r2r_dac.hpp:29
        I(cpphdl_n1688, Vss) <+ 2.9999999999999998e-15 * ddt(V(cpphdl_n1688, Vss)); // Bench initial voltage = 0.0 V.
        // device 1210, IC IC203, analog/basic/mos_r2r_dac.hpp:31
        I(cpphdl_n1683, cpphdl_n1688) <+ V(cpphdl_n1683, cpphdl_n1688) / 1000.0;
        // device 1211, IC IC203, analog/basic/mos_r2r_dac.hpp:33
        I(Vss, cpphdl_n1677) <+ V(Vss, cpphdl_n1677) / 2000.0;
        // device 1212, IC IC212, analog/basic/nmos_resistor_amplifier.hpp:23
        I(Vdd, cpphdl_n1697) <+ V(Vdd, cpphdl_n1697) / 1000.0;
        // device 1213, IC IC212, analog/basic/nmos_resistor_amplifier.hpp:24
        I(Vdd, cpphdl_n1696) <+ V(Vdd, cpphdl_n1696) / 1000.0;
        // device 1214, IC IC212, analog/basic/nmos_resistor_amplifier.hpp:25
        I(cpphdl_n1697, cpphdl_n1691) <+ cpphdl_channel(V(cpphdl_n1687, cpphdl_n1691), V(cpphdl_n1697, cpphdl_n1691), 0.0074999999999999997, 0.69999999999999996, 1.0);
        // device 1215, IC IC212, analog/basic/nmos_resistor_amplifier.hpp:26
        I(cpphdl_n1696, cpphdl_n1692) <+ cpphdl_channel(V(cpphdl_n1688, cpphdl_n1692), V(cpphdl_n1696, cpphdl_n1692), 0.0074999999999999997, 0.69999999999999996, 1.0);
        // device 1216, IC IC212, analog/basic/nmos_resistor_amplifier.hpp:27
        I(cpphdl_n1693, cpphdl_n1691) <+ V(cpphdl_n1693, cpphdl_n1691) / 100.0;
        // device 1217, IC IC212, analog/basic/nmos_resistor_amplifier.hpp:28
        I(cpphdl_n1693, cpphdl_n1692) <+ V(cpphdl_n1693, cpphdl_n1692) / 100.0;
        // device 1218, IC IC212, analog/basic/nmos_resistor_amplifier.hpp:29
        I(Vss, cpphdl_n1693) <+ V(Vss, cpphdl_n1693) / 300.0;
        // device 1219, IC IC212, analog/basic/nmos_resistor_amplifier.hpp:30
        I(cpphdl_n1697, Vdd) <+ 2.9999999999999998e-13 * ddt(V(cpphdl_n1697, Vdd)); // Bench initial voltage = 0.0 V.
        // device 1220, IC IC212, analog/basic/nmos_resistor_amplifier.hpp:31
        I(cpphdl_n1696, Vdd) <+ 2.9999999999999998e-13 * ddt(V(cpphdl_n1696, Vdd)); // Bench initial voltage = 0.0 V.
        // device 1221, IC IC212, analog/basic/nmos_resistor_amplifier.hpp:32
        I(cpphdl_n1693, Vss) <+ 4e-14 * ddt(V(cpphdl_n1693, Vss)); // Bench initial voltage = 0.0 V.
        // device 1222, IC IC212, analog/basic/nmos_resistor_amplifier.hpp:34
        I(cpphdl_n1687, cpphdl_n1691) <+ 2e-14 * ddt(V(cpphdl_n1687, cpphdl_n1691)); // Bench initial voltage = 0.0 V.
        // device 1223, IC IC212, analog/basic/nmos_resistor_amplifier.hpp:35
        I(cpphdl_n1688, cpphdl_n1692) <+ 2e-14 * ddt(V(cpphdl_n1688, cpphdl_n1692)); // Bench initial voltage = 0.0 V.
        // device 1224, IC IC212, analog/basic/nmos_resistor_amplifier.hpp:36
        I(cpphdl_n1687, cpphdl_n1697) <+ 2.9999999999999998e-15 * ddt(V(cpphdl_n1687, cpphdl_n1697)); // Bench initial voltage = 0.0 V.
        // device 1225, IC IC212, analog/basic/nmos_resistor_amplifier.hpp:37
        I(cpphdl_n1688, cpphdl_n1696) <+ 2.9999999999999998e-15 * ddt(V(cpphdl_n1688, cpphdl_n1696)); // Bench initial voltage = 0.0 V.
        // device 1226, IC IC213, analog/basic/strongarm_comparator.hpp:28
        I(cpphdl_n1701, cpphdl_n1703) <+ cpphdl_channel(V(cpphdl_n1696, cpphdl_n1703), V(cpphdl_n1701, cpphdl_n1703), 0.0080000000000000002, 0.69999999999999996, 1.0);
        // device 1227, IC IC213, analog/basic/strongarm_comparator.hpp:29
        I(cpphdl_n1702, cpphdl_n1703) <+ cpphdl_channel(V(cpphdl_n1697, cpphdl_n1703), V(cpphdl_n1702, cpphdl_n1703), 0.0080000000000000002, 0.69999999999999996, 1.0);
        // device 1228, IC IC213, analog/basic/strongarm_comparator.hpp:30
        I(cpphdl_n1703, Vss) <+ cpphdl_channel(V(EVALUATE, Vss), V(cpphdl_n1703, Vss), 0.0080000000000000002, 0.69999999999999996, 1.0);
        // device 1229, IC IC213, analog/basic/strongarm_comparator.hpp:33
        I(cpphdl_n1716, cpphdl_n1701) <+ cpphdl_channel(V(cpphdl_n1720, cpphdl_n1701), V(cpphdl_n1716, cpphdl_n1701), 0.0040000000000000001, 0.69999999999999996, 1.0);
        // device 1230, IC IC213, analog/basic/strongarm_comparator.hpp:34
        I(cpphdl_n1720, cpphdl_n1702) <+ cpphdl_channel(V(cpphdl_n1716, cpphdl_n1702), V(cpphdl_n1720, cpphdl_n1702), 0.0040000000000000001, 0.69999999999999996, 1.0);
        // device 1231, IC IC213, analog/basic/strongarm_comparator.hpp:35
        I(cpphdl_n1720, Vdd) <+ cpphdl_channel(V(cpphdl_n1716, Vdd), V(cpphdl_n1720, Vdd), 0.002, 0.69999999999999996, -1.0);
        // device 1232, IC IC213, analog/basic/strongarm_comparator.hpp:36
        I(cpphdl_n1716, Vdd) <+ cpphdl_channel(V(cpphdl_n1720, Vdd), V(cpphdl_n1716, Vdd), 0.002, 0.69999999999999996, -1.0);
        // device 1233, IC IC213, analog/basic/strongarm_comparator.hpp:38
        I(cpphdl_n1701, Vdd) <+ cpphdl_channel(V(EVALUATE, Vdd), V(cpphdl_n1701, Vdd), 0.002, 0.69999999999999996, -1.0);
        // device 1234, IC IC213, analog/basic/strongarm_comparator.hpp:39
        I(cpphdl_n1702, Vdd) <+ cpphdl_channel(V(EVALUATE, Vdd), V(cpphdl_n1702, Vdd), 0.002, 0.69999999999999996, -1.0);
        // device 1235, IC IC213, analog/basic/strongarm_comparator.hpp:40
        I(cpphdl_n1720, Vdd) <+ cpphdl_channel(V(EVALUATE, Vdd), V(cpphdl_n1720, Vdd), 0.002, 0.69999999999999996, -1.0);
        // device 1236, IC IC213, analog/basic/strongarm_comparator.hpp:41
        I(cpphdl_n1716, Vdd) <+ cpphdl_channel(V(EVALUATE, Vdd), V(cpphdl_n1716, Vdd), 0.002, 0.69999999999999996, -1.0);
        // device 1237, IC IC213, analog/basic/strongarm_comparator.hpp:42
        I(cpphdl_n1701, Vss) <+ 2.9999999999999998e-14 * ddt(V(cpphdl_n1701, Vss)); // Bench initial voltage = 0.0 V.
        // device 1238, IC IC213, analog/basic/strongarm_comparator.hpp:43
        I(cpphdl_n1702, Vss) <+ 2.9999999999999998e-14 * ddt(V(cpphdl_n1702, Vss)); // Bench initial voltage = 0.0 V.
        // device 1239, IC IC213, analog/basic/strongarm_comparator.hpp:44
        I(cpphdl_n1703, Vss) <+ 2.9999999999999998e-14 * ddt(V(cpphdl_n1703, Vss)); // Bench initial voltage = 0.0 V.
        // device 1240, IC IC213, analog/basic/strongarm_comparator.hpp:45
        I(cpphdl_n1720, Vss) <+ 5.0000000000000002e-14 * ddt(V(cpphdl_n1720, Vss)); // Bench initial voltage = 0.0 V.
        // device 1241, IC IC213, analog/basic/strongarm_comparator.hpp:46
        I(cpphdl_n1716, Vss) <+ 5.0000000000000002e-14 * ddt(V(cpphdl_n1716, Vss)); // Bench initial voltage = 0.0 V.
        // device 1242, IC IC213, analog/basic/strongarm_comparator.hpp:47
        I(cpphdl_n1696, cpphdl_n1703) <+ 2e-14 * ddt(V(cpphdl_n1696, cpphdl_n1703)); // Bench initial voltage = 0.0 V.
        // device 1243, IC IC213, analog/basic/strongarm_comparator.hpp:48
        I(cpphdl_n1697, cpphdl_n1703) <+ 2e-14 * ddt(V(cpphdl_n1697, cpphdl_n1703)); // Bench initial voltage = 0.0 V.
        // device 1244, IC IC213, analog/basic/strongarm_comparator.hpp:49
        I(cpphdl_n1696, cpphdl_n1701) <+ 2.9999999999999998e-15 * ddt(V(cpphdl_n1696, cpphdl_n1701)); // Bench initial voltage = 0.0 V.
        // device 1245, IC IC213, analog/basic/strongarm_comparator.hpp:50
        I(cpphdl_n1697, cpphdl_n1702) <+ 2.9999999999999998e-15 * ddt(V(cpphdl_n1697, cpphdl_n1702)); // Bench initial voltage = 0.0 V.
        // device 1246, IC IC215, analog/basic/inverter.hpp:11
        I(cpphdl_n1724, Vdd) <+ cpphdl_channel(V(cpphdl_n1716, Vdd), V(cpphdl_n1724, Vdd), 0.001, 0.69999999999999996, -1.0);
        // device 1247, IC IC215, analog/basic/inverter.hpp:12
        I(cpphdl_n1724, Vss) <+ cpphdl_channel(V(cpphdl_n1716, Vss), V(cpphdl_n1724, Vss), 0.001, 0.69999999999999996, 1.0);
        // device 1248, IC IC217, analog/basic/inverter.hpp:11
        I(cpphdl_n1738, Vdd) <+ cpphdl_channel(V(cpphdl_n1724, Vdd), V(cpphdl_n1738, Vdd), 0.0040000000000000001, 0.69999999999999996, -1.0);
        // device 1249, IC IC217, analog/basic/inverter.hpp:12
        I(cpphdl_n1738, Vss) <+ cpphdl_channel(V(cpphdl_n1724, Vss), V(cpphdl_n1738, Vss), 0.0040000000000000001, 0.69999999999999996, 1.0);
        // device 1250, IC IC214, analog/basic/buffered_nand_latch.hpp:34
        I(cpphdl_n1716, Vss) <+ 2.0000000000000002e-15 * ddt(V(cpphdl_n1716, Vss)); // Bench initial voltage = 0.0 V.
        // device 1251, IC IC214, analog/basic/buffered_nand_latch.hpp:35
        I(cpphdl_n1716, cpphdl_n1724) <+ 1.0000000000000001e-15 * ddt(V(cpphdl_n1716, cpphdl_n1724)); // Bench initial voltage = 0.0 V.
        // device 1252, IC IC214, analog/basic/buffered_nand_latch.hpp:36
        I(cpphdl_n1724, Vss) <+ 5e-15 * ddt(V(cpphdl_n1724, Vss)); // Bench initial voltage = 0.0 V.
        // device 1253, IC IC214, analog/basic/buffered_nand_latch.hpp:37
        I(cpphdl_n1724, Vss) <+ 8.0000000000000006e-15 * ddt(V(cpphdl_n1724, Vss)); // Bench initial voltage = 0.0 V.
        // device 1254, IC IC214, analog/basic/buffered_nand_latch.hpp:38
        I(cpphdl_n1738, Vss) <+ 1e-14 * ddt(V(cpphdl_n1738, Vss)); // Bench initial voltage = 0.0 V.
        // device 1255, IC IC216, analog/basic/inverter.hpp:11
        I(cpphdl_n1728, Vdd) <+ cpphdl_channel(V(cpphdl_n1720, Vdd), V(cpphdl_n1728, Vdd), 0.001, 0.69999999999999996, -1.0);
        // device 1256, IC IC216, analog/basic/inverter.hpp:12
        I(cpphdl_n1728, Vss) <+ cpphdl_channel(V(cpphdl_n1720, Vss), V(cpphdl_n1728, Vss), 0.001, 0.69999999999999996, 1.0);
        // device 1257, IC IC218, analog/basic/inverter.hpp:11
        I(cpphdl_n1744, Vdd) <+ cpphdl_channel(V(cpphdl_n1728, Vdd), V(cpphdl_n1744, Vdd), 0.0040000000000000001, 0.69999999999999996, -1.0);
        // device 1258, IC IC218, analog/basic/inverter.hpp:12
        I(cpphdl_n1744, Vss) <+ cpphdl_channel(V(cpphdl_n1728, Vss), V(cpphdl_n1744, Vss), 0.0040000000000000001, 0.69999999999999996, 1.0);
        // device 1259, IC IC214, analog/basic/buffered_nand_latch.hpp:34
        I(cpphdl_n1720, Vss) <+ 2.0000000000000002e-15 * ddt(V(cpphdl_n1720, Vss)); // Bench initial voltage = 0.0 V.
        // device 1260, IC IC214, analog/basic/buffered_nand_latch.hpp:35
        I(cpphdl_n1720, cpphdl_n1728) <+ 1.0000000000000001e-15 * ddt(V(cpphdl_n1720, cpphdl_n1728)); // Bench initial voltage = 0.0 V.
        // device 1261, IC IC214, analog/basic/buffered_nand_latch.hpp:36
        I(cpphdl_n1728, Vss) <+ 5e-15 * ddt(V(cpphdl_n1728, Vss)); // Bench initial voltage = 0.0 V.
        // device 1262, IC IC214, analog/basic/buffered_nand_latch.hpp:37
        I(cpphdl_n1728, Vss) <+ 8.0000000000000006e-15 * ddt(V(cpphdl_n1728, Vss)); // Bench initial voltage = 0.0 V.
        // device 1263, IC IC214, analog/basic/buffered_nand_latch.hpp:38
        I(cpphdl_n1744, Vss) <+ 1e-14 * ddt(V(cpphdl_n1744, Vss)); // Bench initial voltage = 0.0 V.
        // device 1264, IC IC220, analog/basic/cmos_logic.hpp:17
        I(cpphdl_n2813, Vss) <+ 5.0000000000000002e-14 * ddt(V(cpphdl_n2813, Vss)); // Bench initial voltage = 0.0 V.
        // device 1265, IC IC220, analog/basic/cmos_logic.hpp:18
        I(cpphdl_n2813, Vdd) <+ cpphdl_channel(V(cpphdl_n1738, Vdd), V(cpphdl_n2813, Vdd), 0.01, 0.69999999999999996, -1.0);
        // device 1266, IC IC220, analog/basic/cmos_logic.hpp:19
        I(cpphdl_n2813, Vdd) <+ cpphdl_channel(V(cpphdl_n1746, Vdd), V(cpphdl_n2813, Vdd), 0.01, 0.69999999999999996, -1.0);
        // device 1267, IC IC220, analog/basic/cmos_logic.hpp:20
        I(cpphdl_n2813, cpphdl_n1741) <+ cpphdl_channel(V(cpphdl_n1738, cpphdl_n1741), V(cpphdl_n2813, cpphdl_n1741), 0.01, 0.69999999999999996, 1.0);
        // device 1268, IC IC220, analog/basic/cmos_logic.hpp:21
        I(cpphdl_n1741, Vss) <+ cpphdl_channel(V(cpphdl_n1746, Vss), V(cpphdl_n1741, Vss), 0.01, 0.69999999999999996, 1.0);
        // device 1269, IC IC220, analog/basic/cmos_logic.hpp:27
        I(cpphdl_n1741, Vss) <+ 1e-14 * ddt(V(cpphdl_n1741, Vss)); // Bench initial voltage = 0.0 V.
        // device 1270, IC IC221, analog/basic/cmos_logic.hpp:17
        I(cpphdl_n1746, Vss) <+ 5.0000000000000002e-14 * ddt(V(cpphdl_n1746, Vss)); // Bench initial voltage = 0.0 V.
        // device 1271, IC IC221, analog/basic/cmos_logic.hpp:18
        I(cpphdl_n1746, Vdd) <+ cpphdl_channel(V(cpphdl_n1744, Vdd), V(cpphdl_n1746, Vdd), 0.01, 0.69999999999999996, -1.0);
        // device 1272, IC IC221, analog/basic/cmos_logic.hpp:19
        I(cpphdl_n1746, Vdd) <+ cpphdl_channel(V(cpphdl_n2813, Vdd), V(cpphdl_n1746, Vdd), 0.01, 0.69999999999999996, -1.0);
        // device 1273, IC IC221, analog/basic/cmos_logic.hpp:20
        I(cpphdl_n1746, cpphdl_n1747) <+ cpphdl_channel(V(cpphdl_n1744, cpphdl_n1747), V(cpphdl_n1746, cpphdl_n1747), 0.01, 0.69999999999999996, 1.0);
        // device 1274, IC IC221, analog/basic/cmos_logic.hpp:21
        I(cpphdl_n1747, Vss) <+ cpphdl_channel(V(cpphdl_n2813, Vss), V(cpphdl_n1747, Vss), 0.01, 0.69999999999999996, 1.0);
        // device 1275, IC IC221, analog/basic/cmos_logic.hpp:27
        I(cpphdl_n1747, Vss) <+ 1e-14 * ddt(V(cpphdl_n1747, Vss)); // Bench initial voltage = 0.0 V.
        // device 1276, IC IC219, analog/basic/nand_latch.hpp:36
        I(cpphdl_n1738, Vss) <+ 2.9999999999999998e-15 * ddt(V(cpphdl_n1738, Vss)); // Bench initial voltage = 0.0 V.
        // device 1277, IC IC219, analog/basic/nand_latch.hpp:37
        I(cpphdl_n1744, Vss) <+ 2.9999999999999998e-15 * ddt(V(cpphdl_n1744, Vss)); // Bench initial voltage = 0.0 V.
        // device 1278, IC IC222, analog/basic/inverter.hpp:11
        I(cpphdl_n1752, Vdd) <+ cpphdl_channel(V(CLEAR, Vdd), V(cpphdl_n1752, Vdd), 0.01, 0.69999999999999996, -1.0);
        // device 1279, IC IC222, analog/basic/inverter.hpp:12
        I(cpphdl_n1752, Vss) <+ cpphdl_channel(V(CLEAR, Vss), V(cpphdl_n1752, Vss), 0.01, 0.69999999999999996, 1.0);
        // device 1280, IC IC219, analog/basic/nand_latch.hpp:58
        I(cpphdl_n1752, Vss) <+ 2.9999999999999998e-15 * ddt(V(cpphdl_n1752, Vss)); // Bench initial voltage = 0.0 V.
        // device 1281, IC IC219, analog/basic/nand_latch.hpp:59
        I(cpphdl_n2813, Vss) <+ cpphdl_channel(V(CLEAR, Vss), V(cpphdl_n2813, Vss), 0.050000000000000003, 0.69999999999999996, 1.0);
        // device 1282, IC IC219, analog/basic/nand_latch.hpp:60
        I(cpphdl_n1746, Vdd) <+ cpphdl_channel(V(cpphdl_n1752, Vdd), V(cpphdl_n1746, Vdd), 0.050000000000000003, 0.69999999999999996, -1.0);
        // device 1283, IC IC225, analog/basic/inverter.hpp:11
        I(cpphdl_n1776, Vdd) <+ cpphdl_channel(V(TRACK9, Vdd), V(cpphdl_n1776, Vdd), 0.0040000000000000001, 0.69999999999999996, -1.0);
        // device 1284, IC IC225, analog/basic/inverter.hpp:12
        I(cpphdl_n1776, Vss) <+ cpphdl_channel(V(TRACK9, Vss), V(cpphdl_n1776, Vss), 0.0040000000000000001, 0.69999999999999996, 1.0);
        // device 1285, IC IC224, analog/basic/mos_track_hold.hpp:31
        I(cpphdl_n1776, Vss) <+ 2e-14 * ddt(V(cpphdl_n1776, Vss)); // Bench initial voltage = 0.0 V.
        // device 1286, IC IC224, analog/basic/mos_track_hold.hpp:32
        I(cpphdl_n2628, cpphdl_n1830) <+ cpphdl_channel(V(TRACK9, cpphdl_n1830), V(cpphdl_n2628, cpphdl_n1830), 0.029999999999999999, 0.69999999999999996, 1.0);
        // device 1287, IC IC224, analog/basic/mos_track_hold.hpp:33
        I(cpphdl_n1830, cpphdl_n2628) <+ cpphdl_channel(V(cpphdl_n1776, cpphdl_n2628), V(cpphdl_n1830, cpphdl_n2628), 0.014999999999999999, 0.69999999999999996, -1.0);
        // device 1288, IC IC224, analog/basic/mos_track_hold.hpp:37
        I(cpphdl_n1830, cpphdl_n1830) <+ cpphdl_channel(V(cpphdl_n1776, cpphdl_n1830), V(cpphdl_n1830, cpphdl_n1830), 0.016, 0.69999999999999996, 1.0);
        // device 1289, IC IC224, analog/basic/mos_track_hold.hpp:38
        I(cpphdl_n1830, cpphdl_n1830) <+ cpphdl_channel(V(TRACK9, cpphdl_n1830), V(cpphdl_n1830, cpphdl_n1830), 0.0083999999999999995, 0.69999999999999996, -1.0);
        // device 1290, IC IC224, analog/basic/mos_track_hold.hpp:39
        I(cpphdl_n1830, Vss) <+ 1.5000000000000001e-12 * ddt(V(cpphdl_n1830, Vss)); // Bench initial voltage = 0.0 V.
        // device 1291, IC IC224, analog/basic/mos_track_hold.hpp:42
        I(TRACK9, cpphdl_n1830) <+ 2.0000000000000002e-15 * ddt(V(TRACK9, cpphdl_n1830)); // Bench initial voltage = -0.0 V.
        // device 1292, IC IC224, analog/basic/mos_track_hold.hpp:43
        I(cpphdl_n1776, cpphdl_n1830) <+ 2.0000000000000002e-15 * ddt(V(cpphdl_n1776, cpphdl_n1830)); // Bench initial voltage = 0.0 V.
        // device 1293, IC IC224, analog/basic/mos_track_hold.hpp:44
        I(cpphdl_n2628, cpphdl_n1830) <+ 1.0000000000000001e-15 * ddt(V(cpphdl_n2628, cpphdl_n1830)); // Bench initial voltage = 0.0 V.
        // device 1294, IC IC227, analog/basic/inverter.hpp:11
        I(cpphdl_n1791, Vdd) <+ cpphdl_channel(V(BIT_N9_0, Vdd), V(cpphdl_n1791, Vdd), 0.080000000000000002, 0.69999999999999996, -1.0);
        // device 1295, IC IC227, analog/basic/inverter.hpp:12
        I(cpphdl_n1791, Vss) <+ cpphdl_channel(V(BIT_N9_0, Vss), V(cpphdl_n1791, Vss), 0.080000000000000002, 0.69999999999999996, 1.0);
        // device 1296, IC IC226, analog/basic/mos_r2r_dac.hpp:27
        I(cpphdl_n1791, Vss) <+ 2.9999999999999998e-15 * ddt(V(cpphdl_n1791, Vss)); // Bench initial voltage = 0.0 V.
        // device 1297, IC IC226, analog/basic/mos_r2r_dac.hpp:28
        I(cpphdl_n1791, cpphdl_n1820) <+ V(cpphdl_n1791, cpphdl_n1820) / 2000.0;
        // device 1298, IC IC226, analog/basic/mos_r2r_dac.hpp:29
        I(cpphdl_n1820, Vss) <+ 2.9999999999999998e-15 * ddt(V(cpphdl_n1820, Vss)); // Bench initial voltage = 0.0 V.
        // device 1299, IC IC228, analog/basic/inverter.hpp:11
        I(cpphdl_n1795, Vdd) <+ cpphdl_channel(V(BIT_N9_1, Vdd), V(cpphdl_n1795, Vdd), 0.080000000000000002, 0.69999999999999996, -1.0);
        // device 1300, IC IC228, analog/basic/inverter.hpp:12
        I(cpphdl_n1795, Vss) <+ cpphdl_channel(V(BIT_N9_1, Vss), V(cpphdl_n1795, Vss), 0.080000000000000002, 0.69999999999999996, 1.0);
        // device 1301, IC IC226, analog/basic/mos_r2r_dac.hpp:27
        I(cpphdl_n1795, Vss) <+ 2.9999999999999998e-15 * ddt(V(cpphdl_n1795, Vss)); // Bench initial voltage = 0.0 V.
        // device 1302, IC IC226, analog/basic/mos_r2r_dac.hpp:28
        I(cpphdl_n1795, cpphdl_n1821) <+ V(cpphdl_n1795, cpphdl_n1821) / 2000.0;
        // device 1303, IC IC226, analog/basic/mos_r2r_dac.hpp:29
        I(cpphdl_n1821, Vss) <+ 2.9999999999999998e-15 * ddt(V(cpphdl_n1821, Vss)); // Bench initial voltage = 0.0 V.
        // device 1304, IC IC226, analog/basic/mos_r2r_dac.hpp:31
        I(cpphdl_n1820, cpphdl_n1821) <+ V(cpphdl_n1820, cpphdl_n1821) / 1000.0;
        // device 1305, IC IC229, analog/basic/inverter.hpp:11
        I(cpphdl_n1799, Vdd) <+ cpphdl_channel(V(BIT_N9_2, Vdd), V(cpphdl_n1799, Vdd), 0.080000000000000002, 0.69999999999999996, -1.0);
        // device 1306, IC IC229, analog/basic/inverter.hpp:12
        I(cpphdl_n1799, Vss) <+ cpphdl_channel(V(BIT_N9_2, Vss), V(cpphdl_n1799, Vss), 0.080000000000000002, 0.69999999999999996, 1.0);
        // device 1307, IC IC226, analog/basic/mos_r2r_dac.hpp:27
        I(cpphdl_n1799, Vss) <+ 2.9999999999999998e-15 * ddt(V(cpphdl_n1799, Vss)); // Bench initial voltage = 0.0 V.
        // device 1308, IC IC226, analog/basic/mos_r2r_dac.hpp:28
        I(cpphdl_n1799, cpphdl_n1822) <+ V(cpphdl_n1799, cpphdl_n1822) / 2000.0;
        // device 1309, IC IC226, analog/basic/mos_r2r_dac.hpp:29
        I(cpphdl_n1822, Vss) <+ 2.9999999999999998e-15 * ddt(V(cpphdl_n1822, Vss)); // Bench initial voltage = 0.0 V.
        // device 1310, IC IC226, analog/basic/mos_r2r_dac.hpp:31
        I(cpphdl_n1821, cpphdl_n1822) <+ V(cpphdl_n1821, cpphdl_n1822) / 1000.0;
        // device 1311, IC IC230, analog/basic/inverter.hpp:11
        I(cpphdl_n1803, Vdd) <+ cpphdl_channel(V(BIT_N9_3, Vdd), V(cpphdl_n1803, Vdd), 0.080000000000000002, 0.69999999999999996, -1.0);
        // device 1312, IC IC230, analog/basic/inverter.hpp:12
        I(cpphdl_n1803, Vss) <+ cpphdl_channel(V(BIT_N9_3, Vss), V(cpphdl_n1803, Vss), 0.080000000000000002, 0.69999999999999996, 1.0);
        // device 1313, IC IC226, analog/basic/mos_r2r_dac.hpp:27
        I(cpphdl_n1803, Vss) <+ 2.9999999999999998e-15 * ddt(V(cpphdl_n1803, Vss)); // Bench initial voltage = 0.0 V.
        // device 1314, IC IC226, analog/basic/mos_r2r_dac.hpp:28
        I(cpphdl_n1803, cpphdl_n1823) <+ V(cpphdl_n1803, cpphdl_n1823) / 2000.0;
        // device 1315, IC IC226, analog/basic/mos_r2r_dac.hpp:29
        I(cpphdl_n1823, Vss) <+ 2.9999999999999998e-15 * ddt(V(cpphdl_n1823, Vss)); // Bench initial voltage = 0.0 V.
        // device 1316, IC IC226, analog/basic/mos_r2r_dac.hpp:31
        I(cpphdl_n1822, cpphdl_n1823) <+ V(cpphdl_n1822, cpphdl_n1823) / 1000.0;
        // device 1317, IC IC231, analog/basic/inverter.hpp:11
        I(cpphdl_n1807, Vdd) <+ cpphdl_channel(V(BIT_N9_4, Vdd), V(cpphdl_n1807, Vdd), 0.080000000000000002, 0.69999999999999996, -1.0);
        // device 1318, IC IC231, analog/basic/inverter.hpp:12
        I(cpphdl_n1807, Vss) <+ cpphdl_channel(V(BIT_N9_4, Vss), V(cpphdl_n1807, Vss), 0.080000000000000002, 0.69999999999999996, 1.0);
        // device 1319, IC IC226, analog/basic/mos_r2r_dac.hpp:27
        I(cpphdl_n1807, Vss) <+ 2.9999999999999998e-15 * ddt(V(cpphdl_n1807, Vss)); // Bench initial voltage = 0.0 V.
        // device 1320, IC IC226, analog/basic/mos_r2r_dac.hpp:28
        I(cpphdl_n1807, cpphdl_n1824) <+ V(cpphdl_n1807, cpphdl_n1824) / 2000.0;
        // device 1321, IC IC226, analog/basic/mos_r2r_dac.hpp:29
        I(cpphdl_n1824, Vss) <+ 2.9999999999999998e-15 * ddt(V(cpphdl_n1824, Vss)); // Bench initial voltage = 0.0 V.
        // device 1322, IC IC226, analog/basic/mos_r2r_dac.hpp:31
        I(cpphdl_n1823, cpphdl_n1824) <+ V(cpphdl_n1823, cpphdl_n1824) / 1000.0;
        // device 1323, IC IC232, analog/basic/inverter.hpp:11
        I(cpphdl_n1811, Vdd) <+ cpphdl_channel(V(BIT_N9_5, Vdd), V(cpphdl_n1811, Vdd), 0.080000000000000002, 0.69999999999999996, -1.0);
        // device 1324, IC IC232, analog/basic/inverter.hpp:12
        I(cpphdl_n1811, Vss) <+ cpphdl_channel(V(BIT_N9_5, Vss), V(cpphdl_n1811, Vss), 0.080000000000000002, 0.69999999999999996, 1.0);
        // device 1325, IC IC226, analog/basic/mos_r2r_dac.hpp:27
        I(cpphdl_n1811, Vss) <+ 2.9999999999999998e-15 * ddt(V(cpphdl_n1811, Vss)); // Bench initial voltage = 0.0 V.
        // device 1326, IC IC226, analog/basic/mos_r2r_dac.hpp:28
        I(cpphdl_n1811, cpphdl_n1825) <+ V(cpphdl_n1811, cpphdl_n1825) / 2000.0;
        // device 1327, IC IC226, analog/basic/mos_r2r_dac.hpp:29
        I(cpphdl_n1825, Vss) <+ 2.9999999999999998e-15 * ddt(V(cpphdl_n1825, Vss)); // Bench initial voltage = 0.0 V.
        // device 1328, IC IC226, analog/basic/mos_r2r_dac.hpp:31
        I(cpphdl_n1824, cpphdl_n1825) <+ V(cpphdl_n1824, cpphdl_n1825) / 1000.0;
        // device 1329, IC IC233, analog/basic/inverter.hpp:11
        I(cpphdl_n1815, Vdd) <+ cpphdl_channel(V(BIT_N9_6, Vdd), V(cpphdl_n1815, Vdd), 0.080000000000000002, 0.69999999999999996, -1.0);
        // device 1330, IC IC233, analog/basic/inverter.hpp:12
        I(cpphdl_n1815, Vss) <+ cpphdl_channel(V(BIT_N9_6, Vss), V(cpphdl_n1815, Vss), 0.080000000000000002, 0.69999999999999996, 1.0);
        // device 1331, IC IC226, analog/basic/mos_r2r_dac.hpp:27
        I(cpphdl_n1815, Vss) <+ 2.9999999999999998e-15 * ddt(V(cpphdl_n1815, Vss)); // Bench initial voltage = 0.0 V.
        // device 1332, IC IC226, analog/basic/mos_r2r_dac.hpp:28
        I(cpphdl_n1815, cpphdl_n1826) <+ V(cpphdl_n1815, cpphdl_n1826) / 2000.0;
        // device 1333, IC IC226, analog/basic/mos_r2r_dac.hpp:29
        I(cpphdl_n1826, Vss) <+ 2.9999999999999998e-15 * ddt(V(cpphdl_n1826, Vss)); // Bench initial voltage = 0.0 V.
        // device 1334, IC IC226, analog/basic/mos_r2r_dac.hpp:31
        I(cpphdl_n1825, cpphdl_n1826) <+ V(cpphdl_n1825, cpphdl_n1826) / 1000.0;
        // device 1335, IC IC234, analog/basic/inverter.hpp:11
        I(cpphdl_n1819, Vdd) <+ cpphdl_channel(V(BIT_N9_7, Vdd), V(cpphdl_n1819, Vdd), 0.080000000000000002, 0.69999999999999996, -1.0);
        // device 1336, IC IC234, analog/basic/inverter.hpp:12
        I(cpphdl_n1819, Vss) <+ cpphdl_channel(V(BIT_N9_7, Vss), V(cpphdl_n1819, Vss), 0.080000000000000002, 0.69999999999999996, 1.0);
        // device 1337, IC IC226, analog/basic/mos_r2r_dac.hpp:27
        I(cpphdl_n1819, Vss) <+ 2.9999999999999998e-15 * ddt(V(cpphdl_n1819, Vss)); // Bench initial voltage = 0.0 V.
        // device 1338, IC IC226, analog/basic/mos_r2r_dac.hpp:28
        I(cpphdl_n1819, cpphdl_n1831) <+ V(cpphdl_n1819, cpphdl_n1831) / 2000.0;
        // device 1339, IC IC226, analog/basic/mos_r2r_dac.hpp:29
        I(cpphdl_n1831, Vss) <+ 2.9999999999999998e-15 * ddt(V(cpphdl_n1831, Vss)); // Bench initial voltage = 0.0 V.
        // device 1340, IC IC226, analog/basic/mos_r2r_dac.hpp:31
        I(cpphdl_n1826, cpphdl_n1831) <+ V(cpphdl_n1826, cpphdl_n1831) / 1000.0;
        // device 1341, IC IC226, analog/basic/mos_r2r_dac.hpp:33
        I(Vss, cpphdl_n1820) <+ V(Vss, cpphdl_n1820) / 2000.0;
        // device 1342, IC IC235, analog/basic/nmos_resistor_amplifier.hpp:23
        I(Vdd, cpphdl_n1840) <+ V(Vdd, cpphdl_n1840) / 1000.0;
        // device 1343, IC IC235, analog/basic/nmos_resistor_amplifier.hpp:24
        I(Vdd, cpphdl_n1839) <+ V(Vdd, cpphdl_n1839) / 1000.0;
        // device 1344, IC IC235, analog/basic/nmos_resistor_amplifier.hpp:25
        I(cpphdl_n1840, cpphdl_n1834) <+ cpphdl_channel(V(cpphdl_n1830, cpphdl_n1834), V(cpphdl_n1840, cpphdl_n1834), 0.0074999999999999997, 0.69999999999999996, 1.0);
        // device 1345, IC IC235, analog/basic/nmos_resistor_amplifier.hpp:26
        I(cpphdl_n1839, cpphdl_n1835) <+ cpphdl_channel(V(cpphdl_n1831, cpphdl_n1835), V(cpphdl_n1839, cpphdl_n1835), 0.0074999999999999997, 0.69999999999999996, 1.0);
        // device 1346, IC IC235, analog/basic/nmos_resistor_amplifier.hpp:27
        I(cpphdl_n1836, cpphdl_n1834) <+ V(cpphdl_n1836, cpphdl_n1834) / 100.0;
        // device 1347, IC IC235, analog/basic/nmos_resistor_amplifier.hpp:28
        I(cpphdl_n1836, cpphdl_n1835) <+ V(cpphdl_n1836, cpphdl_n1835) / 100.0;
        // device 1348, IC IC235, analog/basic/nmos_resistor_amplifier.hpp:29
        I(Vss, cpphdl_n1836) <+ V(Vss, cpphdl_n1836) / 300.0;
        // device 1349, IC IC235, analog/basic/nmos_resistor_amplifier.hpp:30
        I(cpphdl_n1840, Vdd) <+ 2.9999999999999998e-13 * ddt(V(cpphdl_n1840, Vdd)); // Bench initial voltage = 0.0 V.
        // device 1350, IC IC235, analog/basic/nmos_resistor_amplifier.hpp:31
        I(cpphdl_n1839, Vdd) <+ 2.9999999999999998e-13 * ddt(V(cpphdl_n1839, Vdd)); // Bench initial voltage = 0.0 V.
        // device 1351, IC IC235, analog/basic/nmos_resistor_amplifier.hpp:32
        I(cpphdl_n1836, Vss) <+ 4e-14 * ddt(V(cpphdl_n1836, Vss)); // Bench initial voltage = 0.0 V.
        // device 1352, IC IC235, analog/basic/nmos_resistor_amplifier.hpp:34
        I(cpphdl_n1830, cpphdl_n1834) <+ 2e-14 * ddt(V(cpphdl_n1830, cpphdl_n1834)); // Bench initial voltage = 0.0 V.
        // device 1353, IC IC235, analog/basic/nmos_resistor_amplifier.hpp:35
        I(cpphdl_n1831, cpphdl_n1835) <+ 2e-14 * ddt(V(cpphdl_n1831, cpphdl_n1835)); // Bench initial voltage = 0.0 V.
        // device 1354, IC IC235, analog/basic/nmos_resistor_amplifier.hpp:36
        I(cpphdl_n1830, cpphdl_n1840) <+ 2.9999999999999998e-15 * ddt(V(cpphdl_n1830, cpphdl_n1840)); // Bench initial voltage = 0.0 V.
        // device 1355, IC IC235, analog/basic/nmos_resistor_amplifier.hpp:37
        I(cpphdl_n1831, cpphdl_n1839) <+ 2.9999999999999998e-15 * ddt(V(cpphdl_n1831, cpphdl_n1839)); // Bench initial voltage = 0.0 V.
        // device 1356, IC IC236, analog/basic/strongarm_comparator.hpp:28
        I(cpphdl_n1844, cpphdl_n1846) <+ cpphdl_channel(V(cpphdl_n1839, cpphdl_n1846), V(cpphdl_n1844, cpphdl_n1846), 0.0080000000000000002, 0.69999999999999996, 1.0);
        // device 1357, IC IC236, analog/basic/strongarm_comparator.hpp:29
        I(cpphdl_n1845, cpphdl_n1846) <+ cpphdl_channel(V(cpphdl_n1840, cpphdl_n1846), V(cpphdl_n1845, cpphdl_n1846), 0.0080000000000000002, 0.69999999999999996, 1.0);
        // device 1358, IC IC236, analog/basic/strongarm_comparator.hpp:30
        I(cpphdl_n1846, Vss) <+ cpphdl_channel(V(EVALUATE, Vss), V(cpphdl_n1846, Vss), 0.0080000000000000002, 0.69999999999999996, 1.0);
        // device 1359, IC IC236, analog/basic/strongarm_comparator.hpp:33
        I(cpphdl_n1859, cpphdl_n1844) <+ cpphdl_channel(V(cpphdl_n1863, cpphdl_n1844), V(cpphdl_n1859, cpphdl_n1844), 0.0040000000000000001, 0.69999999999999996, 1.0);
        // device 1360, IC IC236, analog/basic/strongarm_comparator.hpp:34
        I(cpphdl_n1863, cpphdl_n1845) <+ cpphdl_channel(V(cpphdl_n1859, cpphdl_n1845), V(cpphdl_n1863, cpphdl_n1845), 0.0040000000000000001, 0.69999999999999996, 1.0);
        // device 1361, IC IC236, analog/basic/strongarm_comparator.hpp:35
        I(cpphdl_n1863, Vdd) <+ cpphdl_channel(V(cpphdl_n1859, Vdd), V(cpphdl_n1863, Vdd), 0.002, 0.69999999999999996, -1.0);
        // device 1362, IC IC236, analog/basic/strongarm_comparator.hpp:36
        I(cpphdl_n1859, Vdd) <+ cpphdl_channel(V(cpphdl_n1863, Vdd), V(cpphdl_n1859, Vdd), 0.002, 0.69999999999999996, -1.0);
        // device 1363, IC IC236, analog/basic/strongarm_comparator.hpp:38
        I(cpphdl_n1844, Vdd) <+ cpphdl_channel(V(EVALUATE, Vdd), V(cpphdl_n1844, Vdd), 0.002, 0.69999999999999996, -1.0);
        // device 1364, IC IC236, analog/basic/strongarm_comparator.hpp:39
        I(cpphdl_n1845, Vdd) <+ cpphdl_channel(V(EVALUATE, Vdd), V(cpphdl_n1845, Vdd), 0.002, 0.69999999999999996, -1.0);
        // device 1365, IC IC236, analog/basic/strongarm_comparator.hpp:40
        I(cpphdl_n1863, Vdd) <+ cpphdl_channel(V(EVALUATE, Vdd), V(cpphdl_n1863, Vdd), 0.002, 0.69999999999999996, -1.0);
        // device 1366, IC IC236, analog/basic/strongarm_comparator.hpp:41
        I(cpphdl_n1859, Vdd) <+ cpphdl_channel(V(EVALUATE, Vdd), V(cpphdl_n1859, Vdd), 0.002, 0.69999999999999996, -1.0);
        // device 1367, IC IC236, analog/basic/strongarm_comparator.hpp:42
        I(cpphdl_n1844, Vss) <+ 2.9999999999999998e-14 * ddt(V(cpphdl_n1844, Vss)); // Bench initial voltage = 0.0 V.
        // device 1368, IC IC236, analog/basic/strongarm_comparator.hpp:43
        I(cpphdl_n1845, Vss) <+ 2.9999999999999998e-14 * ddt(V(cpphdl_n1845, Vss)); // Bench initial voltage = 0.0 V.
        // device 1369, IC IC236, analog/basic/strongarm_comparator.hpp:44
        I(cpphdl_n1846, Vss) <+ 2.9999999999999998e-14 * ddt(V(cpphdl_n1846, Vss)); // Bench initial voltage = 0.0 V.
        // device 1370, IC IC236, analog/basic/strongarm_comparator.hpp:45
        I(cpphdl_n1863, Vss) <+ 5.0000000000000002e-14 * ddt(V(cpphdl_n1863, Vss)); // Bench initial voltage = 0.0 V.
        // device 1371, IC IC236, analog/basic/strongarm_comparator.hpp:46
        I(cpphdl_n1859, Vss) <+ 5.0000000000000002e-14 * ddt(V(cpphdl_n1859, Vss)); // Bench initial voltage = 0.0 V.
        // device 1372, IC IC236, analog/basic/strongarm_comparator.hpp:47
        I(cpphdl_n1839, cpphdl_n1846) <+ 2e-14 * ddt(V(cpphdl_n1839, cpphdl_n1846)); // Bench initial voltage = 0.0 V.
        // device 1373, IC IC236, analog/basic/strongarm_comparator.hpp:48
        I(cpphdl_n1840, cpphdl_n1846) <+ 2e-14 * ddt(V(cpphdl_n1840, cpphdl_n1846)); // Bench initial voltage = 0.0 V.
        // device 1374, IC IC236, analog/basic/strongarm_comparator.hpp:49
        I(cpphdl_n1839, cpphdl_n1844) <+ 2.9999999999999998e-15 * ddt(V(cpphdl_n1839, cpphdl_n1844)); // Bench initial voltage = 0.0 V.
        // device 1375, IC IC236, analog/basic/strongarm_comparator.hpp:50
        I(cpphdl_n1840, cpphdl_n1845) <+ 2.9999999999999998e-15 * ddt(V(cpphdl_n1840, cpphdl_n1845)); // Bench initial voltage = 0.0 V.
        // device 1376, IC IC238, analog/basic/inverter.hpp:11
        I(cpphdl_n1867, Vdd) <+ cpphdl_channel(V(cpphdl_n1859, Vdd), V(cpphdl_n1867, Vdd), 0.001, 0.69999999999999996, -1.0);
        // device 1377, IC IC238, analog/basic/inverter.hpp:12
        I(cpphdl_n1867, Vss) <+ cpphdl_channel(V(cpphdl_n1859, Vss), V(cpphdl_n1867, Vss), 0.001, 0.69999999999999996, 1.0);
        // device 1378, IC IC240, analog/basic/inverter.hpp:11
        I(cpphdl_n1881, Vdd) <+ cpphdl_channel(V(cpphdl_n1867, Vdd), V(cpphdl_n1881, Vdd), 0.0040000000000000001, 0.69999999999999996, -1.0);
        // device 1379, IC IC240, analog/basic/inverter.hpp:12
        I(cpphdl_n1881, Vss) <+ cpphdl_channel(V(cpphdl_n1867, Vss), V(cpphdl_n1881, Vss), 0.0040000000000000001, 0.69999999999999996, 1.0);
        // device 1380, IC IC237, analog/basic/buffered_nand_latch.hpp:34
        I(cpphdl_n1859, Vss) <+ 2.0000000000000002e-15 * ddt(V(cpphdl_n1859, Vss)); // Bench initial voltage = 0.0 V.
        // device 1381, IC IC237, analog/basic/buffered_nand_latch.hpp:35
        I(cpphdl_n1859, cpphdl_n1867) <+ 1.0000000000000001e-15 * ddt(V(cpphdl_n1859, cpphdl_n1867)); // Bench initial voltage = 0.0 V.
        // device 1382, IC IC237, analog/basic/buffered_nand_latch.hpp:36
        I(cpphdl_n1867, Vss) <+ 5e-15 * ddt(V(cpphdl_n1867, Vss)); // Bench initial voltage = 0.0 V.
        // device 1383, IC IC237, analog/basic/buffered_nand_latch.hpp:37
        I(cpphdl_n1867, Vss) <+ 8.0000000000000006e-15 * ddt(V(cpphdl_n1867, Vss)); // Bench initial voltage = 0.0 V.
        // device 1384, IC IC237, analog/basic/buffered_nand_latch.hpp:38
        I(cpphdl_n1881, Vss) <+ 1e-14 * ddt(V(cpphdl_n1881, Vss)); // Bench initial voltage = 0.0 V.
        // device 1385, IC IC239, analog/basic/inverter.hpp:11
        I(cpphdl_n1871, Vdd) <+ cpphdl_channel(V(cpphdl_n1863, Vdd), V(cpphdl_n1871, Vdd), 0.001, 0.69999999999999996, -1.0);
        // device 1386, IC IC239, analog/basic/inverter.hpp:12
        I(cpphdl_n1871, Vss) <+ cpphdl_channel(V(cpphdl_n1863, Vss), V(cpphdl_n1871, Vss), 0.001, 0.69999999999999996, 1.0);
        // device 1387, IC IC241, analog/basic/inverter.hpp:11
        I(cpphdl_n1887, Vdd) <+ cpphdl_channel(V(cpphdl_n1871, Vdd), V(cpphdl_n1887, Vdd), 0.0040000000000000001, 0.69999999999999996, -1.0);
        // device 1388, IC IC241, analog/basic/inverter.hpp:12
        I(cpphdl_n1887, Vss) <+ cpphdl_channel(V(cpphdl_n1871, Vss), V(cpphdl_n1887, Vss), 0.0040000000000000001, 0.69999999999999996, 1.0);
        // device 1389, IC IC237, analog/basic/buffered_nand_latch.hpp:34
        I(cpphdl_n1863, Vss) <+ 2.0000000000000002e-15 * ddt(V(cpphdl_n1863, Vss)); // Bench initial voltage = 0.0 V.
        // device 1390, IC IC237, analog/basic/buffered_nand_latch.hpp:35
        I(cpphdl_n1863, cpphdl_n1871) <+ 1.0000000000000001e-15 * ddt(V(cpphdl_n1863, cpphdl_n1871)); // Bench initial voltage = 0.0 V.
        // device 1391, IC IC237, analog/basic/buffered_nand_latch.hpp:36
        I(cpphdl_n1871, Vss) <+ 5e-15 * ddt(V(cpphdl_n1871, Vss)); // Bench initial voltage = 0.0 V.
        // device 1392, IC IC237, analog/basic/buffered_nand_latch.hpp:37
        I(cpphdl_n1871, Vss) <+ 8.0000000000000006e-15 * ddt(V(cpphdl_n1871, Vss)); // Bench initial voltage = 0.0 V.
        // device 1393, IC IC237, analog/basic/buffered_nand_latch.hpp:38
        I(cpphdl_n1887, Vss) <+ 1e-14 * ddt(V(cpphdl_n1887, Vss)); // Bench initial voltage = 0.0 V.
        // device 1394, IC IC243, analog/basic/cmos_logic.hpp:17
        I(cpphdl_n2818, Vss) <+ 5.0000000000000002e-14 * ddt(V(cpphdl_n2818, Vss)); // Bench initial voltage = 0.0 V.
        // device 1395, IC IC243, analog/basic/cmos_logic.hpp:18
        I(cpphdl_n2818, Vdd) <+ cpphdl_channel(V(cpphdl_n1881, Vdd), V(cpphdl_n2818, Vdd), 0.01, 0.69999999999999996, -1.0);
        // device 1396, IC IC243, analog/basic/cmos_logic.hpp:19
        I(cpphdl_n2818, Vdd) <+ cpphdl_channel(V(cpphdl_n1889, Vdd), V(cpphdl_n2818, Vdd), 0.01, 0.69999999999999996, -1.0);
        // device 1397, IC IC243, analog/basic/cmos_logic.hpp:20
        I(cpphdl_n2818, cpphdl_n1884) <+ cpphdl_channel(V(cpphdl_n1881, cpphdl_n1884), V(cpphdl_n2818, cpphdl_n1884), 0.01, 0.69999999999999996, 1.0);
        // device 1398, IC IC243, analog/basic/cmos_logic.hpp:21
        I(cpphdl_n1884, Vss) <+ cpphdl_channel(V(cpphdl_n1889, Vss), V(cpphdl_n1884, Vss), 0.01, 0.69999999999999996, 1.0);
        // device 1399, IC IC243, analog/basic/cmos_logic.hpp:27
        I(cpphdl_n1884, Vss) <+ 1e-14 * ddt(V(cpphdl_n1884, Vss)); // Bench initial voltage = 0.0 V.
        // device 1400, IC IC244, analog/basic/cmos_logic.hpp:17
        I(cpphdl_n1889, Vss) <+ 5.0000000000000002e-14 * ddt(V(cpphdl_n1889, Vss)); // Bench initial voltage = 0.0 V.
        // device 1401, IC IC244, analog/basic/cmos_logic.hpp:18
        I(cpphdl_n1889, Vdd) <+ cpphdl_channel(V(cpphdl_n1887, Vdd), V(cpphdl_n1889, Vdd), 0.01, 0.69999999999999996, -1.0);
        // device 1402, IC IC244, analog/basic/cmos_logic.hpp:19
        I(cpphdl_n1889, Vdd) <+ cpphdl_channel(V(cpphdl_n2818, Vdd), V(cpphdl_n1889, Vdd), 0.01, 0.69999999999999996, -1.0);
        // device 1403, IC IC244, analog/basic/cmos_logic.hpp:20
        I(cpphdl_n1889, cpphdl_n1890) <+ cpphdl_channel(V(cpphdl_n1887, cpphdl_n1890), V(cpphdl_n1889, cpphdl_n1890), 0.01, 0.69999999999999996, 1.0);
        // device 1404, IC IC244, analog/basic/cmos_logic.hpp:21
        I(cpphdl_n1890, Vss) <+ cpphdl_channel(V(cpphdl_n2818, Vss), V(cpphdl_n1890, Vss), 0.01, 0.69999999999999996, 1.0);
        // device 1405, IC IC244, analog/basic/cmos_logic.hpp:27
        I(cpphdl_n1890, Vss) <+ 1e-14 * ddt(V(cpphdl_n1890, Vss)); // Bench initial voltage = 0.0 V.
        // device 1406, IC IC242, analog/basic/nand_latch.hpp:36
        I(cpphdl_n1881, Vss) <+ 2.9999999999999998e-15 * ddt(V(cpphdl_n1881, Vss)); // Bench initial voltage = 0.0 V.
        // device 1407, IC IC242, analog/basic/nand_latch.hpp:37
        I(cpphdl_n1887, Vss) <+ 2.9999999999999998e-15 * ddt(V(cpphdl_n1887, Vss)); // Bench initial voltage = 0.0 V.
        // device 1408, IC IC245, analog/basic/inverter.hpp:11
        I(cpphdl_n1895, Vdd) <+ cpphdl_channel(V(CLEAR, Vdd), V(cpphdl_n1895, Vdd), 0.01, 0.69999999999999996, -1.0);
        // device 1409, IC IC245, analog/basic/inverter.hpp:12
        I(cpphdl_n1895, Vss) <+ cpphdl_channel(V(CLEAR, Vss), V(cpphdl_n1895, Vss), 0.01, 0.69999999999999996, 1.0);
        // device 1410, IC IC242, analog/basic/nand_latch.hpp:58
        I(cpphdl_n1895, Vss) <+ 2.9999999999999998e-15 * ddt(V(cpphdl_n1895, Vss)); // Bench initial voltage = 0.0 V.
        // device 1411, IC IC242, analog/basic/nand_latch.hpp:59
        I(cpphdl_n2818, Vss) <+ cpphdl_channel(V(CLEAR, Vss), V(cpphdl_n2818, Vss), 0.050000000000000003, 0.69999999999999996, 1.0);
        // device 1412, IC IC242, analog/basic/nand_latch.hpp:60
        I(cpphdl_n1889, Vdd) <+ cpphdl_channel(V(cpphdl_n1895, Vdd), V(cpphdl_n1889, Vdd), 0.050000000000000003, 0.69999999999999996, -1.0);
        // device 1413, IC IC248, analog/basic/inverter.hpp:11
        I(cpphdl_n1919, Vdd) <+ cpphdl_channel(V(TRACK10, Vdd), V(cpphdl_n1919, Vdd), 0.0040000000000000001, 0.69999999999999996, -1.0);
        // device 1414, IC IC248, analog/basic/inverter.hpp:12
        I(cpphdl_n1919, Vss) <+ cpphdl_channel(V(TRACK10, Vss), V(cpphdl_n1919, Vss), 0.0040000000000000001, 0.69999999999999996, 1.0);
        // device 1415, IC IC247, analog/basic/mos_track_hold.hpp:31
        I(cpphdl_n1919, Vss) <+ 2e-14 * ddt(V(cpphdl_n1919, Vss)); // Bench initial voltage = 0.0 V.
        // device 1416, IC IC247, analog/basic/mos_track_hold.hpp:32
        I(cpphdl_n2628, cpphdl_n1973) <+ cpphdl_channel(V(TRACK10, cpphdl_n1973), V(cpphdl_n2628, cpphdl_n1973), 0.029999999999999999, 0.69999999999999996, 1.0);
        // device 1417, IC IC247, analog/basic/mos_track_hold.hpp:33
        I(cpphdl_n1973, cpphdl_n2628) <+ cpphdl_channel(V(cpphdl_n1919, cpphdl_n2628), V(cpphdl_n1973, cpphdl_n2628), 0.014999999999999999, 0.69999999999999996, -1.0);
        // device 1418, IC IC247, analog/basic/mos_track_hold.hpp:37
        I(cpphdl_n1973, cpphdl_n1973) <+ cpphdl_channel(V(cpphdl_n1919, cpphdl_n1973), V(cpphdl_n1973, cpphdl_n1973), 0.016, 0.69999999999999996, 1.0);
        // device 1419, IC IC247, analog/basic/mos_track_hold.hpp:38
        I(cpphdl_n1973, cpphdl_n1973) <+ cpphdl_channel(V(TRACK10, cpphdl_n1973), V(cpphdl_n1973, cpphdl_n1973), 0.0083999999999999995, 0.69999999999999996, -1.0);
        // device 1420, IC IC247, analog/basic/mos_track_hold.hpp:39
        I(cpphdl_n1973, Vss) <+ 1.5000000000000001e-12 * ddt(V(cpphdl_n1973, Vss)); // Bench initial voltage = 0.0 V.
        // device 1421, IC IC247, analog/basic/mos_track_hold.hpp:42
        I(TRACK10, cpphdl_n1973) <+ 2.0000000000000002e-15 * ddt(V(TRACK10, cpphdl_n1973)); // Bench initial voltage = -0.0 V.
        // device 1422, IC IC247, analog/basic/mos_track_hold.hpp:43
        I(cpphdl_n1919, cpphdl_n1973) <+ 2.0000000000000002e-15 * ddt(V(cpphdl_n1919, cpphdl_n1973)); // Bench initial voltage = 0.0 V.
        // device 1423, IC IC247, analog/basic/mos_track_hold.hpp:44
        I(cpphdl_n2628, cpphdl_n1973) <+ 1.0000000000000001e-15 * ddt(V(cpphdl_n2628, cpphdl_n1973)); // Bench initial voltage = 0.0 V.
        // device 1424, IC IC250, analog/basic/inverter.hpp:11
        I(cpphdl_n1934, Vdd) <+ cpphdl_channel(V(BIT_N10_0, Vdd), V(cpphdl_n1934, Vdd), 0.080000000000000002, 0.69999999999999996, -1.0);
        // device 1425, IC IC250, analog/basic/inverter.hpp:12
        I(cpphdl_n1934, Vss) <+ cpphdl_channel(V(BIT_N10_0, Vss), V(cpphdl_n1934, Vss), 0.080000000000000002, 0.69999999999999996, 1.0);
        // device 1426, IC IC249, analog/basic/mos_r2r_dac.hpp:27
        I(cpphdl_n1934, Vss) <+ 2.9999999999999998e-15 * ddt(V(cpphdl_n1934, Vss)); // Bench initial voltage = 0.0 V.
        // device 1427, IC IC249, analog/basic/mos_r2r_dac.hpp:28
        I(cpphdl_n1934, cpphdl_n1963) <+ V(cpphdl_n1934, cpphdl_n1963) / 2000.0;
        // device 1428, IC IC249, analog/basic/mos_r2r_dac.hpp:29
        I(cpphdl_n1963, Vss) <+ 2.9999999999999998e-15 * ddt(V(cpphdl_n1963, Vss)); // Bench initial voltage = 0.0 V.
        // device 1429, IC IC251, analog/basic/inverter.hpp:11
        I(cpphdl_n1938, Vdd) <+ cpphdl_channel(V(BIT_N10_1, Vdd), V(cpphdl_n1938, Vdd), 0.080000000000000002, 0.69999999999999996, -1.0);
        // device 1430, IC IC251, analog/basic/inverter.hpp:12
        I(cpphdl_n1938, Vss) <+ cpphdl_channel(V(BIT_N10_1, Vss), V(cpphdl_n1938, Vss), 0.080000000000000002, 0.69999999999999996, 1.0);
        // device 1431, IC IC249, analog/basic/mos_r2r_dac.hpp:27
        I(cpphdl_n1938, Vss) <+ 2.9999999999999998e-15 * ddt(V(cpphdl_n1938, Vss)); // Bench initial voltage = 0.0 V.
        // device 1432, IC IC249, analog/basic/mos_r2r_dac.hpp:28
        I(cpphdl_n1938, cpphdl_n1964) <+ V(cpphdl_n1938, cpphdl_n1964) / 2000.0;
        // device 1433, IC IC249, analog/basic/mos_r2r_dac.hpp:29
        I(cpphdl_n1964, Vss) <+ 2.9999999999999998e-15 * ddt(V(cpphdl_n1964, Vss)); // Bench initial voltage = 0.0 V.
        // device 1434, IC IC249, analog/basic/mos_r2r_dac.hpp:31
        I(cpphdl_n1963, cpphdl_n1964) <+ V(cpphdl_n1963, cpphdl_n1964) / 1000.0;
        // device 1435, IC IC252, analog/basic/inverter.hpp:11
        I(cpphdl_n1942, Vdd) <+ cpphdl_channel(V(BIT_N10_2, Vdd), V(cpphdl_n1942, Vdd), 0.080000000000000002, 0.69999999999999996, -1.0);
        // device 1436, IC IC252, analog/basic/inverter.hpp:12
        I(cpphdl_n1942, Vss) <+ cpphdl_channel(V(BIT_N10_2, Vss), V(cpphdl_n1942, Vss), 0.080000000000000002, 0.69999999999999996, 1.0);
        // device 1437, IC IC249, analog/basic/mos_r2r_dac.hpp:27
        I(cpphdl_n1942, Vss) <+ 2.9999999999999998e-15 * ddt(V(cpphdl_n1942, Vss)); // Bench initial voltage = 0.0 V.
        // device 1438, IC IC249, analog/basic/mos_r2r_dac.hpp:28
        I(cpphdl_n1942, cpphdl_n1965) <+ V(cpphdl_n1942, cpphdl_n1965) / 2000.0;
        // device 1439, IC IC249, analog/basic/mos_r2r_dac.hpp:29
        I(cpphdl_n1965, Vss) <+ 2.9999999999999998e-15 * ddt(V(cpphdl_n1965, Vss)); // Bench initial voltage = 0.0 V.
        // device 1440, IC IC249, analog/basic/mos_r2r_dac.hpp:31
        I(cpphdl_n1964, cpphdl_n1965) <+ V(cpphdl_n1964, cpphdl_n1965) / 1000.0;
        // device 1441, IC IC253, analog/basic/inverter.hpp:11
        I(cpphdl_n1946, Vdd) <+ cpphdl_channel(V(BIT_N10_3, Vdd), V(cpphdl_n1946, Vdd), 0.080000000000000002, 0.69999999999999996, -1.0);
        // device 1442, IC IC253, analog/basic/inverter.hpp:12
        I(cpphdl_n1946, Vss) <+ cpphdl_channel(V(BIT_N10_3, Vss), V(cpphdl_n1946, Vss), 0.080000000000000002, 0.69999999999999996, 1.0);
        // device 1443, IC IC249, analog/basic/mos_r2r_dac.hpp:27
        I(cpphdl_n1946, Vss) <+ 2.9999999999999998e-15 * ddt(V(cpphdl_n1946, Vss)); // Bench initial voltage = 0.0 V.
        // device 1444, IC IC249, analog/basic/mos_r2r_dac.hpp:28
        I(cpphdl_n1946, cpphdl_n1966) <+ V(cpphdl_n1946, cpphdl_n1966) / 2000.0;
        // device 1445, IC IC249, analog/basic/mos_r2r_dac.hpp:29
        I(cpphdl_n1966, Vss) <+ 2.9999999999999998e-15 * ddt(V(cpphdl_n1966, Vss)); // Bench initial voltage = 0.0 V.
        // device 1446, IC IC249, analog/basic/mos_r2r_dac.hpp:31
        I(cpphdl_n1965, cpphdl_n1966) <+ V(cpphdl_n1965, cpphdl_n1966) / 1000.0;
        // device 1447, IC IC254, analog/basic/inverter.hpp:11
        I(cpphdl_n1950, Vdd) <+ cpphdl_channel(V(BIT_N10_4, Vdd), V(cpphdl_n1950, Vdd), 0.080000000000000002, 0.69999999999999996, -1.0);
        // device 1448, IC IC254, analog/basic/inverter.hpp:12
        I(cpphdl_n1950, Vss) <+ cpphdl_channel(V(BIT_N10_4, Vss), V(cpphdl_n1950, Vss), 0.080000000000000002, 0.69999999999999996, 1.0);
        // device 1449, IC IC249, analog/basic/mos_r2r_dac.hpp:27
        I(cpphdl_n1950, Vss) <+ 2.9999999999999998e-15 * ddt(V(cpphdl_n1950, Vss)); // Bench initial voltage = 0.0 V.
        // device 1450, IC IC249, analog/basic/mos_r2r_dac.hpp:28
        I(cpphdl_n1950, cpphdl_n1967) <+ V(cpphdl_n1950, cpphdl_n1967) / 2000.0;
        // device 1451, IC IC249, analog/basic/mos_r2r_dac.hpp:29
        I(cpphdl_n1967, Vss) <+ 2.9999999999999998e-15 * ddt(V(cpphdl_n1967, Vss)); // Bench initial voltage = 0.0 V.
        // device 1452, IC IC249, analog/basic/mos_r2r_dac.hpp:31
        I(cpphdl_n1966, cpphdl_n1967) <+ V(cpphdl_n1966, cpphdl_n1967) / 1000.0;
        // device 1453, IC IC255, analog/basic/inverter.hpp:11
        I(cpphdl_n1954, Vdd) <+ cpphdl_channel(V(BIT_N10_5, Vdd), V(cpphdl_n1954, Vdd), 0.080000000000000002, 0.69999999999999996, -1.0);
        // device 1454, IC IC255, analog/basic/inverter.hpp:12
        I(cpphdl_n1954, Vss) <+ cpphdl_channel(V(BIT_N10_5, Vss), V(cpphdl_n1954, Vss), 0.080000000000000002, 0.69999999999999996, 1.0);
        // device 1455, IC IC249, analog/basic/mos_r2r_dac.hpp:27
        I(cpphdl_n1954, Vss) <+ 2.9999999999999998e-15 * ddt(V(cpphdl_n1954, Vss)); // Bench initial voltage = 0.0 V.
        // device 1456, IC IC249, analog/basic/mos_r2r_dac.hpp:28
        I(cpphdl_n1954, cpphdl_n1968) <+ V(cpphdl_n1954, cpphdl_n1968) / 2000.0;
        // device 1457, IC IC249, analog/basic/mos_r2r_dac.hpp:29
        I(cpphdl_n1968, Vss) <+ 2.9999999999999998e-15 * ddt(V(cpphdl_n1968, Vss)); // Bench initial voltage = 0.0 V.
        // device 1458, IC IC249, analog/basic/mos_r2r_dac.hpp:31
        I(cpphdl_n1967, cpphdl_n1968) <+ V(cpphdl_n1967, cpphdl_n1968) / 1000.0;
        // device 1459, IC IC256, analog/basic/inverter.hpp:11
        I(cpphdl_n1958, Vdd) <+ cpphdl_channel(V(BIT_N10_6, Vdd), V(cpphdl_n1958, Vdd), 0.080000000000000002, 0.69999999999999996, -1.0);
        // device 1460, IC IC256, analog/basic/inverter.hpp:12
        I(cpphdl_n1958, Vss) <+ cpphdl_channel(V(BIT_N10_6, Vss), V(cpphdl_n1958, Vss), 0.080000000000000002, 0.69999999999999996, 1.0);
        // device 1461, IC IC249, analog/basic/mos_r2r_dac.hpp:27
        I(cpphdl_n1958, Vss) <+ 2.9999999999999998e-15 * ddt(V(cpphdl_n1958, Vss)); // Bench initial voltage = 0.0 V.
        // device 1462, IC IC249, analog/basic/mos_r2r_dac.hpp:28
        I(cpphdl_n1958, cpphdl_n1969) <+ V(cpphdl_n1958, cpphdl_n1969) / 2000.0;
        // device 1463, IC IC249, analog/basic/mos_r2r_dac.hpp:29
        I(cpphdl_n1969, Vss) <+ 2.9999999999999998e-15 * ddt(V(cpphdl_n1969, Vss)); // Bench initial voltage = 0.0 V.
        // device 1464, IC IC249, analog/basic/mos_r2r_dac.hpp:31
        I(cpphdl_n1968, cpphdl_n1969) <+ V(cpphdl_n1968, cpphdl_n1969) / 1000.0;
        // device 1465, IC IC257, analog/basic/inverter.hpp:11
        I(cpphdl_n1962, Vdd) <+ cpphdl_channel(V(BIT_N10_7, Vdd), V(cpphdl_n1962, Vdd), 0.080000000000000002, 0.69999999999999996, -1.0);
        // device 1466, IC IC257, analog/basic/inverter.hpp:12
        I(cpphdl_n1962, Vss) <+ cpphdl_channel(V(BIT_N10_7, Vss), V(cpphdl_n1962, Vss), 0.080000000000000002, 0.69999999999999996, 1.0);
        // device 1467, IC IC249, analog/basic/mos_r2r_dac.hpp:27
        I(cpphdl_n1962, Vss) <+ 2.9999999999999998e-15 * ddt(V(cpphdl_n1962, Vss)); // Bench initial voltage = 0.0 V.
        // device 1468, IC IC249, analog/basic/mos_r2r_dac.hpp:28
        I(cpphdl_n1962, cpphdl_n1974) <+ V(cpphdl_n1962, cpphdl_n1974) / 2000.0;
        // device 1469, IC IC249, analog/basic/mos_r2r_dac.hpp:29
        I(cpphdl_n1974, Vss) <+ 2.9999999999999998e-15 * ddt(V(cpphdl_n1974, Vss)); // Bench initial voltage = 0.0 V.
        // device 1470, IC IC249, analog/basic/mos_r2r_dac.hpp:31
        I(cpphdl_n1969, cpphdl_n1974) <+ V(cpphdl_n1969, cpphdl_n1974) / 1000.0;
        // device 1471, IC IC249, analog/basic/mos_r2r_dac.hpp:33
        I(Vss, cpphdl_n1963) <+ V(Vss, cpphdl_n1963) / 2000.0;
        // device 1472, IC IC258, analog/basic/nmos_resistor_amplifier.hpp:23
        I(Vdd, cpphdl_n1983) <+ V(Vdd, cpphdl_n1983) / 1000.0;
        // device 1473, IC IC258, analog/basic/nmos_resistor_amplifier.hpp:24
        I(Vdd, cpphdl_n1982) <+ V(Vdd, cpphdl_n1982) / 1000.0;
        // device 1474, IC IC258, analog/basic/nmos_resistor_amplifier.hpp:25
        I(cpphdl_n1983, cpphdl_n1977) <+ cpphdl_channel(V(cpphdl_n1973, cpphdl_n1977), V(cpphdl_n1983, cpphdl_n1977), 0.0074999999999999997, 0.69999999999999996, 1.0);
        // device 1475, IC IC258, analog/basic/nmos_resistor_amplifier.hpp:26
        I(cpphdl_n1982, cpphdl_n1978) <+ cpphdl_channel(V(cpphdl_n1974, cpphdl_n1978), V(cpphdl_n1982, cpphdl_n1978), 0.0074999999999999997, 0.69999999999999996, 1.0);
        // device 1476, IC IC258, analog/basic/nmos_resistor_amplifier.hpp:27
        I(cpphdl_n1979, cpphdl_n1977) <+ V(cpphdl_n1979, cpphdl_n1977) / 100.0;
        // device 1477, IC IC258, analog/basic/nmos_resistor_amplifier.hpp:28
        I(cpphdl_n1979, cpphdl_n1978) <+ V(cpphdl_n1979, cpphdl_n1978) / 100.0;
        // device 1478, IC IC258, analog/basic/nmos_resistor_amplifier.hpp:29
        I(Vss, cpphdl_n1979) <+ V(Vss, cpphdl_n1979) / 300.0;
        // device 1479, IC IC258, analog/basic/nmos_resistor_amplifier.hpp:30
        I(cpphdl_n1983, Vdd) <+ 2.9999999999999998e-13 * ddt(V(cpphdl_n1983, Vdd)); // Bench initial voltage = 0.0 V.
        // device 1480, IC IC258, analog/basic/nmos_resistor_amplifier.hpp:31
        I(cpphdl_n1982, Vdd) <+ 2.9999999999999998e-13 * ddt(V(cpphdl_n1982, Vdd)); // Bench initial voltage = 0.0 V.
        // device 1481, IC IC258, analog/basic/nmos_resistor_amplifier.hpp:32
        I(cpphdl_n1979, Vss) <+ 4e-14 * ddt(V(cpphdl_n1979, Vss)); // Bench initial voltage = 0.0 V.
        // device 1482, IC IC258, analog/basic/nmos_resistor_amplifier.hpp:34
        I(cpphdl_n1973, cpphdl_n1977) <+ 2e-14 * ddt(V(cpphdl_n1973, cpphdl_n1977)); // Bench initial voltage = 0.0 V.
        // device 1483, IC IC258, analog/basic/nmos_resistor_amplifier.hpp:35
        I(cpphdl_n1974, cpphdl_n1978) <+ 2e-14 * ddt(V(cpphdl_n1974, cpphdl_n1978)); // Bench initial voltage = 0.0 V.
        // device 1484, IC IC258, analog/basic/nmos_resistor_amplifier.hpp:36
        I(cpphdl_n1973, cpphdl_n1983) <+ 2.9999999999999998e-15 * ddt(V(cpphdl_n1973, cpphdl_n1983)); // Bench initial voltage = 0.0 V.
        // device 1485, IC IC258, analog/basic/nmos_resistor_amplifier.hpp:37
        I(cpphdl_n1974, cpphdl_n1982) <+ 2.9999999999999998e-15 * ddt(V(cpphdl_n1974, cpphdl_n1982)); // Bench initial voltage = 0.0 V.
        // device 1486, IC IC259, analog/basic/strongarm_comparator.hpp:28
        I(cpphdl_n1987, cpphdl_n1989) <+ cpphdl_channel(V(cpphdl_n1982, cpphdl_n1989), V(cpphdl_n1987, cpphdl_n1989), 0.0080000000000000002, 0.69999999999999996, 1.0);
        // device 1487, IC IC259, analog/basic/strongarm_comparator.hpp:29
        I(cpphdl_n1988, cpphdl_n1989) <+ cpphdl_channel(V(cpphdl_n1983, cpphdl_n1989), V(cpphdl_n1988, cpphdl_n1989), 0.0080000000000000002, 0.69999999999999996, 1.0);
        // device 1488, IC IC259, analog/basic/strongarm_comparator.hpp:30
        I(cpphdl_n1989, Vss) <+ cpphdl_channel(V(EVALUATE, Vss), V(cpphdl_n1989, Vss), 0.0080000000000000002, 0.69999999999999996, 1.0);
        // device 1489, IC IC259, analog/basic/strongarm_comparator.hpp:33
        I(cpphdl_n2002, cpphdl_n1987) <+ cpphdl_channel(V(cpphdl_n2006, cpphdl_n1987), V(cpphdl_n2002, cpphdl_n1987), 0.0040000000000000001, 0.69999999999999996, 1.0);
        // device 1490, IC IC259, analog/basic/strongarm_comparator.hpp:34
        I(cpphdl_n2006, cpphdl_n1988) <+ cpphdl_channel(V(cpphdl_n2002, cpphdl_n1988), V(cpphdl_n2006, cpphdl_n1988), 0.0040000000000000001, 0.69999999999999996, 1.0);
        // device 1491, IC IC259, analog/basic/strongarm_comparator.hpp:35
        I(cpphdl_n2006, Vdd) <+ cpphdl_channel(V(cpphdl_n2002, Vdd), V(cpphdl_n2006, Vdd), 0.002, 0.69999999999999996, -1.0);
        // device 1492, IC IC259, analog/basic/strongarm_comparator.hpp:36
        I(cpphdl_n2002, Vdd) <+ cpphdl_channel(V(cpphdl_n2006, Vdd), V(cpphdl_n2002, Vdd), 0.002, 0.69999999999999996, -1.0);
        // device 1493, IC IC259, analog/basic/strongarm_comparator.hpp:38
        I(cpphdl_n1987, Vdd) <+ cpphdl_channel(V(EVALUATE, Vdd), V(cpphdl_n1987, Vdd), 0.002, 0.69999999999999996, -1.0);
        // device 1494, IC IC259, analog/basic/strongarm_comparator.hpp:39
        I(cpphdl_n1988, Vdd) <+ cpphdl_channel(V(EVALUATE, Vdd), V(cpphdl_n1988, Vdd), 0.002, 0.69999999999999996, -1.0);
        // device 1495, IC IC259, analog/basic/strongarm_comparator.hpp:40
        I(cpphdl_n2006, Vdd) <+ cpphdl_channel(V(EVALUATE, Vdd), V(cpphdl_n2006, Vdd), 0.002, 0.69999999999999996, -1.0);
        // device 1496, IC IC259, analog/basic/strongarm_comparator.hpp:41
        I(cpphdl_n2002, Vdd) <+ cpphdl_channel(V(EVALUATE, Vdd), V(cpphdl_n2002, Vdd), 0.002, 0.69999999999999996, -1.0);
        // device 1497, IC IC259, analog/basic/strongarm_comparator.hpp:42
        I(cpphdl_n1987, Vss) <+ 2.9999999999999998e-14 * ddt(V(cpphdl_n1987, Vss)); // Bench initial voltage = 0.0 V.
        // device 1498, IC IC259, analog/basic/strongarm_comparator.hpp:43
        I(cpphdl_n1988, Vss) <+ 2.9999999999999998e-14 * ddt(V(cpphdl_n1988, Vss)); // Bench initial voltage = 0.0 V.
        // device 1499, IC IC259, analog/basic/strongarm_comparator.hpp:44
        I(cpphdl_n1989, Vss) <+ 2.9999999999999998e-14 * ddt(V(cpphdl_n1989, Vss)); // Bench initial voltage = 0.0 V.
        // device 1500, IC IC259, analog/basic/strongarm_comparator.hpp:45
        I(cpphdl_n2006, Vss) <+ 5.0000000000000002e-14 * ddt(V(cpphdl_n2006, Vss)); // Bench initial voltage = 0.0 V.
        // device 1501, IC IC259, analog/basic/strongarm_comparator.hpp:46
        I(cpphdl_n2002, Vss) <+ 5.0000000000000002e-14 * ddt(V(cpphdl_n2002, Vss)); // Bench initial voltage = 0.0 V.
        // device 1502, IC IC259, analog/basic/strongarm_comparator.hpp:47
        I(cpphdl_n1982, cpphdl_n1989) <+ 2e-14 * ddt(V(cpphdl_n1982, cpphdl_n1989)); // Bench initial voltage = 0.0 V.
        // device 1503, IC IC259, analog/basic/strongarm_comparator.hpp:48
        I(cpphdl_n1983, cpphdl_n1989) <+ 2e-14 * ddt(V(cpphdl_n1983, cpphdl_n1989)); // Bench initial voltage = 0.0 V.
        // device 1504, IC IC259, analog/basic/strongarm_comparator.hpp:49
        I(cpphdl_n1982, cpphdl_n1987) <+ 2.9999999999999998e-15 * ddt(V(cpphdl_n1982, cpphdl_n1987)); // Bench initial voltage = 0.0 V.
        // device 1505, IC IC259, analog/basic/strongarm_comparator.hpp:50
        I(cpphdl_n1983, cpphdl_n1988) <+ 2.9999999999999998e-15 * ddt(V(cpphdl_n1983, cpphdl_n1988)); // Bench initial voltage = 0.0 V.
        // device 1506, IC IC261, analog/basic/inverter.hpp:11
        I(cpphdl_n2010, Vdd) <+ cpphdl_channel(V(cpphdl_n2002, Vdd), V(cpphdl_n2010, Vdd), 0.001, 0.69999999999999996, -1.0);
        // device 1507, IC IC261, analog/basic/inverter.hpp:12
        I(cpphdl_n2010, Vss) <+ cpphdl_channel(V(cpphdl_n2002, Vss), V(cpphdl_n2010, Vss), 0.001, 0.69999999999999996, 1.0);
        // device 1508, IC IC263, analog/basic/inverter.hpp:11
        I(cpphdl_n2024, Vdd) <+ cpphdl_channel(V(cpphdl_n2010, Vdd), V(cpphdl_n2024, Vdd), 0.0040000000000000001, 0.69999999999999996, -1.0);
        // device 1509, IC IC263, analog/basic/inverter.hpp:12
        I(cpphdl_n2024, Vss) <+ cpphdl_channel(V(cpphdl_n2010, Vss), V(cpphdl_n2024, Vss), 0.0040000000000000001, 0.69999999999999996, 1.0);
        // device 1510, IC IC260, analog/basic/buffered_nand_latch.hpp:34
        I(cpphdl_n2002, Vss) <+ 2.0000000000000002e-15 * ddt(V(cpphdl_n2002, Vss)); // Bench initial voltage = 0.0 V.
        // device 1511, IC IC260, analog/basic/buffered_nand_latch.hpp:35
        I(cpphdl_n2002, cpphdl_n2010) <+ 1.0000000000000001e-15 * ddt(V(cpphdl_n2002, cpphdl_n2010)); // Bench initial voltage = 0.0 V.
        // device 1512, IC IC260, analog/basic/buffered_nand_latch.hpp:36
        I(cpphdl_n2010, Vss) <+ 5e-15 * ddt(V(cpphdl_n2010, Vss)); // Bench initial voltage = 0.0 V.
        // device 1513, IC IC260, analog/basic/buffered_nand_latch.hpp:37
        I(cpphdl_n2010, Vss) <+ 8.0000000000000006e-15 * ddt(V(cpphdl_n2010, Vss)); // Bench initial voltage = 0.0 V.
        // device 1514, IC IC260, analog/basic/buffered_nand_latch.hpp:38
        I(cpphdl_n2024, Vss) <+ 1e-14 * ddt(V(cpphdl_n2024, Vss)); // Bench initial voltage = 0.0 V.
        // device 1515, IC IC262, analog/basic/inverter.hpp:11
        I(cpphdl_n2014, Vdd) <+ cpphdl_channel(V(cpphdl_n2006, Vdd), V(cpphdl_n2014, Vdd), 0.001, 0.69999999999999996, -1.0);
        // device 1516, IC IC262, analog/basic/inverter.hpp:12
        I(cpphdl_n2014, Vss) <+ cpphdl_channel(V(cpphdl_n2006, Vss), V(cpphdl_n2014, Vss), 0.001, 0.69999999999999996, 1.0);
        // device 1517, IC IC264, analog/basic/inverter.hpp:11
        I(cpphdl_n2030, Vdd) <+ cpphdl_channel(V(cpphdl_n2014, Vdd), V(cpphdl_n2030, Vdd), 0.0040000000000000001, 0.69999999999999996, -1.0);
        // device 1518, IC IC264, analog/basic/inverter.hpp:12
        I(cpphdl_n2030, Vss) <+ cpphdl_channel(V(cpphdl_n2014, Vss), V(cpphdl_n2030, Vss), 0.0040000000000000001, 0.69999999999999996, 1.0);
        // device 1519, IC IC260, analog/basic/buffered_nand_latch.hpp:34
        I(cpphdl_n2006, Vss) <+ 2.0000000000000002e-15 * ddt(V(cpphdl_n2006, Vss)); // Bench initial voltage = 0.0 V.
        // device 1520, IC IC260, analog/basic/buffered_nand_latch.hpp:35
        I(cpphdl_n2006, cpphdl_n2014) <+ 1.0000000000000001e-15 * ddt(V(cpphdl_n2006, cpphdl_n2014)); // Bench initial voltage = 0.0 V.
        // device 1521, IC IC260, analog/basic/buffered_nand_latch.hpp:36
        I(cpphdl_n2014, Vss) <+ 5e-15 * ddt(V(cpphdl_n2014, Vss)); // Bench initial voltage = 0.0 V.
        // device 1522, IC IC260, analog/basic/buffered_nand_latch.hpp:37
        I(cpphdl_n2014, Vss) <+ 8.0000000000000006e-15 * ddt(V(cpphdl_n2014, Vss)); // Bench initial voltage = 0.0 V.
        // device 1523, IC IC260, analog/basic/buffered_nand_latch.hpp:38
        I(cpphdl_n2030, Vss) <+ 1e-14 * ddt(V(cpphdl_n2030, Vss)); // Bench initial voltage = 0.0 V.
        // device 1524, IC IC266, analog/basic/cmos_logic.hpp:17
        I(cpphdl_n2823, Vss) <+ 5.0000000000000002e-14 * ddt(V(cpphdl_n2823, Vss)); // Bench initial voltage = 0.0 V.
        // device 1525, IC IC266, analog/basic/cmos_logic.hpp:18
        I(cpphdl_n2823, Vdd) <+ cpphdl_channel(V(cpphdl_n2024, Vdd), V(cpphdl_n2823, Vdd), 0.01, 0.69999999999999996, -1.0);
        // device 1526, IC IC266, analog/basic/cmos_logic.hpp:19
        I(cpphdl_n2823, Vdd) <+ cpphdl_channel(V(cpphdl_n2032, Vdd), V(cpphdl_n2823, Vdd), 0.01, 0.69999999999999996, -1.0);
        // device 1527, IC IC266, analog/basic/cmos_logic.hpp:20
        I(cpphdl_n2823, cpphdl_n2027) <+ cpphdl_channel(V(cpphdl_n2024, cpphdl_n2027), V(cpphdl_n2823, cpphdl_n2027), 0.01, 0.69999999999999996, 1.0);
        // device 1528, IC IC266, analog/basic/cmos_logic.hpp:21
        I(cpphdl_n2027, Vss) <+ cpphdl_channel(V(cpphdl_n2032, Vss), V(cpphdl_n2027, Vss), 0.01, 0.69999999999999996, 1.0);
        // device 1529, IC IC266, analog/basic/cmos_logic.hpp:27
        I(cpphdl_n2027, Vss) <+ 1e-14 * ddt(V(cpphdl_n2027, Vss)); // Bench initial voltage = 0.0 V.
        // device 1530, IC IC267, analog/basic/cmos_logic.hpp:17
        I(cpphdl_n2032, Vss) <+ 5.0000000000000002e-14 * ddt(V(cpphdl_n2032, Vss)); // Bench initial voltage = 0.0 V.
        // device 1531, IC IC267, analog/basic/cmos_logic.hpp:18
        I(cpphdl_n2032, Vdd) <+ cpphdl_channel(V(cpphdl_n2030, Vdd), V(cpphdl_n2032, Vdd), 0.01, 0.69999999999999996, -1.0);
        // device 1532, IC IC267, analog/basic/cmos_logic.hpp:19
        I(cpphdl_n2032, Vdd) <+ cpphdl_channel(V(cpphdl_n2823, Vdd), V(cpphdl_n2032, Vdd), 0.01, 0.69999999999999996, -1.0);
        // device 1533, IC IC267, analog/basic/cmos_logic.hpp:20
        I(cpphdl_n2032, cpphdl_n2033) <+ cpphdl_channel(V(cpphdl_n2030, cpphdl_n2033), V(cpphdl_n2032, cpphdl_n2033), 0.01, 0.69999999999999996, 1.0);
        // device 1534, IC IC267, analog/basic/cmos_logic.hpp:21
        I(cpphdl_n2033, Vss) <+ cpphdl_channel(V(cpphdl_n2823, Vss), V(cpphdl_n2033, Vss), 0.01, 0.69999999999999996, 1.0);
        // device 1535, IC IC267, analog/basic/cmos_logic.hpp:27
        I(cpphdl_n2033, Vss) <+ 1e-14 * ddt(V(cpphdl_n2033, Vss)); // Bench initial voltage = 0.0 V.
        // device 1536, IC IC265, analog/basic/nand_latch.hpp:36
        I(cpphdl_n2024, Vss) <+ 2.9999999999999998e-15 * ddt(V(cpphdl_n2024, Vss)); // Bench initial voltage = 0.0 V.
        // device 1537, IC IC265, analog/basic/nand_latch.hpp:37
        I(cpphdl_n2030, Vss) <+ 2.9999999999999998e-15 * ddt(V(cpphdl_n2030, Vss)); // Bench initial voltage = 0.0 V.
        // device 1538, IC IC268, analog/basic/inverter.hpp:11
        I(cpphdl_n2038, Vdd) <+ cpphdl_channel(V(CLEAR, Vdd), V(cpphdl_n2038, Vdd), 0.01, 0.69999999999999996, -1.0);
        // device 1539, IC IC268, analog/basic/inverter.hpp:12
        I(cpphdl_n2038, Vss) <+ cpphdl_channel(V(CLEAR, Vss), V(cpphdl_n2038, Vss), 0.01, 0.69999999999999996, 1.0);
        // device 1540, IC IC265, analog/basic/nand_latch.hpp:58
        I(cpphdl_n2038, Vss) <+ 2.9999999999999998e-15 * ddt(V(cpphdl_n2038, Vss)); // Bench initial voltage = 0.0 V.
        // device 1541, IC IC265, analog/basic/nand_latch.hpp:59
        I(cpphdl_n2823, Vss) <+ cpphdl_channel(V(CLEAR, Vss), V(cpphdl_n2823, Vss), 0.050000000000000003, 0.69999999999999996, 1.0);
        // device 1542, IC IC265, analog/basic/nand_latch.hpp:60
        I(cpphdl_n2032, Vdd) <+ cpphdl_channel(V(cpphdl_n2038, Vdd), V(cpphdl_n2032, Vdd), 0.050000000000000003, 0.69999999999999996, -1.0);
        // device 1543, IC IC271, analog/basic/inverter.hpp:11
        I(cpphdl_n2062, Vdd) <+ cpphdl_channel(V(TRACK11, Vdd), V(cpphdl_n2062, Vdd), 0.0040000000000000001, 0.69999999999999996, -1.0);
        // device 1544, IC IC271, analog/basic/inverter.hpp:12
        I(cpphdl_n2062, Vss) <+ cpphdl_channel(V(TRACK11, Vss), V(cpphdl_n2062, Vss), 0.0040000000000000001, 0.69999999999999996, 1.0);
        // device 1545, IC IC270, analog/basic/mos_track_hold.hpp:31
        I(cpphdl_n2062, Vss) <+ 2e-14 * ddt(V(cpphdl_n2062, Vss)); // Bench initial voltage = 0.0 V.
        // device 1546, IC IC270, analog/basic/mos_track_hold.hpp:32
        I(cpphdl_n2628, cpphdl_n2116) <+ cpphdl_channel(V(TRACK11, cpphdl_n2116), V(cpphdl_n2628, cpphdl_n2116), 0.029999999999999999, 0.69999999999999996, 1.0);
        // device 1547, IC IC270, analog/basic/mos_track_hold.hpp:33
        I(cpphdl_n2116, cpphdl_n2628) <+ cpphdl_channel(V(cpphdl_n2062, cpphdl_n2628), V(cpphdl_n2116, cpphdl_n2628), 0.014999999999999999, 0.69999999999999996, -1.0);
        // device 1548, IC IC270, analog/basic/mos_track_hold.hpp:37
        I(cpphdl_n2116, cpphdl_n2116) <+ cpphdl_channel(V(cpphdl_n2062, cpphdl_n2116), V(cpphdl_n2116, cpphdl_n2116), 0.016, 0.69999999999999996, 1.0);
        // device 1549, IC IC270, analog/basic/mos_track_hold.hpp:38
        I(cpphdl_n2116, cpphdl_n2116) <+ cpphdl_channel(V(TRACK11, cpphdl_n2116), V(cpphdl_n2116, cpphdl_n2116), 0.0083999999999999995, 0.69999999999999996, -1.0);
        // device 1550, IC IC270, analog/basic/mos_track_hold.hpp:39
        I(cpphdl_n2116, Vss) <+ 1.5000000000000001e-12 * ddt(V(cpphdl_n2116, Vss)); // Bench initial voltage = 0.0 V.
        // device 1551, IC IC270, analog/basic/mos_track_hold.hpp:42
        I(TRACK11, cpphdl_n2116) <+ 2.0000000000000002e-15 * ddt(V(TRACK11, cpphdl_n2116)); // Bench initial voltage = -0.0 V.
        // device 1552, IC IC270, analog/basic/mos_track_hold.hpp:43
        I(cpphdl_n2062, cpphdl_n2116) <+ 2.0000000000000002e-15 * ddt(V(cpphdl_n2062, cpphdl_n2116)); // Bench initial voltage = 0.0 V.
        // device 1553, IC IC270, analog/basic/mos_track_hold.hpp:44
        I(cpphdl_n2628, cpphdl_n2116) <+ 1.0000000000000001e-15 * ddt(V(cpphdl_n2628, cpphdl_n2116)); // Bench initial voltage = 0.0 V.
        // device 1554, IC IC273, analog/basic/inverter.hpp:11
        I(cpphdl_n2077, Vdd) <+ cpphdl_channel(V(BIT_N11_0, Vdd), V(cpphdl_n2077, Vdd), 0.080000000000000002, 0.69999999999999996, -1.0);
        // device 1555, IC IC273, analog/basic/inverter.hpp:12
        I(cpphdl_n2077, Vss) <+ cpphdl_channel(V(BIT_N11_0, Vss), V(cpphdl_n2077, Vss), 0.080000000000000002, 0.69999999999999996, 1.0);
        // device 1556, IC IC272, analog/basic/mos_r2r_dac.hpp:27
        I(cpphdl_n2077, Vss) <+ 2.9999999999999998e-15 * ddt(V(cpphdl_n2077, Vss)); // Bench initial voltage = 0.0 V.
        // device 1557, IC IC272, analog/basic/mos_r2r_dac.hpp:28
        I(cpphdl_n2077, cpphdl_n2106) <+ V(cpphdl_n2077, cpphdl_n2106) / 2000.0;
        // device 1558, IC IC272, analog/basic/mos_r2r_dac.hpp:29
        I(cpphdl_n2106, Vss) <+ 2.9999999999999998e-15 * ddt(V(cpphdl_n2106, Vss)); // Bench initial voltage = 0.0 V.
        // device 1559, IC IC274, analog/basic/inverter.hpp:11
        I(cpphdl_n2081, Vdd) <+ cpphdl_channel(V(BIT_N11_1, Vdd), V(cpphdl_n2081, Vdd), 0.080000000000000002, 0.69999999999999996, -1.0);
        // device 1560, IC IC274, analog/basic/inverter.hpp:12
        I(cpphdl_n2081, Vss) <+ cpphdl_channel(V(BIT_N11_1, Vss), V(cpphdl_n2081, Vss), 0.080000000000000002, 0.69999999999999996, 1.0);
        // device 1561, IC IC272, analog/basic/mos_r2r_dac.hpp:27
        I(cpphdl_n2081, Vss) <+ 2.9999999999999998e-15 * ddt(V(cpphdl_n2081, Vss)); // Bench initial voltage = 0.0 V.
        // device 1562, IC IC272, analog/basic/mos_r2r_dac.hpp:28
        I(cpphdl_n2081, cpphdl_n2107) <+ V(cpphdl_n2081, cpphdl_n2107) / 2000.0;
        // device 1563, IC IC272, analog/basic/mos_r2r_dac.hpp:29
        I(cpphdl_n2107, Vss) <+ 2.9999999999999998e-15 * ddt(V(cpphdl_n2107, Vss)); // Bench initial voltage = 0.0 V.
        // device 1564, IC IC272, analog/basic/mos_r2r_dac.hpp:31
        I(cpphdl_n2106, cpphdl_n2107) <+ V(cpphdl_n2106, cpphdl_n2107) / 1000.0;
        // device 1565, IC IC275, analog/basic/inverter.hpp:11
        I(cpphdl_n2085, Vdd) <+ cpphdl_channel(V(BIT_N11_2, Vdd), V(cpphdl_n2085, Vdd), 0.080000000000000002, 0.69999999999999996, -1.0);
        // device 1566, IC IC275, analog/basic/inverter.hpp:12
        I(cpphdl_n2085, Vss) <+ cpphdl_channel(V(BIT_N11_2, Vss), V(cpphdl_n2085, Vss), 0.080000000000000002, 0.69999999999999996, 1.0);
        // device 1567, IC IC272, analog/basic/mos_r2r_dac.hpp:27
        I(cpphdl_n2085, Vss) <+ 2.9999999999999998e-15 * ddt(V(cpphdl_n2085, Vss)); // Bench initial voltage = 0.0 V.
        // device 1568, IC IC272, analog/basic/mos_r2r_dac.hpp:28
        I(cpphdl_n2085, cpphdl_n2108) <+ V(cpphdl_n2085, cpphdl_n2108) / 2000.0;
        // device 1569, IC IC272, analog/basic/mos_r2r_dac.hpp:29
        I(cpphdl_n2108, Vss) <+ 2.9999999999999998e-15 * ddt(V(cpphdl_n2108, Vss)); // Bench initial voltage = 0.0 V.
        // device 1570, IC IC272, analog/basic/mos_r2r_dac.hpp:31
        I(cpphdl_n2107, cpphdl_n2108) <+ V(cpphdl_n2107, cpphdl_n2108) / 1000.0;
        // device 1571, IC IC276, analog/basic/inverter.hpp:11
        I(cpphdl_n2089, Vdd) <+ cpphdl_channel(V(BIT_N11_3, Vdd), V(cpphdl_n2089, Vdd), 0.080000000000000002, 0.69999999999999996, -1.0);
        // device 1572, IC IC276, analog/basic/inverter.hpp:12
        I(cpphdl_n2089, Vss) <+ cpphdl_channel(V(BIT_N11_3, Vss), V(cpphdl_n2089, Vss), 0.080000000000000002, 0.69999999999999996, 1.0);
        // device 1573, IC IC272, analog/basic/mos_r2r_dac.hpp:27
        I(cpphdl_n2089, Vss) <+ 2.9999999999999998e-15 * ddt(V(cpphdl_n2089, Vss)); // Bench initial voltage = 0.0 V.
        // device 1574, IC IC272, analog/basic/mos_r2r_dac.hpp:28
        I(cpphdl_n2089, cpphdl_n2109) <+ V(cpphdl_n2089, cpphdl_n2109) / 2000.0;
        // device 1575, IC IC272, analog/basic/mos_r2r_dac.hpp:29
        I(cpphdl_n2109, Vss) <+ 2.9999999999999998e-15 * ddt(V(cpphdl_n2109, Vss)); // Bench initial voltage = 0.0 V.
        // device 1576, IC IC272, analog/basic/mos_r2r_dac.hpp:31
        I(cpphdl_n2108, cpphdl_n2109) <+ V(cpphdl_n2108, cpphdl_n2109) / 1000.0;
        // device 1577, IC IC277, analog/basic/inverter.hpp:11
        I(cpphdl_n2093, Vdd) <+ cpphdl_channel(V(BIT_N11_4, Vdd), V(cpphdl_n2093, Vdd), 0.080000000000000002, 0.69999999999999996, -1.0);
        // device 1578, IC IC277, analog/basic/inverter.hpp:12
        I(cpphdl_n2093, Vss) <+ cpphdl_channel(V(BIT_N11_4, Vss), V(cpphdl_n2093, Vss), 0.080000000000000002, 0.69999999999999996, 1.0);
        // device 1579, IC IC272, analog/basic/mos_r2r_dac.hpp:27
        I(cpphdl_n2093, Vss) <+ 2.9999999999999998e-15 * ddt(V(cpphdl_n2093, Vss)); // Bench initial voltage = 0.0 V.
        // device 1580, IC IC272, analog/basic/mos_r2r_dac.hpp:28
        I(cpphdl_n2093, cpphdl_n2110) <+ V(cpphdl_n2093, cpphdl_n2110) / 2000.0;
        // device 1581, IC IC272, analog/basic/mos_r2r_dac.hpp:29
        I(cpphdl_n2110, Vss) <+ 2.9999999999999998e-15 * ddt(V(cpphdl_n2110, Vss)); // Bench initial voltage = 0.0 V.
        // device 1582, IC IC272, analog/basic/mos_r2r_dac.hpp:31
        I(cpphdl_n2109, cpphdl_n2110) <+ V(cpphdl_n2109, cpphdl_n2110) / 1000.0;
        // device 1583, IC IC278, analog/basic/inverter.hpp:11
        I(cpphdl_n2097, Vdd) <+ cpphdl_channel(V(BIT_N11_5, Vdd), V(cpphdl_n2097, Vdd), 0.080000000000000002, 0.69999999999999996, -1.0);
        // device 1584, IC IC278, analog/basic/inverter.hpp:12
        I(cpphdl_n2097, Vss) <+ cpphdl_channel(V(BIT_N11_5, Vss), V(cpphdl_n2097, Vss), 0.080000000000000002, 0.69999999999999996, 1.0);
        // device 1585, IC IC272, analog/basic/mos_r2r_dac.hpp:27
        I(cpphdl_n2097, Vss) <+ 2.9999999999999998e-15 * ddt(V(cpphdl_n2097, Vss)); // Bench initial voltage = 0.0 V.
        // device 1586, IC IC272, analog/basic/mos_r2r_dac.hpp:28
        I(cpphdl_n2097, cpphdl_n2111) <+ V(cpphdl_n2097, cpphdl_n2111) / 2000.0;
        // device 1587, IC IC272, analog/basic/mos_r2r_dac.hpp:29
        I(cpphdl_n2111, Vss) <+ 2.9999999999999998e-15 * ddt(V(cpphdl_n2111, Vss)); // Bench initial voltage = 0.0 V.
        // device 1588, IC IC272, analog/basic/mos_r2r_dac.hpp:31
        I(cpphdl_n2110, cpphdl_n2111) <+ V(cpphdl_n2110, cpphdl_n2111) / 1000.0;
        // device 1589, IC IC279, analog/basic/inverter.hpp:11
        I(cpphdl_n2101, Vdd) <+ cpphdl_channel(V(BIT_N11_6, Vdd), V(cpphdl_n2101, Vdd), 0.080000000000000002, 0.69999999999999996, -1.0);
        // device 1590, IC IC279, analog/basic/inverter.hpp:12
        I(cpphdl_n2101, Vss) <+ cpphdl_channel(V(BIT_N11_6, Vss), V(cpphdl_n2101, Vss), 0.080000000000000002, 0.69999999999999996, 1.0);
        // device 1591, IC IC272, analog/basic/mos_r2r_dac.hpp:27
        I(cpphdl_n2101, Vss) <+ 2.9999999999999998e-15 * ddt(V(cpphdl_n2101, Vss)); // Bench initial voltage = 0.0 V.
        // device 1592, IC IC272, analog/basic/mos_r2r_dac.hpp:28
        I(cpphdl_n2101, cpphdl_n2112) <+ V(cpphdl_n2101, cpphdl_n2112) / 2000.0;
        // device 1593, IC IC272, analog/basic/mos_r2r_dac.hpp:29
        I(cpphdl_n2112, Vss) <+ 2.9999999999999998e-15 * ddt(V(cpphdl_n2112, Vss)); // Bench initial voltage = 0.0 V.
        // device 1594, IC IC272, analog/basic/mos_r2r_dac.hpp:31
        I(cpphdl_n2111, cpphdl_n2112) <+ V(cpphdl_n2111, cpphdl_n2112) / 1000.0;
        // device 1595, IC IC280, analog/basic/inverter.hpp:11
        I(cpphdl_n2105, Vdd) <+ cpphdl_channel(V(BIT_N11_7, Vdd), V(cpphdl_n2105, Vdd), 0.080000000000000002, 0.69999999999999996, -1.0);
        // device 1596, IC IC280, analog/basic/inverter.hpp:12
        I(cpphdl_n2105, Vss) <+ cpphdl_channel(V(BIT_N11_7, Vss), V(cpphdl_n2105, Vss), 0.080000000000000002, 0.69999999999999996, 1.0);
        // device 1597, IC IC272, analog/basic/mos_r2r_dac.hpp:27
        I(cpphdl_n2105, Vss) <+ 2.9999999999999998e-15 * ddt(V(cpphdl_n2105, Vss)); // Bench initial voltage = 0.0 V.
        // device 1598, IC IC272, analog/basic/mos_r2r_dac.hpp:28
        I(cpphdl_n2105, cpphdl_n2117) <+ V(cpphdl_n2105, cpphdl_n2117) / 2000.0;
        // device 1599, IC IC272, analog/basic/mos_r2r_dac.hpp:29
        I(cpphdl_n2117, Vss) <+ 2.9999999999999998e-15 * ddt(V(cpphdl_n2117, Vss)); // Bench initial voltage = 0.0 V.
        // device 1600, IC IC272, analog/basic/mos_r2r_dac.hpp:31
        I(cpphdl_n2112, cpphdl_n2117) <+ V(cpphdl_n2112, cpphdl_n2117) / 1000.0;
        // device 1601, IC IC272, analog/basic/mos_r2r_dac.hpp:33
        I(Vss, cpphdl_n2106) <+ V(Vss, cpphdl_n2106) / 2000.0;
        // device 1602, IC IC281, analog/basic/nmos_resistor_amplifier.hpp:23
        I(Vdd, cpphdl_n2126) <+ V(Vdd, cpphdl_n2126) / 1000.0;
        // device 1603, IC IC281, analog/basic/nmos_resistor_amplifier.hpp:24
        I(Vdd, cpphdl_n2125) <+ V(Vdd, cpphdl_n2125) / 1000.0;
        // device 1604, IC IC281, analog/basic/nmos_resistor_amplifier.hpp:25
        I(cpphdl_n2126, cpphdl_n2120) <+ cpphdl_channel(V(cpphdl_n2116, cpphdl_n2120), V(cpphdl_n2126, cpphdl_n2120), 0.0074999999999999997, 0.69999999999999996, 1.0);
        // device 1605, IC IC281, analog/basic/nmos_resistor_amplifier.hpp:26
        I(cpphdl_n2125, cpphdl_n2121) <+ cpphdl_channel(V(cpphdl_n2117, cpphdl_n2121), V(cpphdl_n2125, cpphdl_n2121), 0.0074999999999999997, 0.69999999999999996, 1.0);
        // device 1606, IC IC281, analog/basic/nmos_resistor_amplifier.hpp:27
        I(cpphdl_n2122, cpphdl_n2120) <+ V(cpphdl_n2122, cpphdl_n2120) / 100.0;
        // device 1607, IC IC281, analog/basic/nmos_resistor_amplifier.hpp:28
        I(cpphdl_n2122, cpphdl_n2121) <+ V(cpphdl_n2122, cpphdl_n2121) / 100.0;
        // device 1608, IC IC281, analog/basic/nmos_resistor_amplifier.hpp:29
        I(Vss, cpphdl_n2122) <+ V(Vss, cpphdl_n2122) / 300.0;
        // device 1609, IC IC281, analog/basic/nmos_resistor_amplifier.hpp:30
        I(cpphdl_n2126, Vdd) <+ 2.9999999999999998e-13 * ddt(V(cpphdl_n2126, Vdd)); // Bench initial voltage = 0.0 V.
        // device 1610, IC IC281, analog/basic/nmos_resistor_amplifier.hpp:31
        I(cpphdl_n2125, Vdd) <+ 2.9999999999999998e-13 * ddt(V(cpphdl_n2125, Vdd)); // Bench initial voltage = 0.0 V.
        // device 1611, IC IC281, analog/basic/nmos_resistor_amplifier.hpp:32
        I(cpphdl_n2122, Vss) <+ 4e-14 * ddt(V(cpphdl_n2122, Vss)); // Bench initial voltage = 0.0 V.
        // device 1612, IC IC281, analog/basic/nmos_resistor_amplifier.hpp:34
        I(cpphdl_n2116, cpphdl_n2120) <+ 2e-14 * ddt(V(cpphdl_n2116, cpphdl_n2120)); // Bench initial voltage = 0.0 V.
        // device 1613, IC IC281, analog/basic/nmos_resistor_amplifier.hpp:35
        I(cpphdl_n2117, cpphdl_n2121) <+ 2e-14 * ddt(V(cpphdl_n2117, cpphdl_n2121)); // Bench initial voltage = 0.0 V.
        // device 1614, IC IC281, analog/basic/nmos_resistor_amplifier.hpp:36
        I(cpphdl_n2116, cpphdl_n2126) <+ 2.9999999999999998e-15 * ddt(V(cpphdl_n2116, cpphdl_n2126)); // Bench initial voltage = 0.0 V.
        // device 1615, IC IC281, analog/basic/nmos_resistor_amplifier.hpp:37
        I(cpphdl_n2117, cpphdl_n2125) <+ 2.9999999999999998e-15 * ddt(V(cpphdl_n2117, cpphdl_n2125)); // Bench initial voltage = 0.0 V.
        // device 1616, IC IC282, analog/basic/strongarm_comparator.hpp:28
        I(cpphdl_n2130, cpphdl_n2132) <+ cpphdl_channel(V(cpphdl_n2125, cpphdl_n2132), V(cpphdl_n2130, cpphdl_n2132), 0.0080000000000000002, 0.69999999999999996, 1.0);
        // device 1617, IC IC282, analog/basic/strongarm_comparator.hpp:29
        I(cpphdl_n2131, cpphdl_n2132) <+ cpphdl_channel(V(cpphdl_n2126, cpphdl_n2132), V(cpphdl_n2131, cpphdl_n2132), 0.0080000000000000002, 0.69999999999999996, 1.0);
        // device 1618, IC IC282, analog/basic/strongarm_comparator.hpp:30
        I(cpphdl_n2132, Vss) <+ cpphdl_channel(V(EVALUATE, Vss), V(cpphdl_n2132, Vss), 0.0080000000000000002, 0.69999999999999996, 1.0);
        // device 1619, IC IC282, analog/basic/strongarm_comparator.hpp:33
        I(cpphdl_n2145, cpphdl_n2130) <+ cpphdl_channel(V(cpphdl_n2149, cpphdl_n2130), V(cpphdl_n2145, cpphdl_n2130), 0.0040000000000000001, 0.69999999999999996, 1.0);
        // device 1620, IC IC282, analog/basic/strongarm_comparator.hpp:34
        I(cpphdl_n2149, cpphdl_n2131) <+ cpphdl_channel(V(cpphdl_n2145, cpphdl_n2131), V(cpphdl_n2149, cpphdl_n2131), 0.0040000000000000001, 0.69999999999999996, 1.0);
        // device 1621, IC IC282, analog/basic/strongarm_comparator.hpp:35
        I(cpphdl_n2149, Vdd) <+ cpphdl_channel(V(cpphdl_n2145, Vdd), V(cpphdl_n2149, Vdd), 0.002, 0.69999999999999996, -1.0);
        // device 1622, IC IC282, analog/basic/strongarm_comparator.hpp:36
        I(cpphdl_n2145, Vdd) <+ cpphdl_channel(V(cpphdl_n2149, Vdd), V(cpphdl_n2145, Vdd), 0.002, 0.69999999999999996, -1.0);
        // device 1623, IC IC282, analog/basic/strongarm_comparator.hpp:38
        I(cpphdl_n2130, Vdd) <+ cpphdl_channel(V(EVALUATE, Vdd), V(cpphdl_n2130, Vdd), 0.002, 0.69999999999999996, -1.0);
        // device 1624, IC IC282, analog/basic/strongarm_comparator.hpp:39
        I(cpphdl_n2131, Vdd) <+ cpphdl_channel(V(EVALUATE, Vdd), V(cpphdl_n2131, Vdd), 0.002, 0.69999999999999996, -1.0);
        // device 1625, IC IC282, analog/basic/strongarm_comparator.hpp:40
        I(cpphdl_n2149, Vdd) <+ cpphdl_channel(V(EVALUATE, Vdd), V(cpphdl_n2149, Vdd), 0.002, 0.69999999999999996, -1.0);
        // device 1626, IC IC282, analog/basic/strongarm_comparator.hpp:41
        I(cpphdl_n2145, Vdd) <+ cpphdl_channel(V(EVALUATE, Vdd), V(cpphdl_n2145, Vdd), 0.002, 0.69999999999999996, -1.0);
        // device 1627, IC IC282, analog/basic/strongarm_comparator.hpp:42
        I(cpphdl_n2130, Vss) <+ 2.9999999999999998e-14 * ddt(V(cpphdl_n2130, Vss)); // Bench initial voltage = 0.0 V.
        // device 1628, IC IC282, analog/basic/strongarm_comparator.hpp:43
        I(cpphdl_n2131, Vss) <+ 2.9999999999999998e-14 * ddt(V(cpphdl_n2131, Vss)); // Bench initial voltage = 0.0 V.
        // device 1629, IC IC282, analog/basic/strongarm_comparator.hpp:44
        I(cpphdl_n2132, Vss) <+ 2.9999999999999998e-14 * ddt(V(cpphdl_n2132, Vss)); // Bench initial voltage = 0.0 V.
        // device 1630, IC IC282, analog/basic/strongarm_comparator.hpp:45
        I(cpphdl_n2149, Vss) <+ 5.0000000000000002e-14 * ddt(V(cpphdl_n2149, Vss)); // Bench initial voltage = 0.0 V.
        // device 1631, IC IC282, analog/basic/strongarm_comparator.hpp:46
        I(cpphdl_n2145, Vss) <+ 5.0000000000000002e-14 * ddt(V(cpphdl_n2145, Vss)); // Bench initial voltage = 0.0 V.
        // device 1632, IC IC282, analog/basic/strongarm_comparator.hpp:47
        I(cpphdl_n2125, cpphdl_n2132) <+ 2e-14 * ddt(V(cpphdl_n2125, cpphdl_n2132)); // Bench initial voltage = 0.0 V.
        // device 1633, IC IC282, analog/basic/strongarm_comparator.hpp:48
        I(cpphdl_n2126, cpphdl_n2132) <+ 2e-14 * ddt(V(cpphdl_n2126, cpphdl_n2132)); // Bench initial voltage = 0.0 V.
        // device 1634, IC IC282, analog/basic/strongarm_comparator.hpp:49
        I(cpphdl_n2125, cpphdl_n2130) <+ 2.9999999999999998e-15 * ddt(V(cpphdl_n2125, cpphdl_n2130)); // Bench initial voltage = 0.0 V.
        // device 1635, IC IC282, analog/basic/strongarm_comparator.hpp:50
        I(cpphdl_n2126, cpphdl_n2131) <+ 2.9999999999999998e-15 * ddt(V(cpphdl_n2126, cpphdl_n2131)); // Bench initial voltage = 0.0 V.
        // device 1636, IC IC284, analog/basic/inverter.hpp:11
        I(cpphdl_n2153, Vdd) <+ cpphdl_channel(V(cpphdl_n2145, Vdd), V(cpphdl_n2153, Vdd), 0.001, 0.69999999999999996, -1.0);
        // device 1637, IC IC284, analog/basic/inverter.hpp:12
        I(cpphdl_n2153, Vss) <+ cpphdl_channel(V(cpphdl_n2145, Vss), V(cpphdl_n2153, Vss), 0.001, 0.69999999999999996, 1.0);
        // device 1638, IC IC286, analog/basic/inverter.hpp:11
        I(cpphdl_n2167, Vdd) <+ cpphdl_channel(V(cpphdl_n2153, Vdd), V(cpphdl_n2167, Vdd), 0.0040000000000000001, 0.69999999999999996, -1.0);
        // device 1639, IC IC286, analog/basic/inverter.hpp:12
        I(cpphdl_n2167, Vss) <+ cpphdl_channel(V(cpphdl_n2153, Vss), V(cpphdl_n2167, Vss), 0.0040000000000000001, 0.69999999999999996, 1.0);
        // device 1640, IC IC283, analog/basic/buffered_nand_latch.hpp:34
        I(cpphdl_n2145, Vss) <+ 2.0000000000000002e-15 * ddt(V(cpphdl_n2145, Vss)); // Bench initial voltage = 0.0 V.
        // device 1641, IC IC283, analog/basic/buffered_nand_latch.hpp:35
        I(cpphdl_n2145, cpphdl_n2153) <+ 1.0000000000000001e-15 * ddt(V(cpphdl_n2145, cpphdl_n2153)); // Bench initial voltage = 0.0 V.
        // device 1642, IC IC283, analog/basic/buffered_nand_latch.hpp:36
        I(cpphdl_n2153, Vss) <+ 5e-15 * ddt(V(cpphdl_n2153, Vss)); // Bench initial voltage = 0.0 V.
        // device 1643, IC IC283, analog/basic/buffered_nand_latch.hpp:37
        I(cpphdl_n2153, Vss) <+ 8.0000000000000006e-15 * ddt(V(cpphdl_n2153, Vss)); // Bench initial voltage = 0.0 V.
        // device 1644, IC IC283, analog/basic/buffered_nand_latch.hpp:38
        I(cpphdl_n2167, Vss) <+ 1e-14 * ddt(V(cpphdl_n2167, Vss)); // Bench initial voltage = 0.0 V.
        // device 1645, IC IC285, analog/basic/inverter.hpp:11
        I(cpphdl_n2157, Vdd) <+ cpphdl_channel(V(cpphdl_n2149, Vdd), V(cpphdl_n2157, Vdd), 0.001, 0.69999999999999996, -1.0);
        // device 1646, IC IC285, analog/basic/inverter.hpp:12
        I(cpphdl_n2157, Vss) <+ cpphdl_channel(V(cpphdl_n2149, Vss), V(cpphdl_n2157, Vss), 0.001, 0.69999999999999996, 1.0);
        // device 1647, IC IC287, analog/basic/inverter.hpp:11
        I(cpphdl_n2173, Vdd) <+ cpphdl_channel(V(cpphdl_n2157, Vdd), V(cpphdl_n2173, Vdd), 0.0040000000000000001, 0.69999999999999996, -1.0);
        // device 1648, IC IC287, analog/basic/inverter.hpp:12
        I(cpphdl_n2173, Vss) <+ cpphdl_channel(V(cpphdl_n2157, Vss), V(cpphdl_n2173, Vss), 0.0040000000000000001, 0.69999999999999996, 1.0);
        // device 1649, IC IC283, analog/basic/buffered_nand_latch.hpp:34
        I(cpphdl_n2149, Vss) <+ 2.0000000000000002e-15 * ddt(V(cpphdl_n2149, Vss)); // Bench initial voltage = 0.0 V.
        // device 1650, IC IC283, analog/basic/buffered_nand_latch.hpp:35
        I(cpphdl_n2149, cpphdl_n2157) <+ 1.0000000000000001e-15 * ddt(V(cpphdl_n2149, cpphdl_n2157)); // Bench initial voltage = 0.0 V.
        // device 1651, IC IC283, analog/basic/buffered_nand_latch.hpp:36
        I(cpphdl_n2157, Vss) <+ 5e-15 * ddt(V(cpphdl_n2157, Vss)); // Bench initial voltage = 0.0 V.
        // device 1652, IC IC283, analog/basic/buffered_nand_latch.hpp:37
        I(cpphdl_n2157, Vss) <+ 8.0000000000000006e-15 * ddt(V(cpphdl_n2157, Vss)); // Bench initial voltage = 0.0 V.
        // device 1653, IC IC283, analog/basic/buffered_nand_latch.hpp:38
        I(cpphdl_n2173, Vss) <+ 1e-14 * ddt(V(cpphdl_n2173, Vss)); // Bench initial voltage = 0.0 V.
        // device 1654, IC IC289, analog/basic/cmos_logic.hpp:17
        I(cpphdl_n2828, Vss) <+ 5.0000000000000002e-14 * ddt(V(cpphdl_n2828, Vss)); // Bench initial voltage = 0.0 V.
        // device 1655, IC IC289, analog/basic/cmos_logic.hpp:18
        I(cpphdl_n2828, Vdd) <+ cpphdl_channel(V(cpphdl_n2167, Vdd), V(cpphdl_n2828, Vdd), 0.01, 0.69999999999999996, -1.0);
        // device 1656, IC IC289, analog/basic/cmos_logic.hpp:19
        I(cpphdl_n2828, Vdd) <+ cpphdl_channel(V(cpphdl_n2175, Vdd), V(cpphdl_n2828, Vdd), 0.01, 0.69999999999999996, -1.0);
        // device 1657, IC IC289, analog/basic/cmos_logic.hpp:20
        I(cpphdl_n2828, cpphdl_n2170) <+ cpphdl_channel(V(cpphdl_n2167, cpphdl_n2170), V(cpphdl_n2828, cpphdl_n2170), 0.01, 0.69999999999999996, 1.0);
        // device 1658, IC IC289, analog/basic/cmos_logic.hpp:21
        I(cpphdl_n2170, Vss) <+ cpphdl_channel(V(cpphdl_n2175, Vss), V(cpphdl_n2170, Vss), 0.01, 0.69999999999999996, 1.0);
        // device 1659, IC IC289, analog/basic/cmos_logic.hpp:27
        I(cpphdl_n2170, Vss) <+ 1e-14 * ddt(V(cpphdl_n2170, Vss)); // Bench initial voltage = 0.0 V.
        // device 1660, IC IC290, analog/basic/cmos_logic.hpp:17
        I(cpphdl_n2175, Vss) <+ 5.0000000000000002e-14 * ddt(V(cpphdl_n2175, Vss)); // Bench initial voltage = 0.0 V.
        // device 1661, IC IC290, analog/basic/cmos_logic.hpp:18
        I(cpphdl_n2175, Vdd) <+ cpphdl_channel(V(cpphdl_n2173, Vdd), V(cpphdl_n2175, Vdd), 0.01, 0.69999999999999996, -1.0);
        // device 1662, IC IC290, analog/basic/cmos_logic.hpp:19
        I(cpphdl_n2175, Vdd) <+ cpphdl_channel(V(cpphdl_n2828, Vdd), V(cpphdl_n2175, Vdd), 0.01, 0.69999999999999996, -1.0);
        // device 1663, IC IC290, analog/basic/cmos_logic.hpp:20
        I(cpphdl_n2175, cpphdl_n2176) <+ cpphdl_channel(V(cpphdl_n2173, cpphdl_n2176), V(cpphdl_n2175, cpphdl_n2176), 0.01, 0.69999999999999996, 1.0);
        // device 1664, IC IC290, analog/basic/cmos_logic.hpp:21
        I(cpphdl_n2176, Vss) <+ cpphdl_channel(V(cpphdl_n2828, Vss), V(cpphdl_n2176, Vss), 0.01, 0.69999999999999996, 1.0);
        // device 1665, IC IC290, analog/basic/cmos_logic.hpp:27
        I(cpphdl_n2176, Vss) <+ 1e-14 * ddt(V(cpphdl_n2176, Vss)); // Bench initial voltage = 0.0 V.
        // device 1666, IC IC288, analog/basic/nand_latch.hpp:36
        I(cpphdl_n2167, Vss) <+ 2.9999999999999998e-15 * ddt(V(cpphdl_n2167, Vss)); // Bench initial voltage = 0.0 V.
        // device 1667, IC IC288, analog/basic/nand_latch.hpp:37
        I(cpphdl_n2173, Vss) <+ 2.9999999999999998e-15 * ddt(V(cpphdl_n2173, Vss)); // Bench initial voltage = 0.0 V.
        // device 1668, IC IC291, analog/basic/inverter.hpp:11
        I(cpphdl_n2181, Vdd) <+ cpphdl_channel(V(CLEAR, Vdd), V(cpphdl_n2181, Vdd), 0.01, 0.69999999999999996, -1.0);
        // device 1669, IC IC291, analog/basic/inverter.hpp:12
        I(cpphdl_n2181, Vss) <+ cpphdl_channel(V(CLEAR, Vss), V(cpphdl_n2181, Vss), 0.01, 0.69999999999999996, 1.0);
        // device 1670, IC IC288, analog/basic/nand_latch.hpp:58
        I(cpphdl_n2181, Vss) <+ 2.9999999999999998e-15 * ddt(V(cpphdl_n2181, Vss)); // Bench initial voltage = 0.0 V.
        // device 1671, IC IC288, analog/basic/nand_latch.hpp:59
        I(cpphdl_n2828, Vss) <+ cpphdl_channel(V(CLEAR, Vss), V(cpphdl_n2828, Vss), 0.050000000000000003, 0.69999999999999996, 1.0);
        // device 1672, IC IC288, analog/basic/nand_latch.hpp:60
        I(cpphdl_n2175, Vdd) <+ cpphdl_channel(V(cpphdl_n2181, Vdd), V(cpphdl_n2175, Vdd), 0.050000000000000003, 0.69999999999999996, -1.0);
        // device 1673, IC IC294, analog/basic/inverter.hpp:11
        I(cpphdl_n2205, Vdd) <+ cpphdl_channel(V(TRACK12, Vdd), V(cpphdl_n2205, Vdd), 0.0040000000000000001, 0.69999999999999996, -1.0);
        // device 1674, IC IC294, analog/basic/inverter.hpp:12
        I(cpphdl_n2205, Vss) <+ cpphdl_channel(V(TRACK12, Vss), V(cpphdl_n2205, Vss), 0.0040000000000000001, 0.69999999999999996, 1.0);
        // device 1675, IC IC293, analog/basic/mos_track_hold.hpp:31
        I(cpphdl_n2205, Vss) <+ 2e-14 * ddt(V(cpphdl_n2205, Vss)); // Bench initial voltage = 0.0 V.
        // device 1676, IC IC293, analog/basic/mos_track_hold.hpp:32
        I(cpphdl_n2628, cpphdl_n2259) <+ cpphdl_channel(V(TRACK12, cpphdl_n2259), V(cpphdl_n2628, cpphdl_n2259), 0.029999999999999999, 0.69999999999999996, 1.0);
        // device 1677, IC IC293, analog/basic/mos_track_hold.hpp:33
        I(cpphdl_n2259, cpphdl_n2628) <+ cpphdl_channel(V(cpphdl_n2205, cpphdl_n2628), V(cpphdl_n2259, cpphdl_n2628), 0.014999999999999999, 0.69999999999999996, -1.0);
        // device 1678, IC IC293, analog/basic/mos_track_hold.hpp:37
        I(cpphdl_n2259, cpphdl_n2259) <+ cpphdl_channel(V(cpphdl_n2205, cpphdl_n2259), V(cpphdl_n2259, cpphdl_n2259), 0.016, 0.69999999999999996, 1.0);
        // device 1679, IC IC293, analog/basic/mos_track_hold.hpp:38
        I(cpphdl_n2259, cpphdl_n2259) <+ cpphdl_channel(V(TRACK12, cpphdl_n2259), V(cpphdl_n2259, cpphdl_n2259), 0.0083999999999999995, 0.69999999999999996, -1.0);
        // device 1680, IC IC293, analog/basic/mos_track_hold.hpp:39
        I(cpphdl_n2259, Vss) <+ 1.5000000000000001e-12 * ddt(V(cpphdl_n2259, Vss)); // Bench initial voltage = 0.0 V.
        // device 1681, IC IC293, analog/basic/mos_track_hold.hpp:42
        I(TRACK12, cpphdl_n2259) <+ 2.0000000000000002e-15 * ddt(V(TRACK12, cpphdl_n2259)); // Bench initial voltage = -0.0 V.
        // device 1682, IC IC293, analog/basic/mos_track_hold.hpp:43
        I(cpphdl_n2205, cpphdl_n2259) <+ 2.0000000000000002e-15 * ddt(V(cpphdl_n2205, cpphdl_n2259)); // Bench initial voltage = 0.0 V.
        // device 1683, IC IC293, analog/basic/mos_track_hold.hpp:44
        I(cpphdl_n2628, cpphdl_n2259) <+ 1.0000000000000001e-15 * ddt(V(cpphdl_n2628, cpphdl_n2259)); // Bench initial voltage = 0.0 V.
        // device 1684, IC IC296, analog/basic/inverter.hpp:11
        I(cpphdl_n2220, Vdd) <+ cpphdl_channel(V(BIT_N12_0, Vdd), V(cpphdl_n2220, Vdd), 0.080000000000000002, 0.69999999999999996, -1.0);
        // device 1685, IC IC296, analog/basic/inverter.hpp:12
        I(cpphdl_n2220, Vss) <+ cpphdl_channel(V(BIT_N12_0, Vss), V(cpphdl_n2220, Vss), 0.080000000000000002, 0.69999999999999996, 1.0);
        // device 1686, IC IC295, analog/basic/mos_r2r_dac.hpp:27
        I(cpphdl_n2220, Vss) <+ 2.9999999999999998e-15 * ddt(V(cpphdl_n2220, Vss)); // Bench initial voltage = 0.0 V.
        // device 1687, IC IC295, analog/basic/mos_r2r_dac.hpp:28
        I(cpphdl_n2220, cpphdl_n2249) <+ V(cpphdl_n2220, cpphdl_n2249) / 2000.0;
        // device 1688, IC IC295, analog/basic/mos_r2r_dac.hpp:29
        I(cpphdl_n2249, Vss) <+ 2.9999999999999998e-15 * ddt(V(cpphdl_n2249, Vss)); // Bench initial voltage = 0.0 V.
        // device 1689, IC IC297, analog/basic/inverter.hpp:11
        I(cpphdl_n2224, Vdd) <+ cpphdl_channel(V(BIT_N12_1, Vdd), V(cpphdl_n2224, Vdd), 0.080000000000000002, 0.69999999999999996, -1.0);
        // device 1690, IC IC297, analog/basic/inverter.hpp:12
        I(cpphdl_n2224, Vss) <+ cpphdl_channel(V(BIT_N12_1, Vss), V(cpphdl_n2224, Vss), 0.080000000000000002, 0.69999999999999996, 1.0);
        // device 1691, IC IC295, analog/basic/mos_r2r_dac.hpp:27
        I(cpphdl_n2224, Vss) <+ 2.9999999999999998e-15 * ddt(V(cpphdl_n2224, Vss)); // Bench initial voltage = 0.0 V.
        // device 1692, IC IC295, analog/basic/mos_r2r_dac.hpp:28
        I(cpphdl_n2224, cpphdl_n2250) <+ V(cpphdl_n2224, cpphdl_n2250) / 2000.0;
        // device 1693, IC IC295, analog/basic/mos_r2r_dac.hpp:29
        I(cpphdl_n2250, Vss) <+ 2.9999999999999998e-15 * ddt(V(cpphdl_n2250, Vss)); // Bench initial voltage = 0.0 V.
        // device 1694, IC IC295, analog/basic/mos_r2r_dac.hpp:31
        I(cpphdl_n2249, cpphdl_n2250) <+ V(cpphdl_n2249, cpphdl_n2250) / 1000.0;
        // device 1695, IC IC298, analog/basic/inverter.hpp:11
        I(cpphdl_n2228, Vdd) <+ cpphdl_channel(V(BIT_N12_2, Vdd), V(cpphdl_n2228, Vdd), 0.080000000000000002, 0.69999999999999996, -1.0);
        // device 1696, IC IC298, analog/basic/inverter.hpp:12
        I(cpphdl_n2228, Vss) <+ cpphdl_channel(V(BIT_N12_2, Vss), V(cpphdl_n2228, Vss), 0.080000000000000002, 0.69999999999999996, 1.0);
        // device 1697, IC IC295, analog/basic/mos_r2r_dac.hpp:27
        I(cpphdl_n2228, Vss) <+ 2.9999999999999998e-15 * ddt(V(cpphdl_n2228, Vss)); // Bench initial voltage = 0.0 V.
        // device 1698, IC IC295, analog/basic/mos_r2r_dac.hpp:28
        I(cpphdl_n2228, cpphdl_n2251) <+ V(cpphdl_n2228, cpphdl_n2251) / 2000.0;
        // device 1699, IC IC295, analog/basic/mos_r2r_dac.hpp:29
        I(cpphdl_n2251, Vss) <+ 2.9999999999999998e-15 * ddt(V(cpphdl_n2251, Vss)); // Bench initial voltage = 0.0 V.
        // device 1700, IC IC295, analog/basic/mos_r2r_dac.hpp:31
        I(cpphdl_n2250, cpphdl_n2251) <+ V(cpphdl_n2250, cpphdl_n2251) / 1000.0;
        // device 1701, IC IC299, analog/basic/inverter.hpp:11
        I(cpphdl_n2232, Vdd) <+ cpphdl_channel(V(BIT_N12_3, Vdd), V(cpphdl_n2232, Vdd), 0.080000000000000002, 0.69999999999999996, -1.0);
        // device 1702, IC IC299, analog/basic/inverter.hpp:12
        I(cpphdl_n2232, Vss) <+ cpphdl_channel(V(BIT_N12_3, Vss), V(cpphdl_n2232, Vss), 0.080000000000000002, 0.69999999999999996, 1.0);
        // device 1703, IC IC295, analog/basic/mos_r2r_dac.hpp:27
        I(cpphdl_n2232, Vss) <+ 2.9999999999999998e-15 * ddt(V(cpphdl_n2232, Vss)); // Bench initial voltage = 0.0 V.
        // device 1704, IC IC295, analog/basic/mos_r2r_dac.hpp:28
        I(cpphdl_n2232, cpphdl_n2252) <+ V(cpphdl_n2232, cpphdl_n2252) / 2000.0;
        // device 1705, IC IC295, analog/basic/mos_r2r_dac.hpp:29
        I(cpphdl_n2252, Vss) <+ 2.9999999999999998e-15 * ddt(V(cpphdl_n2252, Vss)); // Bench initial voltage = 0.0 V.
        // device 1706, IC IC295, analog/basic/mos_r2r_dac.hpp:31
        I(cpphdl_n2251, cpphdl_n2252) <+ V(cpphdl_n2251, cpphdl_n2252) / 1000.0;
        // device 1707, IC IC300, analog/basic/inverter.hpp:11
        I(cpphdl_n2236, Vdd) <+ cpphdl_channel(V(BIT_N12_4, Vdd), V(cpphdl_n2236, Vdd), 0.080000000000000002, 0.69999999999999996, -1.0);
        // device 1708, IC IC300, analog/basic/inverter.hpp:12
        I(cpphdl_n2236, Vss) <+ cpphdl_channel(V(BIT_N12_4, Vss), V(cpphdl_n2236, Vss), 0.080000000000000002, 0.69999999999999996, 1.0);
        // device 1709, IC IC295, analog/basic/mos_r2r_dac.hpp:27
        I(cpphdl_n2236, Vss) <+ 2.9999999999999998e-15 * ddt(V(cpphdl_n2236, Vss)); // Bench initial voltage = 0.0 V.
        // device 1710, IC IC295, analog/basic/mos_r2r_dac.hpp:28
        I(cpphdl_n2236, cpphdl_n2253) <+ V(cpphdl_n2236, cpphdl_n2253) / 2000.0;
        // device 1711, IC IC295, analog/basic/mos_r2r_dac.hpp:29
        I(cpphdl_n2253, Vss) <+ 2.9999999999999998e-15 * ddt(V(cpphdl_n2253, Vss)); // Bench initial voltage = 0.0 V.
        // device 1712, IC IC295, analog/basic/mos_r2r_dac.hpp:31
        I(cpphdl_n2252, cpphdl_n2253) <+ V(cpphdl_n2252, cpphdl_n2253) / 1000.0;
        // device 1713, IC IC301, analog/basic/inverter.hpp:11
        I(cpphdl_n2240, Vdd) <+ cpphdl_channel(V(BIT_N12_5, Vdd), V(cpphdl_n2240, Vdd), 0.080000000000000002, 0.69999999999999996, -1.0);
        // device 1714, IC IC301, analog/basic/inverter.hpp:12
        I(cpphdl_n2240, Vss) <+ cpphdl_channel(V(BIT_N12_5, Vss), V(cpphdl_n2240, Vss), 0.080000000000000002, 0.69999999999999996, 1.0);
        // device 1715, IC IC295, analog/basic/mos_r2r_dac.hpp:27
        I(cpphdl_n2240, Vss) <+ 2.9999999999999998e-15 * ddt(V(cpphdl_n2240, Vss)); // Bench initial voltage = 0.0 V.
        // device 1716, IC IC295, analog/basic/mos_r2r_dac.hpp:28
        I(cpphdl_n2240, cpphdl_n2254) <+ V(cpphdl_n2240, cpphdl_n2254) / 2000.0;
        // device 1717, IC IC295, analog/basic/mos_r2r_dac.hpp:29
        I(cpphdl_n2254, Vss) <+ 2.9999999999999998e-15 * ddt(V(cpphdl_n2254, Vss)); // Bench initial voltage = 0.0 V.
        // device 1718, IC IC295, analog/basic/mos_r2r_dac.hpp:31
        I(cpphdl_n2253, cpphdl_n2254) <+ V(cpphdl_n2253, cpphdl_n2254) / 1000.0;
        // device 1719, IC IC302, analog/basic/inverter.hpp:11
        I(cpphdl_n2244, Vdd) <+ cpphdl_channel(V(BIT_N12_6, Vdd), V(cpphdl_n2244, Vdd), 0.080000000000000002, 0.69999999999999996, -1.0);
        // device 1720, IC IC302, analog/basic/inverter.hpp:12
        I(cpphdl_n2244, Vss) <+ cpphdl_channel(V(BIT_N12_6, Vss), V(cpphdl_n2244, Vss), 0.080000000000000002, 0.69999999999999996, 1.0);
        // device 1721, IC IC295, analog/basic/mos_r2r_dac.hpp:27
        I(cpphdl_n2244, Vss) <+ 2.9999999999999998e-15 * ddt(V(cpphdl_n2244, Vss)); // Bench initial voltage = 0.0 V.
        // device 1722, IC IC295, analog/basic/mos_r2r_dac.hpp:28
        I(cpphdl_n2244, cpphdl_n2255) <+ V(cpphdl_n2244, cpphdl_n2255) / 2000.0;
        // device 1723, IC IC295, analog/basic/mos_r2r_dac.hpp:29
        I(cpphdl_n2255, Vss) <+ 2.9999999999999998e-15 * ddt(V(cpphdl_n2255, Vss)); // Bench initial voltage = 0.0 V.
        // device 1724, IC IC295, analog/basic/mos_r2r_dac.hpp:31
        I(cpphdl_n2254, cpphdl_n2255) <+ V(cpphdl_n2254, cpphdl_n2255) / 1000.0;
        // device 1725, IC IC303, analog/basic/inverter.hpp:11
        I(cpphdl_n2248, Vdd) <+ cpphdl_channel(V(BIT_N12_7, Vdd), V(cpphdl_n2248, Vdd), 0.080000000000000002, 0.69999999999999996, -1.0);
        // device 1726, IC IC303, analog/basic/inverter.hpp:12
        I(cpphdl_n2248, Vss) <+ cpphdl_channel(V(BIT_N12_7, Vss), V(cpphdl_n2248, Vss), 0.080000000000000002, 0.69999999999999996, 1.0);
        // device 1727, IC IC295, analog/basic/mos_r2r_dac.hpp:27
        I(cpphdl_n2248, Vss) <+ 2.9999999999999998e-15 * ddt(V(cpphdl_n2248, Vss)); // Bench initial voltage = 0.0 V.
        // device 1728, IC IC295, analog/basic/mos_r2r_dac.hpp:28
        I(cpphdl_n2248, cpphdl_n2260) <+ V(cpphdl_n2248, cpphdl_n2260) / 2000.0;
        // device 1729, IC IC295, analog/basic/mos_r2r_dac.hpp:29
        I(cpphdl_n2260, Vss) <+ 2.9999999999999998e-15 * ddt(V(cpphdl_n2260, Vss)); // Bench initial voltage = 0.0 V.
        // device 1730, IC IC295, analog/basic/mos_r2r_dac.hpp:31
        I(cpphdl_n2255, cpphdl_n2260) <+ V(cpphdl_n2255, cpphdl_n2260) / 1000.0;
        // device 1731, IC IC295, analog/basic/mos_r2r_dac.hpp:33
        I(Vss, cpphdl_n2249) <+ V(Vss, cpphdl_n2249) / 2000.0;
        // device 1732, IC IC304, analog/basic/nmos_resistor_amplifier.hpp:23
        I(Vdd, cpphdl_n2269) <+ V(Vdd, cpphdl_n2269) / 1000.0;
        // device 1733, IC IC304, analog/basic/nmos_resistor_amplifier.hpp:24
        I(Vdd, cpphdl_n2268) <+ V(Vdd, cpphdl_n2268) / 1000.0;
        // device 1734, IC IC304, analog/basic/nmos_resistor_amplifier.hpp:25
        I(cpphdl_n2269, cpphdl_n2263) <+ cpphdl_channel(V(cpphdl_n2259, cpphdl_n2263), V(cpphdl_n2269, cpphdl_n2263), 0.0074999999999999997, 0.69999999999999996, 1.0);
        // device 1735, IC IC304, analog/basic/nmos_resistor_amplifier.hpp:26
        I(cpphdl_n2268, cpphdl_n2264) <+ cpphdl_channel(V(cpphdl_n2260, cpphdl_n2264), V(cpphdl_n2268, cpphdl_n2264), 0.0074999999999999997, 0.69999999999999996, 1.0);
        // device 1736, IC IC304, analog/basic/nmos_resistor_amplifier.hpp:27
        I(cpphdl_n2265, cpphdl_n2263) <+ V(cpphdl_n2265, cpphdl_n2263) / 100.0;
        // device 1737, IC IC304, analog/basic/nmos_resistor_amplifier.hpp:28
        I(cpphdl_n2265, cpphdl_n2264) <+ V(cpphdl_n2265, cpphdl_n2264) / 100.0;
        // device 1738, IC IC304, analog/basic/nmos_resistor_amplifier.hpp:29
        I(Vss, cpphdl_n2265) <+ V(Vss, cpphdl_n2265) / 300.0;
        // device 1739, IC IC304, analog/basic/nmos_resistor_amplifier.hpp:30
        I(cpphdl_n2269, Vdd) <+ 2.9999999999999998e-13 * ddt(V(cpphdl_n2269, Vdd)); // Bench initial voltage = 0.0 V.
        // device 1740, IC IC304, analog/basic/nmos_resistor_amplifier.hpp:31
        I(cpphdl_n2268, Vdd) <+ 2.9999999999999998e-13 * ddt(V(cpphdl_n2268, Vdd)); // Bench initial voltage = 0.0 V.
        // device 1741, IC IC304, analog/basic/nmos_resistor_amplifier.hpp:32
        I(cpphdl_n2265, Vss) <+ 4e-14 * ddt(V(cpphdl_n2265, Vss)); // Bench initial voltage = 0.0 V.
        // device 1742, IC IC304, analog/basic/nmos_resistor_amplifier.hpp:34
        I(cpphdl_n2259, cpphdl_n2263) <+ 2e-14 * ddt(V(cpphdl_n2259, cpphdl_n2263)); // Bench initial voltage = 0.0 V.
        // device 1743, IC IC304, analog/basic/nmos_resistor_amplifier.hpp:35
        I(cpphdl_n2260, cpphdl_n2264) <+ 2e-14 * ddt(V(cpphdl_n2260, cpphdl_n2264)); // Bench initial voltage = 0.0 V.
        // device 1744, IC IC304, analog/basic/nmos_resistor_amplifier.hpp:36
        I(cpphdl_n2259, cpphdl_n2269) <+ 2.9999999999999998e-15 * ddt(V(cpphdl_n2259, cpphdl_n2269)); // Bench initial voltage = 0.0 V.
        // device 1745, IC IC304, analog/basic/nmos_resistor_amplifier.hpp:37
        I(cpphdl_n2260, cpphdl_n2268) <+ 2.9999999999999998e-15 * ddt(V(cpphdl_n2260, cpphdl_n2268)); // Bench initial voltage = 0.0 V.
        // device 1746, IC IC305, analog/basic/strongarm_comparator.hpp:28
        I(cpphdl_n2273, cpphdl_n2275) <+ cpphdl_channel(V(cpphdl_n2268, cpphdl_n2275), V(cpphdl_n2273, cpphdl_n2275), 0.0080000000000000002, 0.69999999999999996, 1.0);
        // device 1747, IC IC305, analog/basic/strongarm_comparator.hpp:29
        I(cpphdl_n2274, cpphdl_n2275) <+ cpphdl_channel(V(cpphdl_n2269, cpphdl_n2275), V(cpphdl_n2274, cpphdl_n2275), 0.0080000000000000002, 0.69999999999999996, 1.0);
        // device 1748, IC IC305, analog/basic/strongarm_comparator.hpp:30
        I(cpphdl_n2275, Vss) <+ cpphdl_channel(V(EVALUATE, Vss), V(cpphdl_n2275, Vss), 0.0080000000000000002, 0.69999999999999996, 1.0);
        // device 1749, IC IC305, analog/basic/strongarm_comparator.hpp:33
        I(cpphdl_n2288, cpphdl_n2273) <+ cpphdl_channel(V(cpphdl_n2292, cpphdl_n2273), V(cpphdl_n2288, cpphdl_n2273), 0.0040000000000000001, 0.69999999999999996, 1.0);
        // device 1750, IC IC305, analog/basic/strongarm_comparator.hpp:34
        I(cpphdl_n2292, cpphdl_n2274) <+ cpphdl_channel(V(cpphdl_n2288, cpphdl_n2274), V(cpphdl_n2292, cpphdl_n2274), 0.0040000000000000001, 0.69999999999999996, 1.0);
        // device 1751, IC IC305, analog/basic/strongarm_comparator.hpp:35
        I(cpphdl_n2292, Vdd) <+ cpphdl_channel(V(cpphdl_n2288, Vdd), V(cpphdl_n2292, Vdd), 0.002, 0.69999999999999996, -1.0);
        // device 1752, IC IC305, analog/basic/strongarm_comparator.hpp:36
        I(cpphdl_n2288, Vdd) <+ cpphdl_channel(V(cpphdl_n2292, Vdd), V(cpphdl_n2288, Vdd), 0.002, 0.69999999999999996, -1.0);
        // device 1753, IC IC305, analog/basic/strongarm_comparator.hpp:38
        I(cpphdl_n2273, Vdd) <+ cpphdl_channel(V(EVALUATE, Vdd), V(cpphdl_n2273, Vdd), 0.002, 0.69999999999999996, -1.0);
        // device 1754, IC IC305, analog/basic/strongarm_comparator.hpp:39
        I(cpphdl_n2274, Vdd) <+ cpphdl_channel(V(EVALUATE, Vdd), V(cpphdl_n2274, Vdd), 0.002, 0.69999999999999996, -1.0);
        // device 1755, IC IC305, analog/basic/strongarm_comparator.hpp:40
        I(cpphdl_n2292, Vdd) <+ cpphdl_channel(V(EVALUATE, Vdd), V(cpphdl_n2292, Vdd), 0.002, 0.69999999999999996, -1.0);
        // device 1756, IC IC305, analog/basic/strongarm_comparator.hpp:41
        I(cpphdl_n2288, Vdd) <+ cpphdl_channel(V(EVALUATE, Vdd), V(cpphdl_n2288, Vdd), 0.002, 0.69999999999999996, -1.0);
        // device 1757, IC IC305, analog/basic/strongarm_comparator.hpp:42
        I(cpphdl_n2273, Vss) <+ 2.9999999999999998e-14 * ddt(V(cpphdl_n2273, Vss)); // Bench initial voltage = 0.0 V.
        // device 1758, IC IC305, analog/basic/strongarm_comparator.hpp:43
        I(cpphdl_n2274, Vss) <+ 2.9999999999999998e-14 * ddt(V(cpphdl_n2274, Vss)); // Bench initial voltage = 0.0 V.
        // device 1759, IC IC305, analog/basic/strongarm_comparator.hpp:44
        I(cpphdl_n2275, Vss) <+ 2.9999999999999998e-14 * ddt(V(cpphdl_n2275, Vss)); // Bench initial voltage = 0.0 V.
        // device 1760, IC IC305, analog/basic/strongarm_comparator.hpp:45
        I(cpphdl_n2292, Vss) <+ 5.0000000000000002e-14 * ddt(V(cpphdl_n2292, Vss)); // Bench initial voltage = 0.0 V.
        // device 1761, IC IC305, analog/basic/strongarm_comparator.hpp:46
        I(cpphdl_n2288, Vss) <+ 5.0000000000000002e-14 * ddt(V(cpphdl_n2288, Vss)); // Bench initial voltage = 0.0 V.
        // device 1762, IC IC305, analog/basic/strongarm_comparator.hpp:47
        I(cpphdl_n2268, cpphdl_n2275) <+ 2e-14 * ddt(V(cpphdl_n2268, cpphdl_n2275)); // Bench initial voltage = 0.0 V.
        // device 1763, IC IC305, analog/basic/strongarm_comparator.hpp:48
        I(cpphdl_n2269, cpphdl_n2275) <+ 2e-14 * ddt(V(cpphdl_n2269, cpphdl_n2275)); // Bench initial voltage = 0.0 V.
        // device 1764, IC IC305, analog/basic/strongarm_comparator.hpp:49
        I(cpphdl_n2268, cpphdl_n2273) <+ 2.9999999999999998e-15 * ddt(V(cpphdl_n2268, cpphdl_n2273)); // Bench initial voltage = 0.0 V.
        // device 1765, IC IC305, analog/basic/strongarm_comparator.hpp:50
        I(cpphdl_n2269, cpphdl_n2274) <+ 2.9999999999999998e-15 * ddt(V(cpphdl_n2269, cpphdl_n2274)); // Bench initial voltage = 0.0 V.
        // device 1766, IC IC307, analog/basic/inverter.hpp:11
        I(cpphdl_n2296, Vdd) <+ cpphdl_channel(V(cpphdl_n2288, Vdd), V(cpphdl_n2296, Vdd), 0.001, 0.69999999999999996, -1.0);
        // device 1767, IC IC307, analog/basic/inverter.hpp:12
        I(cpphdl_n2296, Vss) <+ cpphdl_channel(V(cpphdl_n2288, Vss), V(cpphdl_n2296, Vss), 0.001, 0.69999999999999996, 1.0);
        // device 1768, IC IC309, analog/basic/inverter.hpp:11
        I(cpphdl_n2310, Vdd) <+ cpphdl_channel(V(cpphdl_n2296, Vdd), V(cpphdl_n2310, Vdd), 0.0040000000000000001, 0.69999999999999996, -1.0);
        // device 1769, IC IC309, analog/basic/inverter.hpp:12
        I(cpphdl_n2310, Vss) <+ cpphdl_channel(V(cpphdl_n2296, Vss), V(cpphdl_n2310, Vss), 0.0040000000000000001, 0.69999999999999996, 1.0);
        // device 1770, IC IC306, analog/basic/buffered_nand_latch.hpp:34
        I(cpphdl_n2288, Vss) <+ 2.0000000000000002e-15 * ddt(V(cpphdl_n2288, Vss)); // Bench initial voltage = 0.0 V.
        // device 1771, IC IC306, analog/basic/buffered_nand_latch.hpp:35
        I(cpphdl_n2288, cpphdl_n2296) <+ 1.0000000000000001e-15 * ddt(V(cpphdl_n2288, cpphdl_n2296)); // Bench initial voltage = 0.0 V.
        // device 1772, IC IC306, analog/basic/buffered_nand_latch.hpp:36
        I(cpphdl_n2296, Vss) <+ 5e-15 * ddt(V(cpphdl_n2296, Vss)); // Bench initial voltage = 0.0 V.
        // device 1773, IC IC306, analog/basic/buffered_nand_latch.hpp:37
        I(cpphdl_n2296, Vss) <+ 8.0000000000000006e-15 * ddt(V(cpphdl_n2296, Vss)); // Bench initial voltage = 0.0 V.
        // device 1774, IC IC306, analog/basic/buffered_nand_latch.hpp:38
        I(cpphdl_n2310, Vss) <+ 1e-14 * ddt(V(cpphdl_n2310, Vss)); // Bench initial voltage = 0.0 V.
        // device 1775, IC IC308, analog/basic/inverter.hpp:11
        I(cpphdl_n2300, Vdd) <+ cpphdl_channel(V(cpphdl_n2292, Vdd), V(cpphdl_n2300, Vdd), 0.001, 0.69999999999999996, -1.0);
        // device 1776, IC IC308, analog/basic/inverter.hpp:12
        I(cpphdl_n2300, Vss) <+ cpphdl_channel(V(cpphdl_n2292, Vss), V(cpphdl_n2300, Vss), 0.001, 0.69999999999999996, 1.0);
        // device 1777, IC IC310, analog/basic/inverter.hpp:11
        I(cpphdl_n2316, Vdd) <+ cpphdl_channel(V(cpphdl_n2300, Vdd), V(cpphdl_n2316, Vdd), 0.0040000000000000001, 0.69999999999999996, -1.0);
        // device 1778, IC IC310, analog/basic/inverter.hpp:12
        I(cpphdl_n2316, Vss) <+ cpphdl_channel(V(cpphdl_n2300, Vss), V(cpphdl_n2316, Vss), 0.0040000000000000001, 0.69999999999999996, 1.0);
        // device 1779, IC IC306, analog/basic/buffered_nand_latch.hpp:34
        I(cpphdl_n2292, Vss) <+ 2.0000000000000002e-15 * ddt(V(cpphdl_n2292, Vss)); // Bench initial voltage = 0.0 V.
        // device 1780, IC IC306, analog/basic/buffered_nand_latch.hpp:35
        I(cpphdl_n2292, cpphdl_n2300) <+ 1.0000000000000001e-15 * ddt(V(cpphdl_n2292, cpphdl_n2300)); // Bench initial voltage = 0.0 V.
        // device 1781, IC IC306, analog/basic/buffered_nand_latch.hpp:36
        I(cpphdl_n2300, Vss) <+ 5e-15 * ddt(V(cpphdl_n2300, Vss)); // Bench initial voltage = 0.0 V.
        // device 1782, IC IC306, analog/basic/buffered_nand_latch.hpp:37
        I(cpphdl_n2300, Vss) <+ 8.0000000000000006e-15 * ddt(V(cpphdl_n2300, Vss)); // Bench initial voltage = 0.0 V.
        // device 1783, IC IC306, analog/basic/buffered_nand_latch.hpp:38
        I(cpphdl_n2316, Vss) <+ 1e-14 * ddt(V(cpphdl_n2316, Vss)); // Bench initial voltage = 0.0 V.
        // device 1784, IC IC312, analog/basic/cmos_logic.hpp:17
        I(cpphdl_n2833, Vss) <+ 5.0000000000000002e-14 * ddt(V(cpphdl_n2833, Vss)); // Bench initial voltage = 0.0 V.
        // device 1785, IC IC312, analog/basic/cmos_logic.hpp:18
        I(cpphdl_n2833, Vdd) <+ cpphdl_channel(V(cpphdl_n2310, Vdd), V(cpphdl_n2833, Vdd), 0.01, 0.69999999999999996, -1.0);
        // device 1786, IC IC312, analog/basic/cmos_logic.hpp:19
        I(cpphdl_n2833, Vdd) <+ cpphdl_channel(V(cpphdl_n2318, Vdd), V(cpphdl_n2833, Vdd), 0.01, 0.69999999999999996, -1.0);
        // device 1787, IC IC312, analog/basic/cmos_logic.hpp:20
        I(cpphdl_n2833, cpphdl_n2313) <+ cpphdl_channel(V(cpphdl_n2310, cpphdl_n2313), V(cpphdl_n2833, cpphdl_n2313), 0.01, 0.69999999999999996, 1.0);
        // device 1788, IC IC312, analog/basic/cmos_logic.hpp:21
        I(cpphdl_n2313, Vss) <+ cpphdl_channel(V(cpphdl_n2318, Vss), V(cpphdl_n2313, Vss), 0.01, 0.69999999999999996, 1.0);
        // device 1789, IC IC312, analog/basic/cmos_logic.hpp:27
        I(cpphdl_n2313, Vss) <+ 1e-14 * ddt(V(cpphdl_n2313, Vss)); // Bench initial voltage = 0.0 V.
        // device 1790, IC IC313, analog/basic/cmos_logic.hpp:17
        I(cpphdl_n2318, Vss) <+ 5.0000000000000002e-14 * ddt(V(cpphdl_n2318, Vss)); // Bench initial voltage = 0.0 V.
        // device 1791, IC IC313, analog/basic/cmos_logic.hpp:18
        I(cpphdl_n2318, Vdd) <+ cpphdl_channel(V(cpphdl_n2316, Vdd), V(cpphdl_n2318, Vdd), 0.01, 0.69999999999999996, -1.0);
        // device 1792, IC IC313, analog/basic/cmos_logic.hpp:19
        I(cpphdl_n2318, Vdd) <+ cpphdl_channel(V(cpphdl_n2833, Vdd), V(cpphdl_n2318, Vdd), 0.01, 0.69999999999999996, -1.0);
        // device 1793, IC IC313, analog/basic/cmos_logic.hpp:20
        I(cpphdl_n2318, cpphdl_n2319) <+ cpphdl_channel(V(cpphdl_n2316, cpphdl_n2319), V(cpphdl_n2318, cpphdl_n2319), 0.01, 0.69999999999999996, 1.0);
        // device 1794, IC IC313, analog/basic/cmos_logic.hpp:21
        I(cpphdl_n2319, Vss) <+ cpphdl_channel(V(cpphdl_n2833, Vss), V(cpphdl_n2319, Vss), 0.01, 0.69999999999999996, 1.0);
        // device 1795, IC IC313, analog/basic/cmos_logic.hpp:27
        I(cpphdl_n2319, Vss) <+ 1e-14 * ddt(V(cpphdl_n2319, Vss)); // Bench initial voltage = 0.0 V.
        // device 1796, IC IC311, analog/basic/nand_latch.hpp:36
        I(cpphdl_n2310, Vss) <+ 2.9999999999999998e-15 * ddt(V(cpphdl_n2310, Vss)); // Bench initial voltage = 0.0 V.
        // device 1797, IC IC311, analog/basic/nand_latch.hpp:37
        I(cpphdl_n2316, Vss) <+ 2.9999999999999998e-15 * ddt(V(cpphdl_n2316, Vss)); // Bench initial voltage = 0.0 V.
        // device 1798, IC IC314, analog/basic/inverter.hpp:11
        I(cpphdl_n2324, Vdd) <+ cpphdl_channel(V(CLEAR, Vdd), V(cpphdl_n2324, Vdd), 0.01, 0.69999999999999996, -1.0);
        // device 1799, IC IC314, analog/basic/inverter.hpp:12
        I(cpphdl_n2324, Vss) <+ cpphdl_channel(V(CLEAR, Vss), V(cpphdl_n2324, Vss), 0.01, 0.69999999999999996, 1.0);
        // device 1800, IC IC311, analog/basic/nand_latch.hpp:58
        I(cpphdl_n2324, Vss) <+ 2.9999999999999998e-15 * ddt(V(cpphdl_n2324, Vss)); // Bench initial voltage = 0.0 V.
        // device 1801, IC IC311, analog/basic/nand_latch.hpp:59
        I(cpphdl_n2833, Vss) <+ cpphdl_channel(V(CLEAR, Vss), V(cpphdl_n2833, Vss), 0.050000000000000003, 0.69999999999999996, 1.0);
        // device 1802, IC IC311, analog/basic/nand_latch.hpp:60
        I(cpphdl_n2318, Vdd) <+ cpphdl_channel(V(cpphdl_n2324, Vdd), V(cpphdl_n2318, Vdd), 0.050000000000000003, 0.69999999999999996, -1.0);
        // device 1803, IC IC317, analog/basic/inverter.hpp:11
        I(cpphdl_n2348, Vdd) <+ cpphdl_channel(V(TRACK13, Vdd), V(cpphdl_n2348, Vdd), 0.0040000000000000001, 0.69999999999999996, -1.0);
        // device 1804, IC IC317, analog/basic/inverter.hpp:12
        I(cpphdl_n2348, Vss) <+ cpphdl_channel(V(TRACK13, Vss), V(cpphdl_n2348, Vss), 0.0040000000000000001, 0.69999999999999996, 1.0);
        // device 1805, IC IC316, analog/basic/mos_track_hold.hpp:31
        I(cpphdl_n2348, Vss) <+ 2e-14 * ddt(V(cpphdl_n2348, Vss)); // Bench initial voltage = 0.0 V.
        // device 1806, IC IC316, analog/basic/mos_track_hold.hpp:32
        I(cpphdl_n2628, cpphdl_n2402) <+ cpphdl_channel(V(TRACK13, cpphdl_n2402), V(cpphdl_n2628, cpphdl_n2402), 0.029999999999999999, 0.69999999999999996, 1.0);
        // device 1807, IC IC316, analog/basic/mos_track_hold.hpp:33
        I(cpphdl_n2402, cpphdl_n2628) <+ cpphdl_channel(V(cpphdl_n2348, cpphdl_n2628), V(cpphdl_n2402, cpphdl_n2628), 0.014999999999999999, 0.69999999999999996, -1.0);
        // device 1808, IC IC316, analog/basic/mos_track_hold.hpp:37
        I(cpphdl_n2402, cpphdl_n2402) <+ cpphdl_channel(V(cpphdl_n2348, cpphdl_n2402), V(cpphdl_n2402, cpphdl_n2402), 0.016, 0.69999999999999996, 1.0);
        // device 1809, IC IC316, analog/basic/mos_track_hold.hpp:38
        I(cpphdl_n2402, cpphdl_n2402) <+ cpphdl_channel(V(TRACK13, cpphdl_n2402), V(cpphdl_n2402, cpphdl_n2402), 0.0083999999999999995, 0.69999999999999996, -1.0);
        // device 1810, IC IC316, analog/basic/mos_track_hold.hpp:39
        I(cpphdl_n2402, Vss) <+ 1.5000000000000001e-12 * ddt(V(cpphdl_n2402, Vss)); // Bench initial voltage = 0.0 V.
        // device 1811, IC IC316, analog/basic/mos_track_hold.hpp:42
        I(TRACK13, cpphdl_n2402) <+ 2.0000000000000002e-15 * ddt(V(TRACK13, cpphdl_n2402)); // Bench initial voltage = -0.0 V.
        // device 1812, IC IC316, analog/basic/mos_track_hold.hpp:43
        I(cpphdl_n2348, cpphdl_n2402) <+ 2.0000000000000002e-15 * ddt(V(cpphdl_n2348, cpphdl_n2402)); // Bench initial voltage = 0.0 V.
        // device 1813, IC IC316, analog/basic/mos_track_hold.hpp:44
        I(cpphdl_n2628, cpphdl_n2402) <+ 1.0000000000000001e-15 * ddt(V(cpphdl_n2628, cpphdl_n2402)); // Bench initial voltage = 0.0 V.
        // device 1814, IC IC319, analog/basic/inverter.hpp:11
        I(cpphdl_n2363, Vdd) <+ cpphdl_channel(V(BIT_N13_0, Vdd), V(cpphdl_n2363, Vdd), 0.080000000000000002, 0.69999999999999996, -1.0);
        // device 1815, IC IC319, analog/basic/inverter.hpp:12
        I(cpphdl_n2363, Vss) <+ cpphdl_channel(V(BIT_N13_0, Vss), V(cpphdl_n2363, Vss), 0.080000000000000002, 0.69999999999999996, 1.0);
        // device 1816, IC IC318, analog/basic/mos_r2r_dac.hpp:27
        I(cpphdl_n2363, Vss) <+ 2.9999999999999998e-15 * ddt(V(cpphdl_n2363, Vss)); // Bench initial voltage = 0.0 V.
        // device 1817, IC IC318, analog/basic/mos_r2r_dac.hpp:28
        I(cpphdl_n2363, cpphdl_n2392) <+ V(cpphdl_n2363, cpphdl_n2392) / 2000.0;
        // device 1818, IC IC318, analog/basic/mos_r2r_dac.hpp:29
        I(cpphdl_n2392, Vss) <+ 2.9999999999999998e-15 * ddt(V(cpphdl_n2392, Vss)); // Bench initial voltage = 0.0 V.
        // device 1819, IC IC320, analog/basic/inverter.hpp:11
        I(cpphdl_n2367, Vdd) <+ cpphdl_channel(V(BIT_N13_1, Vdd), V(cpphdl_n2367, Vdd), 0.080000000000000002, 0.69999999999999996, -1.0);
        // device 1820, IC IC320, analog/basic/inverter.hpp:12
        I(cpphdl_n2367, Vss) <+ cpphdl_channel(V(BIT_N13_1, Vss), V(cpphdl_n2367, Vss), 0.080000000000000002, 0.69999999999999996, 1.0);
        // device 1821, IC IC318, analog/basic/mos_r2r_dac.hpp:27
        I(cpphdl_n2367, Vss) <+ 2.9999999999999998e-15 * ddt(V(cpphdl_n2367, Vss)); // Bench initial voltage = 0.0 V.
        // device 1822, IC IC318, analog/basic/mos_r2r_dac.hpp:28
        I(cpphdl_n2367, cpphdl_n2393) <+ V(cpphdl_n2367, cpphdl_n2393) / 2000.0;
        // device 1823, IC IC318, analog/basic/mos_r2r_dac.hpp:29
        I(cpphdl_n2393, Vss) <+ 2.9999999999999998e-15 * ddt(V(cpphdl_n2393, Vss)); // Bench initial voltage = 0.0 V.
        // device 1824, IC IC318, analog/basic/mos_r2r_dac.hpp:31
        I(cpphdl_n2392, cpphdl_n2393) <+ V(cpphdl_n2392, cpphdl_n2393) / 1000.0;
        // device 1825, IC IC321, analog/basic/inverter.hpp:11
        I(cpphdl_n2371, Vdd) <+ cpphdl_channel(V(BIT_N13_2, Vdd), V(cpphdl_n2371, Vdd), 0.080000000000000002, 0.69999999999999996, -1.0);
        // device 1826, IC IC321, analog/basic/inverter.hpp:12
        I(cpphdl_n2371, Vss) <+ cpphdl_channel(V(BIT_N13_2, Vss), V(cpphdl_n2371, Vss), 0.080000000000000002, 0.69999999999999996, 1.0);
        // device 1827, IC IC318, analog/basic/mos_r2r_dac.hpp:27
        I(cpphdl_n2371, Vss) <+ 2.9999999999999998e-15 * ddt(V(cpphdl_n2371, Vss)); // Bench initial voltage = 0.0 V.
        // device 1828, IC IC318, analog/basic/mos_r2r_dac.hpp:28
        I(cpphdl_n2371, cpphdl_n2394) <+ V(cpphdl_n2371, cpphdl_n2394) / 2000.0;
        // device 1829, IC IC318, analog/basic/mos_r2r_dac.hpp:29
        I(cpphdl_n2394, Vss) <+ 2.9999999999999998e-15 * ddt(V(cpphdl_n2394, Vss)); // Bench initial voltage = 0.0 V.
        // device 1830, IC IC318, analog/basic/mos_r2r_dac.hpp:31
        I(cpphdl_n2393, cpphdl_n2394) <+ V(cpphdl_n2393, cpphdl_n2394) / 1000.0;
        // device 1831, IC IC322, analog/basic/inverter.hpp:11
        I(cpphdl_n2375, Vdd) <+ cpphdl_channel(V(BIT_N13_3, Vdd), V(cpphdl_n2375, Vdd), 0.080000000000000002, 0.69999999999999996, -1.0);
        // device 1832, IC IC322, analog/basic/inverter.hpp:12
        I(cpphdl_n2375, Vss) <+ cpphdl_channel(V(BIT_N13_3, Vss), V(cpphdl_n2375, Vss), 0.080000000000000002, 0.69999999999999996, 1.0);
        // device 1833, IC IC318, analog/basic/mos_r2r_dac.hpp:27
        I(cpphdl_n2375, Vss) <+ 2.9999999999999998e-15 * ddt(V(cpphdl_n2375, Vss)); // Bench initial voltage = 0.0 V.
        // device 1834, IC IC318, analog/basic/mos_r2r_dac.hpp:28
        I(cpphdl_n2375, cpphdl_n2395) <+ V(cpphdl_n2375, cpphdl_n2395) / 2000.0;
        // device 1835, IC IC318, analog/basic/mos_r2r_dac.hpp:29
        I(cpphdl_n2395, Vss) <+ 2.9999999999999998e-15 * ddt(V(cpphdl_n2395, Vss)); // Bench initial voltage = 0.0 V.
        // device 1836, IC IC318, analog/basic/mos_r2r_dac.hpp:31
        I(cpphdl_n2394, cpphdl_n2395) <+ V(cpphdl_n2394, cpphdl_n2395) / 1000.0;
        // device 1837, IC IC323, analog/basic/inverter.hpp:11
        I(cpphdl_n2379, Vdd) <+ cpphdl_channel(V(BIT_N13_4, Vdd), V(cpphdl_n2379, Vdd), 0.080000000000000002, 0.69999999999999996, -1.0);
        // device 1838, IC IC323, analog/basic/inverter.hpp:12
        I(cpphdl_n2379, Vss) <+ cpphdl_channel(V(BIT_N13_4, Vss), V(cpphdl_n2379, Vss), 0.080000000000000002, 0.69999999999999996, 1.0);
        // device 1839, IC IC318, analog/basic/mos_r2r_dac.hpp:27
        I(cpphdl_n2379, Vss) <+ 2.9999999999999998e-15 * ddt(V(cpphdl_n2379, Vss)); // Bench initial voltage = 0.0 V.
        // device 1840, IC IC318, analog/basic/mos_r2r_dac.hpp:28
        I(cpphdl_n2379, cpphdl_n2396) <+ V(cpphdl_n2379, cpphdl_n2396) / 2000.0;
        // device 1841, IC IC318, analog/basic/mos_r2r_dac.hpp:29
        I(cpphdl_n2396, Vss) <+ 2.9999999999999998e-15 * ddt(V(cpphdl_n2396, Vss)); // Bench initial voltage = 0.0 V.
        // device 1842, IC IC318, analog/basic/mos_r2r_dac.hpp:31
        I(cpphdl_n2395, cpphdl_n2396) <+ V(cpphdl_n2395, cpphdl_n2396) / 1000.0;
        // device 1843, IC IC324, analog/basic/inverter.hpp:11
        I(cpphdl_n2383, Vdd) <+ cpphdl_channel(V(BIT_N13_5, Vdd), V(cpphdl_n2383, Vdd), 0.080000000000000002, 0.69999999999999996, -1.0);
        // device 1844, IC IC324, analog/basic/inverter.hpp:12
        I(cpphdl_n2383, Vss) <+ cpphdl_channel(V(BIT_N13_5, Vss), V(cpphdl_n2383, Vss), 0.080000000000000002, 0.69999999999999996, 1.0);
        // device 1845, IC IC318, analog/basic/mos_r2r_dac.hpp:27
        I(cpphdl_n2383, Vss) <+ 2.9999999999999998e-15 * ddt(V(cpphdl_n2383, Vss)); // Bench initial voltage = 0.0 V.
        // device 1846, IC IC318, analog/basic/mos_r2r_dac.hpp:28
        I(cpphdl_n2383, cpphdl_n2397) <+ V(cpphdl_n2383, cpphdl_n2397) / 2000.0;
        // device 1847, IC IC318, analog/basic/mos_r2r_dac.hpp:29
        I(cpphdl_n2397, Vss) <+ 2.9999999999999998e-15 * ddt(V(cpphdl_n2397, Vss)); // Bench initial voltage = 0.0 V.
        // device 1848, IC IC318, analog/basic/mos_r2r_dac.hpp:31
        I(cpphdl_n2396, cpphdl_n2397) <+ V(cpphdl_n2396, cpphdl_n2397) / 1000.0;
        // device 1849, IC IC325, analog/basic/inverter.hpp:11
        I(cpphdl_n2387, Vdd) <+ cpphdl_channel(V(BIT_N13_6, Vdd), V(cpphdl_n2387, Vdd), 0.080000000000000002, 0.69999999999999996, -1.0);
        // device 1850, IC IC325, analog/basic/inverter.hpp:12
        I(cpphdl_n2387, Vss) <+ cpphdl_channel(V(BIT_N13_6, Vss), V(cpphdl_n2387, Vss), 0.080000000000000002, 0.69999999999999996, 1.0);
        // device 1851, IC IC318, analog/basic/mos_r2r_dac.hpp:27
        I(cpphdl_n2387, Vss) <+ 2.9999999999999998e-15 * ddt(V(cpphdl_n2387, Vss)); // Bench initial voltage = 0.0 V.
        // device 1852, IC IC318, analog/basic/mos_r2r_dac.hpp:28
        I(cpphdl_n2387, cpphdl_n2398) <+ V(cpphdl_n2387, cpphdl_n2398) / 2000.0;
        // device 1853, IC IC318, analog/basic/mos_r2r_dac.hpp:29
        I(cpphdl_n2398, Vss) <+ 2.9999999999999998e-15 * ddt(V(cpphdl_n2398, Vss)); // Bench initial voltage = 0.0 V.
        // device 1854, IC IC318, analog/basic/mos_r2r_dac.hpp:31
        I(cpphdl_n2397, cpphdl_n2398) <+ V(cpphdl_n2397, cpphdl_n2398) / 1000.0;
        // device 1855, IC IC326, analog/basic/inverter.hpp:11
        I(cpphdl_n2391, Vdd) <+ cpphdl_channel(V(BIT_N13_7, Vdd), V(cpphdl_n2391, Vdd), 0.080000000000000002, 0.69999999999999996, -1.0);
        // device 1856, IC IC326, analog/basic/inverter.hpp:12
        I(cpphdl_n2391, Vss) <+ cpphdl_channel(V(BIT_N13_7, Vss), V(cpphdl_n2391, Vss), 0.080000000000000002, 0.69999999999999996, 1.0);
        // device 1857, IC IC318, analog/basic/mos_r2r_dac.hpp:27
        I(cpphdl_n2391, Vss) <+ 2.9999999999999998e-15 * ddt(V(cpphdl_n2391, Vss)); // Bench initial voltage = 0.0 V.
        // device 1858, IC IC318, analog/basic/mos_r2r_dac.hpp:28
        I(cpphdl_n2391, cpphdl_n2403) <+ V(cpphdl_n2391, cpphdl_n2403) / 2000.0;
        // device 1859, IC IC318, analog/basic/mos_r2r_dac.hpp:29
        I(cpphdl_n2403, Vss) <+ 2.9999999999999998e-15 * ddt(V(cpphdl_n2403, Vss)); // Bench initial voltage = 0.0 V.
        // device 1860, IC IC318, analog/basic/mos_r2r_dac.hpp:31
        I(cpphdl_n2398, cpphdl_n2403) <+ V(cpphdl_n2398, cpphdl_n2403) / 1000.0;
        // device 1861, IC IC318, analog/basic/mos_r2r_dac.hpp:33
        I(Vss, cpphdl_n2392) <+ V(Vss, cpphdl_n2392) / 2000.0;
        // device 1862, IC IC327, analog/basic/nmos_resistor_amplifier.hpp:23
        I(Vdd, cpphdl_n2412) <+ V(Vdd, cpphdl_n2412) / 1000.0;
        // device 1863, IC IC327, analog/basic/nmos_resistor_amplifier.hpp:24
        I(Vdd, cpphdl_n2411) <+ V(Vdd, cpphdl_n2411) / 1000.0;
        // device 1864, IC IC327, analog/basic/nmos_resistor_amplifier.hpp:25
        I(cpphdl_n2412, cpphdl_n2406) <+ cpphdl_channel(V(cpphdl_n2402, cpphdl_n2406), V(cpphdl_n2412, cpphdl_n2406), 0.0074999999999999997, 0.69999999999999996, 1.0);
        // device 1865, IC IC327, analog/basic/nmos_resistor_amplifier.hpp:26
        I(cpphdl_n2411, cpphdl_n2407) <+ cpphdl_channel(V(cpphdl_n2403, cpphdl_n2407), V(cpphdl_n2411, cpphdl_n2407), 0.0074999999999999997, 0.69999999999999996, 1.0);
        // device 1866, IC IC327, analog/basic/nmos_resistor_amplifier.hpp:27
        I(cpphdl_n2408, cpphdl_n2406) <+ V(cpphdl_n2408, cpphdl_n2406) / 100.0;
        // device 1867, IC IC327, analog/basic/nmos_resistor_amplifier.hpp:28
        I(cpphdl_n2408, cpphdl_n2407) <+ V(cpphdl_n2408, cpphdl_n2407) / 100.0;
        // device 1868, IC IC327, analog/basic/nmos_resistor_amplifier.hpp:29
        I(Vss, cpphdl_n2408) <+ V(Vss, cpphdl_n2408) / 300.0;
        // device 1869, IC IC327, analog/basic/nmos_resistor_amplifier.hpp:30
        I(cpphdl_n2412, Vdd) <+ 2.9999999999999998e-13 * ddt(V(cpphdl_n2412, Vdd)); // Bench initial voltage = 0.0 V.
        // device 1870, IC IC327, analog/basic/nmos_resistor_amplifier.hpp:31
        I(cpphdl_n2411, Vdd) <+ 2.9999999999999998e-13 * ddt(V(cpphdl_n2411, Vdd)); // Bench initial voltage = 0.0 V.
        // device 1871, IC IC327, analog/basic/nmos_resistor_amplifier.hpp:32
        I(cpphdl_n2408, Vss) <+ 4e-14 * ddt(V(cpphdl_n2408, Vss)); // Bench initial voltage = 0.0 V.
        // device 1872, IC IC327, analog/basic/nmos_resistor_amplifier.hpp:34
        I(cpphdl_n2402, cpphdl_n2406) <+ 2e-14 * ddt(V(cpphdl_n2402, cpphdl_n2406)); // Bench initial voltage = 0.0 V.
        // device 1873, IC IC327, analog/basic/nmos_resistor_amplifier.hpp:35
        I(cpphdl_n2403, cpphdl_n2407) <+ 2e-14 * ddt(V(cpphdl_n2403, cpphdl_n2407)); // Bench initial voltage = 0.0 V.
        // device 1874, IC IC327, analog/basic/nmos_resistor_amplifier.hpp:36
        I(cpphdl_n2402, cpphdl_n2412) <+ 2.9999999999999998e-15 * ddt(V(cpphdl_n2402, cpphdl_n2412)); // Bench initial voltage = 0.0 V.
        // device 1875, IC IC327, analog/basic/nmos_resistor_amplifier.hpp:37
        I(cpphdl_n2403, cpphdl_n2411) <+ 2.9999999999999998e-15 * ddt(V(cpphdl_n2403, cpphdl_n2411)); // Bench initial voltage = 0.0 V.
        // device 1876, IC IC328, analog/basic/strongarm_comparator.hpp:28
        I(cpphdl_n2416, cpphdl_n2418) <+ cpphdl_channel(V(cpphdl_n2411, cpphdl_n2418), V(cpphdl_n2416, cpphdl_n2418), 0.0080000000000000002, 0.69999999999999996, 1.0);
        // device 1877, IC IC328, analog/basic/strongarm_comparator.hpp:29
        I(cpphdl_n2417, cpphdl_n2418) <+ cpphdl_channel(V(cpphdl_n2412, cpphdl_n2418), V(cpphdl_n2417, cpphdl_n2418), 0.0080000000000000002, 0.69999999999999996, 1.0);
        // device 1878, IC IC328, analog/basic/strongarm_comparator.hpp:30
        I(cpphdl_n2418, Vss) <+ cpphdl_channel(V(EVALUATE, Vss), V(cpphdl_n2418, Vss), 0.0080000000000000002, 0.69999999999999996, 1.0);
        // device 1879, IC IC328, analog/basic/strongarm_comparator.hpp:33
        I(cpphdl_n2431, cpphdl_n2416) <+ cpphdl_channel(V(cpphdl_n2435, cpphdl_n2416), V(cpphdl_n2431, cpphdl_n2416), 0.0040000000000000001, 0.69999999999999996, 1.0);
        // device 1880, IC IC328, analog/basic/strongarm_comparator.hpp:34
        I(cpphdl_n2435, cpphdl_n2417) <+ cpphdl_channel(V(cpphdl_n2431, cpphdl_n2417), V(cpphdl_n2435, cpphdl_n2417), 0.0040000000000000001, 0.69999999999999996, 1.0);
        // device 1881, IC IC328, analog/basic/strongarm_comparator.hpp:35
        I(cpphdl_n2435, Vdd) <+ cpphdl_channel(V(cpphdl_n2431, Vdd), V(cpphdl_n2435, Vdd), 0.002, 0.69999999999999996, -1.0);
        // device 1882, IC IC328, analog/basic/strongarm_comparator.hpp:36
        I(cpphdl_n2431, Vdd) <+ cpphdl_channel(V(cpphdl_n2435, Vdd), V(cpphdl_n2431, Vdd), 0.002, 0.69999999999999996, -1.0);
        // device 1883, IC IC328, analog/basic/strongarm_comparator.hpp:38
        I(cpphdl_n2416, Vdd) <+ cpphdl_channel(V(EVALUATE, Vdd), V(cpphdl_n2416, Vdd), 0.002, 0.69999999999999996, -1.0);
        // device 1884, IC IC328, analog/basic/strongarm_comparator.hpp:39
        I(cpphdl_n2417, Vdd) <+ cpphdl_channel(V(EVALUATE, Vdd), V(cpphdl_n2417, Vdd), 0.002, 0.69999999999999996, -1.0);
        // device 1885, IC IC328, analog/basic/strongarm_comparator.hpp:40
        I(cpphdl_n2435, Vdd) <+ cpphdl_channel(V(EVALUATE, Vdd), V(cpphdl_n2435, Vdd), 0.002, 0.69999999999999996, -1.0);
        // device 1886, IC IC328, analog/basic/strongarm_comparator.hpp:41
        I(cpphdl_n2431, Vdd) <+ cpphdl_channel(V(EVALUATE, Vdd), V(cpphdl_n2431, Vdd), 0.002, 0.69999999999999996, -1.0);
        // device 1887, IC IC328, analog/basic/strongarm_comparator.hpp:42
        I(cpphdl_n2416, Vss) <+ 2.9999999999999998e-14 * ddt(V(cpphdl_n2416, Vss)); // Bench initial voltage = 0.0 V.
        // device 1888, IC IC328, analog/basic/strongarm_comparator.hpp:43
        I(cpphdl_n2417, Vss) <+ 2.9999999999999998e-14 * ddt(V(cpphdl_n2417, Vss)); // Bench initial voltage = 0.0 V.
        // device 1889, IC IC328, analog/basic/strongarm_comparator.hpp:44
        I(cpphdl_n2418, Vss) <+ 2.9999999999999998e-14 * ddt(V(cpphdl_n2418, Vss)); // Bench initial voltage = 0.0 V.
        // device 1890, IC IC328, analog/basic/strongarm_comparator.hpp:45
        I(cpphdl_n2435, Vss) <+ 5.0000000000000002e-14 * ddt(V(cpphdl_n2435, Vss)); // Bench initial voltage = 0.0 V.
        // device 1891, IC IC328, analog/basic/strongarm_comparator.hpp:46
        I(cpphdl_n2431, Vss) <+ 5.0000000000000002e-14 * ddt(V(cpphdl_n2431, Vss)); // Bench initial voltage = 0.0 V.
        // device 1892, IC IC328, analog/basic/strongarm_comparator.hpp:47
        I(cpphdl_n2411, cpphdl_n2418) <+ 2e-14 * ddt(V(cpphdl_n2411, cpphdl_n2418)); // Bench initial voltage = 0.0 V.
        // device 1893, IC IC328, analog/basic/strongarm_comparator.hpp:48
        I(cpphdl_n2412, cpphdl_n2418) <+ 2e-14 * ddt(V(cpphdl_n2412, cpphdl_n2418)); // Bench initial voltage = 0.0 V.
        // device 1894, IC IC328, analog/basic/strongarm_comparator.hpp:49
        I(cpphdl_n2411, cpphdl_n2416) <+ 2.9999999999999998e-15 * ddt(V(cpphdl_n2411, cpphdl_n2416)); // Bench initial voltage = 0.0 V.
        // device 1895, IC IC328, analog/basic/strongarm_comparator.hpp:50
        I(cpphdl_n2412, cpphdl_n2417) <+ 2.9999999999999998e-15 * ddt(V(cpphdl_n2412, cpphdl_n2417)); // Bench initial voltage = 0.0 V.
        // device 1896, IC IC330, analog/basic/inverter.hpp:11
        I(cpphdl_n2439, Vdd) <+ cpphdl_channel(V(cpphdl_n2431, Vdd), V(cpphdl_n2439, Vdd), 0.001, 0.69999999999999996, -1.0);
        // device 1897, IC IC330, analog/basic/inverter.hpp:12
        I(cpphdl_n2439, Vss) <+ cpphdl_channel(V(cpphdl_n2431, Vss), V(cpphdl_n2439, Vss), 0.001, 0.69999999999999996, 1.0);
        // device 1898, IC IC332, analog/basic/inverter.hpp:11
        I(cpphdl_n2453, Vdd) <+ cpphdl_channel(V(cpphdl_n2439, Vdd), V(cpphdl_n2453, Vdd), 0.0040000000000000001, 0.69999999999999996, -1.0);
        // device 1899, IC IC332, analog/basic/inverter.hpp:12
        I(cpphdl_n2453, Vss) <+ cpphdl_channel(V(cpphdl_n2439, Vss), V(cpphdl_n2453, Vss), 0.0040000000000000001, 0.69999999999999996, 1.0);
        // device 1900, IC IC329, analog/basic/buffered_nand_latch.hpp:34
        I(cpphdl_n2431, Vss) <+ 2.0000000000000002e-15 * ddt(V(cpphdl_n2431, Vss)); // Bench initial voltage = 0.0 V.
        // device 1901, IC IC329, analog/basic/buffered_nand_latch.hpp:35
        I(cpphdl_n2431, cpphdl_n2439) <+ 1.0000000000000001e-15 * ddt(V(cpphdl_n2431, cpphdl_n2439)); // Bench initial voltage = 0.0 V.
        // device 1902, IC IC329, analog/basic/buffered_nand_latch.hpp:36
        I(cpphdl_n2439, Vss) <+ 5e-15 * ddt(V(cpphdl_n2439, Vss)); // Bench initial voltage = 0.0 V.
        // device 1903, IC IC329, analog/basic/buffered_nand_latch.hpp:37
        I(cpphdl_n2439, Vss) <+ 8.0000000000000006e-15 * ddt(V(cpphdl_n2439, Vss)); // Bench initial voltage = 0.0 V.
        // device 1904, IC IC329, analog/basic/buffered_nand_latch.hpp:38
        I(cpphdl_n2453, Vss) <+ 1e-14 * ddt(V(cpphdl_n2453, Vss)); // Bench initial voltage = 0.0 V.
        // device 1905, IC IC331, analog/basic/inverter.hpp:11
        I(cpphdl_n2443, Vdd) <+ cpphdl_channel(V(cpphdl_n2435, Vdd), V(cpphdl_n2443, Vdd), 0.001, 0.69999999999999996, -1.0);
        // device 1906, IC IC331, analog/basic/inverter.hpp:12
        I(cpphdl_n2443, Vss) <+ cpphdl_channel(V(cpphdl_n2435, Vss), V(cpphdl_n2443, Vss), 0.001, 0.69999999999999996, 1.0);
        // device 1907, IC IC333, analog/basic/inverter.hpp:11
        I(cpphdl_n2459, Vdd) <+ cpphdl_channel(V(cpphdl_n2443, Vdd), V(cpphdl_n2459, Vdd), 0.0040000000000000001, 0.69999999999999996, -1.0);
        // device 1908, IC IC333, analog/basic/inverter.hpp:12
        I(cpphdl_n2459, Vss) <+ cpphdl_channel(V(cpphdl_n2443, Vss), V(cpphdl_n2459, Vss), 0.0040000000000000001, 0.69999999999999996, 1.0);
        // device 1909, IC IC329, analog/basic/buffered_nand_latch.hpp:34
        I(cpphdl_n2435, Vss) <+ 2.0000000000000002e-15 * ddt(V(cpphdl_n2435, Vss)); // Bench initial voltage = 0.0 V.
        // device 1910, IC IC329, analog/basic/buffered_nand_latch.hpp:35
        I(cpphdl_n2435, cpphdl_n2443) <+ 1.0000000000000001e-15 * ddt(V(cpphdl_n2435, cpphdl_n2443)); // Bench initial voltage = 0.0 V.
        // device 1911, IC IC329, analog/basic/buffered_nand_latch.hpp:36
        I(cpphdl_n2443, Vss) <+ 5e-15 * ddt(V(cpphdl_n2443, Vss)); // Bench initial voltage = 0.0 V.
        // device 1912, IC IC329, analog/basic/buffered_nand_latch.hpp:37
        I(cpphdl_n2443, Vss) <+ 8.0000000000000006e-15 * ddt(V(cpphdl_n2443, Vss)); // Bench initial voltage = 0.0 V.
        // device 1913, IC IC329, analog/basic/buffered_nand_latch.hpp:38
        I(cpphdl_n2459, Vss) <+ 1e-14 * ddt(V(cpphdl_n2459, Vss)); // Bench initial voltage = 0.0 V.
        // device 1914, IC IC335, analog/basic/cmos_logic.hpp:17
        I(cpphdl_n2838, Vss) <+ 5.0000000000000002e-14 * ddt(V(cpphdl_n2838, Vss)); // Bench initial voltage = 0.0 V.
        // device 1915, IC IC335, analog/basic/cmos_logic.hpp:18
        I(cpphdl_n2838, Vdd) <+ cpphdl_channel(V(cpphdl_n2453, Vdd), V(cpphdl_n2838, Vdd), 0.01, 0.69999999999999996, -1.0);
        // device 1916, IC IC335, analog/basic/cmos_logic.hpp:19
        I(cpphdl_n2838, Vdd) <+ cpphdl_channel(V(cpphdl_n2461, Vdd), V(cpphdl_n2838, Vdd), 0.01, 0.69999999999999996, -1.0);
        // device 1917, IC IC335, analog/basic/cmos_logic.hpp:20
        I(cpphdl_n2838, cpphdl_n2456) <+ cpphdl_channel(V(cpphdl_n2453, cpphdl_n2456), V(cpphdl_n2838, cpphdl_n2456), 0.01, 0.69999999999999996, 1.0);
        // device 1918, IC IC335, analog/basic/cmos_logic.hpp:21
        I(cpphdl_n2456, Vss) <+ cpphdl_channel(V(cpphdl_n2461, Vss), V(cpphdl_n2456, Vss), 0.01, 0.69999999999999996, 1.0);
        // device 1919, IC IC335, analog/basic/cmos_logic.hpp:27
        I(cpphdl_n2456, Vss) <+ 1e-14 * ddt(V(cpphdl_n2456, Vss)); // Bench initial voltage = 0.0 V.
        // device 1920, IC IC336, analog/basic/cmos_logic.hpp:17
        I(cpphdl_n2461, Vss) <+ 5.0000000000000002e-14 * ddt(V(cpphdl_n2461, Vss)); // Bench initial voltage = 0.0 V.
        // device 1921, IC IC336, analog/basic/cmos_logic.hpp:18
        I(cpphdl_n2461, Vdd) <+ cpphdl_channel(V(cpphdl_n2459, Vdd), V(cpphdl_n2461, Vdd), 0.01, 0.69999999999999996, -1.0);
        // device 1922, IC IC336, analog/basic/cmos_logic.hpp:19
        I(cpphdl_n2461, Vdd) <+ cpphdl_channel(V(cpphdl_n2838, Vdd), V(cpphdl_n2461, Vdd), 0.01, 0.69999999999999996, -1.0);
        // device 1923, IC IC336, analog/basic/cmos_logic.hpp:20
        I(cpphdl_n2461, cpphdl_n2462) <+ cpphdl_channel(V(cpphdl_n2459, cpphdl_n2462), V(cpphdl_n2461, cpphdl_n2462), 0.01, 0.69999999999999996, 1.0);
        // device 1924, IC IC336, analog/basic/cmos_logic.hpp:21
        I(cpphdl_n2462, Vss) <+ cpphdl_channel(V(cpphdl_n2838, Vss), V(cpphdl_n2462, Vss), 0.01, 0.69999999999999996, 1.0);
        // device 1925, IC IC336, analog/basic/cmos_logic.hpp:27
        I(cpphdl_n2462, Vss) <+ 1e-14 * ddt(V(cpphdl_n2462, Vss)); // Bench initial voltage = 0.0 V.
        // device 1926, IC IC334, analog/basic/nand_latch.hpp:36
        I(cpphdl_n2453, Vss) <+ 2.9999999999999998e-15 * ddt(V(cpphdl_n2453, Vss)); // Bench initial voltage = 0.0 V.
        // device 1927, IC IC334, analog/basic/nand_latch.hpp:37
        I(cpphdl_n2459, Vss) <+ 2.9999999999999998e-15 * ddt(V(cpphdl_n2459, Vss)); // Bench initial voltage = 0.0 V.
        // device 1928, IC IC337, analog/basic/inverter.hpp:11
        I(cpphdl_n2467, Vdd) <+ cpphdl_channel(V(CLEAR, Vdd), V(cpphdl_n2467, Vdd), 0.01, 0.69999999999999996, -1.0);
        // device 1929, IC IC337, analog/basic/inverter.hpp:12
        I(cpphdl_n2467, Vss) <+ cpphdl_channel(V(CLEAR, Vss), V(cpphdl_n2467, Vss), 0.01, 0.69999999999999996, 1.0);
        // device 1930, IC IC334, analog/basic/nand_latch.hpp:58
        I(cpphdl_n2467, Vss) <+ 2.9999999999999998e-15 * ddt(V(cpphdl_n2467, Vss)); // Bench initial voltage = 0.0 V.
        // device 1931, IC IC334, analog/basic/nand_latch.hpp:59
        I(cpphdl_n2838, Vss) <+ cpphdl_channel(V(CLEAR, Vss), V(cpphdl_n2838, Vss), 0.050000000000000003, 0.69999999999999996, 1.0);
        // device 1932, IC IC334, analog/basic/nand_latch.hpp:60
        I(cpphdl_n2461, Vdd) <+ cpphdl_channel(V(cpphdl_n2467, Vdd), V(cpphdl_n2461, Vdd), 0.050000000000000003, 0.69999999999999996, -1.0);
        // device 1933, IC IC340, analog/basic/inverter.hpp:11
        I(cpphdl_n2491, Vdd) <+ cpphdl_channel(V(TRACK14, Vdd), V(cpphdl_n2491, Vdd), 0.0040000000000000001, 0.69999999999999996, -1.0);
        // device 1934, IC IC340, analog/basic/inverter.hpp:12
        I(cpphdl_n2491, Vss) <+ cpphdl_channel(V(TRACK14, Vss), V(cpphdl_n2491, Vss), 0.0040000000000000001, 0.69999999999999996, 1.0);
        // device 1935, IC IC339, analog/basic/mos_track_hold.hpp:31
        I(cpphdl_n2491, Vss) <+ 2e-14 * ddt(V(cpphdl_n2491, Vss)); // Bench initial voltage = 0.0 V.
        // device 1936, IC IC339, analog/basic/mos_track_hold.hpp:32
        I(cpphdl_n2628, cpphdl_n2545) <+ cpphdl_channel(V(TRACK14, cpphdl_n2545), V(cpphdl_n2628, cpphdl_n2545), 0.029999999999999999, 0.69999999999999996, 1.0);
        // device 1937, IC IC339, analog/basic/mos_track_hold.hpp:33
        I(cpphdl_n2545, cpphdl_n2628) <+ cpphdl_channel(V(cpphdl_n2491, cpphdl_n2628), V(cpphdl_n2545, cpphdl_n2628), 0.014999999999999999, 0.69999999999999996, -1.0);
        // device 1938, IC IC339, analog/basic/mos_track_hold.hpp:37
        I(cpphdl_n2545, cpphdl_n2545) <+ cpphdl_channel(V(cpphdl_n2491, cpphdl_n2545), V(cpphdl_n2545, cpphdl_n2545), 0.016, 0.69999999999999996, 1.0);
        // device 1939, IC IC339, analog/basic/mos_track_hold.hpp:38
        I(cpphdl_n2545, cpphdl_n2545) <+ cpphdl_channel(V(TRACK14, cpphdl_n2545), V(cpphdl_n2545, cpphdl_n2545), 0.0083999999999999995, 0.69999999999999996, -1.0);
        // device 1940, IC IC339, analog/basic/mos_track_hold.hpp:39
        I(cpphdl_n2545, Vss) <+ 1.5000000000000001e-12 * ddt(V(cpphdl_n2545, Vss)); // Bench initial voltage = 0.0 V.
        // device 1941, IC IC339, analog/basic/mos_track_hold.hpp:42
        I(TRACK14, cpphdl_n2545) <+ 2.0000000000000002e-15 * ddt(V(TRACK14, cpphdl_n2545)); // Bench initial voltage = -0.0 V.
        // device 1942, IC IC339, analog/basic/mos_track_hold.hpp:43
        I(cpphdl_n2491, cpphdl_n2545) <+ 2.0000000000000002e-15 * ddt(V(cpphdl_n2491, cpphdl_n2545)); // Bench initial voltage = 0.0 V.
        // device 1943, IC IC339, analog/basic/mos_track_hold.hpp:44
        I(cpphdl_n2628, cpphdl_n2545) <+ 1.0000000000000001e-15 * ddt(V(cpphdl_n2628, cpphdl_n2545)); // Bench initial voltage = 0.0 V.
        // device 1944, IC IC342, analog/basic/inverter.hpp:11
        I(cpphdl_n2506, Vdd) <+ cpphdl_channel(V(BIT_N14_0, Vdd), V(cpphdl_n2506, Vdd), 0.080000000000000002, 0.69999999999999996, -1.0);
        // device 1945, IC IC342, analog/basic/inverter.hpp:12
        I(cpphdl_n2506, Vss) <+ cpphdl_channel(V(BIT_N14_0, Vss), V(cpphdl_n2506, Vss), 0.080000000000000002, 0.69999999999999996, 1.0);
        // device 1946, IC IC341, analog/basic/mos_r2r_dac.hpp:27
        I(cpphdl_n2506, Vss) <+ 2.9999999999999998e-15 * ddt(V(cpphdl_n2506, Vss)); // Bench initial voltage = 0.0 V.
        // device 1947, IC IC341, analog/basic/mos_r2r_dac.hpp:28
        I(cpphdl_n2506, cpphdl_n2535) <+ V(cpphdl_n2506, cpphdl_n2535) / 2000.0;
        // device 1948, IC IC341, analog/basic/mos_r2r_dac.hpp:29
        I(cpphdl_n2535, Vss) <+ 2.9999999999999998e-15 * ddt(V(cpphdl_n2535, Vss)); // Bench initial voltage = 0.0 V.
        // device 1949, IC IC343, analog/basic/inverter.hpp:11
        I(cpphdl_n2510, Vdd) <+ cpphdl_channel(V(BIT_N14_1, Vdd), V(cpphdl_n2510, Vdd), 0.080000000000000002, 0.69999999999999996, -1.0);
        // device 1950, IC IC343, analog/basic/inverter.hpp:12
        I(cpphdl_n2510, Vss) <+ cpphdl_channel(V(BIT_N14_1, Vss), V(cpphdl_n2510, Vss), 0.080000000000000002, 0.69999999999999996, 1.0);
        // device 1951, IC IC341, analog/basic/mos_r2r_dac.hpp:27
        I(cpphdl_n2510, Vss) <+ 2.9999999999999998e-15 * ddt(V(cpphdl_n2510, Vss)); // Bench initial voltage = 0.0 V.
        // device 1952, IC IC341, analog/basic/mos_r2r_dac.hpp:28
        I(cpphdl_n2510, cpphdl_n2536) <+ V(cpphdl_n2510, cpphdl_n2536) / 2000.0;
        // device 1953, IC IC341, analog/basic/mos_r2r_dac.hpp:29
        I(cpphdl_n2536, Vss) <+ 2.9999999999999998e-15 * ddt(V(cpphdl_n2536, Vss)); // Bench initial voltage = 0.0 V.
        // device 1954, IC IC341, analog/basic/mos_r2r_dac.hpp:31
        I(cpphdl_n2535, cpphdl_n2536) <+ V(cpphdl_n2535, cpphdl_n2536) / 1000.0;
        // device 1955, IC IC344, analog/basic/inverter.hpp:11
        I(cpphdl_n2514, Vdd) <+ cpphdl_channel(V(BIT_N14_2, Vdd), V(cpphdl_n2514, Vdd), 0.080000000000000002, 0.69999999999999996, -1.0);
        // device 1956, IC IC344, analog/basic/inverter.hpp:12
        I(cpphdl_n2514, Vss) <+ cpphdl_channel(V(BIT_N14_2, Vss), V(cpphdl_n2514, Vss), 0.080000000000000002, 0.69999999999999996, 1.0);
        // device 1957, IC IC341, analog/basic/mos_r2r_dac.hpp:27
        I(cpphdl_n2514, Vss) <+ 2.9999999999999998e-15 * ddt(V(cpphdl_n2514, Vss)); // Bench initial voltage = 0.0 V.
        // device 1958, IC IC341, analog/basic/mos_r2r_dac.hpp:28
        I(cpphdl_n2514, cpphdl_n2537) <+ V(cpphdl_n2514, cpphdl_n2537) / 2000.0;
        // device 1959, IC IC341, analog/basic/mos_r2r_dac.hpp:29
        I(cpphdl_n2537, Vss) <+ 2.9999999999999998e-15 * ddt(V(cpphdl_n2537, Vss)); // Bench initial voltage = 0.0 V.
        // device 1960, IC IC341, analog/basic/mos_r2r_dac.hpp:31
        I(cpphdl_n2536, cpphdl_n2537) <+ V(cpphdl_n2536, cpphdl_n2537) / 1000.0;
        // device 1961, IC IC345, analog/basic/inverter.hpp:11
        I(cpphdl_n2518, Vdd) <+ cpphdl_channel(V(BIT_N14_3, Vdd), V(cpphdl_n2518, Vdd), 0.080000000000000002, 0.69999999999999996, -1.0);
        // device 1962, IC IC345, analog/basic/inverter.hpp:12
        I(cpphdl_n2518, Vss) <+ cpphdl_channel(V(BIT_N14_3, Vss), V(cpphdl_n2518, Vss), 0.080000000000000002, 0.69999999999999996, 1.0);
        // device 1963, IC IC341, analog/basic/mos_r2r_dac.hpp:27
        I(cpphdl_n2518, Vss) <+ 2.9999999999999998e-15 * ddt(V(cpphdl_n2518, Vss)); // Bench initial voltage = 0.0 V.
        // device 1964, IC IC341, analog/basic/mos_r2r_dac.hpp:28
        I(cpphdl_n2518, cpphdl_n2538) <+ V(cpphdl_n2518, cpphdl_n2538) / 2000.0;
        // device 1965, IC IC341, analog/basic/mos_r2r_dac.hpp:29
        I(cpphdl_n2538, Vss) <+ 2.9999999999999998e-15 * ddt(V(cpphdl_n2538, Vss)); // Bench initial voltage = 0.0 V.
        // device 1966, IC IC341, analog/basic/mos_r2r_dac.hpp:31
        I(cpphdl_n2537, cpphdl_n2538) <+ V(cpphdl_n2537, cpphdl_n2538) / 1000.0;
        // device 1967, IC IC346, analog/basic/inverter.hpp:11
        I(cpphdl_n2522, Vdd) <+ cpphdl_channel(V(BIT_N14_4, Vdd), V(cpphdl_n2522, Vdd), 0.080000000000000002, 0.69999999999999996, -1.0);
        // device 1968, IC IC346, analog/basic/inverter.hpp:12
        I(cpphdl_n2522, Vss) <+ cpphdl_channel(V(BIT_N14_4, Vss), V(cpphdl_n2522, Vss), 0.080000000000000002, 0.69999999999999996, 1.0);
        // device 1969, IC IC341, analog/basic/mos_r2r_dac.hpp:27
        I(cpphdl_n2522, Vss) <+ 2.9999999999999998e-15 * ddt(V(cpphdl_n2522, Vss)); // Bench initial voltage = 0.0 V.
        // device 1970, IC IC341, analog/basic/mos_r2r_dac.hpp:28
        I(cpphdl_n2522, cpphdl_n2539) <+ V(cpphdl_n2522, cpphdl_n2539) / 2000.0;
        // device 1971, IC IC341, analog/basic/mos_r2r_dac.hpp:29
        I(cpphdl_n2539, Vss) <+ 2.9999999999999998e-15 * ddt(V(cpphdl_n2539, Vss)); // Bench initial voltage = 0.0 V.
        // device 1972, IC IC341, analog/basic/mos_r2r_dac.hpp:31
        I(cpphdl_n2538, cpphdl_n2539) <+ V(cpphdl_n2538, cpphdl_n2539) / 1000.0;
        // device 1973, IC IC347, analog/basic/inverter.hpp:11
        I(cpphdl_n2526, Vdd) <+ cpphdl_channel(V(BIT_N14_5, Vdd), V(cpphdl_n2526, Vdd), 0.080000000000000002, 0.69999999999999996, -1.0);
        // device 1974, IC IC347, analog/basic/inverter.hpp:12
        I(cpphdl_n2526, Vss) <+ cpphdl_channel(V(BIT_N14_5, Vss), V(cpphdl_n2526, Vss), 0.080000000000000002, 0.69999999999999996, 1.0);
        // device 1975, IC IC341, analog/basic/mos_r2r_dac.hpp:27
        I(cpphdl_n2526, Vss) <+ 2.9999999999999998e-15 * ddt(V(cpphdl_n2526, Vss)); // Bench initial voltage = 0.0 V.
        // device 1976, IC IC341, analog/basic/mos_r2r_dac.hpp:28
        I(cpphdl_n2526, cpphdl_n2540) <+ V(cpphdl_n2526, cpphdl_n2540) / 2000.0;
        // device 1977, IC IC341, analog/basic/mos_r2r_dac.hpp:29
        I(cpphdl_n2540, Vss) <+ 2.9999999999999998e-15 * ddt(V(cpphdl_n2540, Vss)); // Bench initial voltage = 0.0 V.
        // device 1978, IC IC341, analog/basic/mos_r2r_dac.hpp:31
        I(cpphdl_n2539, cpphdl_n2540) <+ V(cpphdl_n2539, cpphdl_n2540) / 1000.0;
        // device 1979, IC IC348, analog/basic/inverter.hpp:11
        I(cpphdl_n2530, Vdd) <+ cpphdl_channel(V(BIT_N14_6, Vdd), V(cpphdl_n2530, Vdd), 0.080000000000000002, 0.69999999999999996, -1.0);
        // device 1980, IC IC348, analog/basic/inverter.hpp:12
        I(cpphdl_n2530, Vss) <+ cpphdl_channel(V(BIT_N14_6, Vss), V(cpphdl_n2530, Vss), 0.080000000000000002, 0.69999999999999996, 1.0);
        // device 1981, IC IC341, analog/basic/mos_r2r_dac.hpp:27
        I(cpphdl_n2530, Vss) <+ 2.9999999999999998e-15 * ddt(V(cpphdl_n2530, Vss)); // Bench initial voltage = 0.0 V.
        // device 1982, IC IC341, analog/basic/mos_r2r_dac.hpp:28
        I(cpphdl_n2530, cpphdl_n2541) <+ V(cpphdl_n2530, cpphdl_n2541) / 2000.0;
        // device 1983, IC IC341, analog/basic/mos_r2r_dac.hpp:29
        I(cpphdl_n2541, Vss) <+ 2.9999999999999998e-15 * ddt(V(cpphdl_n2541, Vss)); // Bench initial voltage = 0.0 V.
        // device 1984, IC IC341, analog/basic/mos_r2r_dac.hpp:31
        I(cpphdl_n2540, cpphdl_n2541) <+ V(cpphdl_n2540, cpphdl_n2541) / 1000.0;
        // device 1985, IC IC349, analog/basic/inverter.hpp:11
        I(cpphdl_n2534, Vdd) <+ cpphdl_channel(V(BIT_N14_7, Vdd), V(cpphdl_n2534, Vdd), 0.080000000000000002, 0.69999999999999996, -1.0);
        // device 1986, IC IC349, analog/basic/inverter.hpp:12
        I(cpphdl_n2534, Vss) <+ cpphdl_channel(V(BIT_N14_7, Vss), V(cpphdl_n2534, Vss), 0.080000000000000002, 0.69999999999999996, 1.0);
        // device 1987, IC IC341, analog/basic/mos_r2r_dac.hpp:27
        I(cpphdl_n2534, Vss) <+ 2.9999999999999998e-15 * ddt(V(cpphdl_n2534, Vss)); // Bench initial voltage = 0.0 V.
        // device 1988, IC IC341, analog/basic/mos_r2r_dac.hpp:28
        I(cpphdl_n2534, cpphdl_n2546) <+ V(cpphdl_n2534, cpphdl_n2546) / 2000.0;
        // device 1989, IC IC341, analog/basic/mos_r2r_dac.hpp:29
        I(cpphdl_n2546, Vss) <+ 2.9999999999999998e-15 * ddt(V(cpphdl_n2546, Vss)); // Bench initial voltage = 0.0 V.
        // device 1990, IC IC341, analog/basic/mos_r2r_dac.hpp:31
        I(cpphdl_n2541, cpphdl_n2546) <+ V(cpphdl_n2541, cpphdl_n2546) / 1000.0;
        // device 1991, IC IC341, analog/basic/mos_r2r_dac.hpp:33
        I(Vss, cpphdl_n2535) <+ V(Vss, cpphdl_n2535) / 2000.0;
        // device 1992, IC IC350, analog/basic/nmos_resistor_amplifier.hpp:23
        I(Vdd, cpphdl_n2555) <+ V(Vdd, cpphdl_n2555) / 1000.0;
        // device 1993, IC IC350, analog/basic/nmos_resistor_amplifier.hpp:24
        I(Vdd, cpphdl_n2554) <+ V(Vdd, cpphdl_n2554) / 1000.0;
        // device 1994, IC IC350, analog/basic/nmos_resistor_amplifier.hpp:25
        I(cpphdl_n2555, cpphdl_n2549) <+ cpphdl_channel(V(cpphdl_n2545, cpphdl_n2549), V(cpphdl_n2555, cpphdl_n2549), 0.0074999999999999997, 0.69999999999999996, 1.0);
        // device 1995, IC IC350, analog/basic/nmos_resistor_amplifier.hpp:26
        I(cpphdl_n2554, cpphdl_n2550) <+ cpphdl_channel(V(cpphdl_n2546, cpphdl_n2550), V(cpphdl_n2554, cpphdl_n2550), 0.0074999999999999997, 0.69999999999999996, 1.0);
        // device 1996, IC IC350, analog/basic/nmos_resistor_amplifier.hpp:27
        I(cpphdl_n2551, cpphdl_n2549) <+ V(cpphdl_n2551, cpphdl_n2549) / 100.0;
        // device 1997, IC IC350, analog/basic/nmos_resistor_amplifier.hpp:28
        I(cpphdl_n2551, cpphdl_n2550) <+ V(cpphdl_n2551, cpphdl_n2550) / 100.0;
        // device 1998, IC IC350, analog/basic/nmos_resistor_amplifier.hpp:29
        I(Vss, cpphdl_n2551) <+ V(Vss, cpphdl_n2551) / 300.0;
        // device 1999, IC IC350, analog/basic/nmos_resistor_amplifier.hpp:30
        I(cpphdl_n2555, Vdd) <+ 2.9999999999999998e-13 * ddt(V(cpphdl_n2555, Vdd)); // Bench initial voltage = 0.0 V.
        // device 2000, IC IC350, analog/basic/nmos_resistor_amplifier.hpp:31
        I(cpphdl_n2554, Vdd) <+ 2.9999999999999998e-13 * ddt(V(cpphdl_n2554, Vdd)); // Bench initial voltage = 0.0 V.
        // device 2001, IC IC350, analog/basic/nmos_resistor_amplifier.hpp:32
        I(cpphdl_n2551, Vss) <+ 4e-14 * ddt(V(cpphdl_n2551, Vss)); // Bench initial voltage = 0.0 V.
        // device 2002, IC IC350, analog/basic/nmos_resistor_amplifier.hpp:34
        I(cpphdl_n2545, cpphdl_n2549) <+ 2e-14 * ddt(V(cpphdl_n2545, cpphdl_n2549)); // Bench initial voltage = 0.0 V.
        // device 2003, IC IC350, analog/basic/nmos_resistor_amplifier.hpp:35
        I(cpphdl_n2546, cpphdl_n2550) <+ 2e-14 * ddt(V(cpphdl_n2546, cpphdl_n2550)); // Bench initial voltage = 0.0 V.
        // device 2004, IC IC350, analog/basic/nmos_resistor_amplifier.hpp:36
        I(cpphdl_n2545, cpphdl_n2555) <+ 2.9999999999999998e-15 * ddt(V(cpphdl_n2545, cpphdl_n2555)); // Bench initial voltage = 0.0 V.
        // device 2005, IC IC350, analog/basic/nmos_resistor_amplifier.hpp:37
        I(cpphdl_n2546, cpphdl_n2554) <+ 2.9999999999999998e-15 * ddt(V(cpphdl_n2546, cpphdl_n2554)); // Bench initial voltage = 0.0 V.
        // device 2006, IC IC351, analog/basic/strongarm_comparator.hpp:28
        I(cpphdl_n2559, cpphdl_n2561) <+ cpphdl_channel(V(cpphdl_n2554, cpphdl_n2561), V(cpphdl_n2559, cpphdl_n2561), 0.0080000000000000002, 0.69999999999999996, 1.0);
        // device 2007, IC IC351, analog/basic/strongarm_comparator.hpp:29
        I(cpphdl_n2560, cpphdl_n2561) <+ cpphdl_channel(V(cpphdl_n2555, cpphdl_n2561), V(cpphdl_n2560, cpphdl_n2561), 0.0080000000000000002, 0.69999999999999996, 1.0);
        // device 2008, IC IC351, analog/basic/strongarm_comparator.hpp:30
        I(cpphdl_n2561, Vss) <+ cpphdl_channel(V(EVALUATE, Vss), V(cpphdl_n2561, Vss), 0.0080000000000000002, 0.69999999999999996, 1.0);
        // device 2009, IC IC351, analog/basic/strongarm_comparator.hpp:33
        I(cpphdl_n2574, cpphdl_n2559) <+ cpphdl_channel(V(cpphdl_n2578, cpphdl_n2559), V(cpphdl_n2574, cpphdl_n2559), 0.0040000000000000001, 0.69999999999999996, 1.0);
        // device 2010, IC IC351, analog/basic/strongarm_comparator.hpp:34
        I(cpphdl_n2578, cpphdl_n2560) <+ cpphdl_channel(V(cpphdl_n2574, cpphdl_n2560), V(cpphdl_n2578, cpphdl_n2560), 0.0040000000000000001, 0.69999999999999996, 1.0);
        // device 2011, IC IC351, analog/basic/strongarm_comparator.hpp:35
        I(cpphdl_n2578, Vdd) <+ cpphdl_channel(V(cpphdl_n2574, Vdd), V(cpphdl_n2578, Vdd), 0.002, 0.69999999999999996, -1.0);
        // device 2012, IC IC351, analog/basic/strongarm_comparator.hpp:36
        I(cpphdl_n2574, Vdd) <+ cpphdl_channel(V(cpphdl_n2578, Vdd), V(cpphdl_n2574, Vdd), 0.002, 0.69999999999999996, -1.0);
        // device 2013, IC IC351, analog/basic/strongarm_comparator.hpp:38
        I(cpphdl_n2559, Vdd) <+ cpphdl_channel(V(EVALUATE, Vdd), V(cpphdl_n2559, Vdd), 0.002, 0.69999999999999996, -1.0);
        // device 2014, IC IC351, analog/basic/strongarm_comparator.hpp:39
        I(cpphdl_n2560, Vdd) <+ cpphdl_channel(V(EVALUATE, Vdd), V(cpphdl_n2560, Vdd), 0.002, 0.69999999999999996, -1.0);
        // device 2015, IC IC351, analog/basic/strongarm_comparator.hpp:40
        I(cpphdl_n2578, Vdd) <+ cpphdl_channel(V(EVALUATE, Vdd), V(cpphdl_n2578, Vdd), 0.002, 0.69999999999999996, -1.0);
        // device 2016, IC IC351, analog/basic/strongarm_comparator.hpp:41
        I(cpphdl_n2574, Vdd) <+ cpphdl_channel(V(EVALUATE, Vdd), V(cpphdl_n2574, Vdd), 0.002, 0.69999999999999996, -1.0);
        // device 2017, IC IC351, analog/basic/strongarm_comparator.hpp:42
        I(cpphdl_n2559, Vss) <+ 2.9999999999999998e-14 * ddt(V(cpphdl_n2559, Vss)); // Bench initial voltage = 0.0 V.
        // device 2018, IC IC351, analog/basic/strongarm_comparator.hpp:43
        I(cpphdl_n2560, Vss) <+ 2.9999999999999998e-14 * ddt(V(cpphdl_n2560, Vss)); // Bench initial voltage = 0.0 V.
        // device 2019, IC IC351, analog/basic/strongarm_comparator.hpp:44
        I(cpphdl_n2561, Vss) <+ 2.9999999999999998e-14 * ddt(V(cpphdl_n2561, Vss)); // Bench initial voltage = 0.0 V.
        // device 2020, IC IC351, analog/basic/strongarm_comparator.hpp:45
        I(cpphdl_n2578, Vss) <+ 5.0000000000000002e-14 * ddt(V(cpphdl_n2578, Vss)); // Bench initial voltage = 0.0 V.
        // device 2021, IC IC351, analog/basic/strongarm_comparator.hpp:46
        I(cpphdl_n2574, Vss) <+ 5.0000000000000002e-14 * ddt(V(cpphdl_n2574, Vss)); // Bench initial voltage = 0.0 V.
        // device 2022, IC IC351, analog/basic/strongarm_comparator.hpp:47
        I(cpphdl_n2554, cpphdl_n2561) <+ 2e-14 * ddt(V(cpphdl_n2554, cpphdl_n2561)); // Bench initial voltage = 0.0 V.
        // device 2023, IC IC351, analog/basic/strongarm_comparator.hpp:48
        I(cpphdl_n2555, cpphdl_n2561) <+ 2e-14 * ddt(V(cpphdl_n2555, cpphdl_n2561)); // Bench initial voltage = 0.0 V.
        // device 2024, IC IC351, analog/basic/strongarm_comparator.hpp:49
        I(cpphdl_n2554, cpphdl_n2559) <+ 2.9999999999999998e-15 * ddt(V(cpphdl_n2554, cpphdl_n2559)); // Bench initial voltage = 0.0 V.
        // device 2025, IC IC351, analog/basic/strongarm_comparator.hpp:50
        I(cpphdl_n2555, cpphdl_n2560) <+ 2.9999999999999998e-15 * ddt(V(cpphdl_n2555, cpphdl_n2560)); // Bench initial voltage = 0.0 V.
        // device 2026, IC IC353, analog/basic/inverter.hpp:11
        I(cpphdl_n2582, Vdd) <+ cpphdl_channel(V(cpphdl_n2574, Vdd), V(cpphdl_n2582, Vdd), 0.001, 0.69999999999999996, -1.0);
        // device 2027, IC IC353, analog/basic/inverter.hpp:12
        I(cpphdl_n2582, Vss) <+ cpphdl_channel(V(cpphdl_n2574, Vss), V(cpphdl_n2582, Vss), 0.001, 0.69999999999999996, 1.0);
        // device 2028, IC IC355, analog/basic/inverter.hpp:11
        I(cpphdl_n2596, Vdd) <+ cpphdl_channel(V(cpphdl_n2582, Vdd), V(cpphdl_n2596, Vdd), 0.0040000000000000001, 0.69999999999999996, -1.0);
        // device 2029, IC IC355, analog/basic/inverter.hpp:12
        I(cpphdl_n2596, Vss) <+ cpphdl_channel(V(cpphdl_n2582, Vss), V(cpphdl_n2596, Vss), 0.0040000000000000001, 0.69999999999999996, 1.0);
        // device 2030, IC IC352, analog/basic/buffered_nand_latch.hpp:34
        I(cpphdl_n2574, Vss) <+ 2.0000000000000002e-15 * ddt(V(cpphdl_n2574, Vss)); // Bench initial voltage = 0.0 V.
        // device 2031, IC IC352, analog/basic/buffered_nand_latch.hpp:35
        I(cpphdl_n2574, cpphdl_n2582) <+ 1.0000000000000001e-15 * ddt(V(cpphdl_n2574, cpphdl_n2582)); // Bench initial voltage = 0.0 V.
        // device 2032, IC IC352, analog/basic/buffered_nand_latch.hpp:36
        I(cpphdl_n2582, Vss) <+ 5e-15 * ddt(V(cpphdl_n2582, Vss)); // Bench initial voltage = 0.0 V.
        // device 2033, IC IC352, analog/basic/buffered_nand_latch.hpp:37
        I(cpphdl_n2582, Vss) <+ 8.0000000000000006e-15 * ddt(V(cpphdl_n2582, Vss)); // Bench initial voltage = 0.0 V.
        // device 2034, IC IC352, analog/basic/buffered_nand_latch.hpp:38
        I(cpphdl_n2596, Vss) <+ 1e-14 * ddt(V(cpphdl_n2596, Vss)); // Bench initial voltage = 0.0 V.
        // device 2035, IC IC354, analog/basic/inverter.hpp:11
        I(cpphdl_n2586, Vdd) <+ cpphdl_channel(V(cpphdl_n2578, Vdd), V(cpphdl_n2586, Vdd), 0.001, 0.69999999999999996, -1.0);
        // device 2036, IC IC354, analog/basic/inverter.hpp:12
        I(cpphdl_n2586, Vss) <+ cpphdl_channel(V(cpphdl_n2578, Vss), V(cpphdl_n2586, Vss), 0.001, 0.69999999999999996, 1.0);
        // device 2037, IC IC356, analog/basic/inverter.hpp:11
        I(cpphdl_n2602, Vdd) <+ cpphdl_channel(V(cpphdl_n2586, Vdd), V(cpphdl_n2602, Vdd), 0.0040000000000000001, 0.69999999999999996, -1.0);
        // device 2038, IC IC356, analog/basic/inverter.hpp:12
        I(cpphdl_n2602, Vss) <+ cpphdl_channel(V(cpphdl_n2586, Vss), V(cpphdl_n2602, Vss), 0.0040000000000000001, 0.69999999999999996, 1.0);
        // device 2039, IC IC352, analog/basic/buffered_nand_latch.hpp:34
        I(cpphdl_n2578, Vss) <+ 2.0000000000000002e-15 * ddt(V(cpphdl_n2578, Vss)); // Bench initial voltage = 0.0 V.
        // device 2040, IC IC352, analog/basic/buffered_nand_latch.hpp:35
        I(cpphdl_n2578, cpphdl_n2586) <+ 1.0000000000000001e-15 * ddt(V(cpphdl_n2578, cpphdl_n2586)); // Bench initial voltage = 0.0 V.
        // device 2041, IC IC352, analog/basic/buffered_nand_latch.hpp:36
        I(cpphdl_n2586, Vss) <+ 5e-15 * ddt(V(cpphdl_n2586, Vss)); // Bench initial voltage = 0.0 V.
        // device 2042, IC IC352, analog/basic/buffered_nand_latch.hpp:37
        I(cpphdl_n2586, Vss) <+ 8.0000000000000006e-15 * ddt(V(cpphdl_n2586, Vss)); // Bench initial voltage = 0.0 V.
        // device 2043, IC IC352, analog/basic/buffered_nand_latch.hpp:38
        I(cpphdl_n2602, Vss) <+ 1e-14 * ddt(V(cpphdl_n2602, Vss)); // Bench initial voltage = 0.0 V.
        // device 2044, IC IC358, analog/basic/cmos_logic.hpp:17
        I(cpphdl_n2843, Vss) <+ 5.0000000000000002e-14 * ddt(V(cpphdl_n2843, Vss)); // Bench initial voltage = 0.0 V.
        // device 2045, IC IC358, analog/basic/cmos_logic.hpp:18
        I(cpphdl_n2843, Vdd) <+ cpphdl_channel(V(cpphdl_n2596, Vdd), V(cpphdl_n2843, Vdd), 0.01, 0.69999999999999996, -1.0);
        // device 2046, IC IC358, analog/basic/cmos_logic.hpp:19
        I(cpphdl_n2843, Vdd) <+ cpphdl_channel(V(cpphdl_n2604, Vdd), V(cpphdl_n2843, Vdd), 0.01, 0.69999999999999996, -1.0);
        // device 2047, IC IC358, analog/basic/cmos_logic.hpp:20
        I(cpphdl_n2843, cpphdl_n2599) <+ cpphdl_channel(V(cpphdl_n2596, cpphdl_n2599), V(cpphdl_n2843, cpphdl_n2599), 0.01, 0.69999999999999996, 1.0);
        // device 2048, IC IC358, analog/basic/cmos_logic.hpp:21
        I(cpphdl_n2599, Vss) <+ cpphdl_channel(V(cpphdl_n2604, Vss), V(cpphdl_n2599, Vss), 0.01, 0.69999999999999996, 1.0);
        // device 2049, IC IC358, analog/basic/cmos_logic.hpp:27
        I(cpphdl_n2599, Vss) <+ 1e-14 * ddt(V(cpphdl_n2599, Vss)); // Bench initial voltage = 0.0 V.
        // device 2050, IC IC359, analog/basic/cmos_logic.hpp:17
        I(cpphdl_n2604, Vss) <+ 5.0000000000000002e-14 * ddt(V(cpphdl_n2604, Vss)); // Bench initial voltage = 0.0 V.
        // device 2051, IC IC359, analog/basic/cmos_logic.hpp:18
        I(cpphdl_n2604, Vdd) <+ cpphdl_channel(V(cpphdl_n2602, Vdd), V(cpphdl_n2604, Vdd), 0.01, 0.69999999999999996, -1.0);
        // device 2052, IC IC359, analog/basic/cmos_logic.hpp:19
        I(cpphdl_n2604, Vdd) <+ cpphdl_channel(V(cpphdl_n2843, Vdd), V(cpphdl_n2604, Vdd), 0.01, 0.69999999999999996, -1.0);
        // device 2053, IC IC359, analog/basic/cmos_logic.hpp:20
        I(cpphdl_n2604, cpphdl_n2605) <+ cpphdl_channel(V(cpphdl_n2602, cpphdl_n2605), V(cpphdl_n2604, cpphdl_n2605), 0.01, 0.69999999999999996, 1.0);
        // device 2054, IC IC359, analog/basic/cmos_logic.hpp:21
        I(cpphdl_n2605, Vss) <+ cpphdl_channel(V(cpphdl_n2843, Vss), V(cpphdl_n2605, Vss), 0.01, 0.69999999999999996, 1.0);
        // device 2055, IC IC359, analog/basic/cmos_logic.hpp:27
        I(cpphdl_n2605, Vss) <+ 1e-14 * ddt(V(cpphdl_n2605, Vss)); // Bench initial voltage = 0.0 V.
        // device 2056, IC IC357, analog/basic/nand_latch.hpp:36
        I(cpphdl_n2596, Vss) <+ 2.9999999999999998e-15 * ddt(V(cpphdl_n2596, Vss)); // Bench initial voltage = 0.0 V.
        // device 2057, IC IC357, analog/basic/nand_latch.hpp:37
        I(cpphdl_n2602, Vss) <+ 2.9999999999999998e-15 * ddt(V(cpphdl_n2602, Vss)); // Bench initial voltage = 0.0 V.
        // device 2058, IC IC360, analog/basic/inverter.hpp:11
        I(cpphdl_n2610, Vdd) <+ cpphdl_channel(V(CLEAR, Vdd), V(cpphdl_n2610, Vdd), 0.01, 0.69999999999999996, -1.0);
        // device 2059, IC IC360, analog/basic/inverter.hpp:12
        I(cpphdl_n2610, Vss) <+ cpphdl_channel(V(CLEAR, Vss), V(cpphdl_n2610, Vss), 0.01, 0.69999999999999996, 1.0);
        // device 2060, IC IC357, analog/basic/nand_latch.hpp:58
        I(cpphdl_n2610, Vss) <+ 2.9999999999999998e-15 * ddt(V(cpphdl_n2610, Vss)); // Bench initial voltage = 0.0 V.
        // device 2061, IC IC357, analog/basic/nand_latch.hpp:59
        I(cpphdl_n2843, Vss) <+ cpphdl_channel(V(CLEAR, Vss), V(cpphdl_n2843, Vss), 0.050000000000000003, 0.69999999999999996, 1.0);
        // device 2062, IC IC357, analog/basic/nand_latch.hpp:60
        I(cpphdl_n2604, Vdd) <+ cpphdl_channel(V(cpphdl_n2610, Vdd), V(cpphdl_n2604, Vdd), 0.050000000000000003, 0.69999999999999996, -1.0);
        // device 2063, IC IC363, analog/basic/inverter.hpp:11
        I(cpphdl_n2634, Vdd) <+ cpphdl_channel(V(TRACK15, Vdd), V(cpphdl_n2634, Vdd), 0.0040000000000000001, 0.69999999999999996, -1.0);
        // device 2064, IC IC363, analog/basic/inverter.hpp:12
        I(cpphdl_n2634, Vss) <+ cpphdl_channel(V(TRACK15, Vss), V(cpphdl_n2634, Vss), 0.0040000000000000001, 0.69999999999999996, 1.0);
        // device 2065, IC IC362, analog/basic/mos_track_hold.hpp:31
        I(cpphdl_n2634, Vss) <+ 2e-14 * ddt(V(cpphdl_n2634, Vss)); // Bench initial voltage = 0.0 V.
        // device 2066, IC IC362, analog/basic/mos_track_hold.hpp:32
        I(cpphdl_n2628, cpphdl_n2688) <+ cpphdl_channel(V(TRACK15, cpphdl_n2688), V(cpphdl_n2628, cpphdl_n2688), 0.029999999999999999, 0.69999999999999996, 1.0);
        // device 2067, IC IC362, analog/basic/mos_track_hold.hpp:33
        I(cpphdl_n2688, cpphdl_n2628) <+ cpphdl_channel(V(cpphdl_n2634, cpphdl_n2628), V(cpphdl_n2688, cpphdl_n2628), 0.014999999999999999, 0.69999999999999996, -1.0);
        // device 2068, IC IC362, analog/basic/mos_track_hold.hpp:37
        I(cpphdl_n2688, cpphdl_n2688) <+ cpphdl_channel(V(cpphdl_n2634, cpphdl_n2688), V(cpphdl_n2688, cpphdl_n2688), 0.016, 0.69999999999999996, 1.0);
        // device 2069, IC IC362, analog/basic/mos_track_hold.hpp:38
        I(cpphdl_n2688, cpphdl_n2688) <+ cpphdl_channel(V(TRACK15, cpphdl_n2688), V(cpphdl_n2688, cpphdl_n2688), 0.0083999999999999995, 0.69999999999999996, -1.0);
        // device 2070, IC IC362, analog/basic/mos_track_hold.hpp:39
        I(cpphdl_n2688, Vss) <+ 1.5000000000000001e-12 * ddt(V(cpphdl_n2688, Vss)); // Bench initial voltage = 0.0 V.
        // device 2071, IC IC362, analog/basic/mos_track_hold.hpp:42
        I(TRACK15, cpphdl_n2688) <+ 2.0000000000000002e-15 * ddt(V(TRACK15, cpphdl_n2688)); // Bench initial voltage = -0.0 V.
        // device 2072, IC IC362, analog/basic/mos_track_hold.hpp:43
        I(cpphdl_n2634, cpphdl_n2688) <+ 2.0000000000000002e-15 * ddt(V(cpphdl_n2634, cpphdl_n2688)); // Bench initial voltage = 0.0 V.
        // device 2073, IC IC362, analog/basic/mos_track_hold.hpp:44
        I(cpphdl_n2628, cpphdl_n2688) <+ 1.0000000000000001e-15 * ddt(V(cpphdl_n2628, cpphdl_n2688)); // Bench initial voltage = 0.0 V.
        // device 2074, IC IC365, analog/basic/inverter.hpp:11
        I(cpphdl_n2649, Vdd) <+ cpphdl_channel(V(BIT_N15_0, Vdd), V(cpphdl_n2649, Vdd), 0.080000000000000002, 0.69999999999999996, -1.0);
        // device 2075, IC IC365, analog/basic/inverter.hpp:12
        I(cpphdl_n2649, Vss) <+ cpphdl_channel(V(BIT_N15_0, Vss), V(cpphdl_n2649, Vss), 0.080000000000000002, 0.69999999999999996, 1.0);
        // device 2076, IC IC364, analog/basic/mos_r2r_dac.hpp:27
        I(cpphdl_n2649, Vss) <+ 2.9999999999999998e-15 * ddt(V(cpphdl_n2649, Vss)); // Bench initial voltage = 0.0 V.
        // device 2077, IC IC364, analog/basic/mos_r2r_dac.hpp:28
        I(cpphdl_n2649, cpphdl_n2678) <+ V(cpphdl_n2649, cpphdl_n2678) / 2000.0;
        // device 2078, IC IC364, analog/basic/mos_r2r_dac.hpp:29
        I(cpphdl_n2678, Vss) <+ 2.9999999999999998e-15 * ddt(V(cpphdl_n2678, Vss)); // Bench initial voltage = 0.0 V.
        // device 2079, IC IC366, analog/basic/inverter.hpp:11
        I(cpphdl_n2653, Vdd) <+ cpphdl_channel(V(BIT_N15_1, Vdd), V(cpphdl_n2653, Vdd), 0.080000000000000002, 0.69999999999999996, -1.0);
        // device 2080, IC IC366, analog/basic/inverter.hpp:12
        I(cpphdl_n2653, Vss) <+ cpphdl_channel(V(BIT_N15_1, Vss), V(cpphdl_n2653, Vss), 0.080000000000000002, 0.69999999999999996, 1.0);
        // device 2081, IC IC364, analog/basic/mos_r2r_dac.hpp:27
        I(cpphdl_n2653, Vss) <+ 2.9999999999999998e-15 * ddt(V(cpphdl_n2653, Vss)); // Bench initial voltage = 0.0 V.
        // device 2082, IC IC364, analog/basic/mos_r2r_dac.hpp:28
        I(cpphdl_n2653, cpphdl_n2679) <+ V(cpphdl_n2653, cpphdl_n2679) / 2000.0;
        // device 2083, IC IC364, analog/basic/mos_r2r_dac.hpp:29
        I(cpphdl_n2679, Vss) <+ 2.9999999999999998e-15 * ddt(V(cpphdl_n2679, Vss)); // Bench initial voltage = 0.0 V.
        // device 2084, IC IC364, analog/basic/mos_r2r_dac.hpp:31
        I(cpphdl_n2678, cpphdl_n2679) <+ V(cpphdl_n2678, cpphdl_n2679) / 1000.0;
        // device 2085, IC IC367, analog/basic/inverter.hpp:11
        I(cpphdl_n2657, Vdd) <+ cpphdl_channel(V(BIT_N15_2, Vdd), V(cpphdl_n2657, Vdd), 0.080000000000000002, 0.69999999999999996, -1.0);
        // device 2086, IC IC367, analog/basic/inverter.hpp:12
        I(cpphdl_n2657, Vss) <+ cpphdl_channel(V(BIT_N15_2, Vss), V(cpphdl_n2657, Vss), 0.080000000000000002, 0.69999999999999996, 1.0);
        // device 2087, IC IC364, analog/basic/mos_r2r_dac.hpp:27
        I(cpphdl_n2657, Vss) <+ 2.9999999999999998e-15 * ddt(V(cpphdl_n2657, Vss)); // Bench initial voltage = 0.0 V.
        // device 2088, IC IC364, analog/basic/mos_r2r_dac.hpp:28
        I(cpphdl_n2657, cpphdl_n2680) <+ V(cpphdl_n2657, cpphdl_n2680) / 2000.0;
        // device 2089, IC IC364, analog/basic/mos_r2r_dac.hpp:29
        I(cpphdl_n2680, Vss) <+ 2.9999999999999998e-15 * ddt(V(cpphdl_n2680, Vss)); // Bench initial voltage = 0.0 V.
        // device 2090, IC IC364, analog/basic/mos_r2r_dac.hpp:31
        I(cpphdl_n2679, cpphdl_n2680) <+ V(cpphdl_n2679, cpphdl_n2680) / 1000.0;
        // device 2091, IC IC368, analog/basic/inverter.hpp:11
        I(cpphdl_n2661, Vdd) <+ cpphdl_channel(V(BIT_N15_3, Vdd), V(cpphdl_n2661, Vdd), 0.080000000000000002, 0.69999999999999996, -1.0);
        // device 2092, IC IC368, analog/basic/inverter.hpp:12
        I(cpphdl_n2661, Vss) <+ cpphdl_channel(V(BIT_N15_3, Vss), V(cpphdl_n2661, Vss), 0.080000000000000002, 0.69999999999999996, 1.0);
        // device 2093, IC IC364, analog/basic/mos_r2r_dac.hpp:27
        I(cpphdl_n2661, Vss) <+ 2.9999999999999998e-15 * ddt(V(cpphdl_n2661, Vss)); // Bench initial voltage = 0.0 V.
        // device 2094, IC IC364, analog/basic/mos_r2r_dac.hpp:28
        I(cpphdl_n2661, cpphdl_n2681) <+ V(cpphdl_n2661, cpphdl_n2681) / 2000.0;
        // device 2095, IC IC364, analog/basic/mos_r2r_dac.hpp:29
        I(cpphdl_n2681, Vss) <+ 2.9999999999999998e-15 * ddt(V(cpphdl_n2681, Vss)); // Bench initial voltage = 0.0 V.
        // device 2096, IC IC364, analog/basic/mos_r2r_dac.hpp:31
        I(cpphdl_n2680, cpphdl_n2681) <+ V(cpphdl_n2680, cpphdl_n2681) / 1000.0;
        // device 2097, IC IC369, analog/basic/inverter.hpp:11
        I(cpphdl_n2665, Vdd) <+ cpphdl_channel(V(BIT_N15_4, Vdd), V(cpphdl_n2665, Vdd), 0.080000000000000002, 0.69999999999999996, -1.0);
        // device 2098, IC IC369, analog/basic/inverter.hpp:12
        I(cpphdl_n2665, Vss) <+ cpphdl_channel(V(BIT_N15_4, Vss), V(cpphdl_n2665, Vss), 0.080000000000000002, 0.69999999999999996, 1.0);
        // device 2099, IC IC364, analog/basic/mos_r2r_dac.hpp:27
        I(cpphdl_n2665, Vss) <+ 2.9999999999999998e-15 * ddt(V(cpphdl_n2665, Vss)); // Bench initial voltage = 0.0 V.
        // device 2100, IC IC364, analog/basic/mos_r2r_dac.hpp:28
        I(cpphdl_n2665, cpphdl_n2682) <+ V(cpphdl_n2665, cpphdl_n2682) / 2000.0;
        // device 2101, IC IC364, analog/basic/mos_r2r_dac.hpp:29
        I(cpphdl_n2682, Vss) <+ 2.9999999999999998e-15 * ddt(V(cpphdl_n2682, Vss)); // Bench initial voltage = 0.0 V.
        // device 2102, IC IC364, analog/basic/mos_r2r_dac.hpp:31
        I(cpphdl_n2681, cpphdl_n2682) <+ V(cpphdl_n2681, cpphdl_n2682) / 1000.0;
        // device 2103, IC IC370, analog/basic/inverter.hpp:11
        I(cpphdl_n2669, Vdd) <+ cpphdl_channel(V(BIT_N15_5, Vdd), V(cpphdl_n2669, Vdd), 0.080000000000000002, 0.69999999999999996, -1.0);
        // device 2104, IC IC370, analog/basic/inverter.hpp:12
        I(cpphdl_n2669, Vss) <+ cpphdl_channel(V(BIT_N15_5, Vss), V(cpphdl_n2669, Vss), 0.080000000000000002, 0.69999999999999996, 1.0);
        // device 2105, IC IC364, analog/basic/mos_r2r_dac.hpp:27
        I(cpphdl_n2669, Vss) <+ 2.9999999999999998e-15 * ddt(V(cpphdl_n2669, Vss)); // Bench initial voltage = 0.0 V.
        // device 2106, IC IC364, analog/basic/mos_r2r_dac.hpp:28
        I(cpphdl_n2669, cpphdl_n2683) <+ V(cpphdl_n2669, cpphdl_n2683) / 2000.0;
        // device 2107, IC IC364, analog/basic/mos_r2r_dac.hpp:29
        I(cpphdl_n2683, Vss) <+ 2.9999999999999998e-15 * ddt(V(cpphdl_n2683, Vss)); // Bench initial voltage = 0.0 V.
        // device 2108, IC IC364, analog/basic/mos_r2r_dac.hpp:31
        I(cpphdl_n2682, cpphdl_n2683) <+ V(cpphdl_n2682, cpphdl_n2683) / 1000.0;
        // device 2109, IC IC371, analog/basic/inverter.hpp:11
        I(cpphdl_n2673, Vdd) <+ cpphdl_channel(V(BIT_N15_6, Vdd), V(cpphdl_n2673, Vdd), 0.080000000000000002, 0.69999999999999996, -1.0);
        // device 2110, IC IC371, analog/basic/inverter.hpp:12
        I(cpphdl_n2673, Vss) <+ cpphdl_channel(V(BIT_N15_6, Vss), V(cpphdl_n2673, Vss), 0.080000000000000002, 0.69999999999999996, 1.0);
        // device 2111, IC IC364, analog/basic/mos_r2r_dac.hpp:27
        I(cpphdl_n2673, Vss) <+ 2.9999999999999998e-15 * ddt(V(cpphdl_n2673, Vss)); // Bench initial voltage = 0.0 V.
        // device 2112, IC IC364, analog/basic/mos_r2r_dac.hpp:28
        I(cpphdl_n2673, cpphdl_n2684) <+ V(cpphdl_n2673, cpphdl_n2684) / 2000.0;
        // device 2113, IC IC364, analog/basic/mos_r2r_dac.hpp:29
        I(cpphdl_n2684, Vss) <+ 2.9999999999999998e-15 * ddt(V(cpphdl_n2684, Vss)); // Bench initial voltage = 0.0 V.
        // device 2114, IC IC364, analog/basic/mos_r2r_dac.hpp:31
        I(cpphdl_n2683, cpphdl_n2684) <+ V(cpphdl_n2683, cpphdl_n2684) / 1000.0;
        // device 2115, IC IC372, analog/basic/inverter.hpp:11
        I(cpphdl_n2677, Vdd) <+ cpphdl_channel(V(BIT_N15_7, Vdd), V(cpphdl_n2677, Vdd), 0.080000000000000002, 0.69999999999999996, -1.0);
        // device 2116, IC IC372, analog/basic/inverter.hpp:12
        I(cpphdl_n2677, Vss) <+ cpphdl_channel(V(BIT_N15_7, Vss), V(cpphdl_n2677, Vss), 0.080000000000000002, 0.69999999999999996, 1.0);
        // device 2117, IC IC364, analog/basic/mos_r2r_dac.hpp:27
        I(cpphdl_n2677, Vss) <+ 2.9999999999999998e-15 * ddt(V(cpphdl_n2677, Vss)); // Bench initial voltage = 0.0 V.
        // device 2118, IC IC364, analog/basic/mos_r2r_dac.hpp:28
        I(cpphdl_n2677, cpphdl_n2689) <+ V(cpphdl_n2677, cpphdl_n2689) / 2000.0;
        // device 2119, IC IC364, analog/basic/mos_r2r_dac.hpp:29
        I(cpphdl_n2689, Vss) <+ 2.9999999999999998e-15 * ddt(V(cpphdl_n2689, Vss)); // Bench initial voltage = 0.0 V.
        // device 2120, IC IC364, analog/basic/mos_r2r_dac.hpp:31
        I(cpphdl_n2684, cpphdl_n2689) <+ V(cpphdl_n2684, cpphdl_n2689) / 1000.0;
        // device 2121, IC IC364, analog/basic/mos_r2r_dac.hpp:33
        I(Vss, cpphdl_n2678) <+ V(Vss, cpphdl_n2678) / 2000.0;
        // device 2122, IC IC373, analog/basic/nmos_resistor_amplifier.hpp:23
        I(Vdd, cpphdl_n2698) <+ V(Vdd, cpphdl_n2698) / 1000.0;
        // device 2123, IC IC373, analog/basic/nmos_resistor_amplifier.hpp:24
        I(Vdd, cpphdl_n2697) <+ V(Vdd, cpphdl_n2697) / 1000.0;
        // device 2124, IC IC373, analog/basic/nmos_resistor_amplifier.hpp:25
        I(cpphdl_n2698, cpphdl_n2692) <+ cpphdl_channel(V(cpphdl_n2688, cpphdl_n2692), V(cpphdl_n2698, cpphdl_n2692), 0.0074999999999999997, 0.69999999999999996, 1.0);
        // device 2125, IC IC373, analog/basic/nmos_resistor_amplifier.hpp:26
        I(cpphdl_n2697, cpphdl_n2693) <+ cpphdl_channel(V(cpphdl_n2689, cpphdl_n2693), V(cpphdl_n2697, cpphdl_n2693), 0.0074999999999999997, 0.69999999999999996, 1.0);
        // device 2126, IC IC373, analog/basic/nmos_resistor_amplifier.hpp:27
        I(cpphdl_n2694, cpphdl_n2692) <+ V(cpphdl_n2694, cpphdl_n2692) / 100.0;
        // device 2127, IC IC373, analog/basic/nmos_resistor_amplifier.hpp:28
        I(cpphdl_n2694, cpphdl_n2693) <+ V(cpphdl_n2694, cpphdl_n2693) / 100.0;
        // device 2128, IC IC373, analog/basic/nmos_resistor_amplifier.hpp:29
        I(Vss, cpphdl_n2694) <+ V(Vss, cpphdl_n2694) / 300.0;
        // device 2129, IC IC373, analog/basic/nmos_resistor_amplifier.hpp:30
        I(cpphdl_n2698, Vdd) <+ 2.9999999999999998e-13 * ddt(V(cpphdl_n2698, Vdd)); // Bench initial voltage = 0.0 V.
        // device 2130, IC IC373, analog/basic/nmos_resistor_amplifier.hpp:31
        I(cpphdl_n2697, Vdd) <+ 2.9999999999999998e-13 * ddt(V(cpphdl_n2697, Vdd)); // Bench initial voltage = 0.0 V.
        // device 2131, IC IC373, analog/basic/nmos_resistor_amplifier.hpp:32
        I(cpphdl_n2694, Vss) <+ 4e-14 * ddt(V(cpphdl_n2694, Vss)); // Bench initial voltage = 0.0 V.
        // device 2132, IC IC373, analog/basic/nmos_resistor_amplifier.hpp:34
        I(cpphdl_n2688, cpphdl_n2692) <+ 2e-14 * ddt(V(cpphdl_n2688, cpphdl_n2692)); // Bench initial voltage = 0.0 V.
        // device 2133, IC IC373, analog/basic/nmos_resistor_amplifier.hpp:35
        I(cpphdl_n2689, cpphdl_n2693) <+ 2e-14 * ddt(V(cpphdl_n2689, cpphdl_n2693)); // Bench initial voltage = 0.0 V.
        // device 2134, IC IC373, analog/basic/nmos_resistor_amplifier.hpp:36
        I(cpphdl_n2688, cpphdl_n2698) <+ 2.9999999999999998e-15 * ddt(V(cpphdl_n2688, cpphdl_n2698)); // Bench initial voltage = 0.0 V.
        // device 2135, IC IC373, analog/basic/nmos_resistor_amplifier.hpp:37
        I(cpphdl_n2689, cpphdl_n2697) <+ 2.9999999999999998e-15 * ddt(V(cpphdl_n2689, cpphdl_n2697)); // Bench initial voltage = 0.0 V.
        // device 2136, IC IC374, analog/basic/strongarm_comparator.hpp:28
        I(cpphdl_n2702, cpphdl_n2704) <+ cpphdl_channel(V(cpphdl_n2697, cpphdl_n2704), V(cpphdl_n2702, cpphdl_n2704), 0.0080000000000000002, 0.69999999999999996, 1.0);
        // device 2137, IC IC374, analog/basic/strongarm_comparator.hpp:29
        I(cpphdl_n2703, cpphdl_n2704) <+ cpphdl_channel(V(cpphdl_n2698, cpphdl_n2704), V(cpphdl_n2703, cpphdl_n2704), 0.0080000000000000002, 0.69999999999999996, 1.0);
        // device 2138, IC IC374, analog/basic/strongarm_comparator.hpp:30
        I(cpphdl_n2704, Vss) <+ cpphdl_channel(V(EVALUATE, Vss), V(cpphdl_n2704, Vss), 0.0080000000000000002, 0.69999999999999996, 1.0);
        // device 2139, IC IC374, analog/basic/strongarm_comparator.hpp:33
        I(cpphdl_n2717, cpphdl_n2702) <+ cpphdl_channel(V(cpphdl_n2721, cpphdl_n2702), V(cpphdl_n2717, cpphdl_n2702), 0.0040000000000000001, 0.69999999999999996, 1.0);
        // device 2140, IC IC374, analog/basic/strongarm_comparator.hpp:34
        I(cpphdl_n2721, cpphdl_n2703) <+ cpphdl_channel(V(cpphdl_n2717, cpphdl_n2703), V(cpphdl_n2721, cpphdl_n2703), 0.0040000000000000001, 0.69999999999999996, 1.0);
        // device 2141, IC IC374, analog/basic/strongarm_comparator.hpp:35
        I(cpphdl_n2721, Vdd) <+ cpphdl_channel(V(cpphdl_n2717, Vdd), V(cpphdl_n2721, Vdd), 0.002, 0.69999999999999996, -1.0);
        // device 2142, IC IC374, analog/basic/strongarm_comparator.hpp:36
        I(cpphdl_n2717, Vdd) <+ cpphdl_channel(V(cpphdl_n2721, Vdd), V(cpphdl_n2717, Vdd), 0.002, 0.69999999999999996, -1.0);
        // device 2143, IC IC374, analog/basic/strongarm_comparator.hpp:38
        I(cpphdl_n2702, Vdd) <+ cpphdl_channel(V(EVALUATE, Vdd), V(cpphdl_n2702, Vdd), 0.002, 0.69999999999999996, -1.0);
        // device 2144, IC IC374, analog/basic/strongarm_comparator.hpp:39
        I(cpphdl_n2703, Vdd) <+ cpphdl_channel(V(EVALUATE, Vdd), V(cpphdl_n2703, Vdd), 0.002, 0.69999999999999996, -1.0);
        // device 2145, IC IC374, analog/basic/strongarm_comparator.hpp:40
        I(cpphdl_n2721, Vdd) <+ cpphdl_channel(V(EVALUATE, Vdd), V(cpphdl_n2721, Vdd), 0.002, 0.69999999999999996, -1.0);
        // device 2146, IC IC374, analog/basic/strongarm_comparator.hpp:41
        I(cpphdl_n2717, Vdd) <+ cpphdl_channel(V(EVALUATE, Vdd), V(cpphdl_n2717, Vdd), 0.002, 0.69999999999999996, -1.0);
        // device 2147, IC IC374, analog/basic/strongarm_comparator.hpp:42
        I(cpphdl_n2702, Vss) <+ 2.9999999999999998e-14 * ddt(V(cpphdl_n2702, Vss)); // Bench initial voltage = 0.0 V.
        // device 2148, IC IC374, analog/basic/strongarm_comparator.hpp:43
        I(cpphdl_n2703, Vss) <+ 2.9999999999999998e-14 * ddt(V(cpphdl_n2703, Vss)); // Bench initial voltage = 0.0 V.
        // device 2149, IC IC374, analog/basic/strongarm_comparator.hpp:44
        I(cpphdl_n2704, Vss) <+ 2.9999999999999998e-14 * ddt(V(cpphdl_n2704, Vss)); // Bench initial voltage = 0.0 V.
        // device 2150, IC IC374, analog/basic/strongarm_comparator.hpp:45
        I(cpphdl_n2721, Vss) <+ 5.0000000000000002e-14 * ddt(V(cpphdl_n2721, Vss)); // Bench initial voltage = 0.0 V.
        // device 2151, IC IC374, analog/basic/strongarm_comparator.hpp:46
        I(cpphdl_n2717, Vss) <+ 5.0000000000000002e-14 * ddt(V(cpphdl_n2717, Vss)); // Bench initial voltage = 0.0 V.
        // device 2152, IC IC374, analog/basic/strongarm_comparator.hpp:47
        I(cpphdl_n2697, cpphdl_n2704) <+ 2e-14 * ddt(V(cpphdl_n2697, cpphdl_n2704)); // Bench initial voltage = 0.0 V.
        // device 2153, IC IC374, analog/basic/strongarm_comparator.hpp:48
        I(cpphdl_n2698, cpphdl_n2704) <+ 2e-14 * ddt(V(cpphdl_n2698, cpphdl_n2704)); // Bench initial voltage = 0.0 V.
        // device 2154, IC IC374, analog/basic/strongarm_comparator.hpp:49
        I(cpphdl_n2697, cpphdl_n2702) <+ 2.9999999999999998e-15 * ddt(V(cpphdl_n2697, cpphdl_n2702)); // Bench initial voltage = 0.0 V.
        // device 2155, IC IC374, analog/basic/strongarm_comparator.hpp:50
        I(cpphdl_n2698, cpphdl_n2703) <+ 2.9999999999999998e-15 * ddt(V(cpphdl_n2698, cpphdl_n2703)); // Bench initial voltage = 0.0 V.
        // device 2156, IC IC376, analog/basic/inverter.hpp:11
        I(cpphdl_n2725, Vdd) <+ cpphdl_channel(V(cpphdl_n2717, Vdd), V(cpphdl_n2725, Vdd), 0.001, 0.69999999999999996, -1.0);
        // device 2157, IC IC376, analog/basic/inverter.hpp:12
        I(cpphdl_n2725, Vss) <+ cpphdl_channel(V(cpphdl_n2717, Vss), V(cpphdl_n2725, Vss), 0.001, 0.69999999999999996, 1.0);
        // device 2158, IC IC378, analog/basic/inverter.hpp:11
        I(cpphdl_n2739, Vdd) <+ cpphdl_channel(V(cpphdl_n2725, Vdd), V(cpphdl_n2739, Vdd), 0.0040000000000000001, 0.69999999999999996, -1.0);
        // device 2159, IC IC378, analog/basic/inverter.hpp:12
        I(cpphdl_n2739, Vss) <+ cpphdl_channel(V(cpphdl_n2725, Vss), V(cpphdl_n2739, Vss), 0.0040000000000000001, 0.69999999999999996, 1.0);
        // device 2160, IC IC375, analog/basic/buffered_nand_latch.hpp:34
        I(cpphdl_n2717, Vss) <+ 2.0000000000000002e-15 * ddt(V(cpphdl_n2717, Vss)); // Bench initial voltage = 0.0 V.
        // device 2161, IC IC375, analog/basic/buffered_nand_latch.hpp:35
        I(cpphdl_n2717, cpphdl_n2725) <+ 1.0000000000000001e-15 * ddt(V(cpphdl_n2717, cpphdl_n2725)); // Bench initial voltage = 0.0 V.
        // device 2162, IC IC375, analog/basic/buffered_nand_latch.hpp:36
        I(cpphdl_n2725, Vss) <+ 5e-15 * ddt(V(cpphdl_n2725, Vss)); // Bench initial voltage = 0.0 V.
        // device 2163, IC IC375, analog/basic/buffered_nand_latch.hpp:37
        I(cpphdl_n2725, Vss) <+ 8.0000000000000006e-15 * ddt(V(cpphdl_n2725, Vss)); // Bench initial voltage = 0.0 V.
        // device 2164, IC IC375, analog/basic/buffered_nand_latch.hpp:38
        I(cpphdl_n2739, Vss) <+ 1e-14 * ddt(V(cpphdl_n2739, Vss)); // Bench initial voltage = 0.0 V.
        // device 2165, IC IC377, analog/basic/inverter.hpp:11
        I(cpphdl_n2729, Vdd) <+ cpphdl_channel(V(cpphdl_n2721, Vdd), V(cpphdl_n2729, Vdd), 0.001, 0.69999999999999996, -1.0);
        // device 2166, IC IC377, analog/basic/inverter.hpp:12
        I(cpphdl_n2729, Vss) <+ cpphdl_channel(V(cpphdl_n2721, Vss), V(cpphdl_n2729, Vss), 0.001, 0.69999999999999996, 1.0);
        // device 2167, IC IC379, analog/basic/inverter.hpp:11
        I(cpphdl_n2745, Vdd) <+ cpphdl_channel(V(cpphdl_n2729, Vdd), V(cpphdl_n2745, Vdd), 0.0040000000000000001, 0.69999999999999996, -1.0);
        // device 2168, IC IC379, analog/basic/inverter.hpp:12
        I(cpphdl_n2745, Vss) <+ cpphdl_channel(V(cpphdl_n2729, Vss), V(cpphdl_n2745, Vss), 0.0040000000000000001, 0.69999999999999996, 1.0);
        // device 2169, IC IC375, analog/basic/buffered_nand_latch.hpp:34
        I(cpphdl_n2721, Vss) <+ 2.0000000000000002e-15 * ddt(V(cpphdl_n2721, Vss)); // Bench initial voltage = 0.0 V.
        // device 2170, IC IC375, analog/basic/buffered_nand_latch.hpp:35
        I(cpphdl_n2721, cpphdl_n2729) <+ 1.0000000000000001e-15 * ddt(V(cpphdl_n2721, cpphdl_n2729)); // Bench initial voltage = 0.0 V.
        // device 2171, IC IC375, analog/basic/buffered_nand_latch.hpp:36
        I(cpphdl_n2729, Vss) <+ 5e-15 * ddt(V(cpphdl_n2729, Vss)); // Bench initial voltage = 0.0 V.
        // device 2172, IC IC375, analog/basic/buffered_nand_latch.hpp:37
        I(cpphdl_n2729, Vss) <+ 8.0000000000000006e-15 * ddt(V(cpphdl_n2729, Vss)); // Bench initial voltage = 0.0 V.
        // device 2173, IC IC375, analog/basic/buffered_nand_latch.hpp:38
        I(cpphdl_n2745, Vss) <+ 1e-14 * ddt(V(cpphdl_n2745, Vss)); // Bench initial voltage = 0.0 V.
        // device 2174, IC IC381, analog/basic/cmos_logic.hpp:17
        I(cpphdl_n2848, Vss) <+ 5.0000000000000002e-14 * ddt(V(cpphdl_n2848, Vss)); // Bench initial voltage = 0.0 V.
        // device 2175, IC IC381, analog/basic/cmos_logic.hpp:18
        I(cpphdl_n2848, Vdd) <+ cpphdl_channel(V(cpphdl_n2739, Vdd), V(cpphdl_n2848, Vdd), 0.01, 0.69999999999999996, -1.0);
        // device 2176, IC IC381, analog/basic/cmos_logic.hpp:19
        I(cpphdl_n2848, Vdd) <+ cpphdl_channel(V(cpphdl_n2747, Vdd), V(cpphdl_n2848, Vdd), 0.01, 0.69999999999999996, -1.0);
        // device 2177, IC IC381, analog/basic/cmos_logic.hpp:20
        I(cpphdl_n2848, cpphdl_n2742) <+ cpphdl_channel(V(cpphdl_n2739, cpphdl_n2742), V(cpphdl_n2848, cpphdl_n2742), 0.01, 0.69999999999999996, 1.0);
        // device 2178, IC IC381, analog/basic/cmos_logic.hpp:21
        I(cpphdl_n2742, Vss) <+ cpphdl_channel(V(cpphdl_n2747, Vss), V(cpphdl_n2742, Vss), 0.01, 0.69999999999999996, 1.0);
        // device 2179, IC IC381, analog/basic/cmos_logic.hpp:27
        I(cpphdl_n2742, Vss) <+ 1e-14 * ddt(V(cpphdl_n2742, Vss)); // Bench initial voltage = 0.0 V.
        // device 2180, IC IC382, analog/basic/cmos_logic.hpp:17
        I(cpphdl_n2747, Vss) <+ 5.0000000000000002e-14 * ddt(V(cpphdl_n2747, Vss)); // Bench initial voltage = 0.0 V.
        // device 2181, IC IC382, analog/basic/cmos_logic.hpp:18
        I(cpphdl_n2747, Vdd) <+ cpphdl_channel(V(cpphdl_n2745, Vdd), V(cpphdl_n2747, Vdd), 0.01, 0.69999999999999996, -1.0);
        // device 2182, IC IC382, analog/basic/cmos_logic.hpp:19
        I(cpphdl_n2747, Vdd) <+ cpphdl_channel(V(cpphdl_n2848, Vdd), V(cpphdl_n2747, Vdd), 0.01, 0.69999999999999996, -1.0);
        // device 2183, IC IC382, analog/basic/cmos_logic.hpp:20
        I(cpphdl_n2747, cpphdl_n2748) <+ cpphdl_channel(V(cpphdl_n2745, cpphdl_n2748), V(cpphdl_n2747, cpphdl_n2748), 0.01, 0.69999999999999996, 1.0);
        // device 2184, IC IC382, analog/basic/cmos_logic.hpp:21
        I(cpphdl_n2748, Vss) <+ cpphdl_channel(V(cpphdl_n2848, Vss), V(cpphdl_n2748, Vss), 0.01, 0.69999999999999996, 1.0);
        // device 2185, IC IC382, analog/basic/cmos_logic.hpp:27
        I(cpphdl_n2748, Vss) <+ 1e-14 * ddt(V(cpphdl_n2748, Vss)); // Bench initial voltage = 0.0 V.
        // device 2186, IC IC380, analog/basic/nand_latch.hpp:36
        I(cpphdl_n2739, Vss) <+ 2.9999999999999998e-15 * ddt(V(cpphdl_n2739, Vss)); // Bench initial voltage = 0.0 V.
        // device 2187, IC IC380, analog/basic/nand_latch.hpp:37
        I(cpphdl_n2745, Vss) <+ 2.9999999999999998e-15 * ddt(V(cpphdl_n2745, Vss)); // Bench initial voltage = 0.0 V.
        // device 2188, IC IC383, analog/basic/inverter.hpp:11
        I(cpphdl_n2753, Vdd) <+ cpphdl_channel(V(CLEAR, Vdd), V(cpphdl_n2753, Vdd), 0.01, 0.69999999999999996, -1.0);
        // device 2189, IC IC383, analog/basic/inverter.hpp:12
        I(cpphdl_n2753, Vss) <+ cpphdl_channel(V(CLEAR, Vss), V(cpphdl_n2753, Vss), 0.01, 0.69999999999999996, 1.0);
        // device 2190, IC IC380, analog/basic/nand_latch.hpp:58
        I(cpphdl_n2753, Vss) <+ 2.9999999999999998e-15 * ddt(V(cpphdl_n2753, Vss)); // Bench initial voltage = 0.0 V.
        // device 2191, IC IC380, analog/basic/nand_latch.hpp:59
        I(cpphdl_n2848, Vss) <+ cpphdl_channel(V(CLEAR, Vss), V(cpphdl_n2848, Vss), 0.050000000000000003, 0.69999999999999996, 1.0);
        // device 2192, IC IC380, analog/basic/nand_latch.hpp:60
        I(cpphdl_n2747, Vdd) <+ cpphdl_channel(V(cpphdl_n2753, Vdd), V(cpphdl_n2747, Vdd), 0.050000000000000003, 0.69999999999999996, -1.0);
        // device 2193, IC IC384, analog/basic/level_down.hpp:23
        I(cpphdl_n2775, Vlogic) <+ cpphdl_channel(V(Vss, Vlogic), V(cpphdl_n2775, Vlogic), 0.00050000000000000001, 0.34999999999999998, -1.0);
        // device 2194, IC IC384, analog/basic/level_down.hpp:24
        I(cpphdl_n2775, Vss) <+ cpphdl_channel(V(cpphdl_n2773, Vss), V(cpphdl_n2775, Vss), 0.0040000000000000001, 0.69999999999999996, 1.0);
        // device 2195, IC IC384, analog/basic/level_down.hpp:25
        I(CORE_DECISION0, Vlogic) <+ cpphdl_channel(V(cpphdl_n2775, Vlogic), V(CORE_DECISION0, Vlogic), 0.0050000000000000001, 0.34999999999999998, -1.0);
        // device 2196, IC IC384, analog/basic/level_down.hpp:26
        I(CORE_DECISION0, Vss) <+ cpphdl_channel(V(cpphdl_n2775, Vss), V(CORE_DECISION0, Vss), 0.01, 0.34999999999999998, 1.0);
        // device 2197, IC IC384, analog/basic/level_down.hpp:27
        I(cpphdl_n2773, Vss) <+ 5e-15 * ddt(V(cpphdl_n2773, Vss)); // Bench initial voltage = 0.0 V.
        // device 2198, IC IC384, analog/basic/level_down.hpp:28
        I(cpphdl_n2773, Vlogic) <+ 5e-15 * ddt(V(cpphdl_n2773, Vlogic)); // Bench initial voltage = 0.0 V.
        // device 2199, IC IC384, analog/basic/level_down.hpp:29
        I(cpphdl_n2773, cpphdl_n2775) <+ 2.0000000000000002e-15 * ddt(V(cpphdl_n2773, cpphdl_n2775)); // Bench initial voltage = 0.0 V.
        // device 2200, IC IC384, analog/basic/level_down.hpp:30
        I(cpphdl_n2775, Vss) <+ 8e-14 * ddt(V(cpphdl_n2775, Vss)); // Bench initial voltage = 0.0 V.
        // device 2201, IC IC384, analog/basic/level_down.hpp:31
        I(cpphdl_n2775, Vlogic) <+ 5e-15 * ddt(V(cpphdl_n2775, Vlogic)); // Bench initial voltage = 0.0 V.
        // device 2202, IC IC384, analog/basic/level_down.hpp:32
        I(cpphdl_n2775, CORE_DECISION0) <+ 2.0000000000000002e-15 * ddt(V(cpphdl_n2775, CORE_DECISION0)); // Bench initial voltage = 0.0 V.
        // device 2203, IC IC384, analog/basic/level_down.hpp:33
        I(CORE_DECISION0, Vss) <+ 1e-14 * ddt(V(CORE_DECISION0, Vss)); // Bench initial voltage = 0.0 V.
        // device 2204, IC IC385, analog/basic/level_down.hpp:23
        I(cpphdl_n2780, Vlogic) <+ cpphdl_channel(V(Vss, Vlogic), V(cpphdl_n2780, Vlogic), 0.00050000000000000001, 0.34999999999999998, -1.0);
        // device 2205, IC IC385, analog/basic/level_down.hpp:24
        I(cpphdl_n2780, Vss) <+ cpphdl_channel(V(cpphdl_n2778, Vss), V(cpphdl_n2780, Vss), 0.0040000000000000001, 0.69999999999999996, 1.0);
        // device 2206, IC IC385, analog/basic/level_down.hpp:25
        I(CORE_DECISION1, Vlogic) <+ cpphdl_channel(V(cpphdl_n2780, Vlogic), V(CORE_DECISION1, Vlogic), 0.0050000000000000001, 0.34999999999999998, -1.0);
        // device 2207, IC IC385, analog/basic/level_down.hpp:26
        I(CORE_DECISION1, Vss) <+ cpphdl_channel(V(cpphdl_n2780, Vss), V(CORE_DECISION1, Vss), 0.01, 0.34999999999999998, 1.0);
        // device 2208, IC IC385, analog/basic/level_down.hpp:27
        I(cpphdl_n2778, Vss) <+ 5e-15 * ddt(V(cpphdl_n2778, Vss)); // Bench initial voltage = 0.0 V.
        // device 2209, IC IC385, analog/basic/level_down.hpp:28
        I(cpphdl_n2778, Vlogic) <+ 5e-15 * ddt(V(cpphdl_n2778, Vlogic)); // Bench initial voltage = 0.0 V.
        // device 2210, IC IC385, analog/basic/level_down.hpp:29
        I(cpphdl_n2778, cpphdl_n2780) <+ 2.0000000000000002e-15 * ddt(V(cpphdl_n2778, cpphdl_n2780)); // Bench initial voltage = 0.0 V.
        // device 2211, IC IC385, analog/basic/level_down.hpp:30
        I(cpphdl_n2780, Vss) <+ 8e-14 * ddt(V(cpphdl_n2780, Vss)); // Bench initial voltage = 0.0 V.
        // device 2212, IC IC385, analog/basic/level_down.hpp:31
        I(cpphdl_n2780, Vlogic) <+ 5e-15 * ddt(V(cpphdl_n2780, Vlogic)); // Bench initial voltage = 0.0 V.
        // device 2213, IC IC385, analog/basic/level_down.hpp:32
        I(cpphdl_n2780, CORE_DECISION1) <+ 2.0000000000000002e-15 * ddt(V(cpphdl_n2780, CORE_DECISION1)); // Bench initial voltage = 0.0 V.
        // device 2214, IC IC385, analog/basic/level_down.hpp:33
        I(CORE_DECISION1, Vss) <+ 1e-14 * ddt(V(CORE_DECISION1, Vss)); // Bench initial voltage = 0.0 V.
        // device 2215, IC IC386, analog/basic/level_down.hpp:23
        I(cpphdl_n2785, Vlogic) <+ cpphdl_channel(V(Vss, Vlogic), V(cpphdl_n2785, Vlogic), 0.00050000000000000001, 0.34999999999999998, -1.0);
        // device 2216, IC IC386, analog/basic/level_down.hpp:24
        I(cpphdl_n2785, Vss) <+ cpphdl_channel(V(cpphdl_n2783, Vss), V(cpphdl_n2785, Vss), 0.0040000000000000001, 0.69999999999999996, 1.0);
        // device 2217, IC IC386, analog/basic/level_down.hpp:25
        I(CORE_DECISION2, Vlogic) <+ cpphdl_channel(V(cpphdl_n2785, Vlogic), V(CORE_DECISION2, Vlogic), 0.0050000000000000001, 0.34999999999999998, -1.0);
        // device 2218, IC IC386, analog/basic/level_down.hpp:26
        I(CORE_DECISION2, Vss) <+ cpphdl_channel(V(cpphdl_n2785, Vss), V(CORE_DECISION2, Vss), 0.01, 0.34999999999999998, 1.0);
        // device 2219, IC IC386, analog/basic/level_down.hpp:27
        I(cpphdl_n2783, Vss) <+ 5e-15 * ddt(V(cpphdl_n2783, Vss)); // Bench initial voltage = 0.0 V.
        // device 2220, IC IC386, analog/basic/level_down.hpp:28
        I(cpphdl_n2783, Vlogic) <+ 5e-15 * ddt(V(cpphdl_n2783, Vlogic)); // Bench initial voltage = 0.0 V.
        // device 2221, IC IC386, analog/basic/level_down.hpp:29
        I(cpphdl_n2783, cpphdl_n2785) <+ 2.0000000000000002e-15 * ddt(V(cpphdl_n2783, cpphdl_n2785)); // Bench initial voltage = 0.0 V.
        // device 2222, IC IC386, analog/basic/level_down.hpp:30
        I(cpphdl_n2785, Vss) <+ 8e-14 * ddt(V(cpphdl_n2785, Vss)); // Bench initial voltage = 0.0 V.
        // device 2223, IC IC386, analog/basic/level_down.hpp:31
        I(cpphdl_n2785, Vlogic) <+ 5e-15 * ddt(V(cpphdl_n2785, Vlogic)); // Bench initial voltage = 0.0 V.
        // device 2224, IC IC386, analog/basic/level_down.hpp:32
        I(cpphdl_n2785, CORE_DECISION2) <+ 2.0000000000000002e-15 * ddt(V(cpphdl_n2785, CORE_DECISION2)); // Bench initial voltage = 0.0 V.
        // device 2225, IC IC386, analog/basic/level_down.hpp:33
        I(CORE_DECISION2, Vss) <+ 1e-14 * ddt(V(CORE_DECISION2, Vss)); // Bench initial voltage = 0.0 V.
        // device 2226, IC IC387, analog/basic/level_down.hpp:23
        I(cpphdl_n2790, Vlogic) <+ cpphdl_channel(V(Vss, Vlogic), V(cpphdl_n2790, Vlogic), 0.00050000000000000001, 0.34999999999999998, -1.0);
        // device 2227, IC IC387, analog/basic/level_down.hpp:24
        I(cpphdl_n2790, Vss) <+ cpphdl_channel(V(cpphdl_n2788, Vss), V(cpphdl_n2790, Vss), 0.0040000000000000001, 0.69999999999999996, 1.0);
        // device 2228, IC IC387, analog/basic/level_down.hpp:25
        I(CORE_DECISION3, Vlogic) <+ cpphdl_channel(V(cpphdl_n2790, Vlogic), V(CORE_DECISION3, Vlogic), 0.0050000000000000001, 0.34999999999999998, -1.0);
        // device 2229, IC IC387, analog/basic/level_down.hpp:26
        I(CORE_DECISION3, Vss) <+ cpphdl_channel(V(cpphdl_n2790, Vss), V(CORE_DECISION3, Vss), 0.01, 0.34999999999999998, 1.0);
        // device 2230, IC IC387, analog/basic/level_down.hpp:27
        I(cpphdl_n2788, Vss) <+ 5e-15 * ddt(V(cpphdl_n2788, Vss)); // Bench initial voltage = 0.0 V.
        // device 2231, IC IC387, analog/basic/level_down.hpp:28
        I(cpphdl_n2788, Vlogic) <+ 5e-15 * ddt(V(cpphdl_n2788, Vlogic)); // Bench initial voltage = 0.0 V.
        // device 2232, IC IC387, analog/basic/level_down.hpp:29
        I(cpphdl_n2788, cpphdl_n2790) <+ 2.0000000000000002e-15 * ddt(V(cpphdl_n2788, cpphdl_n2790)); // Bench initial voltage = 0.0 V.
        // device 2233, IC IC387, analog/basic/level_down.hpp:30
        I(cpphdl_n2790, Vss) <+ 8e-14 * ddt(V(cpphdl_n2790, Vss)); // Bench initial voltage = 0.0 V.
        // device 2234, IC IC387, analog/basic/level_down.hpp:31
        I(cpphdl_n2790, Vlogic) <+ 5e-15 * ddt(V(cpphdl_n2790, Vlogic)); // Bench initial voltage = 0.0 V.
        // device 2235, IC IC387, analog/basic/level_down.hpp:32
        I(cpphdl_n2790, CORE_DECISION3) <+ 2.0000000000000002e-15 * ddt(V(cpphdl_n2790, CORE_DECISION3)); // Bench initial voltage = 0.0 V.
        // device 2236, IC IC387, analog/basic/level_down.hpp:33
        I(CORE_DECISION3, Vss) <+ 1e-14 * ddt(V(CORE_DECISION3, Vss)); // Bench initial voltage = 0.0 V.
        // device 2237, IC IC388, analog/basic/level_down.hpp:23
        I(cpphdl_n2795, Vlogic) <+ cpphdl_channel(V(Vss, Vlogic), V(cpphdl_n2795, Vlogic), 0.00050000000000000001, 0.34999999999999998, -1.0);
        // device 2238, IC IC388, analog/basic/level_down.hpp:24
        I(cpphdl_n2795, Vss) <+ cpphdl_channel(V(cpphdl_n2793, Vss), V(cpphdl_n2795, Vss), 0.0040000000000000001, 0.69999999999999996, 1.0);
        // device 2239, IC IC388, analog/basic/level_down.hpp:25
        I(CORE_DECISION4, Vlogic) <+ cpphdl_channel(V(cpphdl_n2795, Vlogic), V(CORE_DECISION4, Vlogic), 0.0050000000000000001, 0.34999999999999998, -1.0);
        // device 2240, IC IC388, analog/basic/level_down.hpp:26
        I(CORE_DECISION4, Vss) <+ cpphdl_channel(V(cpphdl_n2795, Vss), V(CORE_DECISION4, Vss), 0.01, 0.34999999999999998, 1.0);
        // device 2241, IC IC388, analog/basic/level_down.hpp:27
        I(cpphdl_n2793, Vss) <+ 5e-15 * ddt(V(cpphdl_n2793, Vss)); // Bench initial voltage = 0.0 V.
        // device 2242, IC IC388, analog/basic/level_down.hpp:28
        I(cpphdl_n2793, Vlogic) <+ 5e-15 * ddt(V(cpphdl_n2793, Vlogic)); // Bench initial voltage = 0.0 V.
        // device 2243, IC IC388, analog/basic/level_down.hpp:29
        I(cpphdl_n2793, cpphdl_n2795) <+ 2.0000000000000002e-15 * ddt(V(cpphdl_n2793, cpphdl_n2795)); // Bench initial voltage = 0.0 V.
        // device 2244, IC IC388, analog/basic/level_down.hpp:30
        I(cpphdl_n2795, Vss) <+ 8e-14 * ddt(V(cpphdl_n2795, Vss)); // Bench initial voltage = 0.0 V.
        // device 2245, IC IC388, analog/basic/level_down.hpp:31
        I(cpphdl_n2795, Vlogic) <+ 5e-15 * ddt(V(cpphdl_n2795, Vlogic)); // Bench initial voltage = 0.0 V.
        // device 2246, IC IC388, analog/basic/level_down.hpp:32
        I(cpphdl_n2795, CORE_DECISION4) <+ 2.0000000000000002e-15 * ddt(V(cpphdl_n2795, CORE_DECISION4)); // Bench initial voltage = 0.0 V.
        // device 2247, IC IC388, analog/basic/level_down.hpp:33
        I(CORE_DECISION4, Vss) <+ 1e-14 * ddt(V(CORE_DECISION4, Vss)); // Bench initial voltage = 0.0 V.
        // device 2248, IC IC389, analog/basic/level_down.hpp:23
        I(cpphdl_n2800, Vlogic) <+ cpphdl_channel(V(Vss, Vlogic), V(cpphdl_n2800, Vlogic), 0.00050000000000000001, 0.34999999999999998, -1.0);
        // device 2249, IC IC389, analog/basic/level_down.hpp:24
        I(cpphdl_n2800, Vss) <+ cpphdl_channel(V(cpphdl_n2798, Vss), V(cpphdl_n2800, Vss), 0.0040000000000000001, 0.69999999999999996, 1.0);
        // device 2250, IC IC389, analog/basic/level_down.hpp:25
        I(CORE_DECISION5, Vlogic) <+ cpphdl_channel(V(cpphdl_n2800, Vlogic), V(CORE_DECISION5, Vlogic), 0.0050000000000000001, 0.34999999999999998, -1.0);
        // device 2251, IC IC389, analog/basic/level_down.hpp:26
        I(CORE_DECISION5, Vss) <+ cpphdl_channel(V(cpphdl_n2800, Vss), V(CORE_DECISION5, Vss), 0.01, 0.34999999999999998, 1.0);
        // device 2252, IC IC389, analog/basic/level_down.hpp:27
        I(cpphdl_n2798, Vss) <+ 5e-15 * ddt(V(cpphdl_n2798, Vss)); // Bench initial voltage = 0.0 V.
        // device 2253, IC IC389, analog/basic/level_down.hpp:28
        I(cpphdl_n2798, Vlogic) <+ 5e-15 * ddt(V(cpphdl_n2798, Vlogic)); // Bench initial voltage = 0.0 V.
        // device 2254, IC IC389, analog/basic/level_down.hpp:29
        I(cpphdl_n2798, cpphdl_n2800) <+ 2.0000000000000002e-15 * ddt(V(cpphdl_n2798, cpphdl_n2800)); // Bench initial voltage = 0.0 V.
        // device 2255, IC IC389, analog/basic/level_down.hpp:30
        I(cpphdl_n2800, Vss) <+ 8e-14 * ddt(V(cpphdl_n2800, Vss)); // Bench initial voltage = 0.0 V.
        // device 2256, IC IC389, analog/basic/level_down.hpp:31
        I(cpphdl_n2800, Vlogic) <+ 5e-15 * ddt(V(cpphdl_n2800, Vlogic)); // Bench initial voltage = 0.0 V.
        // device 2257, IC IC389, analog/basic/level_down.hpp:32
        I(cpphdl_n2800, CORE_DECISION5) <+ 2.0000000000000002e-15 * ddt(V(cpphdl_n2800, CORE_DECISION5)); // Bench initial voltage = 0.0 V.
        // device 2258, IC IC389, analog/basic/level_down.hpp:33
        I(CORE_DECISION5, Vss) <+ 1e-14 * ddt(V(CORE_DECISION5, Vss)); // Bench initial voltage = 0.0 V.
        // device 2259, IC IC390, analog/basic/level_down.hpp:23
        I(cpphdl_n2805, Vlogic) <+ cpphdl_channel(V(Vss, Vlogic), V(cpphdl_n2805, Vlogic), 0.00050000000000000001, 0.34999999999999998, -1.0);
        // device 2260, IC IC390, analog/basic/level_down.hpp:24
        I(cpphdl_n2805, Vss) <+ cpphdl_channel(V(cpphdl_n2803, Vss), V(cpphdl_n2805, Vss), 0.0040000000000000001, 0.69999999999999996, 1.0);
        // device 2261, IC IC390, analog/basic/level_down.hpp:25
        I(CORE_DECISION6, Vlogic) <+ cpphdl_channel(V(cpphdl_n2805, Vlogic), V(CORE_DECISION6, Vlogic), 0.0050000000000000001, 0.34999999999999998, -1.0);
        // device 2262, IC IC390, analog/basic/level_down.hpp:26
        I(CORE_DECISION6, Vss) <+ cpphdl_channel(V(cpphdl_n2805, Vss), V(CORE_DECISION6, Vss), 0.01, 0.34999999999999998, 1.0);
        // device 2263, IC IC390, analog/basic/level_down.hpp:27
        I(cpphdl_n2803, Vss) <+ 5e-15 * ddt(V(cpphdl_n2803, Vss)); // Bench initial voltage = 0.0 V.
        // device 2264, IC IC390, analog/basic/level_down.hpp:28
        I(cpphdl_n2803, Vlogic) <+ 5e-15 * ddt(V(cpphdl_n2803, Vlogic)); // Bench initial voltage = 0.0 V.
        // device 2265, IC IC390, analog/basic/level_down.hpp:29
        I(cpphdl_n2803, cpphdl_n2805) <+ 2.0000000000000002e-15 * ddt(V(cpphdl_n2803, cpphdl_n2805)); // Bench initial voltage = 0.0 V.
        // device 2266, IC IC390, analog/basic/level_down.hpp:30
        I(cpphdl_n2805, Vss) <+ 8e-14 * ddt(V(cpphdl_n2805, Vss)); // Bench initial voltage = 0.0 V.
        // device 2267, IC IC390, analog/basic/level_down.hpp:31
        I(cpphdl_n2805, Vlogic) <+ 5e-15 * ddt(V(cpphdl_n2805, Vlogic)); // Bench initial voltage = 0.0 V.
        // device 2268, IC IC390, analog/basic/level_down.hpp:32
        I(cpphdl_n2805, CORE_DECISION6) <+ 2.0000000000000002e-15 * ddt(V(cpphdl_n2805, CORE_DECISION6)); // Bench initial voltage = 0.0 V.
        // device 2269, IC IC390, analog/basic/level_down.hpp:33
        I(CORE_DECISION6, Vss) <+ 1e-14 * ddt(V(CORE_DECISION6, Vss)); // Bench initial voltage = 0.0 V.
        // device 2270, IC IC391, analog/basic/level_down.hpp:23
        I(cpphdl_n2810, Vlogic) <+ cpphdl_channel(V(Vss, Vlogic), V(cpphdl_n2810, Vlogic), 0.00050000000000000001, 0.34999999999999998, -1.0);
        // device 2271, IC IC391, analog/basic/level_down.hpp:24
        I(cpphdl_n2810, Vss) <+ cpphdl_channel(V(cpphdl_n2808, Vss), V(cpphdl_n2810, Vss), 0.0040000000000000001, 0.69999999999999996, 1.0);
        // device 2272, IC IC391, analog/basic/level_down.hpp:25
        I(CORE_DECISION7, Vlogic) <+ cpphdl_channel(V(cpphdl_n2810, Vlogic), V(CORE_DECISION7, Vlogic), 0.0050000000000000001, 0.34999999999999998, -1.0);
        // device 2273, IC IC391, analog/basic/level_down.hpp:26
        I(CORE_DECISION7, Vss) <+ cpphdl_channel(V(cpphdl_n2810, Vss), V(CORE_DECISION7, Vss), 0.01, 0.34999999999999998, 1.0);
        // device 2274, IC IC391, analog/basic/level_down.hpp:27
        I(cpphdl_n2808, Vss) <+ 5e-15 * ddt(V(cpphdl_n2808, Vss)); // Bench initial voltage = 0.0 V.
        // device 2275, IC IC391, analog/basic/level_down.hpp:28
        I(cpphdl_n2808, Vlogic) <+ 5e-15 * ddt(V(cpphdl_n2808, Vlogic)); // Bench initial voltage = 0.0 V.
        // device 2276, IC IC391, analog/basic/level_down.hpp:29
        I(cpphdl_n2808, cpphdl_n2810) <+ 2.0000000000000002e-15 * ddt(V(cpphdl_n2808, cpphdl_n2810)); // Bench initial voltage = 0.0 V.
        // device 2277, IC IC391, analog/basic/level_down.hpp:30
        I(cpphdl_n2810, Vss) <+ 8e-14 * ddt(V(cpphdl_n2810, Vss)); // Bench initial voltage = 0.0 V.
        // device 2278, IC IC391, analog/basic/level_down.hpp:31
        I(cpphdl_n2810, Vlogic) <+ 5e-15 * ddt(V(cpphdl_n2810, Vlogic)); // Bench initial voltage = 0.0 V.
        // device 2279, IC IC391, analog/basic/level_down.hpp:32
        I(cpphdl_n2810, CORE_DECISION7) <+ 2.0000000000000002e-15 * ddt(V(cpphdl_n2810, CORE_DECISION7)); // Bench initial voltage = 0.0 V.
        // device 2280, IC IC391, analog/basic/level_down.hpp:33
        I(CORE_DECISION7, Vss) <+ 1e-14 * ddt(V(CORE_DECISION7, Vss)); // Bench initial voltage = 0.0 V.
        // device 2281, IC IC392, analog/basic/level_down.hpp:23
        I(cpphdl_n2815, Vlogic) <+ cpphdl_channel(V(Vss, Vlogic), V(cpphdl_n2815, Vlogic), 0.00050000000000000001, 0.34999999999999998, -1.0);
        // device 2282, IC IC392, analog/basic/level_down.hpp:24
        I(cpphdl_n2815, Vss) <+ cpphdl_channel(V(cpphdl_n2813, Vss), V(cpphdl_n2815, Vss), 0.0040000000000000001, 0.69999999999999996, 1.0);
        // device 2283, IC IC392, analog/basic/level_down.hpp:25
        I(CORE_DECISION8, Vlogic) <+ cpphdl_channel(V(cpphdl_n2815, Vlogic), V(CORE_DECISION8, Vlogic), 0.0050000000000000001, 0.34999999999999998, -1.0);
        // device 2284, IC IC392, analog/basic/level_down.hpp:26
        I(CORE_DECISION8, Vss) <+ cpphdl_channel(V(cpphdl_n2815, Vss), V(CORE_DECISION8, Vss), 0.01, 0.34999999999999998, 1.0);
        // device 2285, IC IC392, analog/basic/level_down.hpp:27
        I(cpphdl_n2813, Vss) <+ 5e-15 * ddt(V(cpphdl_n2813, Vss)); // Bench initial voltage = 0.0 V.
        // device 2286, IC IC392, analog/basic/level_down.hpp:28
        I(cpphdl_n2813, Vlogic) <+ 5e-15 * ddt(V(cpphdl_n2813, Vlogic)); // Bench initial voltage = 0.0 V.
        // device 2287, IC IC392, analog/basic/level_down.hpp:29
        I(cpphdl_n2813, cpphdl_n2815) <+ 2.0000000000000002e-15 * ddt(V(cpphdl_n2813, cpphdl_n2815)); // Bench initial voltage = 0.0 V.
        // device 2288, IC IC392, analog/basic/level_down.hpp:30
        I(cpphdl_n2815, Vss) <+ 8e-14 * ddt(V(cpphdl_n2815, Vss)); // Bench initial voltage = 0.0 V.
        // device 2289, IC IC392, analog/basic/level_down.hpp:31
        I(cpphdl_n2815, Vlogic) <+ 5e-15 * ddt(V(cpphdl_n2815, Vlogic)); // Bench initial voltage = 0.0 V.
        // device 2290, IC IC392, analog/basic/level_down.hpp:32
        I(cpphdl_n2815, CORE_DECISION8) <+ 2.0000000000000002e-15 * ddt(V(cpphdl_n2815, CORE_DECISION8)); // Bench initial voltage = 0.0 V.
        // device 2291, IC IC392, analog/basic/level_down.hpp:33
        I(CORE_DECISION8, Vss) <+ 1e-14 * ddt(V(CORE_DECISION8, Vss)); // Bench initial voltage = 0.0 V.
        // device 2292, IC IC393, analog/basic/level_down.hpp:23
        I(cpphdl_n2820, Vlogic) <+ cpphdl_channel(V(Vss, Vlogic), V(cpphdl_n2820, Vlogic), 0.00050000000000000001, 0.34999999999999998, -1.0);
        // device 2293, IC IC393, analog/basic/level_down.hpp:24
        I(cpphdl_n2820, Vss) <+ cpphdl_channel(V(cpphdl_n2818, Vss), V(cpphdl_n2820, Vss), 0.0040000000000000001, 0.69999999999999996, 1.0);
        // device 2294, IC IC393, analog/basic/level_down.hpp:25
        I(CORE_DECISION9, Vlogic) <+ cpphdl_channel(V(cpphdl_n2820, Vlogic), V(CORE_DECISION9, Vlogic), 0.0050000000000000001, 0.34999999999999998, -1.0);
        // device 2295, IC IC393, analog/basic/level_down.hpp:26
        I(CORE_DECISION9, Vss) <+ cpphdl_channel(V(cpphdl_n2820, Vss), V(CORE_DECISION9, Vss), 0.01, 0.34999999999999998, 1.0);
        // device 2296, IC IC393, analog/basic/level_down.hpp:27
        I(cpphdl_n2818, Vss) <+ 5e-15 * ddt(V(cpphdl_n2818, Vss)); // Bench initial voltage = 0.0 V.
        // device 2297, IC IC393, analog/basic/level_down.hpp:28
        I(cpphdl_n2818, Vlogic) <+ 5e-15 * ddt(V(cpphdl_n2818, Vlogic)); // Bench initial voltage = 0.0 V.
        // device 2298, IC IC393, analog/basic/level_down.hpp:29
        I(cpphdl_n2818, cpphdl_n2820) <+ 2.0000000000000002e-15 * ddt(V(cpphdl_n2818, cpphdl_n2820)); // Bench initial voltage = 0.0 V.
        // device 2299, IC IC393, analog/basic/level_down.hpp:30
        I(cpphdl_n2820, Vss) <+ 8e-14 * ddt(V(cpphdl_n2820, Vss)); // Bench initial voltage = 0.0 V.
        // device 2300, IC IC393, analog/basic/level_down.hpp:31
        I(cpphdl_n2820, Vlogic) <+ 5e-15 * ddt(V(cpphdl_n2820, Vlogic)); // Bench initial voltage = 0.0 V.
        // device 2301, IC IC393, analog/basic/level_down.hpp:32
        I(cpphdl_n2820, CORE_DECISION9) <+ 2.0000000000000002e-15 * ddt(V(cpphdl_n2820, CORE_DECISION9)); // Bench initial voltage = 0.0 V.
        // device 2302, IC IC393, analog/basic/level_down.hpp:33
        I(CORE_DECISION9, Vss) <+ 1e-14 * ddt(V(CORE_DECISION9, Vss)); // Bench initial voltage = 0.0 V.
        // device 2303, IC IC394, analog/basic/level_down.hpp:23
        I(cpphdl_n2825, Vlogic) <+ cpphdl_channel(V(Vss, Vlogic), V(cpphdl_n2825, Vlogic), 0.00050000000000000001, 0.34999999999999998, -1.0);
        // device 2304, IC IC394, analog/basic/level_down.hpp:24
        I(cpphdl_n2825, Vss) <+ cpphdl_channel(V(cpphdl_n2823, Vss), V(cpphdl_n2825, Vss), 0.0040000000000000001, 0.69999999999999996, 1.0);
        // device 2305, IC IC394, analog/basic/level_down.hpp:25
        I(CORE_DECISION10, Vlogic) <+ cpphdl_channel(V(cpphdl_n2825, Vlogic), V(CORE_DECISION10, Vlogic), 0.0050000000000000001, 0.34999999999999998, -1.0);
        // device 2306, IC IC394, analog/basic/level_down.hpp:26
        I(CORE_DECISION10, Vss) <+ cpphdl_channel(V(cpphdl_n2825, Vss), V(CORE_DECISION10, Vss), 0.01, 0.34999999999999998, 1.0);
        // device 2307, IC IC394, analog/basic/level_down.hpp:27
        I(cpphdl_n2823, Vss) <+ 5e-15 * ddt(V(cpphdl_n2823, Vss)); // Bench initial voltage = 0.0 V.
        // device 2308, IC IC394, analog/basic/level_down.hpp:28
        I(cpphdl_n2823, Vlogic) <+ 5e-15 * ddt(V(cpphdl_n2823, Vlogic)); // Bench initial voltage = 0.0 V.
        // device 2309, IC IC394, analog/basic/level_down.hpp:29
        I(cpphdl_n2823, cpphdl_n2825) <+ 2.0000000000000002e-15 * ddt(V(cpphdl_n2823, cpphdl_n2825)); // Bench initial voltage = 0.0 V.
        // device 2310, IC IC394, analog/basic/level_down.hpp:30
        I(cpphdl_n2825, Vss) <+ 8e-14 * ddt(V(cpphdl_n2825, Vss)); // Bench initial voltage = 0.0 V.
        // device 2311, IC IC394, analog/basic/level_down.hpp:31
        I(cpphdl_n2825, Vlogic) <+ 5e-15 * ddt(V(cpphdl_n2825, Vlogic)); // Bench initial voltage = 0.0 V.
        // device 2312, IC IC394, analog/basic/level_down.hpp:32
        I(cpphdl_n2825, CORE_DECISION10) <+ 2.0000000000000002e-15 * ddt(V(cpphdl_n2825, CORE_DECISION10)); // Bench initial voltage = 0.0 V.
        // device 2313, IC IC394, analog/basic/level_down.hpp:33
        I(CORE_DECISION10, Vss) <+ 1e-14 * ddt(V(CORE_DECISION10, Vss)); // Bench initial voltage = 0.0 V.
        // device 2314, IC IC395, analog/basic/level_down.hpp:23
        I(cpphdl_n2830, Vlogic) <+ cpphdl_channel(V(Vss, Vlogic), V(cpphdl_n2830, Vlogic), 0.00050000000000000001, 0.34999999999999998, -1.0);
        // device 2315, IC IC395, analog/basic/level_down.hpp:24
        I(cpphdl_n2830, Vss) <+ cpphdl_channel(V(cpphdl_n2828, Vss), V(cpphdl_n2830, Vss), 0.0040000000000000001, 0.69999999999999996, 1.0);
        // device 2316, IC IC395, analog/basic/level_down.hpp:25
        I(CORE_DECISION11, Vlogic) <+ cpphdl_channel(V(cpphdl_n2830, Vlogic), V(CORE_DECISION11, Vlogic), 0.0050000000000000001, 0.34999999999999998, -1.0);
        // device 2317, IC IC395, analog/basic/level_down.hpp:26
        I(CORE_DECISION11, Vss) <+ cpphdl_channel(V(cpphdl_n2830, Vss), V(CORE_DECISION11, Vss), 0.01, 0.34999999999999998, 1.0);
        // device 2318, IC IC395, analog/basic/level_down.hpp:27
        I(cpphdl_n2828, Vss) <+ 5e-15 * ddt(V(cpphdl_n2828, Vss)); // Bench initial voltage = 0.0 V.
        // device 2319, IC IC395, analog/basic/level_down.hpp:28
        I(cpphdl_n2828, Vlogic) <+ 5e-15 * ddt(V(cpphdl_n2828, Vlogic)); // Bench initial voltage = 0.0 V.
        // device 2320, IC IC395, analog/basic/level_down.hpp:29
        I(cpphdl_n2828, cpphdl_n2830) <+ 2.0000000000000002e-15 * ddt(V(cpphdl_n2828, cpphdl_n2830)); // Bench initial voltage = 0.0 V.
        // device 2321, IC IC395, analog/basic/level_down.hpp:30
        I(cpphdl_n2830, Vss) <+ 8e-14 * ddt(V(cpphdl_n2830, Vss)); // Bench initial voltage = 0.0 V.
        // device 2322, IC IC395, analog/basic/level_down.hpp:31
        I(cpphdl_n2830, Vlogic) <+ 5e-15 * ddt(V(cpphdl_n2830, Vlogic)); // Bench initial voltage = 0.0 V.
        // device 2323, IC IC395, analog/basic/level_down.hpp:32
        I(cpphdl_n2830, CORE_DECISION11) <+ 2.0000000000000002e-15 * ddt(V(cpphdl_n2830, CORE_DECISION11)); // Bench initial voltage = 0.0 V.
        // device 2324, IC IC395, analog/basic/level_down.hpp:33
        I(CORE_DECISION11, Vss) <+ 1e-14 * ddt(V(CORE_DECISION11, Vss)); // Bench initial voltage = 0.0 V.
        // device 2325, IC IC396, analog/basic/level_down.hpp:23
        I(cpphdl_n2835, Vlogic) <+ cpphdl_channel(V(Vss, Vlogic), V(cpphdl_n2835, Vlogic), 0.00050000000000000001, 0.34999999999999998, -1.0);
        // device 2326, IC IC396, analog/basic/level_down.hpp:24
        I(cpphdl_n2835, Vss) <+ cpphdl_channel(V(cpphdl_n2833, Vss), V(cpphdl_n2835, Vss), 0.0040000000000000001, 0.69999999999999996, 1.0);
        // device 2327, IC IC396, analog/basic/level_down.hpp:25
        I(CORE_DECISION12, Vlogic) <+ cpphdl_channel(V(cpphdl_n2835, Vlogic), V(CORE_DECISION12, Vlogic), 0.0050000000000000001, 0.34999999999999998, -1.0);
        // device 2328, IC IC396, analog/basic/level_down.hpp:26
        I(CORE_DECISION12, Vss) <+ cpphdl_channel(V(cpphdl_n2835, Vss), V(CORE_DECISION12, Vss), 0.01, 0.34999999999999998, 1.0);
        // device 2329, IC IC396, analog/basic/level_down.hpp:27
        I(cpphdl_n2833, Vss) <+ 5e-15 * ddt(V(cpphdl_n2833, Vss)); // Bench initial voltage = 0.0 V.
        // device 2330, IC IC396, analog/basic/level_down.hpp:28
        I(cpphdl_n2833, Vlogic) <+ 5e-15 * ddt(V(cpphdl_n2833, Vlogic)); // Bench initial voltage = 0.0 V.
        // device 2331, IC IC396, analog/basic/level_down.hpp:29
        I(cpphdl_n2833, cpphdl_n2835) <+ 2.0000000000000002e-15 * ddt(V(cpphdl_n2833, cpphdl_n2835)); // Bench initial voltage = 0.0 V.
        // device 2332, IC IC396, analog/basic/level_down.hpp:30
        I(cpphdl_n2835, Vss) <+ 8e-14 * ddt(V(cpphdl_n2835, Vss)); // Bench initial voltage = 0.0 V.
        // device 2333, IC IC396, analog/basic/level_down.hpp:31
        I(cpphdl_n2835, Vlogic) <+ 5e-15 * ddt(V(cpphdl_n2835, Vlogic)); // Bench initial voltage = 0.0 V.
        // device 2334, IC IC396, analog/basic/level_down.hpp:32
        I(cpphdl_n2835, CORE_DECISION12) <+ 2.0000000000000002e-15 * ddt(V(cpphdl_n2835, CORE_DECISION12)); // Bench initial voltage = 0.0 V.
        // device 2335, IC IC396, analog/basic/level_down.hpp:33
        I(CORE_DECISION12, Vss) <+ 1e-14 * ddt(V(CORE_DECISION12, Vss)); // Bench initial voltage = 0.0 V.
        // device 2336, IC IC397, analog/basic/level_down.hpp:23
        I(cpphdl_n2840, Vlogic) <+ cpphdl_channel(V(Vss, Vlogic), V(cpphdl_n2840, Vlogic), 0.00050000000000000001, 0.34999999999999998, -1.0);
        // device 2337, IC IC397, analog/basic/level_down.hpp:24
        I(cpphdl_n2840, Vss) <+ cpphdl_channel(V(cpphdl_n2838, Vss), V(cpphdl_n2840, Vss), 0.0040000000000000001, 0.69999999999999996, 1.0);
        // device 2338, IC IC397, analog/basic/level_down.hpp:25
        I(CORE_DECISION13, Vlogic) <+ cpphdl_channel(V(cpphdl_n2840, Vlogic), V(CORE_DECISION13, Vlogic), 0.0050000000000000001, 0.34999999999999998, -1.0);
        // device 2339, IC IC397, analog/basic/level_down.hpp:26
        I(CORE_DECISION13, Vss) <+ cpphdl_channel(V(cpphdl_n2840, Vss), V(CORE_DECISION13, Vss), 0.01, 0.34999999999999998, 1.0);
        // device 2340, IC IC397, analog/basic/level_down.hpp:27
        I(cpphdl_n2838, Vss) <+ 5e-15 * ddt(V(cpphdl_n2838, Vss)); // Bench initial voltage = 0.0 V.
        // device 2341, IC IC397, analog/basic/level_down.hpp:28
        I(cpphdl_n2838, Vlogic) <+ 5e-15 * ddt(V(cpphdl_n2838, Vlogic)); // Bench initial voltage = 0.0 V.
        // device 2342, IC IC397, analog/basic/level_down.hpp:29
        I(cpphdl_n2838, cpphdl_n2840) <+ 2.0000000000000002e-15 * ddt(V(cpphdl_n2838, cpphdl_n2840)); // Bench initial voltage = 0.0 V.
        // device 2343, IC IC397, analog/basic/level_down.hpp:30
        I(cpphdl_n2840, Vss) <+ 8e-14 * ddt(V(cpphdl_n2840, Vss)); // Bench initial voltage = 0.0 V.
        // device 2344, IC IC397, analog/basic/level_down.hpp:31
        I(cpphdl_n2840, Vlogic) <+ 5e-15 * ddt(V(cpphdl_n2840, Vlogic)); // Bench initial voltage = 0.0 V.
        // device 2345, IC IC397, analog/basic/level_down.hpp:32
        I(cpphdl_n2840, CORE_DECISION13) <+ 2.0000000000000002e-15 * ddt(V(cpphdl_n2840, CORE_DECISION13)); // Bench initial voltage = 0.0 V.
        // device 2346, IC IC397, analog/basic/level_down.hpp:33
        I(CORE_DECISION13, Vss) <+ 1e-14 * ddt(V(CORE_DECISION13, Vss)); // Bench initial voltage = 0.0 V.
        // device 2347, IC IC398, analog/basic/level_down.hpp:23
        I(cpphdl_n2845, Vlogic) <+ cpphdl_channel(V(Vss, Vlogic), V(cpphdl_n2845, Vlogic), 0.00050000000000000001, 0.34999999999999998, -1.0);
        // device 2348, IC IC398, analog/basic/level_down.hpp:24
        I(cpphdl_n2845, Vss) <+ cpphdl_channel(V(cpphdl_n2843, Vss), V(cpphdl_n2845, Vss), 0.0040000000000000001, 0.69999999999999996, 1.0);
        // device 2349, IC IC398, analog/basic/level_down.hpp:25
        I(CORE_DECISION14, Vlogic) <+ cpphdl_channel(V(cpphdl_n2845, Vlogic), V(CORE_DECISION14, Vlogic), 0.0050000000000000001, 0.34999999999999998, -1.0);
        // device 2350, IC IC398, analog/basic/level_down.hpp:26
        I(CORE_DECISION14, Vss) <+ cpphdl_channel(V(cpphdl_n2845, Vss), V(CORE_DECISION14, Vss), 0.01, 0.34999999999999998, 1.0);
        // device 2351, IC IC398, analog/basic/level_down.hpp:27
        I(cpphdl_n2843, Vss) <+ 5e-15 * ddt(V(cpphdl_n2843, Vss)); // Bench initial voltage = 0.0 V.
        // device 2352, IC IC398, analog/basic/level_down.hpp:28
        I(cpphdl_n2843, Vlogic) <+ 5e-15 * ddt(V(cpphdl_n2843, Vlogic)); // Bench initial voltage = 0.0 V.
        // device 2353, IC IC398, analog/basic/level_down.hpp:29
        I(cpphdl_n2843, cpphdl_n2845) <+ 2.0000000000000002e-15 * ddt(V(cpphdl_n2843, cpphdl_n2845)); // Bench initial voltage = 0.0 V.
        // device 2354, IC IC398, analog/basic/level_down.hpp:30
        I(cpphdl_n2845, Vss) <+ 8e-14 * ddt(V(cpphdl_n2845, Vss)); // Bench initial voltage = 0.0 V.
        // device 2355, IC IC398, analog/basic/level_down.hpp:31
        I(cpphdl_n2845, Vlogic) <+ 5e-15 * ddt(V(cpphdl_n2845, Vlogic)); // Bench initial voltage = 0.0 V.
        // device 2356, IC IC398, analog/basic/level_down.hpp:32
        I(cpphdl_n2845, CORE_DECISION14) <+ 2.0000000000000002e-15 * ddt(V(cpphdl_n2845, CORE_DECISION14)); // Bench initial voltage = 0.0 V.
        // device 2357, IC IC398, analog/basic/level_down.hpp:33
        I(CORE_DECISION14, Vss) <+ 1e-14 * ddt(V(CORE_DECISION14, Vss)); // Bench initial voltage = 0.0 V.
        // device 2358, IC IC399, analog/basic/level_down.hpp:23
        I(cpphdl_n2850, Vlogic) <+ cpphdl_channel(V(Vss, Vlogic), V(cpphdl_n2850, Vlogic), 0.00050000000000000001, 0.34999999999999998, -1.0);
        // device 2359, IC IC399, analog/basic/level_down.hpp:24
        I(cpphdl_n2850, Vss) <+ cpphdl_channel(V(cpphdl_n2848, Vss), V(cpphdl_n2850, Vss), 0.0040000000000000001, 0.69999999999999996, 1.0);
        // device 2360, IC IC399, analog/basic/level_down.hpp:25
        I(CORE_DECISION15, Vlogic) <+ cpphdl_channel(V(cpphdl_n2850, Vlogic), V(CORE_DECISION15, Vlogic), 0.0050000000000000001, 0.34999999999999998, -1.0);
        // device 2361, IC IC399, analog/basic/level_down.hpp:26
        I(CORE_DECISION15, Vss) <+ cpphdl_channel(V(cpphdl_n2850, Vss), V(CORE_DECISION15, Vss), 0.01, 0.34999999999999998, 1.0);
        // device 2362, IC IC399, analog/basic/level_down.hpp:27
        I(cpphdl_n2848, Vss) <+ 5e-15 * ddt(V(cpphdl_n2848, Vss)); // Bench initial voltage = 0.0 V.
        // device 2363, IC IC399, analog/basic/level_down.hpp:28
        I(cpphdl_n2848, Vlogic) <+ 5e-15 * ddt(V(cpphdl_n2848, Vlogic)); // Bench initial voltage = 0.0 V.
        // device 2364, IC IC399, analog/basic/level_down.hpp:29
        I(cpphdl_n2848, cpphdl_n2850) <+ 2.0000000000000002e-15 * ddt(V(cpphdl_n2848, cpphdl_n2850)); // Bench initial voltage = 0.0 V.
        // device 2365, IC IC399, analog/basic/level_down.hpp:30
        I(cpphdl_n2850, Vss) <+ 8e-14 * ddt(V(cpphdl_n2850, Vss)); // Bench initial voltage = 0.0 V.
        // device 2366, IC IC399, analog/basic/level_down.hpp:31
        I(cpphdl_n2850, Vlogic) <+ 5e-15 * ddt(V(cpphdl_n2850, Vlogic)); // Bench initial voltage = 0.0 V.
        // device 2367, IC IC399, analog/basic/level_down.hpp:32
        I(cpphdl_n2850, CORE_DECISION15) <+ 2.0000000000000002e-15 * ddt(V(cpphdl_n2850, CORE_DECISION15)); // Bench initial voltage = 0.0 V.
        // device 2368, IC IC399, analog/basic/level_down.hpp:33
        I(CORE_DECISION15, Vss) <+ 1e-14 * ddt(V(CORE_DECISION15, Vss)); // Bench initial voltage = 0.0 V.
    end
endmodule
