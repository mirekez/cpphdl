// SIMULATION APPROXIMATION: controlled conductances are not physical MOS devices.
// Generated from elaborated C++HDL IC purposes; all contributions coexist.
// Capacitor initialization belongs to the host analysis; declared initial voltages appear below.
`include "disciplines.vams"

module OneGIHPLeadReceiveCommonReference(Vdd, Vss, OUT);
    inout Vdd, Vss, OUT;
    electrical Vdd, Vss, OUT;
    electrical cpphdl_n31;
    electrical cpphdl_n32;
    electrical cpphdl_n33;
    electrical cpphdl_n34;
    electrical cpphdl_n35;
    electrical cpphdl_n36;
    electrical cpphdl_n37;
    electrical cpphdl_n38;
    electrical cpphdl_n39;
    electrical cpphdl_n40;
    electrical cpphdl_n41;
    electrical cpphdl_n54;

    // Square-law channel, including reverse conduction. This is not a BSIM model.
    analog function real cpphdl_channel;
        input vgs, vds, beta, threshold, polarity;
        real vgs, vds, beta, threshold, polarity;
        real gate, drain, direction, overdrive, current;
        begin
            gate = polarity * vgs;
            drain = polarity * vds;
            direction = 1.0;
            if (drain < 0.0) begin
                gate = gate - drain;
                drain = -drain;
                direction = -1.0;
            end
            overdrive = gate - threshold;
            current = 0.0;
            if (overdrive > 0.0) begin
                if (drain < overdrive)
                    current = beta * (overdrive * drain - drain * drain / 2.0);
                else
                    current = beta * overdrive * overdrive / 2.0;
            end
            cpphdl_channel = polarity * direction * current;
        end
    endfunction

    analog begin
        // device 0, IC IC1, analog/basic/resistor_divider.hpp:15
        I(Vdd, cpphdl_n31) <+ V(Vdd, cpphdl_n31) / 10000.0;
        // device 1, IC IC1, analog/basic/resistor_divider.hpp:16
        I(cpphdl_n31, Vss) <+ V(cpphdl_n31, Vss) / 12150.0;
        // device 2, IC OneGIHPLeadReceiveCommonReference, analog/1G/IHPSG13G2/lead_receive_common_reference.hpp:24
        I(cpphdl_n31, Vss) <+ 9.9999999999999994e-12 * ddt(V(cpphdl_n31, Vss)); // Bench initial voltage = 0.0 V.
        // device 3, IC IC2, analog/basic/resistor_divider.hpp:15
        I(Vdd, cpphdl_n33) <+ V(Vdd, cpphdl_n33) / 12000.0;
        // device 4, IC IC2, analog/basic/resistor_divider.hpp:16
        I(cpphdl_n33, Vss) <+ V(cpphdl_n33, Vss) / 21000.0;
        // device 5, IC OneGIHPLeadReceiveCommonReference, analog/1G/IHPSG13G2/lead_receive_common_reference.hpp:30
        I(cpphdl_n33, Vss) <+ 9.9999999999999994e-12 * ddt(V(cpphdl_n33, Vss)); // Bench initial voltage = 0.0 V.
        // device 6, IC IC3, analog/basic/resistor_divider.hpp:15
        I(Vdd, cpphdl_n34) <+ V(Vdd, cpphdl_n34) / 23000.0;
        // device 7, IC IC3, analog/basic/resistor_divider.hpp:16
        I(cpphdl_n34, Vss) <+ V(cpphdl_n34, Vss) / 43000.0;
        // device 8, IC OneGIHPLeadReceiveCommonReference, analog/1G/IHPSG13G2/lead_receive_common_reference.hpp:36
        I(cpphdl_n34, Vss) <+ 9.9999999999999994e-12 * ddt(V(cpphdl_n34, Vss)); // Bench initial voltage = 0.0 V.
        // device 9, IC OneGIHPLeadReceiveCommonReference, analog/1G/IHPSG13G2/lead_receive_common_reference.hpp:37
        I(Vdd, cpphdl_n35) <+ V(Vdd, cpphdl_n35) / 2500.0;
        // device 10, IC OneGIHPLeadReceiveCommonReference, analog/1G/IHPSG13G2/lead_receive_common_reference.hpp:38
        I(cpphdl_n35, Vss) <+ cpphdl_channel(V(cpphdl_n35, Vss), V(cpphdl_n35, Vss), 0.029999999999999999, 0.69999999999999996, 1.0);
        // device 11, IC OneGIHPLeadReceiveCommonReference, analog/1G/IHPSG13G2/lead_receive_common_reference.hpp:39
        I(cpphdl_n35, Vss) <+ 9.9999999999999994e-12 * ddt(V(cpphdl_n35, Vss)); // Bench initial voltage = 0.0 V.
        // device 12, IC IC5, analog/basic/cascode_ota.hpp:29
        I(cpphdl_n36, cpphdl_n41) <+ cpphdl_channel(V(OUT, cpphdl_n41), V(cpphdl_n36, cpphdl_n41), 0.029999999999999999, 0.69999999999999996, 1.0);
        // device 13, IC IC5, analog/basic/cascode_ota.hpp:30
        I(cpphdl_n37, cpphdl_n41) <+ cpphdl_channel(V(cpphdl_n31, cpphdl_n41), V(cpphdl_n37, cpphdl_n41), 0.029999999999999999, 0.69999999999999996, 1.0);
        // device 14, IC IC5, analog/basic/cascode_ota.hpp:31
        I(cpphdl_n38, cpphdl_n36) <+ cpphdl_channel(V(cpphdl_n33, cpphdl_n36), V(cpphdl_n38, cpphdl_n36), 0.059999999999999998, 0.69999999999999996, 1.0);
        // device 15, IC IC5, analog/basic/cascode_ota.hpp:32
        I(cpphdl_n32, cpphdl_n37) <+ cpphdl_channel(V(cpphdl_n33, cpphdl_n37), V(cpphdl_n32, cpphdl_n37), 0.059999999999999998, 0.69999999999999996, 1.0);
        // device 16, IC IC5, analog/basic/cascode_ota.hpp:33
        I(cpphdl_n39, Vdd) <+ cpphdl_channel(V(cpphdl_n38, Vdd), V(cpphdl_n39, Vdd), 0.029999999999999999, 0.69999999999999996, -1.0);
        // device 17, IC IC5, analog/basic/cascode_ota.hpp:34
        I(cpphdl_n40, Vdd) <+ cpphdl_channel(V(cpphdl_n38, Vdd), V(cpphdl_n40, Vdd), 0.029999999999999999, 0.69999999999999996, -1.0);
        // device 18, IC IC5, analog/basic/cascode_ota.hpp:35
        I(cpphdl_n38, cpphdl_n39) <+ cpphdl_channel(V(cpphdl_n34, cpphdl_n39), V(cpphdl_n38, cpphdl_n39), 0.059999999999999998, 0.69999999999999996, -1.0);
        // device 19, IC IC5, analog/basic/cascode_ota.hpp:36
        I(cpphdl_n32, cpphdl_n40) <+ cpphdl_channel(V(cpphdl_n34, cpphdl_n40), V(cpphdl_n32, cpphdl_n40), 0.059999999999999998, 0.69999999999999996, -1.0);
        // device 20, IC IC5, analog/basic/cascode_ota.hpp:37
        I(cpphdl_n41, Vss) <+ cpphdl_channel(V(cpphdl_n35, Vss), V(cpphdl_n41, Vss), 0.059999999999999998, 0.69999999999999996, 1.0);
        // device 21, IC IC5, analog/basic/cascode_ota.hpp:38
        I(cpphdl_n32, Vss) <+ 2.4999999999999999e-13 * ddt(V(cpphdl_n32, Vss)); // Bench initial voltage = 0.0 V.
        // device 22, IC IC5, analog/basic/cascode_ota.hpp:39
        I(cpphdl_n36, Vss) <+ 4e-14 * ddt(V(cpphdl_n36, Vss)); // Bench initial voltage = 0.0 V.
        // device 23, IC IC5, analog/basic/cascode_ota.hpp:40
        I(cpphdl_n37, Vss) <+ 4e-14 * ddt(V(cpphdl_n37, Vss)); // Bench initial voltage = 0.0 V.
        // device 24, IC IC5, analog/basic/cascode_ota.hpp:41
        I(cpphdl_n41, Vss) <+ 4e-14 * ddt(V(cpphdl_n41, Vss)); // Bench initial voltage = 0.0 V.
        // device 25, IC IC5, analog/basic/cascode_ota.hpp:42
        I(cpphdl_n39, Vdd) <+ 4e-14 * ddt(V(cpphdl_n39, Vdd)); // Bench initial voltage = 0.0 V.
        // device 26, IC IC5, analog/basic/cascode_ota.hpp:43
        I(cpphdl_n40, Vdd) <+ 4e-14 * ddt(V(cpphdl_n40, Vdd)); // Bench initial voltage = 0.0 V.
        // device 27, IC IC5, analog/basic/cascode_ota.hpp:44
        I(cpphdl_n38, Vss) <+ 4e-14 * ddt(V(cpphdl_n38, Vss)); // Bench initial voltage = 0.0 V.
        // device 28, IC IC5, analog/basic/cascode_ota.hpp:45
        I(OUT, cpphdl_n41) <+ 4e-14 * ddt(V(OUT, cpphdl_n41)); // Bench initial voltage = 0.0 V.
        // device 29, IC IC5, analog/basic/cascode_ota.hpp:46
        I(cpphdl_n31, cpphdl_n41) <+ 4e-14 * ddt(V(cpphdl_n31, cpphdl_n41)); // Bench initial voltage = 0.0 V.
        // device 30, IC IC5, analog/basic/cascode_ota.hpp:47
        I(OUT, cpphdl_n36) <+ 1e-14 * ddt(V(OUT, cpphdl_n36)); // Bench initial voltage = 0.0 V.
        // device 31, IC IC5, analog/basic/cascode_ota.hpp:48
        I(cpphdl_n31, cpphdl_n37) <+ 1e-14 * ddt(V(cpphdl_n31, cpphdl_n37)); // Bench initial voltage = 0.0 V.
        // device 32, IC IC4, analog/basic/shunt_voltage_buffer.hpp:34
        I(Vdd, OUT) <+ V(Vdd, OUT) / 1000.0;
        // device 33, IC IC4, analog/basic/shunt_voltage_buffer.hpp:35
        I(OUT, Vss) <+ cpphdl_channel(V(cpphdl_n32, Vss), V(OUT, Vss), 0.029999999999999999, 0.69999999999999996, 1.0);
        // device 34, IC IC4, analog/basic/shunt_voltage_buffer.hpp:36
        I(OUT, Vss) <+ 7.9999999999999995e-11 * ddt(V(OUT, Vss)); // Bench initial voltage = 0.0 V.
        // device 35, IC IC4, analog/basic/shunt_voltage_buffer.hpp:37
        I(cpphdl_n32, Vss) <+ 8e-14 * ddt(V(cpphdl_n32, Vss)); // Bench initial voltage = 0.0 V.
        // device 36, IC IC4, analog/basic/shunt_voltage_buffer.hpp:38
        I(cpphdl_n32, OUT) <+ 2e-14 * ddt(V(cpphdl_n32, OUT)); // Bench initial voltage = 0.0 V.
        // device 37, IC IC4, analog/basic/lead_shunt_voltage_buffer.hpp:15
        I(cpphdl_n32, cpphdl_n54) <+ V(cpphdl_n32, cpphdl_n54) / 1000.0;
        // device 38, IC IC4, analog/basic/lead_shunt_voltage_buffer.hpp:16
        I(cpphdl_n54, OUT) <+ 2e-12 * ddt(V(cpphdl_n54, OUT)); // Bench initial voltage = 0.0 V.
    end
endmodule
