// SIMULATION APPROXIMATION: controlled conductances are not physical MOS devices.
// Generated from elaborated C++HDL IC purposes; all contributions coexist.
// Capacitor initialization belongs to the host analysis; declared initial voltages appear below.
`include "disciplines.vams"

module OneGIHPCompactDifferentialReceiveFrontend(Vdd, Vss, Vlogic, VREF, EVALUATE, CLEAR, PLUS, MINUS, SELECT_N0, SELECT_N1, SELECT_N2, SELECT_N3, SELECT_N4, TRACK0, CORE_DECISION0, BIT_N0_0, BIT_N0_1, BIT_N0_2, BIT_N0_3, BIT_N0_4, BIT_N0_5, BIT_N0_6, BIT_N0_7, TRACK1, CORE_DECISION1, BIT_N1_0, BIT_N1_1, BIT_N1_2, BIT_N1_3, BIT_N1_4, BIT_N1_5, BIT_N1_6, BIT_N1_7, TRACK2, CORE_DECISION2, BIT_N2_0, BIT_N2_1, BIT_N2_2, BIT_N2_3, BIT_N2_4, BIT_N2_5, BIT_N2_6, BIT_N2_7, TRACK3, CORE_DECISION3, BIT_N3_0, BIT_N3_1, BIT_N3_2, BIT_N3_3, BIT_N3_4, BIT_N3_5, BIT_N3_6, BIT_N3_7, TRACK4, CORE_DECISION4, BIT_N4_0, BIT_N4_1, BIT_N4_2, BIT_N4_3, BIT_N4_4, BIT_N4_5, BIT_N4_6, BIT_N4_7, TRACK5, CORE_DECISION5, BIT_N5_0, BIT_N5_1, BIT_N5_2, BIT_N5_3, BIT_N5_4, BIT_N5_5, BIT_N5_6, BIT_N5_7, TRACK6, CORE_DECISION6, BIT_N6_0, BIT_N6_1, BIT_N6_2, BIT_N6_3, BIT_N6_4, BIT_N6_5, BIT_N6_6, BIT_N6_7, TRACK7, CORE_DECISION7, BIT_N7_0, BIT_N7_1, BIT_N7_2, BIT_N7_3, BIT_N7_4, BIT_N7_5, BIT_N7_6, BIT_N7_7, TRACK8, CORE_DECISION8, BIT_N8_0, BIT_N8_1, BIT_N8_2, BIT_N8_3, BIT_N8_4, BIT_N8_5, BIT_N8_6, BIT_N8_7, TRACK9, CORE_DECISION9, BIT_N9_0, BIT_N9_1, BIT_N9_2, BIT_N9_3, BIT_N9_4, BIT_N9_5, BIT_N9_6, BIT_N9_7, TRACK10, CORE_DECISION10, BIT_N10_0, BIT_N10_1, BIT_N10_2, BIT_N10_3, BIT_N10_4, BIT_N10_5, BIT_N10_6, BIT_N10_7, TRACK11, CORE_DECISION11, BIT_N11_0, BIT_N11_1, BIT_N11_2, BIT_N11_3, BIT_N11_4, BIT_N11_5, BIT_N11_6, BIT_N11_7, TRACK12, CORE_DECISION12, BIT_N12_0, BIT_N12_1, BIT_N12_2, BIT_N12_3, BIT_N12_4, BIT_N12_5, BIT_N12_6, BIT_N12_7);
    inout Vdd, Vss, Vlogic, VREF, EVALUATE, CLEAR, PLUS, MINUS, SELECT_N0, SELECT_N1, SELECT_N2, SELECT_N3, SELECT_N4, TRACK0, CORE_DECISION0, BIT_N0_0, BIT_N0_1, BIT_N0_2, BIT_N0_3, BIT_N0_4, BIT_N0_5, BIT_N0_6, BIT_N0_7, TRACK1, CORE_DECISION1, BIT_N1_0, BIT_N1_1, BIT_N1_2, BIT_N1_3, BIT_N1_4, BIT_N1_5, BIT_N1_6, BIT_N1_7, TRACK2, CORE_DECISION2, BIT_N2_0, BIT_N2_1, BIT_N2_2, BIT_N2_3, BIT_N2_4, BIT_N2_5, BIT_N2_6, BIT_N2_7, TRACK3, CORE_DECISION3, BIT_N3_0, BIT_N3_1, BIT_N3_2, BIT_N3_3, BIT_N3_4, BIT_N3_5, BIT_N3_6, BIT_N3_7, TRACK4, CORE_DECISION4, BIT_N4_0, BIT_N4_1, BIT_N4_2, BIT_N4_3, BIT_N4_4, BIT_N4_5, BIT_N4_6, BIT_N4_7, TRACK5, CORE_DECISION5, BIT_N5_0, BIT_N5_1, BIT_N5_2, BIT_N5_3, BIT_N5_4, BIT_N5_5, BIT_N5_6, BIT_N5_7, TRACK6, CORE_DECISION6, BIT_N6_0, BIT_N6_1, BIT_N6_2, BIT_N6_3, BIT_N6_4, BIT_N6_5, BIT_N6_6, BIT_N6_7, TRACK7, CORE_DECISION7, BIT_N7_0, BIT_N7_1, BIT_N7_2, BIT_N7_3, BIT_N7_4, BIT_N7_5, BIT_N7_6, BIT_N7_7, TRACK8, CORE_DECISION8, BIT_N8_0, BIT_N8_1, BIT_N8_2, BIT_N8_3, BIT_N8_4, BIT_N8_5, BIT_N8_6, BIT_N8_7, TRACK9, CORE_DECISION9, BIT_N9_0, BIT_N9_1, BIT_N9_2, BIT_N9_3, BIT_N9_4, BIT_N9_5, BIT_N9_6, BIT_N9_7, TRACK10, CORE_DECISION10, BIT_N10_0, BIT_N10_1, BIT_N10_2, BIT_N10_3, BIT_N10_4, BIT_N10_5, BIT_N10_6, BIT_N10_7, TRACK11, CORE_DECISION11, BIT_N11_0, BIT_N11_1, BIT_N11_2, BIT_N11_3, BIT_N11_4, BIT_N11_5, BIT_N11_6, BIT_N11_7, TRACK12, CORE_DECISION12, BIT_N12_0, BIT_N12_1, BIT_N12_2, BIT_N12_3, BIT_N12_4, BIT_N12_5, BIT_N12_6, BIT_N12_7;
    electrical Vdd, Vss, Vlogic, VREF, EVALUATE, CLEAR, PLUS, MINUS, SELECT_N0, SELECT_N1, SELECT_N2, SELECT_N3, SELECT_N4, TRACK0, CORE_DECISION0, BIT_N0_0, BIT_N0_1, BIT_N0_2, BIT_N0_3, BIT_N0_4, BIT_N0_5, BIT_N0_6, BIT_N0_7, TRACK1, CORE_DECISION1, BIT_N1_0, BIT_N1_1, BIT_N1_2, BIT_N1_3, BIT_N1_4, BIT_N1_5, BIT_N1_6, BIT_N1_7, TRACK2, CORE_DECISION2, BIT_N2_0, BIT_N2_1, BIT_N2_2, BIT_N2_3, BIT_N2_4, BIT_N2_5, BIT_N2_6, BIT_N2_7, TRACK3, CORE_DECISION3, BIT_N3_0, BIT_N3_1, BIT_N3_2, BIT_N3_3, BIT_N3_4, BIT_N3_5, BIT_N3_6, BIT_N3_7, TRACK4, CORE_DECISION4, BIT_N4_0, BIT_N4_1, BIT_N4_2, BIT_N4_3, BIT_N4_4, BIT_N4_5, BIT_N4_6, BIT_N4_7, TRACK5, CORE_DECISION5, BIT_N5_0, BIT_N5_1, BIT_N5_2, BIT_N5_3, BIT_N5_4, BIT_N5_5, BIT_N5_6, BIT_N5_7, TRACK6, CORE_DECISION6, BIT_N6_0, BIT_N6_1, BIT_N6_2, BIT_N6_3, BIT_N6_4, BIT_N6_5, BIT_N6_6, BIT_N6_7, TRACK7, CORE_DECISION7, BIT_N7_0, BIT_N7_1, BIT_N7_2, BIT_N7_3, BIT_N7_4, BIT_N7_5, BIT_N7_6, BIT_N7_7, TRACK8, CORE_DECISION8, BIT_N8_0, BIT_N8_1, BIT_N8_2, BIT_N8_3, BIT_N8_4, BIT_N8_5, BIT_N8_6, BIT_N8_7, TRACK9, CORE_DECISION9, BIT_N9_0, BIT_N9_1, BIT_N9_2, BIT_N9_3, BIT_N9_4, BIT_N9_5, BIT_N9_6, BIT_N9_7, TRACK10, CORE_DECISION10, BIT_N10_0, BIT_N10_1, BIT_N10_2, BIT_N10_3, BIT_N10_4, BIT_N10_5, BIT_N10_6, BIT_N10_7, TRACK11, CORE_DECISION11, BIT_N11_0, BIT_N11_1, BIT_N11_2, BIT_N11_3, BIT_N11_4, BIT_N11_5, BIT_N11_6, BIT_N11_7, TRACK12, CORE_DECISION12, BIT_N12_0, BIT_N12_1, BIT_N12_2, BIT_N12_3, BIT_N12_4, BIT_N12_5, BIT_N12_6, BIT_N12_7;
    electrical cpphdl_n161;
    electrical cpphdl_n162;
    electrical cpphdl_n163;
    electrical cpphdl_n166;
    electrical cpphdl_n167;
    electrical cpphdl_n170;
    electrical cpphdl_n171;
    electrical cpphdl_n187;
    electrical cpphdl_n188;
    electrical cpphdl_n189;
    electrical cpphdl_n190;
    electrical cpphdl_n191;
    electrical cpphdl_n192;
    electrical cpphdl_n193;
    electrical cpphdl_n194;
    electrical cpphdl_n195;
    electrical cpphdl_n196;
    electrical cpphdl_n197;
    electrical cpphdl_n198;
    electrical cpphdl_n199;
    electrical cpphdl_n200;
    electrical cpphdl_n201;
    electrical cpphdl_n202;
    electrical cpphdl_n206;
    electrical cpphdl_n210;
    electrical cpphdl_n214;
    electrical cpphdl_n218;
    electrical cpphdl_n222;
    electrical cpphdl_n223;
    electrical cpphdl_n224;
    electrical cpphdl_n225;
    electrical cpphdl_n226;
    electrical cpphdl_n229;
    electrical cpphdl_n230;
    electrical cpphdl_n232;
    electrical cpphdl_n233;
    electrical cpphdl_n234;
    electrical cpphdl_n235;
    electrical cpphdl_n236;
    electrical cpphdl_n237;
    electrical cpphdl_n238;
    electrical cpphdl_n239;
    electrical cpphdl_n240;
    electrical cpphdl_n243;
    electrical cpphdl_n426;
    electrical cpphdl_n441;
    electrical cpphdl_n445;
    electrical cpphdl_n449;
    electrical cpphdl_n453;
    electrical cpphdl_n457;
    electrical cpphdl_n461;
    electrical cpphdl_n465;
    electrical cpphdl_n469;
    electrical cpphdl_n470;
    electrical cpphdl_n471;
    electrical cpphdl_n472;
    electrical cpphdl_n473;
    electrical cpphdl_n474;
    electrical cpphdl_n475;
    electrical cpphdl_n476;
    electrical cpphdl_n480;
    electrical cpphdl_n481;
    electrical cpphdl_n484;
    electrical cpphdl_n485;
    electrical cpphdl_n486;
    electrical cpphdl_n489;
    electrical cpphdl_n490;
    electrical cpphdl_n494;
    electrical cpphdl_n495;
    electrical cpphdl_n496;
    electrical cpphdl_n509;
    electrical cpphdl_n513;
    electrical cpphdl_n517;
    electrical cpphdl_n521;
    electrical cpphdl_n531;
    electrical cpphdl_n534;
    electrical cpphdl_n537;
    electrical cpphdl_n539;
    electrical cpphdl_n540;
    electrical cpphdl_n545;
    electrical cpphdl_n569;
    electrical cpphdl_n584;
    electrical cpphdl_n588;
    electrical cpphdl_n592;
    electrical cpphdl_n596;
    electrical cpphdl_n600;
    electrical cpphdl_n604;
    electrical cpphdl_n608;
    electrical cpphdl_n612;
    electrical cpphdl_n613;
    electrical cpphdl_n614;
    electrical cpphdl_n615;
    electrical cpphdl_n616;
    electrical cpphdl_n617;
    electrical cpphdl_n618;
    electrical cpphdl_n619;
    electrical cpphdl_n623;
    electrical cpphdl_n624;
    electrical cpphdl_n627;
    electrical cpphdl_n628;
    electrical cpphdl_n629;
    electrical cpphdl_n632;
    electrical cpphdl_n633;
    electrical cpphdl_n637;
    electrical cpphdl_n638;
    electrical cpphdl_n639;
    electrical cpphdl_n652;
    electrical cpphdl_n656;
    electrical cpphdl_n660;
    electrical cpphdl_n664;
    electrical cpphdl_n674;
    electrical cpphdl_n677;
    electrical cpphdl_n680;
    electrical cpphdl_n682;
    electrical cpphdl_n683;
    electrical cpphdl_n688;
    electrical cpphdl_n712;
    electrical cpphdl_n727;
    electrical cpphdl_n731;
    electrical cpphdl_n735;
    electrical cpphdl_n739;
    electrical cpphdl_n743;
    electrical cpphdl_n747;
    electrical cpphdl_n751;
    electrical cpphdl_n755;
    electrical cpphdl_n756;
    electrical cpphdl_n757;
    electrical cpphdl_n758;
    electrical cpphdl_n759;
    electrical cpphdl_n760;
    electrical cpphdl_n761;
    electrical cpphdl_n762;
    electrical cpphdl_n766;
    electrical cpphdl_n767;
    electrical cpphdl_n770;
    electrical cpphdl_n771;
    electrical cpphdl_n772;
    electrical cpphdl_n775;
    electrical cpphdl_n776;
    electrical cpphdl_n780;
    electrical cpphdl_n781;
    electrical cpphdl_n782;
    electrical cpphdl_n795;
    electrical cpphdl_n799;
    electrical cpphdl_n803;
    electrical cpphdl_n807;
    electrical cpphdl_n817;
    electrical cpphdl_n820;
    electrical cpphdl_n823;
    electrical cpphdl_n825;
    electrical cpphdl_n826;
    electrical cpphdl_n831;
    electrical cpphdl_n855;
    electrical cpphdl_n870;
    electrical cpphdl_n874;
    electrical cpphdl_n878;
    electrical cpphdl_n882;
    electrical cpphdl_n886;
    electrical cpphdl_n890;
    electrical cpphdl_n894;
    electrical cpphdl_n898;
    electrical cpphdl_n899;
    electrical cpphdl_n900;
    electrical cpphdl_n901;
    electrical cpphdl_n902;
    electrical cpphdl_n903;
    electrical cpphdl_n904;
    electrical cpphdl_n905;
    electrical cpphdl_n909;
    electrical cpphdl_n910;
    electrical cpphdl_n913;
    electrical cpphdl_n914;
    electrical cpphdl_n915;
    electrical cpphdl_n918;
    electrical cpphdl_n919;
    electrical cpphdl_n923;
    electrical cpphdl_n924;
    electrical cpphdl_n925;
    electrical cpphdl_n938;
    electrical cpphdl_n942;
    electrical cpphdl_n946;
    electrical cpphdl_n950;
    electrical cpphdl_n960;
    electrical cpphdl_n963;
    electrical cpphdl_n966;
    electrical cpphdl_n968;
    electrical cpphdl_n969;
    electrical cpphdl_n974;
    electrical cpphdl_n998;
    electrical cpphdl_n1013;
    electrical cpphdl_n1017;
    electrical cpphdl_n1021;
    electrical cpphdl_n1025;
    electrical cpphdl_n1029;
    electrical cpphdl_n1033;
    electrical cpphdl_n1037;
    electrical cpphdl_n1041;
    electrical cpphdl_n1042;
    electrical cpphdl_n1043;
    electrical cpphdl_n1044;
    electrical cpphdl_n1045;
    electrical cpphdl_n1046;
    electrical cpphdl_n1047;
    electrical cpphdl_n1048;
    electrical cpphdl_n1052;
    electrical cpphdl_n1053;
    electrical cpphdl_n1056;
    electrical cpphdl_n1057;
    electrical cpphdl_n1058;
    electrical cpphdl_n1061;
    electrical cpphdl_n1062;
    electrical cpphdl_n1066;
    electrical cpphdl_n1067;
    electrical cpphdl_n1068;
    electrical cpphdl_n1081;
    electrical cpphdl_n1085;
    electrical cpphdl_n1089;
    electrical cpphdl_n1093;
    electrical cpphdl_n1103;
    electrical cpphdl_n1106;
    electrical cpphdl_n1109;
    electrical cpphdl_n1111;
    electrical cpphdl_n1112;
    electrical cpphdl_n1117;
    electrical cpphdl_n1141;
    electrical cpphdl_n1156;
    electrical cpphdl_n1160;
    electrical cpphdl_n1164;
    electrical cpphdl_n1168;
    electrical cpphdl_n1172;
    electrical cpphdl_n1176;
    electrical cpphdl_n1180;
    electrical cpphdl_n1184;
    electrical cpphdl_n1185;
    electrical cpphdl_n1186;
    electrical cpphdl_n1187;
    electrical cpphdl_n1188;
    electrical cpphdl_n1189;
    electrical cpphdl_n1190;
    electrical cpphdl_n1191;
    electrical cpphdl_n1195;
    electrical cpphdl_n1196;
    electrical cpphdl_n1199;
    electrical cpphdl_n1200;
    electrical cpphdl_n1201;
    electrical cpphdl_n1204;
    electrical cpphdl_n1205;
    electrical cpphdl_n1209;
    electrical cpphdl_n1210;
    electrical cpphdl_n1211;
    electrical cpphdl_n1224;
    electrical cpphdl_n1228;
    electrical cpphdl_n1232;
    electrical cpphdl_n1236;
    electrical cpphdl_n1246;
    electrical cpphdl_n1249;
    electrical cpphdl_n1252;
    electrical cpphdl_n1254;
    electrical cpphdl_n1255;
    electrical cpphdl_n1260;
    electrical cpphdl_n1284;
    electrical cpphdl_n1299;
    electrical cpphdl_n1303;
    electrical cpphdl_n1307;
    electrical cpphdl_n1311;
    electrical cpphdl_n1315;
    electrical cpphdl_n1319;
    electrical cpphdl_n1323;
    electrical cpphdl_n1327;
    electrical cpphdl_n1328;
    electrical cpphdl_n1329;
    electrical cpphdl_n1330;
    electrical cpphdl_n1331;
    electrical cpphdl_n1332;
    electrical cpphdl_n1333;
    electrical cpphdl_n1334;
    electrical cpphdl_n1338;
    electrical cpphdl_n1339;
    electrical cpphdl_n1342;
    electrical cpphdl_n1343;
    electrical cpphdl_n1344;
    electrical cpphdl_n1347;
    electrical cpphdl_n1348;
    electrical cpphdl_n1352;
    electrical cpphdl_n1353;
    electrical cpphdl_n1354;
    electrical cpphdl_n1367;
    electrical cpphdl_n1371;
    electrical cpphdl_n1375;
    electrical cpphdl_n1379;
    electrical cpphdl_n1389;
    electrical cpphdl_n1392;
    electrical cpphdl_n1395;
    electrical cpphdl_n1397;
    electrical cpphdl_n1398;
    electrical cpphdl_n1403;
    electrical cpphdl_n1427;
    electrical cpphdl_n1442;
    electrical cpphdl_n1446;
    electrical cpphdl_n1450;
    electrical cpphdl_n1454;
    electrical cpphdl_n1458;
    electrical cpphdl_n1462;
    electrical cpphdl_n1466;
    electrical cpphdl_n1470;
    electrical cpphdl_n1471;
    electrical cpphdl_n1472;
    electrical cpphdl_n1473;
    electrical cpphdl_n1474;
    electrical cpphdl_n1475;
    electrical cpphdl_n1476;
    electrical cpphdl_n1477;
    electrical cpphdl_n1481;
    electrical cpphdl_n1482;
    electrical cpphdl_n1485;
    electrical cpphdl_n1486;
    electrical cpphdl_n1487;
    electrical cpphdl_n1490;
    electrical cpphdl_n1491;
    electrical cpphdl_n1495;
    electrical cpphdl_n1496;
    electrical cpphdl_n1497;
    electrical cpphdl_n1510;
    electrical cpphdl_n1514;
    electrical cpphdl_n1518;
    electrical cpphdl_n1522;
    electrical cpphdl_n1532;
    electrical cpphdl_n1535;
    electrical cpphdl_n1538;
    electrical cpphdl_n1540;
    electrical cpphdl_n1541;
    electrical cpphdl_n1546;
    electrical cpphdl_n1570;
    electrical cpphdl_n1585;
    electrical cpphdl_n1589;
    electrical cpphdl_n1593;
    electrical cpphdl_n1597;
    electrical cpphdl_n1601;
    electrical cpphdl_n1605;
    electrical cpphdl_n1609;
    electrical cpphdl_n1613;
    electrical cpphdl_n1614;
    electrical cpphdl_n1615;
    electrical cpphdl_n1616;
    electrical cpphdl_n1617;
    electrical cpphdl_n1618;
    electrical cpphdl_n1619;
    electrical cpphdl_n1620;
    electrical cpphdl_n1624;
    electrical cpphdl_n1625;
    electrical cpphdl_n1628;
    electrical cpphdl_n1629;
    electrical cpphdl_n1630;
    electrical cpphdl_n1633;
    electrical cpphdl_n1634;
    electrical cpphdl_n1638;
    electrical cpphdl_n1639;
    electrical cpphdl_n1640;
    electrical cpphdl_n1653;
    electrical cpphdl_n1657;
    electrical cpphdl_n1661;
    electrical cpphdl_n1665;
    electrical cpphdl_n1675;
    electrical cpphdl_n1678;
    electrical cpphdl_n1681;
    electrical cpphdl_n1683;
    electrical cpphdl_n1684;
    electrical cpphdl_n1689;
    electrical cpphdl_n1713;
    electrical cpphdl_n1728;
    electrical cpphdl_n1732;
    electrical cpphdl_n1736;
    electrical cpphdl_n1740;
    electrical cpphdl_n1744;
    electrical cpphdl_n1748;
    electrical cpphdl_n1752;
    electrical cpphdl_n1756;
    electrical cpphdl_n1757;
    electrical cpphdl_n1758;
    electrical cpphdl_n1759;
    electrical cpphdl_n1760;
    electrical cpphdl_n1761;
    electrical cpphdl_n1762;
    electrical cpphdl_n1763;
    electrical cpphdl_n1767;
    electrical cpphdl_n1768;
    electrical cpphdl_n1771;
    electrical cpphdl_n1772;
    electrical cpphdl_n1773;
    electrical cpphdl_n1776;
    electrical cpphdl_n1777;
    electrical cpphdl_n1781;
    electrical cpphdl_n1782;
    electrical cpphdl_n1783;
    electrical cpphdl_n1796;
    electrical cpphdl_n1800;
    electrical cpphdl_n1804;
    electrical cpphdl_n1808;
    electrical cpphdl_n1818;
    electrical cpphdl_n1821;
    electrical cpphdl_n1824;
    electrical cpphdl_n1826;
    electrical cpphdl_n1827;
    electrical cpphdl_n1832;
    electrical cpphdl_n1856;
    electrical cpphdl_n1871;
    electrical cpphdl_n1875;
    electrical cpphdl_n1879;
    electrical cpphdl_n1883;
    electrical cpphdl_n1887;
    electrical cpphdl_n1891;
    electrical cpphdl_n1895;
    electrical cpphdl_n1899;
    electrical cpphdl_n1900;
    electrical cpphdl_n1901;
    electrical cpphdl_n1902;
    electrical cpphdl_n1903;
    electrical cpphdl_n1904;
    electrical cpphdl_n1905;
    electrical cpphdl_n1906;
    electrical cpphdl_n1910;
    electrical cpphdl_n1911;
    electrical cpphdl_n1914;
    electrical cpphdl_n1915;
    electrical cpphdl_n1916;
    electrical cpphdl_n1919;
    electrical cpphdl_n1920;
    electrical cpphdl_n1924;
    electrical cpphdl_n1925;
    electrical cpphdl_n1926;
    electrical cpphdl_n1939;
    electrical cpphdl_n1943;
    electrical cpphdl_n1947;
    electrical cpphdl_n1951;
    electrical cpphdl_n1961;
    electrical cpphdl_n1964;
    electrical cpphdl_n1967;
    electrical cpphdl_n1969;
    electrical cpphdl_n1970;
    electrical cpphdl_n1975;
    electrical cpphdl_n1999;
    electrical cpphdl_n2014;
    electrical cpphdl_n2018;
    electrical cpphdl_n2022;
    electrical cpphdl_n2026;
    electrical cpphdl_n2030;
    electrical cpphdl_n2034;
    electrical cpphdl_n2038;
    electrical cpphdl_n2042;
    electrical cpphdl_n2043;
    electrical cpphdl_n2044;
    electrical cpphdl_n2045;
    electrical cpphdl_n2046;
    electrical cpphdl_n2047;
    electrical cpphdl_n2048;
    electrical cpphdl_n2049;
    electrical cpphdl_n2053;
    electrical cpphdl_n2054;
    electrical cpphdl_n2057;
    electrical cpphdl_n2058;
    electrical cpphdl_n2059;
    electrical cpphdl_n2062;
    electrical cpphdl_n2063;
    electrical cpphdl_n2067;
    electrical cpphdl_n2068;
    electrical cpphdl_n2069;
    electrical cpphdl_n2082;
    electrical cpphdl_n2086;
    electrical cpphdl_n2090;
    electrical cpphdl_n2094;
    electrical cpphdl_n2104;
    electrical cpphdl_n2107;
    electrical cpphdl_n2110;
    electrical cpphdl_n2112;
    electrical cpphdl_n2113;
    electrical cpphdl_n2118;
    electrical cpphdl_n2136;
    electrical cpphdl_n2142;
    electrical cpphdl_n2157;
    electrical cpphdl_n2161;
    electrical cpphdl_n2165;
    electrical cpphdl_n2169;
    electrical cpphdl_n2173;
    electrical cpphdl_n2177;
    electrical cpphdl_n2181;
    electrical cpphdl_n2185;
    electrical cpphdl_n2186;
    electrical cpphdl_n2187;
    electrical cpphdl_n2188;
    electrical cpphdl_n2189;
    electrical cpphdl_n2190;
    electrical cpphdl_n2191;
    electrical cpphdl_n2192;
    electrical cpphdl_n2196;
    electrical cpphdl_n2197;
    electrical cpphdl_n2200;
    electrical cpphdl_n2201;
    electrical cpphdl_n2202;
    electrical cpphdl_n2205;
    electrical cpphdl_n2206;
    electrical cpphdl_n2210;
    electrical cpphdl_n2211;
    electrical cpphdl_n2212;
    electrical cpphdl_n2225;
    electrical cpphdl_n2229;
    electrical cpphdl_n2233;
    electrical cpphdl_n2237;
    electrical cpphdl_n2247;
    electrical cpphdl_n2250;
    electrical cpphdl_n2253;
    electrical cpphdl_n2255;
    electrical cpphdl_n2256;
    electrical cpphdl_n2261;
    electrical cpphdl_n2278;
    electrical cpphdl_n2280;
    electrical cpphdl_n2283;
    electrical cpphdl_n2285;
    electrical cpphdl_n2288;
    electrical cpphdl_n2290;
    electrical cpphdl_n2293;
    electrical cpphdl_n2295;
    electrical cpphdl_n2298;
    electrical cpphdl_n2300;
    electrical cpphdl_n2303;
    electrical cpphdl_n2305;
    electrical cpphdl_n2308;
    electrical cpphdl_n2310;
    electrical cpphdl_n2313;
    electrical cpphdl_n2315;
    electrical cpphdl_n2318;
    electrical cpphdl_n2320;
    electrical cpphdl_n2323;
    electrical cpphdl_n2325;
    electrical cpphdl_n2328;
    electrical cpphdl_n2330;
    electrical cpphdl_n2333;
    electrical cpphdl_n2335;
    electrical cpphdl_n2338;
    electrical cpphdl_n2340;

    // Square-law channel, including reverse conduction. This is not a BSIM model.
    analog function real cpphdl_channel;
        input vgs, vds, beta, threshold, polarity;
        real vgs, vds, beta, threshold, polarity;
        real gate, drain, direction, overdrive, current;
        begin
            gate = polarity * vgs;
            drain = polarity * vds;
            direction = 1.0;
            if (drain < 0.0) begin
                gate = gate - drain;
                drain = -drain;
                direction = -1.0;
            end
            overdrive = gate - threshold;
            current = 0.0;
            if (overdrive > 0.0) begin
                if (drain < overdrive)
                    current = beta * (overdrive * drain - drain * drain / 2.0);
                else
                    current = beta * overdrive * overdrive / 2.0;
            end
            cpphdl_channel = polarity * direction * current;
        end
    endfunction

    analog begin
        // device 0, IC IC1, analog/1G/IHPSG13G2/differential_receive_frontend.hpp:24
        I(PLUS, MINUS) <+ V(PLUS, MINUS) / 100.0;
        // device 1, IC IC2, analog/basic/nmos_resistor_amplifier.hpp:23
        I(Vdd, cpphdl_n170) <+ V(Vdd, cpphdl_n170) / 500.0;
        // device 2, IC IC2, analog/basic/nmos_resistor_amplifier.hpp:24
        I(Vdd, cpphdl_n166) <+ V(Vdd, cpphdl_n166) / 500.0;
        // device 3, IC IC2, analog/basic/nmos_resistor_amplifier.hpp:25
        I(cpphdl_n170, cpphdl_n161) <+ cpphdl_channel(V(PLUS, cpphdl_n161), V(cpphdl_n170, cpphdl_n161), 0.014999999999999999, 0.69999999999999996, 1.0);
        // device 4, IC IC2, analog/basic/nmos_resistor_amplifier.hpp:26
        I(cpphdl_n166, cpphdl_n162) <+ cpphdl_channel(V(MINUS, cpphdl_n162), V(cpphdl_n166, cpphdl_n162), 0.014999999999999999, 0.69999999999999996, 1.0);
        // device 5, IC IC2, analog/basic/nmos_resistor_amplifier.hpp:27
        I(cpphdl_n163, cpphdl_n161) <+ V(cpphdl_n163, cpphdl_n161) / 50.0;
        // device 6, IC IC2, analog/basic/nmos_resistor_amplifier.hpp:28
        I(cpphdl_n163, cpphdl_n162) <+ V(cpphdl_n163, cpphdl_n162) / 50.0;
        // device 7, IC IC2, analog/basic/nmos_resistor_amplifier.hpp:29
        I(Vss, cpphdl_n163) <+ V(Vss, cpphdl_n163) / 150.0;
        // device 8, IC IC2, analog/basic/nmos_resistor_amplifier.hpp:30
        I(cpphdl_n170, Vdd) <+ 1e-13 * ddt(V(cpphdl_n170, Vdd)); // Bench initial voltage = 0.0 V.
        // device 9, IC IC2, analog/basic/nmos_resistor_amplifier.hpp:31
        I(cpphdl_n166, Vdd) <+ 1e-13 * ddt(V(cpphdl_n166, Vdd)); // Bench initial voltage = 0.0 V.
        // device 10, IC IC2, analog/basic/nmos_resistor_amplifier.hpp:32
        I(cpphdl_n163, Vss) <+ 4e-14 * ddt(V(cpphdl_n163, Vss)); // Bench initial voltage = 0.0 V.
        // device 11, IC IC2, analog/basic/nmos_resistor_amplifier.hpp:34
        I(PLUS, cpphdl_n161) <+ 1.4999999999999999e-13 * ddt(V(PLUS, cpphdl_n161)); // Bench initial voltage = 0.0 V.
        // device 12, IC IC2, analog/basic/nmos_resistor_amplifier.hpp:35
        I(MINUS, cpphdl_n162) <+ 1.4999999999999999e-13 * ddt(V(MINUS, cpphdl_n162)); // Bench initial voltage = 0.0 V.
        // device 13, IC IC2, analog/basic/nmos_resistor_amplifier.hpp:36
        I(PLUS, cpphdl_n170) <+ 2e-14 * ddt(V(PLUS, cpphdl_n170)); // Bench initial voltage = 0.0 V.
        // device 14, IC IC2, analog/basic/nmos_resistor_amplifier.hpp:37
        I(MINUS, cpphdl_n166) <+ 2e-14 * ddt(V(MINUS, cpphdl_n166)); // Bench initial voltage = 0.0 V.
        // device 15, IC IC3, analog/basic/nmos_source_follower.hpp:19
        I(Vdd, cpphdl_n167) <+ cpphdl_channel(V(cpphdl_n166, cpphdl_n167), V(Vdd, cpphdl_n167), 0.10000000000000001, 0.69999999999999996, 1.0);
        // device 16, IC IC3, analog/basic/nmos_source_follower.hpp:20
        I(Vss, cpphdl_n167) <+ V(Vss, cpphdl_n167) / 250.0;
        // device 17, IC IC3, analog/basic/nmos_source_follower.hpp:23
        I(cpphdl_n166, cpphdl_n167) <+ 4e-14 * ddt(V(cpphdl_n166, cpphdl_n167)); // Bench initial voltage = 0.0 V.
        // device 18, IC IC3, analog/basic/nmos_source_follower.hpp:24
        I(cpphdl_n166, Vdd) <+ 1e-14 * ddt(V(cpphdl_n166, Vdd)); // Bench initial voltage = 0.0 V.
        // device 19, IC IC3, analog/basic/nmos_source_follower.hpp:25
        I(cpphdl_n167, Vss) <+ 4e-14 * ddt(V(cpphdl_n167, Vss)); // Bench initial voltage = 0.0 V.
        // device 20, IC IC4, analog/basic/nmos_source_follower.hpp:19
        I(Vdd, cpphdl_n171) <+ cpphdl_channel(V(cpphdl_n170, cpphdl_n171), V(Vdd, cpphdl_n171), 0.10000000000000001, 0.69999999999999996, 1.0);
        // device 21, IC IC4, analog/basic/nmos_source_follower.hpp:20
        I(Vss, cpphdl_n171) <+ V(Vss, cpphdl_n171) / 250.0;
        // device 22, IC IC4, analog/basic/nmos_source_follower.hpp:23
        I(cpphdl_n170, cpphdl_n171) <+ 4e-14 * ddt(V(cpphdl_n170, cpphdl_n171)); // Bench initial voltage = 0.0 V.
        // device 23, IC IC4, analog/basic/nmos_source_follower.hpp:24
        I(cpphdl_n170, Vdd) <+ 1e-14 * ddt(V(cpphdl_n170, Vdd)); // Bench initial voltage = 0.0 V.
        // device 24, IC IC4, analog/basic/nmos_source_follower.hpp:25
        I(cpphdl_n171, Vss) <+ 4e-14 * ddt(V(cpphdl_n171, Vss)); // Bench initial voltage = 0.0 V.
        // device 25, IC IC6, analog/basic/inverter.hpp:11
        I(cpphdl_n206, Vdd) <+ cpphdl_channel(V(SELECT_N0, Vdd), V(cpphdl_n206, Vdd), 0.0030000000000000001, 0.69999999999999996, -1.0);
        // device 26, IC IC6, analog/basic/inverter.hpp:12
        I(cpphdl_n206, Vss) <+ cpphdl_channel(V(SELECT_N0, Vss), V(cpphdl_n206, Vss), 0.0030000000000000001, 0.69999999999999996, 1.0);
        // device 27, IC IC5, analog/1G/IHPSG13G2/differential_receive_gain.hpp:41
        I(cpphdl_n206, Vss) <+ 2e-14 * ddt(V(cpphdl_n206, Vss)); // Bench initial voltage = 0.0 V.
        // device 28, IC IC7, analog/basic/inverter.hpp:11
        I(cpphdl_n210, Vdd) <+ cpphdl_channel(V(SELECT_N1, Vdd), V(cpphdl_n210, Vdd), 0.0030000000000000001, 0.69999999999999996, -1.0);
        // device 29, IC IC7, analog/basic/inverter.hpp:12
        I(cpphdl_n210, Vss) <+ cpphdl_channel(V(SELECT_N1, Vss), V(cpphdl_n210, Vss), 0.0030000000000000001, 0.69999999999999996, 1.0);
        // device 30, IC IC5, analog/1G/IHPSG13G2/differential_receive_gain.hpp:41
        I(cpphdl_n210, Vss) <+ 2e-14 * ddt(V(cpphdl_n210, Vss)); // Bench initial voltage = 0.0 V.
        // device 31, IC IC8, analog/basic/inverter.hpp:11
        I(cpphdl_n214, Vdd) <+ cpphdl_channel(V(SELECT_N2, Vdd), V(cpphdl_n214, Vdd), 0.0030000000000000001, 0.69999999999999996, -1.0);
        // device 32, IC IC8, analog/basic/inverter.hpp:12
        I(cpphdl_n214, Vss) <+ cpphdl_channel(V(SELECT_N2, Vss), V(cpphdl_n214, Vss), 0.0030000000000000001, 0.69999999999999996, 1.0);
        // device 33, IC IC5, analog/1G/IHPSG13G2/differential_receive_gain.hpp:41
        I(cpphdl_n214, Vss) <+ 2e-14 * ddt(V(cpphdl_n214, Vss)); // Bench initial voltage = 0.0 V.
        // device 34, IC IC9, analog/basic/inverter.hpp:11
        I(cpphdl_n218, Vdd) <+ cpphdl_channel(V(SELECT_N3, Vdd), V(cpphdl_n218, Vdd), 0.0030000000000000001, 0.69999999999999996, -1.0);
        // device 35, IC IC9, analog/basic/inverter.hpp:12
        I(cpphdl_n218, Vss) <+ cpphdl_channel(V(SELECT_N3, Vss), V(cpphdl_n218, Vss), 0.0030000000000000001, 0.69999999999999996, 1.0);
        // device 36, IC IC5, analog/1G/IHPSG13G2/differential_receive_gain.hpp:41
        I(cpphdl_n218, Vss) <+ 2e-14 * ddt(V(cpphdl_n218, Vss)); // Bench initial voltage = 0.0 V.
        // device 37, IC IC10, analog/basic/inverter.hpp:11
        I(cpphdl_n222, Vdd) <+ cpphdl_channel(V(SELECT_N4, Vdd), V(cpphdl_n222, Vdd), 0.0030000000000000001, 0.69999999999999996, -1.0);
        // device 38, IC IC10, analog/basic/inverter.hpp:12
        I(cpphdl_n222, Vss) <+ cpphdl_channel(V(SELECT_N4, Vss), V(cpphdl_n222, Vss), 0.0030000000000000001, 0.69999999999999996, 1.0);
        // device 39, IC IC5, analog/1G/IHPSG13G2/differential_receive_gain.hpp:41
        I(cpphdl_n222, Vss) <+ 2e-14 * ddt(V(cpphdl_n222, Vss)); // Bench initial voltage = 0.0 V.
        // device 40, IC IC5, analog/1G/IHPSG13G2/differential_receive_gain.hpp:43
        I(VREF, cpphdl_n195) <+ V(VREF, cpphdl_n195) / 100.0;
        // device 41, IC IC5, analog/1G/IHPSG13G2/differential_receive_gain.hpp:45
        I(cpphdl_n195, cpphdl_n196) <+ V(cpphdl_n195, cpphdl_n196) / 100.0;
        // device 42, IC IC5, analog/1G/IHPSG13G2/differential_receive_gain.hpp:45
        I(cpphdl_n196, cpphdl_n197) <+ V(cpphdl_n196, cpphdl_n197) / 100.0;
        // device 43, IC IC5, analog/1G/IHPSG13G2/differential_receive_gain.hpp:45
        I(cpphdl_n197, cpphdl_n198) <+ V(cpphdl_n197, cpphdl_n198) / 100.0;
        // device 44, IC IC5, analog/1G/IHPSG13G2/differential_receive_gain.hpp:45
        I(cpphdl_n198, cpphdl_n199) <+ V(cpphdl_n198, cpphdl_n199) / 100.0;
        // device 45, IC IC5, analog/1G/IHPSG13G2/differential_receive_gain.hpp:45
        I(cpphdl_n199, cpphdl_n200) <+ V(cpphdl_n199, cpphdl_n200) / 100.0;
        // device 46, IC IC5, analog/1G/IHPSG13G2/differential_receive_gain.hpp:45
        I(cpphdl_n200, cpphdl_n201) <+ V(cpphdl_n200, cpphdl_n201) / 100.0;
        // device 47, IC IC5, analog/1G/IHPSG13G2/differential_receive_gain.hpp:45
        I(cpphdl_n201, cpphdl_n202) <+ V(cpphdl_n201, cpphdl_n202) / 100.0;
        // device 48, IC IC5, analog/1G/IHPSG13G2/differential_receive_gain.hpp:46
        I(cpphdl_n202, cpphdl_n167) <+ V(cpphdl_n202, cpphdl_n167) / 100.0;
        // device 49, IC IC5, analog/1G/IHPSG13G2/differential_receive_gain.hpp:48
        I(cpphdl_n198, cpphdl_n229) <+ cpphdl_channel(V(cpphdl_n206, cpphdl_n229), V(cpphdl_n198, cpphdl_n229), 0.029999999999999999, 0.69999999999999996, 1.0);
        // device 50, IC IC5, analog/1G/IHPSG13G2/differential_receive_gain.hpp:48
        I(cpphdl_n199, cpphdl_n229) <+ cpphdl_channel(V(cpphdl_n210, cpphdl_n229), V(cpphdl_n199, cpphdl_n229), 0.029999999999999999, 0.69999999999999996, 1.0);
        // device 51, IC IC5, analog/1G/IHPSG13G2/differential_receive_gain.hpp:48
        I(cpphdl_n200, cpphdl_n229) <+ cpphdl_channel(V(cpphdl_n214, cpphdl_n229), V(cpphdl_n200, cpphdl_n229), 0.029999999999999999, 0.69999999999999996, 1.0);
        // device 52, IC IC5, analog/1G/IHPSG13G2/differential_receive_gain.hpp:48
        I(cpphdl_n201, cpphdl_n229) <+ cpphdl_channel(V(cpphdl_n218, cpphdl_n229), V(cpphdl_n201, cpphdl_n229), 0.029999999999999999, 0.69999999999999996, 1.0);
        // device 53, IC IC5, analog/1G/IHPSG13G2/differential_receive_gain.hpp:48
        I(cpphdl_n202, cpphdl_n229) <+ cpphdl_channel(V(cpphdl_n222, cpphdl_n229), V(cpphdl_n202, cpphdl_n229), 0.029999999999999999, 0.69999999999999996, 1.0);
        // device 54, IC IC5, analog/1G/IHPSG13G2/differential_receive_gain.hpp:49
        I(cpphdl_n171, cpphdl_n229) <+ V(cpphdl_n171, cpphdl_n229) / 100000.0;
        // device 55, IC IC5, analog/1G/IHPSG13G2/differential_receive_gain.hpp:50
        I(cpphdl_n229, Vss) <+ 5.0000000000000002e-14 * ddt(V(cpphdl_n229, Vss)); // Bench initial voltage = 0.0 V.
        // device 56, IC IC13, analog/basic/resistor_divider.hpp:15
        I(Vdd, cpphdl_n232) <+ V(Vdd, cpphdl_n232) / 15000.0;
        // device 57, IC IC13, analog/basic/resistor_divider.hpp:16
        I(cpphdl_n232, Vss) <+ V(cpphdl_n232, Vss) / 18000.0;
        // device 58, IC IC14, analog/basic/resistor_divider.hpp:15
        I(Vdd, cpphdl_n233) <+ V(Vdd, cpphdl_n233) / 23000.0;
        // device 59, IC IC14, analog/basic/resistor_divider.hpp:16
        I(cpphdl_n233, Vss) <+ V(cpphdl_n233, Vss) / 43000.0;
        // device 60, IC IC5, analog/1G/IHPSG13G2/differential_receive_gain.hpp:61
        I(cpphdl_n232, Vss) <+ 9.9999999999999994e-12 * ddt(V(cpphdl_n232, Vss)); // Bench initial voltage = 0.0 V.
        // device 61, IC IC5, analog/1G/IHPSG13G2/differential_receive_gain.hpp:62
        I(cpphdl_n233, Vss) <+ 9.9999999999999994e-12 * ddt(V(cpphdl_n233, Vss)); // Bench initial voltage = 0.0 V.
        // device 62, IC IC5, analog/1G/IHPSG13G2/differential_receive_gain.hpp:63
        I(Vdd, cpphdl_n234) <+ V(Vdd, cpphdl_n234) / 2500.0;
        // device 63, IC IC5, analog/1G/IHPSG13G2/differential_receive_gain.hpp:64
        I(cpphdl_n234, Vss) <+ cpphdl_channel(V(cpphdl_n234, Vss), V(cpphdl_n234, Vss), 0.029999999999999999, 0.69999999999999996, 1.0);
        // device 64, IC IC5, analog/1G/IHPSG13G2/differential_receive_gain.hpp:65
        I(cpphdl_n234, Vss) <+ 9.9999999999999994e-12 * ddt(V(cpphdl_n234, Vss)); // Bench initial voltage = 0.0 V.
        // device 65, IC IC5, analog/1G/IHPSG13G2/differential_receive_gain.hpp:67
        I(cpphdl_n2136, cpphdl_n187) <+ V(cpphdl_n2136, cpphdl_n187) / 100.0;
        // device 66, IC IC5, analog/1G/IHPSG13G2/differential_receive_gain.hpp:69
        I(cpphdl_n187, cpphdl_n188) <+ V(cpphdl_n187, cpphdl_n188) / 100.0;
        // device 67, IC IC5, analog/1G/IHPSG13G2/differential_receive_gain.hpp:69
        I(cpphdl_n188, cpphdl_n189) <+ V(cpphdl_n188, cpphdl_n189) / 100.0;
        // device 68, IC IC5, analog/1G/IHPSG13G2/differential_receive_gain.hpp:69
        I(cpphdl_n189, cpphdl_n190) <+ V(cpphdl_n189, cpphdl_n190) / 100.0;
        // device 69, IC IC5, analog/1G/IHPSG13G2/differential_receive_gain.hpp:69
        I(cpphdl_n190, cpphdl_n191) <+ V(cpphdl_n190, cpphdl_n191) / 100.0;
        // device 70, IC IC5, analog/1G/IHPSG13G2/differential_receive_gain.hpp:69
        I(cpphdl_n191, cpphdl_n192) <+ V(cpphdl_n191, cpphdl_n192) / 100.0;
        // device 71, IC IC5, analog/1G/IHPSG13G2/differential_receive_gain.hpp:69
        I(cpphdl_n192, cpphdl_n193) <+ V(cpphdl_n192, cpphdl_n193) / 100.0;
        // device 72, IC IC5, analog/1G/IHPSG13G2/differential_receive_gain.hpp:69
        I(cpphdl_n193, cpphdl_n194) <+ V(cpphdl_n193, cpphdl_n194) / 100.0;
        // device 73, IC IC5, analog/1G/IHPSG13G2/differential_receive_gain.hpp:70
        I(cpphdl_n194, cpphdl_n171) <+ V(cpphdl_n194, cpphdl_n171) / 100.0;
        // device 74, IC IC5, analog/1G/IHPSG13G2/differential_receive_gain.hpp:73
        I(cpphdl_n190, cpphdl_n230) <+ cpphdl_channel(V(cpphdl_n206, cpphdl_n230), V(cpphdl_n190, cpphdl_n230), 0.029999999999999999, 0.69999999999999996, 1.0);
        // device 75, IC IC5, analog/1G/IHPSG13G2/differential_receive_gain.hpp:75
        I(cpphdl_n223, cpphdl_n243) <+ cpphdl_channel(V(SELECT_N0, cpphdl_n243), V(cpphdl_n223, cpphdl_n243), 0.02, 0.69999999999999996, -1.0);
        // device 76, IC IC5, analog/1G/IHPSG13G2/differential_receive_gain.hpp:76
        I(cpphdl_n223, Vss) <+ 9.9999999999999998e-13 * ddt(V(cpphdl_n223, Vss)); // Bench initial voltage = 0.0 V.
        // device 77, IC IC5, analog/1G/IHPSG13G2/differential_receive_gain.hpp:73
        I(cpphdl_n191, cpphdl_n230) <+ cpphdl_channel(V(cpphdl_n210, cpphdl_n230), V(cpphdl_n191, cpphdl_n230), 0.029999999999999999, 0.69999999999999996, 1.0);
        // device 78, IC IC5, analog/1G/IHPSG13G2/differential_receive_gain.hpp:75
        I(cpphdl_n224, cpphdl_n243) <+ cpphdl_channel(V(SELECT_N1, cpphdl_n243), V(cpphdl_n224, cpphdl_n243), 0.02, 0.69999999999999996, -1.0);
        // device 79, IC IC5, analog/1G/IHPSG13G2/differential_receive_gain.hpp:76
        I(cpphdl_n224, Vss) <+ 7.5000000000000004e-13 * ddt(V(cpphdl_n224, Vss)); // Bench initial voltage = 0.0 V.
        // device 80, IC IC5, analog/1G/IHPSG13G2/differential_receive_gain.hpp:73
        I(cpphdl_n192, cpphdl_n230) <+ cpphdl_channel(V(cpphdl_n214, cpphdl_n230), V(cpphdl_n192, cpphdl_n230), 0.029999999999999999, 0.69999999999999996, 1.0);
        // device 81, IC IC5, analog/1G/IHPSG13G2/differential_receive_gain.hpp:75
        I(cpphdl_n225, cpphdl_n243) <+ cpphdl_channel(V(SELECT_N2, cpphdl_n243), V(cpphdl_n225, cpphdl_n243), 0.02, 0.69999999999999996, -1.0);
        // device 82, IC IC5, analog/1G/IHPSG13G2/differential_receive_gain.hpp:76
        I(cpphdl_n225, Vss) <+ 4.9999999999999999e-13 * ddt(V(cpphdl_n225, Vss)); // Bench initial voltage = 0.0 V.
        // device 83, IC IC5, analog/1G/IHPSG13G2/differential_receive_gain.hpp:73
        I(cpphdl_n193, cpphdl_n230) <+ cpphdl_channel(V(cpphdl_n218, cpphdl_n230), V(cpphdl_n193, cpphdl_n230), 0.029999999999999999, 0.69999999999999996, 1.0);
        // device 84, IC IC5, analog/1G/IHPSG13G2/differential_receive_gain.hpp:75
        I(cpphdl_n226, cpphdl_n243) <+ cpphdl_channel(V(SELECT_N3, cpphdl_n243), V(cpphdl_n226, cpphdl_n243), 0.02, 0.69999999999999996, -1.0);
        // device 85, IC IC5, analog/1G/IHPSG13G2/differential_receive_gain.hpp:76
        I(cpphdl_n226, Vss) <+ 2.4999999999999999e-13 * ddt(V(cpphdl_n226, Vss)); // Bench initial voltage = 0.0 V.
        // device 86, IC IC5, analog/1G/IHPSG13G2/differential_receive_gain.hpp:73
        I(cpphdl_n194, cpphdl_n230) <+ cpphdl_channel(V(cpphdl_n222, cpphdl_n230), V(cpphdl_n194, cpphdl_n230), 0.029999999999999999, 0.69999999999999996, 1.0);
        // device 87, IC IC11, analog/basic/cascode_ota.hpp:29
        I(cpphdl_n235, cpphdl_n240) <+ cpphdl_channel(V(cpphdl_n229, cpphdl_n240), V(cpphdl_n235, cpphdl_n240), 0.029999999999999999, 0.69999999999999996, 1.0);
        // device 88, IC IC11, analog/basic/cascode_ota.hpp:30
        I(cpphdl_n236, cpphdl_n240) <+ cpphdl_channel(V(cpphdl_n230, cpphdl_n240), V(cpphdl_n236, cpphdl_n240), 0.029999999999999999, 0.69999999999999996, 1.0);
        // device 89, IC IC11, analog/basic/cascode_ota.hpp:31
        I(cpphdl_n237, cpphdl_n235) <+ cpphdl_channel(V(cpphdl_n232, cpphdl_n235), V(cpphdl_n237, cpphdl_n235), 0.059999999999999998, 0.69999999999999996, 1.0);
        // device 90, IC IC11, analog/basic/cascode_ota.hpp:32
        I(cpphdl_n243, cpphdl_n236) <+ cpphdl_channel(V(cpphdl_n232, cpphdl_n236), V(cpphdl_n243, cpphdl_n236), 0.059999999999999998, 0.69999999999999996, 1.0);
        // device 91, IC IC11, analog/basic/cascode_ota.hpp:33
        I(cpphdl_n238, Vdd) <+ cpphdl_channel(V(cpphdl_n237, Vdd), V(cpphdl_n238, Vdd), 0.029999999999999999, 0.69999999999999996, -1.0);
        // device 92, IC IC11, analog/basic/cascode_ota.hpp:34
        I(cpphdl_n239, Vdd) <+ cpphdl_channel(V(cpphdl_n237, Vdd), V(cpphdl_n239, Vdd), 0.029999999999999999, 0.69999999999999996, -1.0);
        // device 93, IC IC11, analog/basic/cascode_ota.hpp:35
        I(cpphdl_n237, cpphdl_n238) <+ cpphdl_channel(V(cpphdl_n233, cpphdl_n238), V(cpphdl_n237, cpphdl_n238), 0.059999999999999998, 0.69999999999999996, -1.0);
        // device 94, IC IC11, analog/basic/cascode_ota.hpp:36
        I(cpphdl_n243, cpphdl_n239) <+ cpphdl_channel(V(cpphdl_n233, cpphdl_n239), V(cpphdl_n243, cpphdl_n239), 0.059999999999999998, 0.69999999999999996, -1.0);
        // device 95, IC IC11, analog/basic/cascode_ota.hpp:37
        I(cpphdl_n240, Vss) <+ cpphdl_channel(V(cpphdl_n234, Vss), V(cpphdl_n240, Vss), 0.059999999999999998, 0.69999999999999996, 1.0);
        // device 96, IC IC11, analog/basic/cascode_ota.hpp:38
        I(cpphdl_n243, Vss) <+ 2.4999999999999999e-13 * ddt(V(cpphdl_n243, Vss)); // Bench initial voltage = 0.0 V.
        // device 97, IC IC11, analog/basic/cascode_ota.hpp:39
        I(cpphdl_n235, Vss) <+ 4e-14 * ddt(V(cpphdl_n235, Vss)); // Bench initial voltage = 0.0 V.
        // device 98, IC IC11, analog/basic/cascode_ota.hpp:40
        I(cpphdl_n236, Vss) <+ 4e-14 * ddt(V(cpphdl_n236, Vss)); // Bench initial voltage = 0.0 V.
        // device 99, IC IC11, analog/basic/cascode_ota.hpp:41
        I(cpphdl_n240, Vss) <+ 4e-14 * ddt(V(cpphdl_n240, Vss)); // Bench initial voltage = 0.0 V.
        // device 100, IC IC11, analog/basic/cascode_ota.hpp:42
        I(cpphdl_n238, Vdd) <+ 4e-14 * ddt(V(cpphdl_n238, Vdd)); // Bench initial voltage = 0.0 V.
        // device 101, IC IC11, analog/basic/cascode_ota.hpp:43
        I(cpphdl_n239, Vdd) <+ 4e-14 * ddt(V(cpphdl_n239, Vdd)); // Bench initial voltage = 0.0 V.
        // device 102, IC IC11, analog/basic/cascode_ota.hpp:44
        I(cpphdl_n237, Vss) <+ 4e-14 * ddt(V(cpphdl_n237, Vss)); // Bench initial voltage = 0.0 V.
        // device 103, IC IC11, analog/basic/cascode_ota.hpp:45
        I(cpphdl_n229, cpphdl_n240) <+ 4e-14 * ddt(V(cpphdl_n229, cpphdl_n240)); // Bench initial voltage = 0.0 V.
        // device 104, IC IC11, analog/basic/cascode_ota.hpp:46
        I(cpphdl_n230, cpphdl_n240) <+ 4e-14 * ddt(V(cpphdl_n230, cpphdl_n240)); // Bench initial voltage = 0.0 V.
        // device 105, IC IC11, analog/basic/cascode_ota.hpp:47
        I(cpphdl_n229, cpphdl_n235) <+ 1e-14 * ddt(V(cpphdl_n229, cpphdl_n235)); // Bench initial voltage = 0.0 V.
        // device 106, IC IC11, analog/basic/cascode_ota.hpp:48
        I(cpphdl_n230, cpphdl_n236) <+ 1e-14 * ddt(V(cpphdl_n230, cpphdl_n236)); // Bench initial voltage = 0.0 V.
        // device 107, IC IC12, analog/basic/nmos_source_follower.hpp:19
        I(Vdd, cpphdl_n2136) <+ cpphdl_channel(V(cpphdl_n243, cpphdl_n2136), V(Vdd, cpphdl_n2136), 0.20000000000000001, 0.69999999999999996, 1.0);
        // device 108, IC IC12, analog/basic/nmos_source_follower.hpp:20
        I(Vss, cpphdl_n2136) <+ V(Vss, cpphdl_n2136) / 500.0;
        // device 109, IC IC12, analog/basic/nmos_source_follower.hpp:23
        I(cpphdl_n243, cpphdl_n2136) <+ 8e-14 * ddt(V(cpphdl_n243, cpphdl_n2136)); // Bench initial voltage = 0.0 V.
        // device 110, IC IC12, analog/basic/nmos_source_follower.hpp:24
        I(cpphdl_n243, Vdd) <+ 2e-14 * ddt(V(cpphdl_n243, Vdd)); // Bench initial voltage = 0.0 V.
        // device 111, IC IC12, analog/basic/nmos_source_follower.hpp:25
        I(cpphdl_n2136, Vss) <+ 8e-14 * ddt(V(cpphdl_n2136, Vss)); // Bench initial voltage = 0.0 V.
        // device 112, IC IC1, analog/1G/IHPSG13G2/differential_receive_frontend.hpp:60
        I(cpphdl_n2136, Vss) <+ 3.0000000000000001e-12 * ddt(V(cpphdl_n2136, Vss)); // Bench initial voltage = 0.0 V.
        // device 113, IC IC18, analog/basic/inverter.hpp:11
        I(cpphdl_n426, Vdd) <+ cpphdl_channel(V(TRACK0, Vdd), V(cpphdl_n426, Vdd), 0.0040000000000000001, 0.69999999999999996, -1.0);
        // device 114, IC IC18, analog/basic/inverter.hpp:12
        I(cpphdl_n426, Vss) <+ cpphdl_channel(V(TRACK0, Vss), V(cpphdl_n426, Vss), 0.0040000000000000001, 0.69999999999999996, 1.0);
        // device 115, IC IC17, analog/basic/mos_track_hold.hpp:31
        I(cpphdl_n426, Vss) <+ 2e-14 * ddt(V(cpphdl_n426, Vss)); // Bench initial voltage = 0.0 V.
        // device 116, IC IC17, analog/basic/mos_track_hold.hpp:32
        I(cpphdl_n2136, cpphdl_n480) <+ cpphdl_channel(V(TRACK0, cpphdl_n480), V(cpphdl_n2136, cpphdl_n480), 0.029999999999999999, 0.69999999999999996, 1.0);
        // device 117, IC IC17, analog/basic/mos_track_hold.hpp:33
        I(cpphdl_n480, cpphdl_n2136) <+ cpphdl_channel(V(cpphdl_n426, cpphdl_n2136), V(cpphdl_n480, cpphdl_n2136), 0.014999999999999999, 0.69999999999999996, -1.0);
        // device 118, IC IC17, analog/basic/mos_track_hold.hpp:37
        I(cpphdl_n480, cpphdl_n480) <+ cpphdl_channel(V(cpphdl_n426, cpphdl_n480), V(cpphdl_n480, cpphdl_n480), 0.016, 0.69999999999999996, 1.0);
        // device 119, IC IC17, analog/basic/mos_track_hold.hpp:38
        I(cpphdl_n480, cpphdl_n480) <+ cpphdl_channel(V(TRACK0, cpphdl_n480), V(cpphdl_n480, cpphdl_n480), 0.0083999999999999995, 0.69999999999999996, -1.0);
        // device 120, IC IC17, analog/basic/mos_track_hold.hpp:39
        I(cpphdl_n480, Vss) <+ 1.5000000000000001e-12 * ddt(V(cpphdl_n480, Vss)); // Bench initial voltage = 0.0 V.
        // device 121, IC IC17, analog/basic/mos_track_hold.hpp:42
        I(TRACK0, cpphdl_n480) <+ 2.0000000000000002e-15 * ddt(V(TRACK0, cpphdl_n480)); // Bench initial voltage = -0.0 V.
        // device 122, IC IC17, analog/basic/mos_track_hold.hpp:43
        I(cpphdl_n426, cpphdl_n480) <+ 2.0000000000000002e-15 * ddt(V(cpphdl_n426, cpphdl_n480)); // Bench initial voltage = 0.0 V.
        // device 123, IC IC17, analog/basic/mos_track_hold.hpp:44
        I(cpphdl_n2136, cpphdl_n480) <+ 1.0000000000000001e-15 * ddt(V(cpphdl_n2136, cpphdl_n480)); // Bench initial voltage = 0.0 V.
        // device 124, IC IC20, analog/basic/inverter.hpp:11
        I(cpphdl_n441, Vdd) <+ cpphdl_channel(V(BIT_N0_0, Vdd), V(cpphdl_n441, Vdd), 0.080000000000000002, 0.69999999999999996, -1.0);
        // device 125, IC IC20, analog/basic/inverter.hpp:12
        I(cpphdl_n441, Vss) <+ cpphdl_channel(V(BIT_N0_0, Vss), V(cpphdl_n441, Vss), 0.080000000000000002, 0.69999999999999996, 1.0);
        // device 126, IC IC19, analog/basic/mos_r2r_dac.hpp:27
        I(cpphdl_n441, Vss) <+ 2.9999999999999998e-15 * ddt(V(cpphdl_n441, Vss)); // Bench initial voltage = 0.0 V.
        // device 127, IC IC19, analog/basic/mos_r2r_dac.hpp:28
        I(cpphdl_n441, cpphdl_n470) <+ V(cpphdl_n441, cpphdl_n470) / 2000.0;
        // device 128, IC IC19, analog/basic/mos_r2r_dac.hpp:29
        I(cpphdl_n470, Vss) <+ 2.9999999999999998e-15 * ddt(V(cpphdl_n470, Vss)); // Bench initial voltage = 0.0 V.
        // device 129, IC IC21, analog/basic/inverter.hpp:11
        I(cpphdl_n445, Vdd) <+ cpphdl_channel(V(BIT_N0_1, Vdd), V(cpphdl_n445, Vdd), 0.080000000000000002, 0.69999999999999996, -1.0);
        // device 130, IC IC21, analog/basic/inverter.hpp:12
        I(cpphdl_n445, Vss) <+ cpphdl_channel(V(BIT_N0_1, Vss), V(cpphdl_n445, Vss), 0.080000000000000002, 0.69999999999999996, 1.0);
        // device 131, IC IC19, analog/basic/mos_r2r_dac.hpp:27
        I(cpphdl_n445, Vss) <+ 2.9999999999999998e-15 * ddt(V(cpphdl_n445, Vss)); // Bench initial voltage = 0.0 V.
        // device 132, IC IC19, analog/basic/mos_r2r_dac.hpp:28
        I(cpphdl_n445, cpphdl_n471) <+ V(cpphdl_n445, cpphdl_n471) / 2000.0;
        // device 133, IC IC19, analog/basic/mos_r2r_dac.hpp:29
        I(cpphdl_n471, Vss) <+ 2.9999999999999998e-15 * ddt(V(cpphdl_n471, Vss)); // Bench initial voltage = 0.0 V.
        // device 134, IC IC19, analog/basic/mos_r2r_dac.hpp:31
        I(cpphdl_n470, cpphdl_n471) <+ V(cpphdl_n470, cpphdl_n471) / 1000.0;
        // device 135, IC IC22, analog/basic/inverter.hpp:11
        I(cpphdl_n449, Vdd) <+ cpphdl_channel(V(BIT_N0_2, Vdd), V(cpphdl_n449, Vdd), 0.080000000000000002, 0.69999999999999996, -1.0);
        // device 136, IC IC22, analog/basic/inverter.hpp:12
        I(cpphdl_n449, Vss) <+ cpphdl_channel(V(BIT_N0_2, Vss), V(cpphdl_n449, Vss), 0.080000000000000002, 0.69999999999999996, 1.0);
        // device 137, IC IC19, analog/basic/mos_r2r_dac.hpp:27
        I(cpphdl_n449, Vss) <+ 2.9999999999999998e-15 * ddt(V(cpphdl_n449, Vss)); // Bench initial voltage = 0.0 V.
        // device 138, IC IC19, analog/basic/mos_r2r_dac.hpp:28
        I(cpphdl_n449, cpphdl_n472) <+ V(cpphdl_n449, cpphdl_n472) / 2000.0;
        // device 139, IC IC19, analog/basic/mos_r2r_dac.hpp:29
        I(cpphdl_n472, Vss) <+ 2.9999999999999998e-15 * ddt(V(cpphdl_n472, Vss)); // Bench initial voltage = 0.0 V.
        // device 140, IC IC19, analog/basic/mos_r2r_dac.hpp:31
        I(cpphdl_n471, cpphdl_n472) <+ V(cpphdl_n471, cpphdl_n472) / 1000.0;
        // device 141, IC IC23, analog/basic/inverter.hpp:11
        I(cpphdl_n453, Vdd) <+ cpphdl_channel(V(BIT_N0_3, Vdd), V(cpphdl_n453, Vdd), 0.080000000000000002, 0.69999999999999996, -1.0);
        // device 142, IC IC23, analog/basic/inverter.hpp:12
        I(cpphdl_n453, Vss) <+ cpphdl_channel(V(BIT_N0_3, Vss), V(cpphdl_n453, Vss), 0.080000000000000002, 0.69999999999999996, 1.0);
        // device 143, IC IC19, analog/basic/mos_r2r_dac.hpp:27
        I(cpphdl_n453, Vss) <+ 2.9999999999999998e-15 * ddt(V(cpphdl_n453, Vss)); // Bench initial voltage = 0.0 V.
        // device 144, IC IC19, analog/basic/mos_r2r_dac.hpp:28
        I(cpphdl_n453, cpphdl_n473) <+ V(cpphdl_n453, cpphdl_n473) / 2000.0;
        // device 145, IC IC19, analog/basic/mos_r2r_dac.hpp:29
        I(cpphdl_n473, Vss) <+ 2.9999999999999998e-15 * ddt(V(cpphdl_n473, Vss)); // Bench initial voltage = 0.0 V.
        // device 146, IC IC19, analog/basic/mos_r2r_dac.hpp:31
        I(cpphdl_n472, cpphdl_n473) <+ V(cpphdl_n472, cpphdl_n473) / 1000.0;
        // device 147, IC IC24, analog/basic/inverter.hpp:11
        I(cpphdl_n457, Vdd) <+ cpphdl_channel(V(BIT_N0_4, Vdd), V(cpphdl_n457, Vdd), 0.080000000000000002, 0.69999999999999996, -1.0);
        // device 148, IC IC24, analog/basic/inverter.hpp:12
        I(cpphdl_n457, Vss) <+ cpphdl_channel(V(BIT_N0_4, Vss), V(cpphdl_n457, Vss), 0.080000000000000002, 0.69999999999999996, 1.0);
        // device 149, IC IC19, analog/basic/mos_r2r_dac.hpp:27
        I(cpphdl_n457, Vss) <+ 2.9999999999999998e-15 * ddt(V(cpphdl_n457, Vss)); // Bench initial voltage = 0.0 V.
        // device 150, IC IC19, analog/basic/mos_r2r_dac.hpp:28
        I(cpphdl_n457, cpphdl_n474) <+ V(cpphdl_n457, cpphdl_n474) / 2000.0;
        // device 151, IC IC19, analog/basic/mos_r2r_dac.hpp:29
        I(cpphdl_n474, Vss) <+ 2.9999999999999998e-15 * ddt(V(cpphdl_n474, Vss)); // Bench initial voltage = 0.0 V.
        // device 152, IC IC19, analog/basic/mos_r2r_dac.hpp:31
        I(cpphdl_n473, cpphdl_n474) <+ V(cpphdl_n473, cpphdl_n474) / 1000.0;
        // device 153, IC IC25, analog/basic/inverter.hpp:11
        I(cpphdl_n461, Vdd) <+ cpphdl_channel(V(BIT_N0_5, Vdd), V(cpphdl_n461, Vdd), 0.080000000000000002, 0.69999999999999996, -1.0);
        // device 154, IC IC25, analog/basic/inverter.hpp:12
        I(cpphdl_n461, Vss) <+ cpphdl_channel(V(BIT_N0_5, Vss), V(cpphdl_n461, Vss), 0.080000000000000002, 0.69999999999999996, 1.0);
        // device 155, IC IC19, analog/basic/mos_r2r_dac.hpp:27
        I(cpphdl_n461, Vss) <+ 2.9999999999999998e-15 * ddt(V(cpphdl_n461, Vss)); // Bench initial voltage = 0.0 V.
        // device 156, IC IC19, analog/basic/mos_r2r_dac.hpp:28
        I(cpphdl_n461, cpphdl_n475) <+ V(cpphdl_n461, cpphdl_n475) / 2000.0;
        // device 157, IC IC19, analog/basic/mos_r2r_dac.hpp:29
        I(cpphdl_n475, Vss) <+ 2.9999999999999998e-15 * ddt(V(cpphdl_n475, Vss)); // Bench initial voltage = 0.0 V.
        // device 158, IC IC19, analog/basic/mos_r2r_dac.hpp:31
        I(cpphdl_n474, cpphdl_n475) <+ V(cpphdl_n474, cpphdl_n475) / 1000.0;
        // device 159, IC IC26, analog/basic/inverter.hpp:11
        I(cpphdl_n465, Vdd) <+ cpphdl_channel(V(BIT_N0_6, Vdd), V(cpphdl_n465, Vdd), 0.080000000000000002, 0.69999999999999996, -1.0);
        // device 160, IC IC26, analog/basic/inverter.hpp:12
        I(cpphdl_n465, Vss) <+ cpphdl_channel(V(BIT_N0_6, Vss), V(cpphdl_n465, Vss), 0.080000000000000002, 0.69999999999999996, 1.0);
        // device 161, IC IC19, analog/basic/mos_r2r_dac.hpp:27
        I(cpphdl_n465, Vss) <+ 2.9999999999999998e-15 * ddt(V(cpphdl_n465, Vss)); // Bench initial voltage = 0.0 V.
        // device 162, IC IC19, analog/basic/mos_r2r_dac.hpp:28
        I(cpphdl_n465, cpphdl_n476) <+ V(cpphdl_n465, cpphdl_n476) / 2000.0;
        // device 163, IC IC19, analog/basic/mos_r2r_dac.hpp:29
        I(cpphdl_n476, Vss) <+ 2.9999999999999998e-15 * ddt(V(cpphdl_n476, Vss)); // Bench initial voltage = 0.0 V.
        // device 164, IC IC19, analog/basic/mos_r2r_dac.hpp:31
        I(cpphdl_n475, cpphdl_n476) <+ V(cpphdl_n475, cpphdl_n476) / 1000.0;
        // device 165, IC IC27, analog/basic/inverter.hpp:11
        I(cpphdl_n469, Vdd) <+ cpphdl_channel(V(BIT_N0_7, Vdd), V(cpphdl_n469, Vdd), 0.080000000000000002, 0.69999999999999996, -1.0);
        // device 166, IC IC27, analog/basic/inverter.hpp:12
        I(cpphdl_n469, Vss) <+ cpphdl_channel(V(BIT_N0_7, Vss), V(cpphdl_n469, Vss), 0.080000000000000002, 0.69999999999999996, 1.0);
        // device 167, IC IC19, analog/basic/mos_r2r_dac.hpp:27
        I(cpphdl_n469, Vss) <+ 2.9999999999999998e-15 * ddt(V(cpphdl_n469, Vss)); // Bench initial voltage = 0.0 V.
        // device 168, IC IC19, analog/basic/mos_r2r_dac.hpp:28
        I(cpphdl_n469, cpphdl_n481) <+ V(cpphdl_n469, cpphdl_n481) / 2000.0;
        // device 169, IC IC19, analog/basic/mos_r2r_dac.hpp:29
        I(cpphdl_n481, Vss) <+ 2.9999999999999998e-15 * ddt(V(cpphdl_n481, Vss)); // Bench initial voltage = 0.0 V.
        // device 170, IC IC19, analog/basic/mos_r2r_dac.hpp:31
        I(cpphdl_n476, cpphdl_n481) <+ V(cpphdl_n476, cpphdl_n481) / 1000.0;
        // device 171, IC IC19, analog/basic/mos_r2r_dac.hpp:33
        I(Vss, cpphdl_n470) <+ V(Vss, cpphdl_n470) / 2000.0;
        // device 172, IC IC28, analog/basic/nmos_resistor_amplifier.hpp:23
        I(Vdd, cpphdl_n490) <+ V(Vdd, cpphdl_n490) / 1000.0;
        // device 173, IC IC28, analog/basic/nmos_resistor_amplifier.hpp:24
        I(Vdd, cpphdl_n489) <+ V(Vdd, cpphdl_n489) / 1000.0;
        // device 174, IC IC28, analog/basic/nmos_resistor_amplifier.hpp:25
        I(cpphdl_n490, cpphdl_n484) <+ cpphdl_channel(V(cpphdl_n480, cpphdl_n484), V(cpphdl_n490, cpphdl_n484), 0.0074999999999999997, 0.69999999999999996, 1.0);
        // device 175, IC IC28, analog/basic/nmos_resistor_amplifier.hpp:26
        I(cpphdl_n489, cpphdl_n485) <+ cpphdl_channel(V(cpphdl_n481, cpphdl_n485), V(cpphdl_n489, cpphdl_n485), 0.0074999999999999997, 0.69999999999999996, 1.0);
        // device 176, IC IC28, analog/basic/nmos_resistor_amplifier.hpp:27
        I(cpphdl_n486, cpphdl_n484) <+ V(cpphdl_n486, cpphdl_n484) / 100.0;
        // device 177, IC IC28, analog/basic/nmos_resistor_amplifier.hpp:28
        I(cpphdl_n486, cpphdl_n485) <+ V(cpphdl_n486, cpphdl_n485) / 100.0;
        // device 178, IC IC28, analog/basic/nmos_resistor_amplifier.hpp:29
        I(Vss, cpphdl_n486) <+ V(Vss, cpphdl_n486) / 300.0;
        // device 179, IC IC28, analog/basic/nmos_resistor_amplifier.hpp:30
        I(cpphdl_n490, Vdd) <+ 2.9999999999999998e-13 * ddt(V(cpphdl_n490, Vdd)); // Bench initial voltage = 0.0 V.
        // device 180, IC IC28, analog/basic/nmos_resistor_amplifier.hpp:31
        I(cpphdl_n489, Vdd) <+ 2.9999999999999998e-13 * ddt(V(cpphdl_n489, Vdd)); // Bench initial voltage = 0.0 V.
        // device 181, IC IC28, analog/basic/nmos_resistor_amplifier.hpp:32
        I(cpphdl_n486, Vss) <+ 4e-14 * ddt(V(cpphdl_n486, Vss)); // Bench initial voltage = 0.0 V.
        // device 182, IC IC28, analog/basic/nmos_resistor_amplifier.hpp:34
        I(cpphdl_n480, cpphdl_n484) <+ 2e-14 * ddt(V(cpphdl_n480, cpphdl_n484)); // Bench initial voltage = 0.0 V.
        // device 183, IC IC28, analog/basic/nmos_resistor_amplifier.hpp:35
        I(cpphdl_n481, cpphdl_n485) <+ 2e-14 * ddt(V(cpphdl_n481, cpphdl_n485)); // Bench initial voltage = 0.0 V.
        // device 184, IC IC28, analog/basic/nmos_resistor_amplifier.hpp:36
        I(cpphdl_n480, cpphdl_n490) <+ 2.9999999999999998e-15 * ddt(V(cpphdl_n480, cpphdl_n490)); // Bench initial voltage = 0.0 V.
        // device 185, IC IC28, analog/basic/nmos_resistor_amplifier.hpp:37
        I(cpphdl_n481, cpphdl_n489) <+ 2.9999999999999998e-15 * ddt(V(cpphdl_n481, cpphdl_n489)); // Bench initial voltage = 0.0 V.
        // device 186, IC IC29, analog/basic/strongarm_comparator.hpp:28
        I(cpphdl_n494, cpphdl_n496) <+ cpphdl_channel(V(cpphdl_n489, cpphdl_n496), V(cpphdl_n494, cpphdl_n496), 0.0080000000000000002, 0.69999999999999996, 1.0);
        // device 187, IC IC29, analog/basic/strongarm_comparator.hpp:29
        I(cpphdl_n495, cpphdl_n496) <+ cpphdl_channel(V(cpphdl_n490, cpphdl_n496), V(cpphdl_n495, cpphdl_n496), 0.0080000000000000002, 0.69999999999999996, 1.0);
        // device 188, IC IC29, analog/basic/strongarm_comparator.hpp:30
        I(cpphdl_n496, Vss) <+ cpphdl_channel(V(EVALUATE, Vss), V(cpphdl_n496, Vss), 0.0080000000000000002, 0.69999999999999996, 1.0);
        // device 189, IC IC29, analog/basic/strongarm_comparator.hpp:33
        I(cpphdl_n509, cpphdl_n494) <+ cpphdl_channel(V(cpphdl_n513, cpphdl_n494), V(cpphdl_n509, cpphdl_n494), 0.0040000000000000001, 0.69999999999999996, 1.0);
        // device 190, IC IC29, analog/basic/strongarm_comparator.hpp:34
        I(cpphdl_n513, cpphdl_n495) <+ cpphdl_channel(V(cpphdl_n509, cpphdl_n495), V(cpphdl_n513, cpphdl_n495), 0.0040000000000000001, 0.69999999999999996, 1.0);
        // device 191, IC IC29, analog/basic/strongarm_comparator.hpp:35
        I(cpphdl_n513, Vdd) <+ cpphdl_channel(V(cpphdl_n509, Vdd), V(cpphdl_n513, Vdd), 0.002, 0.69999999999999996, -1.0);
        // device 192, IC IC29, analog/basic/strongarm_comparator.hpp:36
        I(cpphdl_n509, Vdd) <+ cpphdl_channel(V(cpphdl_n513, Vdd), V(cpphdl_n509, Vdd), 0.002, 0.69999999999999996, -1.0);
        // device 193, IC IC29, analog/basic/strongarm_comparator.hpp:38
        I(cpphdl_n494, Vdd) <+ cpphdl_channel(V(EVALUATE, Vdd), V(cpphdl_n494, Vdd), 0.002, 0.69999999999999996, -1.0);
        // device 194, IC IC29, analog/basic/strongarm_comparator.hpp:39
        I(cpphdl_n495, Vdd) <+ cpphdl_channel(V(EVALUATE, Vdd), V(cpphdl_n495, Vdd), 0.002, 0.69999999999999996, -1.0);
        // device 195, IC IC29, analog/basic/strongarm_comparator.hpp:40
        I(cpphdl_n513, Vdd) <+ cpphdl_channel(V(EVALUATE, Vdd), V(cpphdl_n513, Vdd), 0.002, 0.69999999999999996, -1.0);
        // device 196, IC IC29, analog/basic/strongarm_comparator.hpp:41
        I(cpphdl_n509, Vdd) <+ cpphdl_channel(V(EVALUATE, Vdd), V(cpphdl_n509, Vdd), 0.002, 0.69999999999999996, -1.0);
        // device 197, IC IC29, analog/basic/strongarm_comparator.hpp:42
        I(cpphdl_n494, Vss) <+ 2.9999999999999998e-14 * ddt(V(cpphdl_n494, Vss)); // Bench initial voltage = 0.0 V.
        // device 198, IC IC29, analog/basic/strongarm_comparator.hpp:43
        I(cpphdl_n495, Vss) <+ 2.9999999999999998e-14 * ddt(V(cpphdl_n495, Vss)); // Bench initial voltage = 0.0 V.
        // device 199, IC IC29, analog/basic/strongarm_comparator.hpp:44
        I(cpphdl_n496, Vss) <+ 2.9999999999999998e-14 * ddt(V(cpphdl_n496, Vss)); // Bench initial voltage = 0.0 V.
        // device 200, IC IC29, analog/basic/strongarm_comparator.hpp:45
        I(cpphdl_n513, Vss) <+ 5.0000000000000002e-14 * ddt(V(cpphdl_n513, Vss)); // Bench initial voltage = 0.0 V.
        // device 201, IC IC29, analog/basic/strongarm_comparator.hpp:46
        I(cpphdl_n509, Vss) <+ 5.0000000000000002e-14 * ddt(V(cpphdl_n509, Vss)); // Bench initial voltage = 0.0 V.
        // device 202, IC IC29, analog/basic/strongarm_comparator.hpp:47
        I(cpphdl_n489, cpphdl_n496) <+ 2e-14 * ddt(V(cpphdl_n489, cpphdl_n496)); // Bench initial voltage = 0.0 V.
        // device 203, IC IC29, analog/basic/strongarm_comparator.hpp:48
        I(cpphdl_n490, cpphdl_n496) <+ 2e-14 * ddt(V(cpphdl_n490, cpphdl_n496)); // Bench initial voltage = 0.0 V.
        // device 204, IC IC29, analog/basic/strongarm_comparator.hpp:49
        I(cpphdl_n489, cpphdl_n494) <+ 2.9999999999999998e-15 * ddt(V(cpphdl_n489, cpphdl_n494)); // Bench initial voltage = 0.0 V.
        // device 205, IC IC29, analog/basic/strongarm_comparator.hpp:50
        I(cpphdl_n490, cpphdl_n495) <+ 2.9999999999999998e-15 * ddt(V(cpphdl_n490, cpphdl_n495)); // Bench initial voltage = 0.0 V.
        // device 206, IC IC31, analog/basic/inverter.hpp:11
        I(cpphdl_n517, Vdd) <+ cpphdl_channel(V(cpphdl_n509, Vdd), V(cpphdl_n517, Vdd), 0.001, 0.69999999999999996, -1.0);
        // device 207, IC IC31, analog/basic/inverter.hpp:12
        I(cpphdl_n517, Vss) <+ cpphdl_channel(V(cpphdl_n509, Vss), V(cpphdl_n517, Vss), 0.001, 0.69999999999999996, 1.0);
        // device 208, IC IC33, analog/basic/inverter.hpp:11
        I(cpphdl_n531, Vdd) <+ cpphdl_channel(V(cpphdl_n517, Vdd), V(cpphdl_n531, Vdd), 0.0040000000000000001, 0.69999999999999996, -1.0);
        // device 209, IC IC33, analog/basic/inverter.hpp:12
        I(cpphdl_n531, Vss) <+ cpphdl_channel(V(cpphdl_n517, Vss), V(cpphdl_n531, Vss), 0.0040000000000000001, 0.69999999999999996, 1.0);
        // device 210, IC IC30, analog/basic/buffered_nand_latch.hpp:34
        I(cpphdl_n509, Vss) <+ 2.0000000000000002e-15 * ddt(V(cpphdl_n509, Vss)); // Bench initial voltage = 0.0 V.
        // device 211, IC IC30, analog/basic/buffered_nand_latch.hpp:35
        I(cpphdl_n509, cpphdl_n517) <+ 1.0000000000000001e-15 * ddt(V(cpphdl_n509, cpphdl_n517)); // Bench initial voltage = 0.0 V.
        // device 212, IC IC30, analog/basic/buffered_nand_latch.hpp:36
        I(cpphdl_n517, Vss) <+ 5e-15 * ddt(V(cpphdl_n517, Vss)); // Bench initial voltage = 0.0 V.
        // device 213, IC IC30, analog/basic/buffered_nand_latch.hpp:37
        I(cpphdl_n517, Vss) <+ 8.0000000000000006e-15 * ddt(V(cpphdl_n517, Vss)); // Bench initial voltage = 0.0 V.
        // device 214, IC IC30, analog/basic/buffered_nand_latch.hpp:38
        I(cpphdl_n531, Vss) <+ 1e-14 * ddt(V(cpphdl_n531, Vss)); // Bench initial voltage = 0.0 V.
        // device 215, IC IC32, analog/basic/inverter.hpp:11
        I(cpphdl_n521, Vdd) <+ cpphdl_channel(V(cpphdl_n513, Vdd), V(cpphdl_n521, Vdd), 0.001, 0.69999999999999996, -1.0);
        // device 216, IC IC32, analog/basic/inverter.hpp:12
        I(cpphdl_n521, Vss) <+ cpphdl_channel(V(cpphdl_n513, Vss), V(cpphdl_n521, Vss), 0.001, 0.69999999999999996, 1.0);
        // device 217, IC IC34, analog/basic/inverter.hpp:11
        I(cpphdl_n537, Vdd) <+ cpphdl_channel(V(cpphdl_n521, Vdd), V(cpphdl_n537, Vdd), 0.0040000000000000001, 0.69999999999999996, -1.0);
        // device 218, IC IC34, analog/basic/inverter.hpp:12
        I(cpphdl_n537, Vss) <+ cpphdl_channel(V(cpphdl_n521, Vss), V(cpphdl_n537, Vss), 0.0040000000000000001, 0.69999999999999996, 1.0);
        // device 219, IC IC30, analog/basic/buffered_nand_latch.hpp:34
        I(cpphdl_n513, Vss) <+ 2.0000000000000002e-15 * ddt(V(cpphdl_n513, Vss)); // Bench initial voltage = 0.0 V.
        // device 220, IC IC30, analog/basic/buffered_nand_latch.hpp:35
        I(cpphdl_n513, cpphdl_n521) <+ 1.0000000000000001e-15 * ddt(V(cpphdl_n513, cpphdl_n521)); // Bench initial voltage = 0.0 V.
        // device 221, IC IC30, analog/basic/buffered_nand_latch.hpp:36
        I(cpphdl_n521, Vss) <+ 5e-15 * ddt(V(cpphdl_n521, Vss)); // Bench initial voltage = 0.0 V.
        // device 222, IC IC30, analog/basic/buffered_nand_latch.hpp:37
        I(cpphdl_n521, Vss) <+ 8.0000000000000006e-15 * ddt(V(cpphdl_n521, Vss)); // Bench initial voltage = 0.0 V.
        // device 223, IC IC30, analog/basic/buffered_nand_latch.hpp:38
        I(cpphdl_n537, Vss) <+ 1e-14 * ddt(V(cpphdl_n537, Vss)); // Bench initial voltage = 0.0 V.
        // device 224, IC IC36, analog/basic/cmos_logic.hpp:17
        I(cpphdl_n2278, Vss) <+ 5.0000000000000002e-14 * ddt(V(cpphdl_n2278, Vss)); // Bench initial voltage = 0.0 V.
        // device 225, IC IC36, analog/basic/cmos_logic.hpp:18
        I(cpphdl_n2278, Vdd) <+ cpphdl_channel(V(cpphdl_n531, Vdd), V(cpphdl_n2278, Vdd), 0.01, 0.69999999999999996, -1.0);
        // device 226, IC IC36, analog/basic/cmos_logic.hpp:19
        I(cpphdl_n2278, Vdd) <+ cpphdl_channel(V(cpphdl_n539, Vdd), V(cpphdl_n2278, Vdd), 0.01, 0.69999999999999996, -1.0);
        // device 227, IC IC36, analog/basic/cmos_logic.hpp:20
        I(cpphdl_n2278, cpphdl_n534) <+ cpphdl_channel(V(cpphdl_n531, cpphdl_n534), V(cpphdl_n2278, cpphdl_n534), 0.01, 0.69999999999999996, 1.0);
        // device 228, IC IC36, analog/basic/cmos_logic.hpp:21
        I(cpphdl_n534, Vss) <+ cpphdl_channel(V(cpphdl_n539, Vss), V(cpphdl_n534, Vss), 0.01, 0.69999999999999996, 1.0);
        // device 229, IC IC36, analog/basic/cmos_logic.hpp:27
        I(cpphdl_n534, Vss) <+ 1e-14 * ddt(V(cpphdl_n534, Vss)); // Bench initial voltage = 0.0 V.
        // device 230, IC IC37, analog/basic/cmos_logic.hpp:17
        I(cpphdl_n539, Vss) <+ 5.0000000000000002e-14 * ddt(V(cpphdl_n539, Vss)); // Bench initial voltage = 0.0 V.
        // device 231, IC IC37, analog/basic/cmos_logic.hpp:18
        I(cpphdl_n539, Vdd) <+ cpphdl_channel(V(cpphdl_n537, Vdd), V(cpphdl_n539, Vdd), 0.01, 0.69999999999999996, -1.0);
        // device 232, IC IC37, analog/basic/cmos_logic.hpp:19
        I(cpphdl_n539, Vdd) <+ cpphdl_channel(V(cpphdl_n2278, Vdd), V(cpphdl_n539, Vdd), 0.01, 0.69999999999999996, -1.0);
        // device 233, IC IC37, analog/basic/cmos_logic.hpp:20
        I(cpphdl_n539, cpphdl_n540) <+ cpphdl_channel(V(cpphdl_n537, cpphdl_n540), V(cpphdl_n539, cpphdl_n540), 0.01, 0.69999999999999996, 1.0);
        // device 234, IC IC37, analog/basic/cmos_logic.hpp:21
        I(cpphdl_n540, Vss) <+ cpphdl_channel(V(cpphdl_n2278, Vss), V(cpphdl_n540, Vss), 0.01, 0.69999999999999996, 1.0);
        // device 235, IC IC37, analog/basic/cmos_logic.hpp:27
        I(cpphdl_n540, Vss) <+ 1e-14 * ddt(V(cpphdl_n540, Vss)); // Bench initial voltage = 0.0 V.
        // device 236, IC IC35, analog/basic/nand_latch.hpp:36
        I(cpphdl_n531, Vss) <+ 2.9999999999999998e-15 * ddt(V(cpphdl_n531, Vss)); // Bench initial voltage = 0.0 V.
        // device 237, IC IC35, analog/basic/nand_latch.hpp:37
        I(cpphdl_n537, Vss) <+ 2.9999999999999998e-15 * ddt(V(cpphdl_n537, Vss)); // Bench initial voltage = 0.0 V.
        // device 238, IC IC38, analog/basic/inverter.hpp:11
        I(cpphdl_n545, Vdd) <+ cpphdl_channel(V(CLEAR, Vdd), V(cpphdl_n545, Vdd), 0.01, 0.69999999999999996, -1.0);
        // device 239, IC IC38, analog/basic/inverter.hpp:12
        I(cpphdl_n545, Vss) <+ cpphdl_channel(V(CLEAR, Vss), V(cpphdl_n545, Vss), 0.01, 0.69999999999999996, 1.0);
        // device 240, IC IC35, analog/basic/nand_latch.hpp:58
        I(cpphdl_n545, Vss) <+ 2.9999999999999998e-15 * ddt(V(cpphdl_n545, Vss)); // Bench initial voltage = 0.0 V.
        // device 241, IC IC35, analog/basic/nand_latch.hpp:59
        I(cpphdl_n2278, Vss) <+ cpphdl_channel(V(CLEAR, Vss), V(cpphdl_n2278, Vss), 0.050000000000000003, 0.69999999999999996, 1.0);
        // device 242, IC IC35, analog/basic/nand_latch.hpp:60
        I(cpphdl_n539, Vdd) <+ cpphdl_channel(V(cpphdl_n545, Vdd), V(cpphdl_n539, Vdd), 0.050000000000000003, 0.69999999999999996, -1.0);
        // device 243, IC IC41, analog/basic/inverter.hpp:11
        I(cpphdl_n569, Vdd) <+ cpphdl_channel(V(TRACK1, Vdd), V(cpphdl_n569, Vdd), 0.0040000000000000001, 0.69999999999999996, -1.0);
        // device 244, IC IC41, analog/basic/inverter.hpp:12
        I(cpphdl_n569, Vss) <+ cpphdl_channel(V(TRACK1, Vss), V(cpphdl_n569, Vss), 0.0040000000000000001, 0.69999999999999996, 1.0);
        // device 245, IC IC40, analog/basic/mos_track_hold.hpp:31
        I(cpphdl_n569, Vss) <+ 2e-14 * ddt(V(cpphdl_n569, Vss)); // Bench initial voltage = 0.0 V.
        // device 246, IC IC40, analog/basic/mos_track_hold.hpp:32
        I(cpphdl_n2136, cpphdl_n623) <+ cpphdl_channel(V(TRACK1, cpphdl_n623), V(cpphdl_n2136, cpphdl_n623), 0.029999999999999999, 0.69999999999999996, 1.0);
        // device 247, IC IC40, analog/basic/mos_track_hold.hpp:33
        I(cpphdl_n623, cpphdl_n2136) <+ cpphdl_channel(V(cpphdl_n569, cpphdl_n2136), V(cpphdl_n623, cpphdl_n2136), 0.014999999999999999, 0.69999999999999996, -1.0);
        // device 248, IC IC40, analog/basic/mos_track_hold.hpp:37
        I(cpphdl_n623, cpphdl_n623) <+ cpphdl_channel(V(cpphdl_n569, cpphdl_n623), V(cpphdl_n623, cpphdl_n623), 0.016, 0.69999999999999996, 1.0);
        // device 249, IC IC40, analog/basic/mos_track_hold.hpp:38
        I(cpphdl_n623, cpphdl_n623) <+ cpphdl_channel(V(TRACK1, cpphdl_n623), V(cpphdl_n623, cpphdl_n623), 0.0083999999999999995, 0.69999999999999996, -1.0);
        // device 250, IC IC40, analog/basic/mos_track_hold.hpp:39
        I(cpphdl_n623, Vss) <+ 1.5000000000000001e-12 * ddt(V(cpphdl_n623, Vss)); // Bench initial voltage = 0.0 V.
        // device 251, IC IC40, analog/basic/mos_track_hold.hpp:42
        I(TRACK1, cpphdl_n623) <+ 2.0000000000000002e-15 * ddt(V(TRACK1, cpphdl_n623)); // Bench initial voltage = -0.0 V.
        // device 252, IC IC40, analog/basic/mos_track_hold.hpp:43
        I(cpphdl_n569, cpphdl_n623) <+ 2.0000000000000002e-15 * ddt(V(cpphdl_n569, cpphdl_n623)); // Bench initial voltage = 0.0 V.
        // device 253, IC IC40, analog/basic/mos_track_hold.hpp:44
        I(cpphdl_n2136, cpphdl_n623) <+ 1.0000000000000001e-15 * ddt(V(cpphdl_n2136, cpphdl_n623)); // Bench initial voltage = 0.0 V.
        // device 254, IC IC43, analog/basic/inverter.hpp:11
        I(cpphdl_n584, Vdd) <+ cpphdl_channel(V(BIT_N1_0, Vdd), V(cpphdl_n584, Vdd), 0.080000000000000002, 0.69999999999999996, -1.0);
        // device 255, IC IC43, analog/basic/inverter.hpp:12
        I(cpphdl_n584, Vss) <+ cpphdl_channel(V(BIT_N1_0, Vss), V(cpphdl_n584, Vss), 0.080000000000000002, 0.69999999999999996, 1.0);
        // device 256, IC IC42, analog/basic/mos_r2r_dac.hpp:27
        I(cpphdl_n584, Vss) <+ 2.9999999999999998e-15 * ddt(V(cpphdl_n584, Vss)); // Bench initial voltage = 0.0 V.
        // device 257, IC IC42, analog/basic/mos_r2r_dac.hpp:28
        I(cpphdl_n584, cpphdl_n613) <+ V(cpphdl_n584, cpphdl_n613) / 2000.0;
        // device 258, IC IC42, analog/basic/mos_r2r_dac.hpp:29
        I(cpphdl_n613, Vss) <+ 2.9999999999999998e-15 * ddt(V(cpphdl_n613, Vss)); // Bench initial voltage = 0.0 V.
        // device 259, IC IC44, analog/basic/inverter.hpp:11
        I(cpphdl_n588, Vdd) <+ cpphdl_channel(V(BIT_N1_1, Vdd), V(cpphdl_n588, Vdd), 0.080000000000000002, 0.69999999999999996, -1.0);
        // device 260, IC IC44, analog/basic/inverter.hpp:12
        I(cpphdl_n588, Vss) <+ cpphdl_channel(V(BIT_N1_1, Vss), V(cpphdl_n588, Vss), 0.080000000000000002, 0.69999999999999996, 1.0);
        // device 261, IC IC42, analog/basic/mos_r2r_dac.hpp:27
        I(cpphdl_n588, Vss) <+ 2.9999999999999998e-15 * ddt(V(cpphdl_n588, Vss)); // Bench initial voltage = 0.0 V.
        // device 262, IC IC42, analog/basic/mos_r2r_dac.hpp:28
        I(cpphdl_n588, cpphdl_n614) <+ V(cpphdl_n588, cpphdl_n614) / 2000.0;
        // device 263, IC IC42, analog/basic/mos_r2r_dac.hpp:29
        I(cpphdl_n614, Vss) <+ 2.9999999999999998e-15 * ddt(V(cpphdl_n614, Vss)); // Bench initial voltage = 0.0 V.
        // device 264, IC IC42, analog/basic/mos_r2r_dac.hpp:31
        I(cpphdl_n613, cpphdl_n614) <+ V(cpphdl_n613, cpphdl_n614) / 1000.0;
        // device 265, IC IC45, analog/basic/inverter.hpp:11
        I(cpphdl_n592, Vdd) <+ cpphdl_channel(V(BIT_N1_2, Vdd), V(cpphdl_n592, Vdd), 0.080000000000000002, 0.69999999999999996, -1.0);
        // device 266, IC IC45, analog/basic/inverter.hpp:12
        I(cpphdl_n592, Vss) <+ cpphdl_channel(V(BIT_N1_2, Vss), V(cpphdl_n592, Vss), 0.080000000000000002, 0.69999999999999996, 1.0);
        // device 267, IC IC42, analog/basic/mos_r2r_dac.hpp:27
        I(cpphdl_n592, Vss) <+ 2.9999999999999998e-15 * ddt(V(cpphdl_n592, Vss)); // Bench initial voltage = 0.0 V.
        // device 268, IC IC42, analog/basic/mos_r2r_dac.hpp:28
        I(cpphdl_n592, cpphdl_n615) <+ V(cpphdl_n592, cpphdl_n615) / 2000.0;
        // device 269, IC IC42, analog/basic/mos_r2r_dac.hpp:29
        I(cpphdl_n615, Vss) <+ 2.9999999999999998e-15 * ddt(V(cpphdl_n615, Vss)); // Bench initial voltage = 0.0 V.
        // device 270, IC IC42, analog/basic/mos_r2r_dac.hpp:31
        I(cpphdl_n614, cpphdl_n615) <+ V(cpphdl_n614, cpphdl_n615) / 1000.0;
        // device 271, IC IC46, analog/basic/inverter.hpp:11
        I(cpphdl_n596, Vdd) <+ cpphdl_channel(V(BIT_N1_3, Vdd), V(cpphdl_n596, Vdd), 0.080000000000000002, 0.69999999999999996, -1.0);
        // device 272, IC IC46, analog/basic/inverter.hpp:12
        I(cpphdl_n596, Vss) <+ cpphdl_channel(V(BIT_N1_3, Vss), V(cpphdl_n596, Vss), 0.080000000000000002, 0.69999999999999996, 1.0);
        // device 273, IC IC42, analog/basic/mos_r2r_dac.hpp:27
        I(cpphdl_n596, Vss) <+ 2.9999999999999998e-15 * ddt(V(cpphdl_n596, Vss)); // Bench initial voltage = 0.0 V.
        // device 274, IC IC42, analog/basic/mos_r2r_dac.hpp:28
        I(cpphdl_n596, cpphdl_n616) <+ V(cpphdl_n596, cpphdl_n616) / 2000.0;
        // device 275, IC IC42, analog/basic/mos_r2r_dac.hpp:29
        I(cpphdl_n616, Vss) <+ 2.9999999999999998e-15 * ddt(V(cpphdl_n616, Vss)); // Bench initial voltage = 0.0 V.
        // device 276, IC IC42, analog/basic/mos_r2r_dac.hpp:31
        I(cpphdl_n615, cpphdl_n616) <+ V(cpphdl_n615, cpphdl_n616) / 1000.0;
        // device 277, IC IC47, analog/basic/inverter.hpp:11
        I(cpphdl_n600, Vdd) <+ cpphdl_channel(V(BIT_N1_4, Vdd), V(cpphdl_n600, Vdd), 0.080000000000000002, 0.69999999999999996, -1.0);
        // device 278, IC IC47, analog/basic/inverter.hpp:12
        I(cpphdl_n600, Vss) <+ cpphdl_channel(V(BIT_N1_4, Vss), V(cpphdl_n600, Vss), 0.080000000000000002, 0.69999999999999996, 1.0);
        // device 279, IC IC42, analog/basic/mos_r2r_dac.hpp:27
        I(cpphdl_n600, Vss) <+ 2.9999999999999998e-15 * ddt(V(cpphdl_n600, Vss)); // Bench initial voltage = 0.0 V.
        // device 280, IC IC42, analog/basic/mos_r2r_dac.hpp:28
        I(cpphdl_n600, cpphdl_n617) <+ V(cpphdl_n600, cpphdl_n617) / 2000.0;
        // device 281, IC IC42, analog/basic/mos_r2r_dac.hpp:29
        I(cpphdl_n617, Vss) <+ 2.9999999999999998e-15 * ddt(V(cpphdl_n617, Vss)); // Bench initial voltage = 0.0 V.
        // device 282, IC IC42, analog/basic/mos_r2r_dac.hpp:31
        I(cpphdl_n616, cpphdl_n617) <+ V(cpphdl_n616, cpphdl_n617) / 1000.0;
        // device 283, IC IC48, analog/basic/inverter.hpp:11
        I(cpphdl_n604, Vdd) <+ cpphdl_channel(V(BIT_N1_5, Vdd), V(cpphdl_n604, Vdd), 0.080000000000000002, 0.69999999999999996, -1.0);
        // device 284, IC IC48, analog/basic/inverter.hpp:12
        I(cpphdl_n604, Vss) <+ cpphdl_channel(V(BIT_N1_5, Vss), V(cpphdl_n604, Vss), 0.080000000000000002, 0.69999999999999996, 1.0);
        // device 285, IC IC42, analog/basic/mos_r2r_dac.hpp:27
        I(cpphdl_n604, Vss) <+ 2.9999999999999998e-15 * ddt(V(cpphdl_n604, Vss)); // Bench initial voltage = 0.0 V.
        // device 286, IC IC42, analog/basic/mos_r2r_dac.hpp:28
        I(cpphdl_n604, cpphdl_n618) <+ V(cpphdl_n604, cpphdl_n618) / 2000.0;
        // device 287, IC IC42, analog/basic/mos_r2r_dac.hpp:29
        I(cpphdl_n618, Vss) <+ 2.9999999999999998e-15 * ddt(V(cpphdl_n618, Vss)); // Bench initial voltage = 0.0 V.
        // device 288, IC IC42, analog/basic/mos_r2r_dac.hpp:31
        I(cpphdl_n617, cpphdl_n618) <+ V(cpphdl_n617, cpphdl_n618) / 1000.0;
        // device 289, IC IC49, analog/basic/inverter.hpp:11
        I(cpphdl_n608, Vdd) <+ cpphdl_channel(V(BIT_N1_6, Vdd), V(cpphdl_n608, Vdd), 0.080000000000000002, 0.69999999999999996, -1.0);
        // device 290, IC IC49, analog/basic/inverter.hpp:12
        I(cpphdl_n608, Vss) <+ cpphdl_channel(V(BIT_N1_6, Vss), V(cpphdl_n608, Vss), 0.080000000000000002, 0.69999999999999996, 1.0);
        // device 291, IC IC42, analog/basic/mos_r2r_dac.hpp:27
        I(cpphdl_n608, Vss) <+ 2.9999999999999998e-15 * ddt(V(cpphdl_n608, Vss)); // Bench initial voltage = 0.0 V.
        // device 292, IC IC42, analog/basic/mos_r2r_dac.hpp:28
        I(cpphdl_n608, cpphdl_n619) <+ V(cpphdl_n608, cpphdl_n619) / 2000.0;
        // device 293, IC IC42, analog/basic/mos_r2r_dac.hpp:29
        I(cpphdl_n619, Vss) <+ 2.9999999999999998e-15 * ddt(V(cpphdl_n619, Vss)); // Bench initial voltage = 0.0 V.
        // device 294, IC IC42, analog/basic/mos_r2r_dac.hpp:31
        I(cpphdl_n618, cpphdl_n619) <+ V(cpphdl_n618, cpphdl_n619) / 1000.0;
        // device 295, IC IC50, analog/basic/inverter.hpp:11
        I(cpphdl_n612, Vdd) <+ cpphdl_channel(V(BIT_N1_7, Vdd), V(cpphdl_n612, Vdd), 0.080000000000000002, 0.69999999999999996, -1.0);
        // device 296, IC IC50, analog/basic/inverter.hpp:12
        I(cpphdl_n612, Vss) <+ cpphdl_channel(V(BIT_N1_7, Vss), V(cpphdl_n612, Vss), 0.080000000000000002, 0.69999999999999996, 1.0);
        // device 297, IC IC42, analog/basic/mos_r2r_dac.hpp:27
        I(cpphdl_n612, Vss) <+ 2.9999999999999998e-15 * ddt(V(cpphdl_n612, Vss)); // Bench initial voltage = 0.0 V.
        // device 298, IC IC42, analog/basic/mos_r2r_dac.hpp:28
        I(cpphdl_n612, cpphdl_n624) <+ V(cpphdl_n612, cpphdl_n624) / 2000.0;
        // device 299, IC IC42, analog/basic/mos_r2r_dac.hpp:29
        I(cpphdl_n624, Vss) <+ 2.9999999999999998e-15 * ddt(V(cpphdl_n624, Vss)); // Bench initial voltage = 0.0 V.
        // device 300, IC IC42, analog/basic/mos_r2r_dac.hpp:31
        I(cpphdl_n619, cpphdl_n624) <+ V(cpphdl_n619, cpphdl_n624) / 1000.0;
        // device 301, IC IC42, analog/basic/mos_r2r_dac.hpp:33
        I(Vss, cpphdl_n613) <+ V(Vss, cpphdl_n613) / 2000.0;
        // device 302, IC IC51, analog/basic/nmos_resistor_amplifier.hpp:23
        I(Vdd, cpphdl_n633) <+ V(Vdd, cpphdl_n633) / 1000.0;
        // device 303, IC IC51, analog/basic/nmos_resistor_amplifier.hpp:24
        I(Vdd, cpphdl_n632) <+ V(Vdd, cpphdl_n632) / 1000.0;
        // device 304, IC IC51, analog/basic/nmos_resistor_amplifier.hpp:25
        I(cpphdl_n633, cpphdl_n627) <+ cpphdl_channel(V(cpphdl_n623, cpphdl_n627), V(cpphdl_n633, cpphdl_n627), 0.0074999999999999997, 0.69999999999999996, 1.0);
        // device 305, IC IC51, analog/basic/nmos_resistor_amplifier.hpp:26
        I(cpphdl_n632, cpphdl_n628) <+ cpphdl_channel(V(cpphdl_n624, cpphdl_n628), V(cpphdl_n632, cpphdl_n628), 0.0074999999999999997, 0.69999999999999996, 1.0);
        // device 306, IC IC51, analog/basic/nmos_resistor_amplifier.hpp:27
        I(cpphdl_n629, cpphdl_n627) <+ V(cpphdl_n629, cpphdl_n627) / 100.0;
        // device 307, IC IC51, analog/basic/nmos_resistor_amplifier.hpp:28
        I(cpphdl_n629, cpphdl_n628) <+ V(cpphdl_n629, cpphdl_n628) / 100.0;
        // device 308, IC IC51, analog/basic/nmos_resistor_amplifier.hpp:29
        I(Vss, cpphdl_n629) <+ V(Vss, cpphdl_n629) / 300.0;
        // device 309, IC IC51, analog/basic/nmos_resistor_amplifier.hpp:30
        I(cpphdl_n633, Vdd) <+ 2.9999999999999998e-13 * ddt(V(cpphdl_n633, Vdd)); // Bench initial voltage = 0.0 V.
        // device 310, IC IC51, analog/basic/nmos_resistor_amplifier.hpp:31
        I(cpphdl_n632, Vdd) <+ 2.9999999999999998e-13 * ddt(V(cpphdl_n632, Vdd)); // Bench initial voltage = 0.0 V.
        // device 311, IC IC51, analog/basic/nmos_resistor_amplifier.hpp:32
        I(cpphdl_n629, Vss) <+ 4e-14 * ddt(V(cpphdl_n629, Vss)); // Bench initial voltage = 0.0 V.
        // device 312, IC IC51, analog/basic/nmos_resistor_amplifier.hpp:34
        I(cpphdl_n623, cpphdl_n627) <+ 2e-14 * ddt(V(cpphdl_n623, cpphdl_n627)); // Bench initial voltage = 0.0 V.
        // device 313, IC IC51, analog/basic/nmos_resistor_amplifier.hpp:35
        I(cpphdl_n624, cpphdl_n628) <+ 2e-14 * ddt(V(cpphdl_n624, cpphdl_n628)); // Bench initial voltage = 0.0 V.
        // device 314, IC IC51, analog/basic/nmos_resistor_amplifier.hpp:36
        I(cpphdl_n623, cpphdl_n633) <+ 2.9999999999999998e-15 * ddt(V(cpphdl_n623, cpphdl_n633)); // Bench initial voltage = 0.0 V.
        // device 315, IC IC51, analog/basic/nmos_resistor_amplifier.hpp:37
        I(cpphdl_n624, cpphdl_n632) <+ 2.9999999999999998e-15 * ddt(V(cpphdl_n624, cpphdl_n632)); // Bench initial voltage = 0.0 V.
        // device 316, IC IC52, analog/basic/strongarm_comparator.hpp:28
        I(cpphdl_n637, cpphdl_n639) <+ cpphdl_channel(V(cpphdl_n632, cpphdl_n639), V(cpphdl_n637, cpphdl_n639), 0.0080000000000000002, 0.69999999999999996, 1.0);
        // device 317, IC IC52, analog/basic/strongarm_comparator.hpp:29
        I(cpphdl_n638, cpphdl_n639) <+ cpphdl_channel(V(cpphdl_n633, cpphdl_n639), V(cpphdl_n638, cpphdl_n639), 0.0080000000000000002, 0.69999999999999996, 1.0);
        // device 318, IC IC52, analog/basic/strongarm_comparator.hpp:30
        I(cpphdl_n639, Vss) <+ cpphdl_channel(V(EVALUATE, Vss), V(cpphdl_n639, Vss), 0.0080000000000000002, 0.69999999999999996, 1.0);
        // device 319, IC IC52, analog/basic/strongarm_comparator.hpp:33
        I(cpphdl_n652, cpphdl_n637) <+ cpphdl_channel(V(cpphdl_n656, cpphdl_n637), V(cpphdl_n652, cpphdl_n637), 0.0040000000000000001, 0.69999999999999996, 1.0);
        // device 320, IC IC52, analog/basic/strongarm_comparator.hpp:34
        I(cpphdl_n656, cpphdl_n638) <+ cpphdl_channel(V(cpphdl_n652, cpphdl_n638), V(cpphdl_n656, cpphdl_n638), 0.0040000000000000001, 0.69999999999999996, 1.0);
        // device 321, IC IC52, analog/basic/strongarm_comparator.hpp:35
        I(cpphdl_n656, Vdd) <+ cpphdl_channel(V(cpphdl_n652, Vdd), V(cpphdl_n656, Vdd), 0.002, 0.69999999999999996, -1.0);
        // device 322, IC IC52, analog/basic/strongarm_comparator.hpp:36
        I(cpphdl_n652, Vdd) <+ cpphdl_channel(V(cpphdl_n656, Vdd), V(cpphdl_n652, Vdd), 0.002, 0.69999999999999996, -1.0);
        // device 323, IC IC52, analog/basic/strongarm_comparator.hpp:38
        I(cpphdl_n637, Vdd) <+ cpphdl_channel(V(EVALUATE, Vdd), V(cpphdl_n637, Vdd), 0.002, 0.69999999999999996, -1.0);
        // device 324, IC IC52, analog/basic/strongarm_comparator.hpp:39
        I(cpphdl_n638, Vdd) <+ cpphdl_channel(V(EVALUATE, Vdd), V(cpphdl_n638, Vdd), 0.002, 0.69999999999999996, -1.0);
        // device 325, IC IC52, analog/basic/strongarm_comparator.hpp:40
        I(cpphdl_n656, Vdd) <+ cpphdl_channel(V(EVALUATE, Vdd), V(cpphdl_n656, Vdd), 0.002, 0.69999999999999996, -1.0);
        // device 326, IC IC52, analog/basic/strongarm_comparator.hpp:41
        I(cpphdl_n652, Vdd) <+ cpphdl_channel(V(EVALUATE, Vdd), V(cpphdl_n652, Vdd), 0.002, 0.69999999999999996, -1.0);
        // device 327, IC IC52, analog/basic/strongarm_comparator.hpp:42
        I(cpphdl_n637, Vss) <+ 2.9999999999999998e-14 * ddt(V(cpphdl_n637, Vss)); // Bench initial voltage = 0.0 V.
        // device 328, IC IC52, analog/basic/strongarm_comparator.hpp:43
        I(cpphdl_n638, Vss) <+ 2.9999999999999998e-14 * ddt(V(cpphdl_n638, Vss)); // Bench initial voltage = 0.0 V.
        // device 329, IC IC52, analog/basic/strongarm_comparator.hpp:44
        I(cpphdl_n639, Vss) <+ 2.9999999999999998e-14 * ddt(V(cpphdl_n639, Vss)); // Bench initial voltage = 0.0 V.
        // device 330, IC IC52, analog/basic/strongarm_comparator.hpp:45
        I(cpphdl_n656, Vss) <+ 5.0000000000000002e-14 * ddt(V(cpphdl_n656, Vss)); // Bench initial voltage = 0.0 V.
        // device 331, IC IC52, analog/basic/strongarm_comparator.hpp:46
        I(cpphdl_n652, Vss) <+ 5.0000000000000002e-14 * ddt(V(cpphdl_n652, Vss)); // Bench initial voltage = 0.0 V.
        // device 332, IC IC52, analog/basic/strongarm_comparator.hpp:47
        I(cpphdl_n632, cpphdl_n639) <+ 2e-14 * ddt(V(cpphdl_n632, cpphdl_n639)); // Bench initial voltage = 0.0 V.
        // device 333, IC IC52, analog/basic/strongarm_comparator.hpp:48
        I(cpphdl_n633, cpphdl_n639) <+ 2e-14 * ddt(V(cpphdl_n633, cpphdl_n639)); // Bench initial voltage = 0.0 V.
        // device 334, IC IC52, analog/basic/strongarm_comparator.hpp:49
        I(cpphdl_n632, cpphdl_n637) <+ 2.9999999999999998e-15 * ddt(V(cpphdl_n632, cpphdl_n637)); // Bench initial voltage = 0.0 V.
        // device 335, IC IC52, analog/basic/strongarm_comparator.hpp:50
        I(cpphdl_n633, cpphdl_n638) <+ 2.9999999999999998e-15 * ddt(V(cpphdl_n633, cpphdl_n638)); // Bench initial voltage = 0.0 V.
        // device 336, IC IC54, analog/basic/inverter.hpp:11
        I(cpphdl_n660, Vdd) <+ cpphdl_channel(V(cpphdl_n652, Vdd), V(cpphdl_n660, Vdd), 0.001, 0.69999999999999996, -1.0);
        // device 337, IC IC54, analog/basic/inverter.hpp:12
        I(cpphdl_n660, Vss) <+ cpphdl_channel(V(cpphdl_n652, Vss), V(cpphdl_n660, Vss), 0.001, 0.69999999999999996, 1.0);
        // device 338, IC IC56, analog/basic/inverter.hpp:11
        I(cpphdl_n674, Vdd) <+ cpphdl_channel(V(cpphdl_n660, Vdd), V(cpphdl_n674, Vdd), 0.0040000000000000001, 0.69999999999999996, -1.0);
        // device 339, IC IC56, analog/basic/inverter.hpp:12
        I(cpphdl_n674, Vss) <+ cpphdl_channel(V(cpphdl_n660, Vss), V(cpphdl_n674, Vss), 0.0040000000000000001, 0.69999999999999996, 1.0);
        // device 340, IC IC53, analog/basic/buffered_nand_latch.hpp:34
        I(cpphdl_n652, Vss) <+ 2.0000000000000002e-15 * ddt(V(cpphdl_n652, Vss)); // Bench initial voltage = 0.0 V.
        // device 341, IC IC53, analog/basic/buffered_nand_latch.hpp:35
        I(cpphdl_n652, cpphdl_n660) <+ 1.0000000000000001e-15 * ddt(V(cpphdl_n652, cpphdl_n660)); // Bench initial voltage = 0.0 V.
        // device 342, IC IC53, analog/basic/buffered_nand_latch.hpp:36
        I(cpphdl_n660, Vss) <+ 5e-15 * ddt(V(cpphdl_n660, Vss)); // Bench initial voltage = 0.0 V.
        // device 343, IC IC53, analog/basic/buffered_nand_latch.hpp:37
        I(cpphdl_n660, Vss) <+ 8.0000000000000006e-15 * ddt(V(cpphdl_n660, Vss)); // Bench initial voltage = 0.0 V.
        // device 344, IC IC53, analog/basic/buffered_nand_latch.hpp:38
        I(cpphdl_n674, Vss) <+ 1e-14 * ddt(V(cpphdl_n674, Vss)); // Bench initial voltage = 0.0 V.
        // device 345, IC IC55, analog/basic/inverter.hpp:11
        I(cpphdl_n664, Vdd) <+ cpphdl_channel(V(cpphdl_n656, Vdd), V(cpphdl_n664, Vdd), 0.001, 0.69999999999999996, -1.0);
        // device 346, IC IC55, analog/basic/inverter.hpp:12
        I(cpphdl_n664, Vss) <+ cpphdl_channel(V(cpphdl_n656, Vss), V(cpphdl_n664, Vss), 0.001, 0.69999999999999996, 1.0);
        // device 347, IC IC57, analog/basic/inverter.hpp:11
        I(cpphdl_n680, Vdd) <+ cpphdl_channel(V(cpphdl_n664, Vdd), V(cpphdl_n680, Vdd), 0.0040000000000000001, 0.69999999999999996, -1.0);
        // device 348, IC IC57, analog/basic/inverter.hpp:12
        I(cpphdl_n680, Vss) <+ cpphdl_channel(V(cpphdl_n664, Vss), V(cpphdl_n680, Vss), 0.0040000000000000001, 0.69999999999999996, 1.0);
        // device 349, IC IC53, analog/basic/buffered_nand_latch.hpp:34
        I(cpphdl_n656, Vss) <+ 2.0000000000000002e-15 * ddt(V(cpphdl_n656, Vss)); // Bench initial voltage = 0.0 V.
        // device 350, IC IC53, analog/basic/buffered_nand_latch.hpp:35
        I(cpphdl_n656, cpphdl_n664) <+ 1.0000000000000001e-15 * ddt(V(cpphdl_n656, cpphdl_n664)); // Bench initial voltage = 0.0 V.
        // device 351, IC IC53, analog/basic/buffered_nand_latch.hpp:36
        I(cpphdl_n664, Vss) <+ 5e-15 * ddt(V(cpphdl_n664, Vss)); // Bench initial voltage = 0.0 V.
        // device 352, IC IC53, analog/basic/buffered_nand_latch.hpp:37
        I(cpphdl_n664, Vss) <+ 8.0000000000000006e-15 * ddt(V(cpphdl_n664, Vss)); // Bench initial voltage = 0.0 V.
        // device 353, IC IC53, analog/basic/buffered_nand_latch.hpp:38
        I(cpphdl_n680, Vss) <+ 1e-14 * ddt(V(cpphdl_n680, Vss)); // Bench initial voltage = 0.0 V.
        // device 354, IC IC59, analog/basic/cmos_logic.hpp:17
        I(cpphdl_n2283, Vss) <+ 5.0000000000000002e-14 * ddt(V(cpphdl_n2283, Vss)); // Bench initial voltage = 0.0 V.
        // device 355, IC IC59, analog/basic/cmos_logic.hpp:18
        I(cpphdl_n2283, Vdd) <+ cpphdl_channel(V(cpphdl_n674, Vdd), V(cpphdl_n2283, Vdd), 0.01, 0.69999999999999996, -1.0);
        // device 356, IC IC59, analog/basic/cmos_logic.hpp:19
        I(cpphdl_n2283, Vdd) <+ cpphdl_channel(V(cpphdl_n682, Vdd), V(cpphdl_n2283, Vdd), 0.01, 0.69999999999999996, -1.0);
        // device 357, IC IC59, analog/basic/cmos_logic.hpp:20
        I(cpphdl_n2283, cpphdl_n677) <+ cpphdl_channel(V(cpphdl_n674, cpphdl_n677), V(cpphdl_n2283, cpphdl_n677), 0.01, 0.69999999999999996, 1.0);
        // device 358, IC IC59, analog/basic/cmos_logic.hpp:21
        I(cpphdl_n677, Vss) <+ cpphdl_channel(V(cpphdl_n682, Vss), V(cpphdl_n677, Vss), 0.01, 0.69999999999999996, 1.0);
        // device 359, IC IC59, analog/basic/cmos_logic.hpp:27
        I(cpphdl_n677, Vss) <+ 1e-14 * ddt(V(cpphdl_n677, Vss)); // Bench initial voltage = 0.0 V.
        // device 360, IC IC60, analog/basic/cmos_logic.hpp:17
        I(cpphdl_n682, Vss) <+ 5.0000000000000002e-14 * ddt(V(cpphdl_n682, Vss)); // Bench initial voltage = 0.0 V.
        // device 361, IC IC60, analog/basic/cmos_logic.hpp:18
        I(cpphdl_n682, Vdd) <+ cpphdl_channel(V(cpphdl_n680, Vdd), V(cpphdl_n682, Vdd), 0.01, 0.69999999999999996, -1.0);
        // device 362, IC IC60, analog/basic/cmos_logic.hpp:19
        I(cpphdl_n682, Vdd) <+ cpphdl_channel(V(cpphdl_n2283, Vdd), V(cpphdl_n682, Vdd), 0.01, 0.69999999999999996, -1.0);
        // device 363, IC IC60, analog/basic/cmos_logic.hpp:20
        I(cpphdl_n682, cpphdl_n683) <+ cpphdl_channel(V(cpphdl_n680, cpphdl_n683), V(cpphdl_n682, cpphdl_n683), 0.01, 0.69999999999999996, 1.0);
        // device 364, IC IC60, analog/basic/cmos_logic.hpp:21
        I(cpphdl_n683, Vss) <+ cpphdl_channel(V(cpphdl_n2283, Vss), V(cpphdl_n683, Vss), 0.01, 0.69999999999999996, 1.0);
        // device 365, IC IC60, analog/basic/cmos_logic.hpp:27
        I(cpphdl_n683, Vss) <+ 1e-14 * ddt(V(cpphdl_n683, Vss)); // Bench initial voltage = 0.0 V.
        // device 366, IC IC58, analog/basic/nand_latch.hpp:36
        I(cpphdl_n674, Vss) <+ 2.9999999999999998e-15 * ddt(V(cpphdl_n674, Vss)); // Bench initial voltage = 0.0 V.
        // device 367, IC IC58, analog/basic/nand_latch.hpp:37
        I(cpphdl_n680, Vss) <+ 2.9999999999999998e-15 * ddt(V(cpphdl_n680, Vss)); // Bench initial voltage = 0.0 V.
        // device 368, IC IC61, analog/basic/inverter.hpp:11
        I(cpphdl_n688, Vdd) <+ cpphdl_channel(V(CLEAR, Vdd), V(cpphdl_n688, Vdd), 0.01, 0.69999999999999996, -1.0);
        // device 369, IC IC61, analog/basic/inverter.hpp:12
        I(cpphdl_n688, Vss) <+ cpphdl_channel(V(CLEAR, Vss), V(cpphdl_n688, Vss), 0.01, 0.69999999999999996, 1.0);
        // device 370, IC IC58, analog/basic/nand_latch.hpp:58
        I(cpphdl_n688, Vss) <+ 2.9999999999999998e-15 * ddt(V(cpphdl_n688, Vss)); // Bench initial voltage = 0.0 V.
        // device 371, IC IC58, analog/basic/nand_latch.hpp:59
        I(cpphdl_n2283, Vss) <+ cpphdl_channel(V(CLEAR, Vss), V(cpphdl_n2283, Vss), 0.050000000000000003, 0.69999999999999996, 1.0);
        // device 372, IC IC58, analog/basic/nand_latch.hpp:60
        I(cpphdl_n682, Vdd) <+ cpphdl_channel(V(cpphdl_n688, Vdd), V(cpphdl_n682, Vdd), 0.050000000000000003, 0.69999999999999996, -1.0);
        // device 373, IC IC64, analog/basic/inverter.hpp:11
        I(cpphdl_n712, Vdd) <+ cpphdl_channel(V(TRACK2, Vdd), V(cpphdl_n712, Vdd), 0.0040000000000000001, 0.69999999999999996, -1.0);
        // device 374, IC IC64, analog/basic/inverter.hpp:12
        I(cpphdl_n712, Vss) <+ cpphdl_channel(V(TRACK2, Vss), V(cpphdl_n712, Vss), 0.0040000000000000001, 0.69999999999999996, 1.0);
        // device 375, IC IC63, analog/basic/mos_track_hold.hpp:31
        I(cpphdl_n712, Vss) <+ 2e-14 * ddt(V(cpphdl_n712, Vss)); // Bench initial voltage = 0.0 V.
        // device 376, IC IC63, analog/basic/mos_track_hold.hpp:32
        I(cpphdl_n2136, cpphdl_n766) <+ cpphdl_channel(V(TRACK2, cpphdl_n766), V(cpphdl_n2136, cpphdl_n766), 0.029999999999999999, 0.69999999999999996, 1.0);
        // device 377, IC IC63, analog/basic/mos_track_hold.hpp:33
        I(cpphdl_n766, cpphdl_n2136) <+ cpphdl_channel(V(cpphdl_n712, cpphdl_n2136), V(cpphdl_n766, cpphdl_n2136), 0.014999999999999999, 0.69999999999999996, -1.0);
        // device 378, IC IC63, analog/basic/mos_track_hold.hpp:37
        I(cpphdl_n766, cpphdl_n766) <+ cpphdl_channel(V(cpphdl_n712, cpphdl_n766), V(cpphdl_n766, cpphdl_n766), 0.016, 0.69999999999999996, 1.0);
        // device 379, IC IC63, analog/basic/mos_track_hold.hpp:38
        I(cpphdl_n766, cpphdl_n766) <+ cpphdl_channel(V(TRACK2, cpphdl_n766), V(cpphdl_n766, cpphdl_n766), 0.0083999999999999995, 0.69999999999999996, -1.0);
        // device 380, IC IC63, analog/basic/mos_track_hold.hpp:39
        I(cpphdl_n766, Vss) <+ 1.5000000000000001e-12 * ddt(V(cpphdl_n766, Vss)); // Bench initial voltage = 0.0 V.
        // device 381, IC IC63, analog/basic/mos_track_hold.hpp:42
        I(TRACK2, cpphdl_n766) <+ 2.0000000000000002e-15 * ddt(V(TRACK2, cpphdl_n766)); // Bench initial voltage = -0.0 V.
        // device 382, IC IC63, analog/basic/mos_track_hold.hpp:43
        I(cpphdl_n712, cpphdl_n766) <+ 2.0000000000000002e-15 * ddt(V(cpphdl_n712, cpphdl_n766)); // Bench initial voltage = 0.0 V.
        // device 383, IC IC63, analog/basic/mos_track_hold.hpp:44
        I(cpphdl_n2136, cpphdl_n766) <+ 1.0000000000000001e-15 * ddt(V(cpphdl_n2136, cpphdl_n766)); // Bench initial voltage = 0.0 V.
        // device 384, IC IC66, analog/basic/inverter.hpp:11
        I(cpphdl_n727, Vdd) <+ cpphdl_channel(V(BIT_N2_0, Vdd), V(cpphdl_n727, Vdd), 0.080000000000000002, 0.69999999999999996, -1.0);
        // device 385, IC IC66, analog/basic/inverter.hpp:12
        I(cpphdl_n727, Vss) <+ cpphdl_channel(V(BIT_N2_0, Vss), V(cpphdl_n727, Vss), 0.080000000000000002, 0.69999999999999996, 1.0);
        // device 386, IC IC65, analog/basic/mos_r2r_dac.hpp:27
        I(cpphdl_n727, Vss) <+ 2.9999999999999998e-15 * ddt(V(cpphdl_n727, Vss)); // Bench initial voltage = 0.0 V.
        // device 387, IC IC65, analog/basic/mos_r2r_dac.hpp:28
        I(cpphdl_n727, cpphdl_n756) <+ V(cpphdl_n727, cpphdl_n756) / 2000.0;
        // device 388, IC IC65, analog/basic/mos_r2r_dac.hpp:29
        I(cpphdl_n756, Vss) <+ 2.9999999999999998e-15 * ddt(V(cpphdl_n756, Vss)); // Bench initial voltage = 0.0 V.
        // device 389, IC IC67, analog/basic/inverter.hpp:11
        I(cpphdl_n731, Vdd) <+ cpphdl_channel(V(BIT_N2_1, Vdd), V(cpphdl_n731, Vdd), 0.080000000000000002, 0.69999999999999996, -1.0);
        // device 390, IC IC67, analog/basic/inverter.hpp:12
        I(cpphdl_n731, Vss) <+ cpphdl_channel(V(BIT_N2_1, Vss), V(cpphdl_n731, Vss), 0.080000000000000002, 0.69999999999999996, 1.0);
        // device 391, IC IC65, analog/basic/mos_r2r_dac.hpp:27
        I(cpphdl_n731, Vss) <+ 2.9999999999999998e-15 * ddt(V(cpphdl_n731, Vss)); // Bench initial voltage = 0.0 V.
        // device 392, IC IC65, analog/basic/mos_r2r_dac.hpp:28
        I(cpphdl_n731, cpphdl_n757) <+ V(cpphdl_n731, cpphdl_n757) / 2000.0;
        // device 393, IC IC65, analog/basic/mos_r2r_dac.hpp:29
        I(cpphdl_n757, Vss) <+ 2.9999999999999998e-15 * ddt(V(cpphdl_n757, Vss)); // Bench initial voltage = 0.0 V.
        // device 394, IC IC65, analog/basic/mos_r2r_dac.hpp:31
        I(cpphdl_n756, cpphdl_n757) <+ V(cpphdl_n756, cpphdl_n757) / 1000.0;
        // device 395, IC IC68, analog/basic/inverter.hpp:11
        I(cpphdl_n735, Vdd) <+ cpphdl_channel(V(BIT_N2_2, Vdd), V(cpphdl_n735, Vdd), 0.080000000000000002, 0.69999999999999996, -1.0);
        // device 396, IC IC68, analog/basic/inverter.hpp:12
        I(cpphdl_n735, Vss) <+ cpphdl_channel(V(BIT_N2_2, Vss), V(cpphdl_n735, Vss), 0.080000000000000002, 0.69999999999999996, 1.0);
        // device 397, IC IC65, analog/basic/mos_r2r_dac.hpp:27
        I(cpphdl_n735, Vss) <+ 2.9999999999999998e-15 * ddt(V(cpphdl_n735, Vss)); // Bench initial voltage = 0.0 V.
        // device 398, IC IC65, analog/basic/mos_r2r_dac.hpp:28
        I(cpphdl_n735, cpphdl_n758) <+ V(cpphdl_n735, cpphdl_n758) / 2000.0;
        // device 399, IC IC65, analog/basic/mos_r2r_dac.hpp:29
        I(cpphdl_n758, Vss) <+ 2.9999999999999998e-15 * ddt(V(cpphdl_n758, Vss)); // Bench initial voltage = 0.0 V.
        // device 400, IC IC65, analog/basic/mos_r2r_dac.hpp:31
        I(cpphdl_n757, cpphdl_n758) <+ V(cpphdl_n757, cpphdl_n758) / 1000.0;
        // device 401, IC IC69, analog/basic/inverter.hpp:11
        I(cpphdl_n739, Vdd) <+ cpphdl_channel(V(BIT_N2_3, Vdd), V(cpphdl_n739, Vdd), 0.080000000000000002, 0.69999999999999996, -1.0);
        // device 402, IC IC69, analog/basic/inverter.hpp:12
        I(cpphdl_n739, Vss) <+ cpphdl_channel(V(BIT_N2_3, Vss), V(cpphdl_n739, Vss), 0.080000000000000002, 0.69999999999999996, 1.0);
        // device 403, IC IC65, analog/basic/mos_r2r_dac.hpp:27
        I(cpphdl_n739, Vss) <+ 2.9999999999999998e-15 * ddt(V(cpphdl_n739, Vss)); // Bench initial voltage = 0.0 V.
        // device 404, IC IC65, analog/basic/mos_r2r_dac.hpp:28
        I(cpphdl_n739, cpphdl_n759) <+ V(cpphdl_n739, cpphdl_n759) / 2000.0;
        // device 405, IC IC65, analog/basic/mos_r2r_dac.hpp:29
        I(cpphdl_n759, Vss) <+ 2.9999999999999998e-15 * ddt(V(cpphdl_n759, Vss)); // Bench initial voltage = 0.0 V.
        // device 406, IC IC65, analog/basic/mos_r2r_dac.hpp:31
        I(cpphdl_n758, cpphdl_n759) <+ V(cpphdl_n758, cpphdl_n759) / 1000.0;
        // device 407, IC IC70, analog/basic/inverter.hpp:11
        I(cpphdl_n743, Vdd) <+ cpphdl_channel(V(BIT_N2_4, Vdd), V(cpphdl_n743, Vdd), 0.080000000000000002, 0.69999999999999996, -1.0);
        // device 408, IC IC70, analog/basic/inverter.hpp:12
        I(cpphdl_n743, Vss) <+ cpphdl_channel(V(BIT_N2_4, Vss), V(cpphdl_n743, Vss), 0.080000000000000002, 0.69999999999999996, 1.0);
        // device 409, IC IC65, analog/basic/mos_r2r_dac.hpp:27
        I(cpphdl_n743, Vss) <+ 2.9999999999999998e-15 * ddt(V(cpphdl_n743, Vss)); // Bench initial voltage = 0.0 V.
        // device 410, IC IC65, analog/basic/mos_r2r_dac.hpp:28
        I(cpphdl_n743, cpphdl_n760) <+ V(cpphdl_n743, cpphdl_n760) / 2000.0;
        // device 411, IC IC65, analog/basic/mos_r2r_dac.hpp:29
        I(cpphdl_n760, Vss) <+ 2.9999999999999998e-15 * ddt(V(cpphdl_n760, Vss)); // Bench initial voltage = 0.0 V.
        // device 412, IC IC65, analog/basic/mos_r2r_dac.hpp:31
        I(cpphdl_n759, cpphdl_n760) <+ V(cpphdl_n759, cpphdl_n760) / 1000.0;
        // device 413, IC IC71, analog/basic/inverter.hpp:11
        I(cpphdl_n747, Vdd) <+ cpphdl_channel(V(BIT_N2_5, Vdd), V(cpphdl_n747, Vdd), 0.080000000000000002, 0.69999999999999996, -1.0);
        // device 414, IC IC71, analog/basic/inverter.hpp:12
        I(cpphdl_n747, Vss) <+ cpphdl_channel(V(BIT_N2_5, Vss), V(cpphdl_n747, Vss), 0.080000000000000002, 0.69999999999999996, 1.0);
        // device 415, IC IC65, analog/basic/mos_r2r_dac.hpp:27
        I(cpphdl_n747, Vss) <+ 2.9999999999999998e-15 * ddt(V(cpphdl_n747, Vss)); // Bench initial voltage = 0.0 V.
        // device 416, IC IC65, analog/basic/mos_r2r_dac.hpp:28
        I(cpphdl_n747, cpphdl_n761) <+ V(cpphdl_n747, cpphdl_n761) / 2000.0;
        // device 417, IC IC65, analog/basic/mos_r2r_dac.hpp:29
        I(cpphdl_n761, Vss) <+ 2.9999999999999998e-15 * ddt(V(cpphdl_n761, Vss)); // Bench initial voltage = 0.0 V.
        // device 418, IC IC65, analog/basic/mos_r2r_dac.hpp:31
        I(cpphdl_n760, cpphdl_n761) <+ V(cpphdl_n760, cpphdl_n761) / 1000.0;
        // device 419, IC IC72, analog/basic/inverter.hpp:11
        I(cpphdl_n751, Vdd) <+ cpphdl_channel(V(BIT_N2_6, Vdd), V(cpphdl_n751, Vdd), 0.080000000000000002, 0.69999999999999996, -1.0);
        // device 420, IC IC72, analog/basic/inverter.hpp:12
        I(cpphdl_n751, Vss) <+ cpphdl_channel(V(BIT_N2_6, Vss), V(cpphdl_n751, Vss), 0.080000000000000002, 0.69999999999999996, 1.0);
        // device 421, IC IC65, analog/basic/mos_r2r_dac.hpp:27
        I(cpphdl_n751, Vss) <+ 2.9999999999999998e-15 * ddt(V(cpphdl_n751, Vss)); // Bench initial voltage = 0.0 V.
        // device 422, IC IC65, analog/basic/mos_r2r_dac.hpp:28
        I(cpphdl_n751, cpphdl_n762) <+ V(cpphdl_n751, cpphdl_n762) / 2000.0;
        // device 423, IC IC65, analog/basic/mos_r2r_dac.hpp:29
        I(cpphdl_n762, Vss) <+ 2.9999999999999998e-15 * ddt(V(cpphdl_n762, Vss)); // Bench initial voltage = 0.0 V.
        // device 424, IC IC65, analog/basic/mos_r2r_dac.hpp:31
        I(cpphdl_n761, cpphdl_n762) <+ V(cpphdl_n761, cpphdl_n762) / 1000.0;
        // device 425, IC IC73, analog/basic/inverter.hpp:11
        I(cpphdl_n755, Vdd) <+ cpphdl_channel(V(BIT_N2_7, Vdd), V(cpphdl_n755, Vdd), 0.080000000000000002, 0.69999999999999996, -1.0);
        // device 426, IC IC73, analog/basic/inverter.hpp:12
        I(cpphdl_n755, Vss) <+ cpphdl_channel(V(BIT_N2_7, Vss), V(cpphdl_n755, Vss), 0.080000000000000002, 0.69999999999999996, 1.0);
        // device 427, IC IC65, analog/basic/mos_r2r_dac.hpp:27
        I(cpphdl_n755, Vss) <+ 2.9999999999999998e-15 * ddt(V(cpphdl_n755, Vss)); // Bench initial voltage = 0.0 V.
        // device 428, IC IC65, analog/basic/mos_r2r_dac.hpp:28
        I(cpphdl_n755, cpphdl_n767) <+ V(cpphdl_n755, cpphdl_n767) / 2000.0;
        // device 429, IC IC65, analog/basic/mos_r2r_dac.hpp:29
        I(cpphdl_n767, Vss) <+ 2.9999999999999998e-15 * ddt(V(cpphdl_n767, Vss)); // Bench initial voltage = 0.0 V.
        // device 430, IC IC65, analog/basic/mos_r2r_dac.hpp:31
        I(cpphdl_n762, cpphdl_n767) <+ V(cpphdl_n762, cpphdl_n767) / 1000.0;
        // device 431, IC IC65, analog/basic/mos_r2r_dac.hpp:33
        I(Vss, cpphdl_n756) <+ V(Vss, cpphdl_n756) / 2000.0;
        // device 432, IC IC74, analog/basic/nmos_resistor_amplifier.hpp:23
        I(Vdd, cpphdl_n776) <+ V(Vdd, cpphdl_n776) / 1000.0;
        // device 433, IC IC74, analog/basic/nmos_resistor_amplifier.hpp:24
        I(Vdd, cpphdl_n775) <+ V(Vdd, cpphdl_n775) / 1000.0;
        // device 434, IC IC74, analog/basic/nmos_resistor_amplifier.hpp:25
        I(cpphdl_n776, cpphdl_n770) <+ cpphdl_channel(V(cpphdl_n766, cpphdl_n770), V(cpphdl_n776, cpphdl_n770), 0.0074999999999999997, 0.69999999999999996, 1.0);
        // device 435, IC IC74, analog/basic/nmos_resistor_amplifier.hpp:26
        I(cpphdl_n775, cpphdl_n771) <+ cpphdl_channel(V(cpphdl_n767, cpphdl_n771), V(cpphdl_n775, cpphdl_n771), 0.0074999999999999997, 0.69999999999999996, 1.0);
        // device 436, IC IC74, analog/basic/nmos_resistor_amplifier.hpp:27
        I(cpphdl_n772, cpphdl_n770) <+ V(cpphdl_n772, cpphdl_n770) / 100.0;
        // device 437, IC IC74, analog/basic/nmos_resistor_amplifier.hpp:28
        I(cpphdl_n772, cpphdl_n771) <+ V(cpphdl_n772, cpphdl_n771) / 100.0;
        // device 438, IC IC74, analog/basic/nmos_resistor_amplifier.hpp:29
        I(Vss, cpphdl_n772) <+ V(Vss, cpphdl_n772) / 300.0;
        // device 439, IC IC74, analog/basic/nmos_resistor_amplifier.hpp:30
        I(cpphdl_n776, Vdd) <+ 2.9999999999999998e-13 * ddt(V(cpphdl_n776, Vdd)); // Bench initial voltage = 0.0 V.
        // device 440, IC IC74, analog/basic/nmos_resistor_amplifier.hpp:31
        I(cpphdl_n775, Vdd) <+ 2.9999999999999998e-13 * ddt(V(cpphdl_n775, Vdd)); // Bench initial voltage = 0.0 V.
        // device 441, IC IC74, analog/basic/nmos_resistor_amplifier.hpp:32
        I(cpphdl_n772, Vss) <+ 4e-14 * ddt(V(cpphdl_n772, Vss)); // Bench initial voltage = 0.0 V.
        // device 442, IC IC74, analog/basic/nmos_resistor_amplifier.hpp:34
        I(cpphdl_n766, cpphdl_n770) <+ 2e-14 * ddt(V(cpphdl_n766, cpphdl_n770)); // Bench initial voltage = 0.0 V.
        // device 443, IC IC74, analog/basic/nmos_resistor_amplifier.hpp:35
        I(cpphdl_n767, cpphdl_n771) <+ 2e-14 * ddt(V(cpphdl_n767, cpphdl_n771)); // Bench initial voltage = 0.0 V.
        // device 444, IC IC74, analog/basic/nmos_resistor_amplifier.hpp:36
        I(cpphdl_n766, cpphdl_n776) <+ 2.9999999999999998e-15 * ddt(V(cpphdl_n766, cpphdl_n776)); // Bench initial voltage = 0.0 V.
        // device 445, IC IC74, analog/basic/nmos_resistor_amplifier.hpp:37
        I(cpphdl_n767, cpphdl_n775) <+ 2.9999999999999998e-15 * ddt(V(cpphdl_n767, cpphdl_n775)); // Bench initial voltage = 0.0 V.
        // device 446, IC IC75, analog/basic/strongarm_comparator.hpp:28
        I(cpphdl_n780, cpphdl_n782) <+ cpphdl_channel(V(cpphdl_n775, cpphdl_n782), V(cpphdl_n780, cpphdl_n782), 0.0080000000000000002, 0.69999999999999996, 1.0);
        // device 447, IC IC75, analog/basic/strongarm_comparator.hpp:29
        I(cpphdl_n781, cpphdl_n782) <+ cpphdl_channel(V(cpphdl_n776, cpphdl_n782), V(cpphdl_n781, cpphdl_n782), 0.0080000000000000002, 0.69999999999999996, 1.0);
        // device 448, IC IC75, analog/basic/strongarm_comparator.hpp:30
        I(cpphdl_n782, Vss) <+ cpphdl_channel(V(EVALUATE, Vss), V(cpphdl_n782, Vss), 0.0080000000000000002, 0.69999999999999996, 1.0);
        // device 449, IC IC75, analog/basic/strongarm_comparator.hpp:33
        I(cpphdl_n795, cpphdl_n780) <+ cpphdl_channel(V(cpphdl_n799, cpphdl_n780), V(cpphdl_n795, cpphdl_n780), 0.0040000000000000001, 0.69999999999999996, 1.0);
        // device 450, IC IC75, analog/basic/strongarm_comparator.hpp:34
        I(cpphdl_n799, cpphdl_n781) <+ cpphdl_channel(V(cpphdl_n795, cpphdl_n781), V(cpphdl_n799, cpphdl_n781), 0.0040000000000000001, 0.69999999999999996, 1.0);
        // device 451, IC IC75, analog/basic/strongarm_comparator.hpp:35
        I(cpphdl_n799, Vdd) <+ cpphdl_channel(V(cpphdl_n795, Vdd), V(cpphdl_n799, Vdd), 0.002, 0.69999999999999996, -1.0);
        // device 452, IC IC75, analog/basic/strongarm_comparator.hpp:36
        I(cpphdl_n795, Vdd) <+ cpphdl_channel(V(cpphdl_n799, Vdd), V(cpphdl_n795, Vdd), 0.002, 0.69999999999999996, -1.0);
        // device 453, IC IC75, analog/basic/strongarm_comparator.hpp:38
        I(cpphdl_n780, Vdd) <+ cpphdl_channel(V(EVALUATE, Vdd), V(cpphdl_n780, Vdd), 0.002, 0.69999999999999996, -1.0);
        // device 454, IC IC75, analog/basic/strongarm_comparator.hpp:39
        I(cpphdl_n781, Vdd) <+ cpphdl_channel(V(EVALUATE, Vdd), V(cpphdl_n781, Vdd), 0.002, 0.69999999999999996, -1.0);
        // device 455, IC IC75, analog/basic/strongarm_comparator.hpp:40
        I(cpphdl_n799, Vdd) <+ cpphdl_channel(V(EVALUATE, Vdd), V(cpphdl_n799, Vdd), 0.002, 0.69999999999999996, -1.0);
        // device 456, IC IC75, analog/basic/strongarm_comparator.hpp:41
        I(cpphdl_n795, Vdd) <+ cpphdl_channel(V(EVALUATE, Vdd), V(cpphdl_n795, Vdd), 0.002, 0.69999999999999996, -1.0);
        // device 457, IC IC75, analog/basic/strongarm_comparator.hpp:42
        I(cpphdl_n780, Vss) <+ 2.9999999999999998e-14 * ddt(V(cpphdl_n780, Vss)); // Bench initial voltage = 0.0 V.
        // device 458, IC IC75, analog/basic/strongarm_comparator.hpp:43
        I(cpphdl_n781, Vss) <+ 2.9999999999999998e-14 * ddt(V(cpphdl_n781, Vss)); // Bench initial voltage = 0.0 V.
        // device 459, IC IC75, analog/basic/strongarm_comparator.hpp:44
        I(cpphdl_n782, Vss) <+ 2.9999999999999998e-14 * ddt(V(cpphdl_n782, Vss)); // Bench initial voltage = 0.0 V.
        // device 460, IC IC75, analog/basic/strongarm_comparator.hpp:45
        I(cpphdl_n799, Vss) <+ 5.0000000000000002e-14 * ddt(V(cpphdl_n799, Vss)); // Bench initial voltage = 0.0 V.
        // device 461, IC IC75, analog/basic/strongarm_comparator.hpp:46
        I(cpphdl_n795, Vss) <+ 5.0000000000000002e-14 * ddt(V(cpphdl_n795, Vss)); // Bench initial voltage = 0.0 V.
        // device 462, IC IC75, analog/basic/strongarm_comparator.hpp:47
        I(cpphdl_n775, cpphdl_n782) <+ 2e-14 * ddt(V(cpphdl_n775, cpphdl_n782)); // Bench initial voltage = 0.0 V.
        // device 463, IC IC75, analog/basic/strongarm_comparator.hpp:48
        I(cpphdl_n776, cpphdl_n782) <+ 2e-14 * ddt(V(cpphdl_n776, cpphdl_n782)); // Bench initial voltage = 0.0 V.
        // device 464, IC IC75, analog/basic/strongarm_comparator.hpp:49
        I(cpphdl_n775, cpphdl_n780) <+ 2.9999999999999998e-15 * ddt(V(cpphdl_n775, cpphdl_n780)); // Bench initial voltage = 0.0 V.
        // device 465, IC IC75, analog/basic/strongarm_comparator.hpp:50
        I(cpphdl_n776, cpphdl_n781) <+ 2.9999999999999998e-15 * ddt(V(cpphdl_n776, cpphdl_n781)); // Bench initial voltage = 0.0 V.
        // device 466, IC IC77, analog/basic/inverter.hpp:11
        I(cpphdl_n803, Vdd) <+ cpphdl_channel(V(cpphdl_n795, Vdd), V(cpphdl_n803, Vdd), 0.001, 0.69999999999999996, -1.0);
        // device 467, IC IC77, analog/basic/inverter.hpp:12
        I(cpphdl_n803, Vss) <+ cpphdl_channel(V(cpphdl_n795, Vss), V(cpphdl_n803, Vss), 0.001, 0.69999999999999996, 1.0);
        // device 468, IC IC79, analog/basic/inverter.hpp:11
        I(cpphdl_n817, Vdd) <+ cpphdl_channel(V(cpphdl_n803, Vdd), V(cpphdl_n817, Vdd), 0.0040000000000000001, 0.69999999999999996, -1.0);
        // device 469, IC IC79, analog/basic/inverter.hpp:12
        I(cpphdl_n817, Vss) <+ cpphdl_channel(V(cpphdl_n803, Vss), V(cpphdl_n817, Vss), 0.0040000000000000001, 0.69999999999999996, 1.0);
        // device 470, IC IC76, analog/basic/buffered_nand_latch.hpp:34
        I(cpphdl_n795, Vss) <+ 2.0000000000000002e-15 * ddt(V(cpphdl_n795, Vss)); // Bench initial voltage = 0.0 V.
        // device 471, IC IC76, analog/basic/buffered_nand_latch.hpp:35
        I(cpphdl_n795, cpphdl_n803) <+ 1.0000000000000001e-15 * ddt(V(cpphdl_n795, cpphdl_n803)); // Bench initial voltage = 0.0 V.
        // device 472, IC IC76, analog/basic/buffered_nand_latch.hpp:36
        I(cpphdl_n803, Vss) <+ 5e-15 * ddt(V(cpphdl_n803, Vss)); // Bench initial voltage = 0.0 V.
        // device 473, IC IC76, analog/basic/buffered_nand_latch.hpp:37
        I(cpphdl_n803, Vss) <+ 8.0000000000000006e-15 * ddt(V(cpphdl_n803, Vss)); // Bench initial voltage = 0.0 V.
        // device 474, IC IC76, analog/basic/buffered_nand_latch.hpp:38
        I(cpphdl_n817, Vss) <+ 1e-14 * ddt(V(cpphdl_n817, Vss)); // Bench initial voltage = 0.0 V.
        // device 475, IC IC78, analog/basic/inverter.hpp:11
        I(cpphdl_n807, Vdd) <+ cpphdl_channel(V(cpphdl_n799, Vdd), V(cpphdl_n807, Vdd), 0.001, 0.69999999999999996, -1.0);
        // device 476, IC IC78, analog/basic/inverter.hpp:12
        I(cpphdl_n807, Vss) <+ cpphdl_channel(V(cpphdl_n799, Vss), V(cpphdl_n807, Vss), 0.001, 0.69999999999999996, 1.0);
        // device 477, IC IC80, analog/basic/inverter.hpp:11
        I(cpphdl_n823, Vdd) <+ cpphdl_channel(V(cpphdl_n807, Vdd), V(cpphdl_n823, Vdd), 0.0040000000000000001, 0.69999999999999996, -1.0);
        // device 478, IC IC80, analog/basic/inverter.hpp:12
        I(cpphdl_n823, Vss) <+ cpphdl_channel(V(cpphdl_n807, Vss), V(cpphdl_n823, Vss), 0.0040000000000000001, 0.69999999999999996, 1.0);
        // device 479, IC IC76, analog/basic/buffered_nand_latch.hpp:34
        I(cpphdl_n799, Vss) <+ 2.0000000000000002e-15 * ddt(V(cpphdl_n799, Vss)); // Bench initial voltage = 0.0 V.
        // device 480, IC IC76, analog/basic/buffered_nand_latch.hpp:35
        I(cpphdl_n799, cpphdl_n807) <+ 1.0000000000000001e-15 * ddt(V(cpphdl_n799, cpphdl_n807)); // Bench initial voltage = 0.0 V.
        // device 481, IC IC76, analog/basic/buffered_nand_latch.hpp:36
        I(cpphdl_n807, Vss) <+ 5e-15 * ddt(V(cpphdl_n807, Vss)); // Bench initial voltage = 0.0 V.
        // device 482, IC IC76, analog/basic/buffered_nand_latch.hpp:37
        I(cpphdl_n807, Vss) <+ 8.0000000000000006e-15 * ddt(V(cpphdl_n807, Vss)); // Bench initial voltage = 0.0 V.
        // device 483, IC IC76, analog/basic/buffered_nand_latch.hpp:38
        I(cpphdl_n823, Vss) <+ 1e-14 * ddt(V(cpphdl_n823, Vss)); // Bench initial voltage = 0.0 V.
        // device 484, IC IC82, analog/basic/cmos_logic.hpp:17
        I(cpphdl_n2288, Vss) <+ 5.0000000000000002e-14 * ddt(V(cpphdl_n2288, Vss)); // Bench initial voltage = 0.0 V.
        // device 485, IC IC82, analog/basic/cmos_logic.hpp:18
        I(cpphdl_n2288, Vdd) <+ cpphdl_channel(V(cpphdl_n817, Vdd), V(cpphdl_n2288, Vdd), 0.01, 0.69999999999999996, -1.0);
        // device 486, IC IC82, analog/basic/cmos_logic.hpp:19
        I(cpphdl_n2288, Vdd) <+ cpphdl_channel(V(cpphdl_n825, Vdd), V(cpphdl_n2288, Vdd), 0.01, 0.69999999999999996, -1.0);
        // device 487, IC IC82, analog/basic/cmos_logic.hpp:20
        I(cpphdl_n2288, cpphdl_n820) <+ cpphdl_channel(V(cpphdl_n817, cpphdl_n820), V(cpphdl_n2288, cpphdl_n820), 0.01, 0.69999999999999996, 1.0);
        // device 488, IC IC82, analog/basic/cmos_logic.hpp:21
        I(cpphdl_n820, Vss) <+ cpphdl_channel(V(cpphdl_n825, Vss), V(cpphdl_n820, Vss), 0.01, 0.69999999999999996, 1.0);
        // device 489, IC IC82, analog/basic/cmos_logic.hpp:27
        I(cpphdl_n820, Vss) <+ 1e-14 * ddt(V(cpphdl_n820, Vss)); // Bench initial voltage = 0.0 V.
        // device 490, IC IC83, analog/basic/cmos_logic.hpp:17
        I(cpphdl_n825, Vss) <+ 5.0000000000000002e-14 * ddt(V(cpphdl_n825, Vss)); // Bench initial voltage = 0.0 V.
        // device 491, IC IC83, analog/basic/cmos_logic.hpp:18
        I(cpphdl_n825, Vdd) <+ cpphdl_channel(V(cpphdl_n823, Vdd), V(cpphdl_n825, Vdd), 0.01, 0.69999999999999996, -1.0);
        // device 492, IC IC83, analog/basic/cmos_logic.hpp:19
        I(cpphdl_n825, Vdd) <+ cpphdl_channel(V(cpphdl_n2288, Vdd), V(cpphdl_n825, Vdd), 0.01, 0.69999999999999996, -1.0);
        // device 493, IC IC83, analog/basic/cmos_logic.hpp:20
        I(cpphdl_n825, cpphdl_n826) <+ cpphdl_channel(V(cpphdl_n823, cpphdl_n826), V(cpphdl_n825, cpphdl_n826), 0.01, 0.69999999999999996, 1.0);
        // device 494, IC IC83, analog/basic/cmos_logic.hpp:21
        I(cpphdl_n826, Vss) <+ cpphdl_channel(V(cpphdl_n2288, Vss), V(cpphdl_n826, Vss), 0.01, 0.69999999999999996, 1.0);
        // device 495, IC IC83, analog/basic/cmos_logic.hpp:27
        I(cpphdl_n826, Vss) <+ 1e-14 * ddt(V(cpphdl_n826, Vss)); // Bench initial voltage = 0.0 V.
        // device 496, IC IC81, analog/basic/nand_latch.hpp:36
        I(cpphdl_n817, Vss) <+ 2.9999999999999998e-15 * ddt(V(cpphdl_n817, Vss)); // Bench initial voltage = 0.0 V.
        // device 497, IC IC81, analog/basic/nand_latch.hpp:37
        I(cpphdl_n823, Vss) <+ 2.9999999999999998e-15 * ddt(V(cpphdl_n823, Vss)); // Bench initial voltage = 0.0 V.
        // device 498, IC IC84, analog/basic/inverter.hpp:11
        I(cpphdl_n831, Vdd) <+ cpphdl_channel(V(CLEAR, Vdd), V(cpphdl_n831, Vdd), 0.01, 0.69999999999999996, -1.0);
        // device 499, IC IC84, analog/basic/inverter.hpp:12
        I(cpphdl_n831, Vss) <+ cpphdl_channel(V(CLEAR, Vss), V(cpphdl_n831, Vss), 0.01, 0.69999999999999996, 1.0);
        // device 500, IC IC81, analog/basic/nand_latch.hpp:58
        I(cpphdl_n831, Vss) <+ 2.9999999999999998e-15 * ddt(V(cpphdl_n831, Vss)); // Bench initial voltage = 0.0 V.
        // device 501, IC IC81, analog/basic/nand_latch.hpp:59
        I(cpphdl_n2288, Vss) <+ cpphdl_channel(V(CLEAR, Vss), V(cpphdl_n2288, Vss), 0.050000000000000003, 0.69999999999999996, 1.0);
        // device 502, IC IC81, analog/basic/nand_latch.hpp:60
        I(cpphdl_n825, Vdd) <+ cpphdl_channel(V(cpphdl_n831, Vdd), V(cpphdl_n825, Vdd), 0.050000000000000003, 0.69999999999999996, -1.0);
        // device 503, IC IC87, analog/basic/inverter.hpp:11
        I(cpphdl_n855, Vdd) <+ cpphdl_channel(V(TRACK3, Vdd), V(cpphdl_n855, Vdd), 0.0040000000000000001, 0.69999999999999996, -1.0);
        // device 504, IC IC87, analog/basic/inverter.hpp:12
        I(cpphdl_n855, Vss) <+ cpphdl_channel(V(TRACK3, Vss), V(cpphdl_n855, Vss), 0.0040000000000000001, 0.69999999999999996, 1.0);
        // device 505, IC IC86, analog/basic/mos_track_hold.hpp:31
        I(cpphdl_n855, Vss) <+ 2e-14 * ddt(V(cpphdl_n855, Vss)); // Bench initial voltage = 0.0 V.
        // device 506, IC IC86, analog/basic/mos_track_hold.hpp:32
        I(cpphdl_n2136, cpphdl_n909) <+ cpphdl_channel(V(TRACK3, cpphdl_n909), V(cpphdl_n2136, cpphdl_n909), 0.029999999999999999, 0.69999999999999996, 1.0);
        // device 507, IC IC86, analog/basic/mos_track_hold.hpp:33
        I(cpphdl_n909, cpphdl_n2136) <+ cpphdl_channel(V(cpphdl_n855, cpphdl_n2136), V(cpphdl_n909, cpphdl_n2136), 0.014999999999999999, 0.69999999999999996, -1.0);
        // device 508, IC IC86, analog/basic/mos_track_hold.hpp:37
        I(cpphdl_n909, cpphdl_n909) <+ cpphdl_channel(V(cpphdl_n855, cpphdl_n909), V(cpphdl_n909, cpphdl_n909), 0.016, 0.69999999999999996, 1.0);
        // device 509, IC IC86, analog/basic/mos_track_hold.hpp:38
        I(cpphdl_n909, cpphdl_n909) <+ cpphdl_channel(V(TRACK3, cpphdl_n909), V(cpphdl_n909, cpphdl_n909), 0.0083999999999999995, 0.69999999999999996, -1.0);
        // device 510, IC IC86, analog/basic/mos_track_hold.hpp:39
        I(cpphdl_n909, Vss) <+ 1.5000000000000001e-12 * ddt(V(cpphdl_n909, Vss)); // Bench initial voltage = 0.0 V.
        // device 511, IC IC86, analog/basic/mos_track_hold.hpp:42
        I(TRACK3, cpphdl_n909) <+ 2.0000000000000002e-15 * ddt(V(TRACK3, cpphdl_n909)); // Bench initial voltage = -0.0 V.
        // device 512, IC IC86, analog/basic/mos_track_hold.hpp:43
        I(cpphdl_n855, cpphdl_n909) <+ 2.0000000000000002e-15 * ddt(V(cpphdl_n855, cpphdl_n909)); // Bench initial voltage = 0.0 V.
        // device 513, IC IC86, analog/basic/mos_track_hold.hpp:44
        I(cpphdl_n2136, cpphdl_n909) <+ 1.0000000000000001e-15 * ddt(V(cpphdl_n2136, cpphdl_n909)); // Bench initial voltage = 0.0 V.
        // device 514, IC IC89, analog/basic/inverter.hpp:11
        I(cpphdl_n870, Vdd) <+ cpphdl_channel(V(BIT_N3_0, Vdd), V(cpphdl_n870, Vdd), 0.080000000000000002, 0.69999999999999996, -1.0);
        // device 515, IC IC89, analog/basic/inverter.hpp:12
        I(cpphdl_n870, Vss) <+ cpphdl_channel(V(BIT_N3_0, Vss), V(cpphdl_n870, Vss), 0.080000000000000002, 0.69999999999999996, 1.0);
        // device 516, IC IC88, analog/basic/mos_r2r_dac.hpp:27
        I(cpphdl_n870, Vss) <+ 2.9999999999999998e-15 * ddt(V(cpphdl_n870, Vss)); // Bench initial voltage = 0.0 V.
        // device 517, IC IC88, analog/basic/mos_r2r_dac.hpp:28
        I(cpphdl_n870, cpphdl_n899) <+ V(cpphdl_n870, cpphdl_n899) / 2000.0;
        // device 518, IC IC88, analog/basic/mos_r2r_dac.hpp:29
        I(cpphdl_n899, Vss) <+ 2.9999999999999998e-15 * ddt(V(cpphdl_n899, Vss)); // Bench initial voltage = 0.0 V.
        // device 519, IC IC90, analog/basic/inverter.hpp:11
        I(cpphdl_n874, Vdd) <+ cpphdl_channel(V(BIT_N3_1, Vdd), V(cpphdl_n874, Vdd), 0.080000000000000002, 0.69999999999999996, -1.0);
        // device 520, IC IC90, analog/basic/inverter.hpp:12
        I(cpphdl_n874, Vss) <+ cpphdl_channel(V(BIT_N3_1, Vss), V(cpphdl_n874, Vss), 0.080000000000000002, 0.69999999999999996, 1.0);
        // device 521, IC IC88, analog/basic/mos_r2r_dac.hpp:27
        I(cpphdl_n874, Vss) <+ 2.9999999999999998e-15 * ddt(V(cpphdl_n874, Vss)); // Bench initial voltage = 0.0 V.
        // device 522, IC IC88, analog/basic/mos_r2r_dac.hpp:28
        I(cpphdl_n874, cpphdl_n900) <+ V(cpphdl_n874, cpphdl_n900) / 2000.0;
        // device 523, IC IC88, analog/basic/mos_r2r_dac.hpp:29
        I(cpphdl_n900, Vss) <+ 2.9999999999999998e-15 * ddt(V(cpphdl_n900, Vss)); // Bench initial voltage = 0.0 V.
        // device 524, IC IC88, analog/basic/mos_r2r_dac.hpp:31
        I(cpphdl_n899, cpphdl_n900) <+ V(cpphdl_n899, cpphdl_n900) / 1000.0;
        // device 525, IC IC91, analog/basic/inverter.hpp:11
        I(cpphdl_n878, Vdd) <+ cpphdl_channel(V(BIT_N3_2, Vdd), V(cpphdl_n878, Vdd), 0.080000000000000002, 0.69999999999999996, -1.0);
        // device 526, IC IC91, analog/basic/inverter.hpp:12
        I(cpphdl_n878, Vss) <+ cpphdl_channel(V(BIT_N3_2, Vss), V(cpphdl_n878, Vss), 0.080000000000000002, 0.69999999999999996, 1.0);
        // device 527, IC IC88, analog/basic/mos_r2r_dac.hpp:27
        I(cpphdl_n878, Vss) <+ 2.9999999999999998e-15 * ddt(V(cpphdl_n878, Vss)); // Bench initial voltage = 0.0 V.
        // device 528, IC IC88, analog/basic/mos_r2r_dac.hpp:28
        I(cpphdl_n878, cpphdl_n901) <+ V(cpphdl_n878, cpphdl_n901) / 2000.0;
        // device 529, IC IC88, analog/basic/mos_r2r_dac.hpp:29
        I(cpphdl_n901, Vss) <+ 2.9999999999999998e-15 * ddt(V(cpphdl_n901, Vss)); // Bench initial voltage = 0.0 V.
        // device 530, IC IC88, analog/basic/mos_r2r_dac.hpp:31
        I(cpphdl_n900, cpphdl_n901) <+ V(cpphdl_n900, cpphdl_n901) / 1000.0;
        // device 531, IC IC92, analog/basic/inverter.hpp:11
        I(cpphdl_n882, Vdd) <+ cpphdl_channel(V(BIT_N3_3, Vdd), V(cpphdl_n882, Vdd), 0.080000000000000002, 0.69999999999999996, -1.0);
        // device 532, IC IC92, analog/basic/inverter.hpp:12
        I(cpphdl_n882, Vss) <+ cpphdl_channel(V(BIT_N3_3, Vss), V(cpphdl_n882, Vss), 0.080000000000000002, 0.69999999999999996, 1.0);
        // device 533, IC IC88, analog/basic/mos_r2r_dac.hpp:27
        I(cpphdl_n882, Vss) <+ 2.9999999999999998e-15 * ddt(V(cpphdl_n882, Vss)); // Bench initial voltage = 0.0 V.
        // device 534, IC IC88, analog/basic/mos_r2r_dac.hpp:28
        I(cpphdl_n882, cpphdl_n902) <+ V(cpphdl_n882, cpphdl_n902) / 2000.0;
        // device 535, IC IC88, analog/basic/mos_r2r_dac.hpp:29
        I(cpphdl_n902, Vss) <+ 2.9999999999999998e-15 * ddt(V(cpphdl_n902, Vss)); // Bench initial voltage = 0.0 V.
        // device 536, IC IC88, analog/basic/mos_r2r_dac.hpp:31
        I(cpphdl_n901, cpphdl_n902) <+ V(cpphdl_n901, cpphdl_n902) / 1000.0;
        // device 537, IC IC93, analog/basic/inverter.hpp:11
        I(cpphdl_n886, Vdd) <+ cpphdl_channel(V(BIT_N3_4, Vdd), V(cpphdl_n886, Vdd), 0.080000000000000002, 0.69999999999999996, -1.0);
        // device 538, IC IC93, analog/basic/inverter.hpp:12
        I(cpphdl_n886, Vss) <+ cpphdl_channel(V(BIT_N3_4, Vss), V(cpphdl_n886, Vss), 0.080000000000000002, 0.69999999999999996, 1.0);
        // device 539, IC IC88, analog/basic/mos_r2r_dac.hpp:27
        I(cpphdl_n886, Vss) <+ 2.9999999999999998e-15 * ddt(V(cpphdl_n886, Vss)); // Bench initial voltage = 0.0 V.
        // device 540, IC IC88, analog/basic/mos_r2r_dac.hpp:28
        I(cpphdl_n886, cpphdl_n903) <+ V(cpphdl_n886, cpphdl_n903) / 2000.0;
        // device 541, IC IC88, analog/basic/mos_r2r_dac.hpp:29
        I(cpphdl_n903, Vss) <+ 2.9999999999999998e-15 * ddt(V(cpphdl_n903, Vss)); // Bench initial voltage = 0.0 V.
        // device 542, IC IC88, analog/basic/mos_r2r_dac.hpp:31
        I(cpphdl_n902, cpphdl_n903) <+ V(cpphdl_n902, cpphdl_n903) / 1000.0;
        // device 543, IC IC94, analog/basic/inverter.hpp:11
        I(cpphdl_n890, Vdd) <+ cpphdl_channel(V(BIT_N3_5, Vdd), V(cpphdl_n890, Vdd), 0.080000000000000002, 0.69999999999999996, -1.0);
        // device 544, IC IC94, analog/basic/inverter.hpp:12
        I(cpphdl_n890, Vss) <+ cpphdl_channel(V(BIT_N3_5, Vss), V(cpphdl_n890, Vss), 0.080000000000000002, 0.69999999999999996, 1.0);
        // device 545, IC IC88, analog/basic/mos_r2r_dac.hpp:27
        I(cpphdl_n890, Vss) <+ 2.9999999999999998e-15 * ddt(V(cpphdl_n890, Vss)); // Bench initial voltage = 0.0 V.
        // device 546, IC IC88, analog/basic/mos_r2r_dac.hpp:28
        I(cpphdl_n890, cpphdl_n904) <+ V(cpphdl_n890, cpphdl_n904) / 2000.0;
        // device 547, IC IC88, analog/basic/mos_r2r_dac.hpp:29
        I(cpphdl_n904, Vss) <+ 2.9999999999999998e-15 * ddt(V(cpphdl_n904, Vss)); // Bench initial voltage = 0.0 V.
        // device 548, IC IC88, analog/basic/mos_r2r_dac.hpp:31
        I(cpphdl_n903, cpphdl_n904) <+ V(cpphdl_n903, cpphdl_n904) / 1000.0;
        // device 549, IC IC95, analog/basic/inverter.hpp:11
        I(cpphdl_n894, Vdd) <+ cpphdl_channel(V(BIT_N3_6, Vdd), V(cpphdl_n894, Vdd), 0.080000000000000002, 0.69999999999999996, -1.0);
        // device 550, IC IC95, analog/basic/inverter.hpp:12
        I(cpphdl_n894, Vss) <+ cpphdl_channel(V(BIT_N3_6, Vss), V(cpphdl_n894, Vss), 0.080000000000000002, 0.69999999999999996, 1.0);
        // device 551, IC IC88, analog/basic/mos_r2r_dac.hpp:27
        I(cpphdl_n894, Vss) <+ 2.9999999999999998e-15 * ddt(V(cpphdl_n894, Vss)); // Bench initial voltage = 0.0 V.
        // device 552, IC IC88, analog/basic/mos_r2r_dac.hpp:28
        I(cpphdl_n894, cpphdl_n905) <+ V(cpphdl_n894, cpphdl_n905) / 2000.0;
        // device 553, IC IC88, analog/basic/mos_r2r_dac.hpp:29
        I(cpphdl_n905, Vss) <+ 2.9999999999999998e-15 * ddt(V(cpphdl_n905, Vss)); // Bench initial voltage = 0.0 V.
        // device 554, IC IC88, analog/basic/mos_r2r_dac.hpp:31
        I(cpphdl_n904, cpphdl_n905) <+ V(cpphdl_n904, cpphdl_n905) / 1000.0;
        // device 555, IC IC96, analog/basic/inverter.hpp:11
        I(cpphdl_n898, Vdd) <+ cpphdl_channel(V(BIT_N3_7, Vdd), V(cpphdl_n898, Vdd), 0.080000000000000002, 0.69999999999999996, -1.0);
        // device 556, IC IC96, analog/basic/inverter.hpp:12
        I(cpphdl_n898, Vss) <+ cpphdl_channel(V(BIT_N3_7, Vss), V(cpphdl_n898, Vss), 0.080000000000000002, 0.69999999999999996, 1.0);
        // device 557, IC IC88, analog/basic/mos_r2r_dac.hpp:27
        I(cpphdl_n898, Vss) <+ 2.9999999999999998e-15 * ddt(V(cpphdl_n898, Vss)); // Bench initial voltage = 0.0 V.
        // device 558, IC IC88, analog/basic/mos_r2r_dac.hpp:28
        I(cpphdl_n898, cpphdl_n910) <+ V(cpphdl_n898, cpphdl_n910) / 2000.0;
        // device 559, IC IC88, analog/basic/mos_r2r_dac.hpp:29
        I(cpphdl_n910, Vss) <+ 2.9999999999999998e-15 * ddt(V(cpphdl_n910, Vss)); // Bench initial voltage = 0.0 V.
        // device 560, IC IC88, analog/basic/mos_r2r_dac.hpp:31
        I(cpphdl_n905, cpphdl_n910) <+ V(cpphdl_n905, cpphdl_n910) / 1000.0;
        // device 561, IC IC88, analog/basic/mos_r2r_dac.hpp:33
        I(Vss, cpphdl_n899) <+ V(Vss, cpphdl_n899) / 2000.0;
        // device 562, IC IC97, analog/basic/nmos_resistor_amplifier.hpp:23
        I(Vdd, cpphdl_n919) <+ V(Vdd, cpphdl_n919) / 1000.0;
        // device 563, IC IC97, analog/basic/nmos_resistor_amplifier.hpp:24
        I(Vdd, cpphdl_n918) <+ V(Vdd, cpphdl_n918) / 1000.0;
        // device 564, IC IC97, analog/basic/nmos_resistor_amplifier.hpp:25
        I(cpphdl_n919, cpphdl_n913) <+ cpphdl_channel(V(cpphdl_n909, cpphdl_n913), V(cpphdl_n919, cpphdl_n913), 0.0074999999999999997, 0.69999999999999996, 1.0);
        // device 565, IC IC97, analog/basic/nmos_resistor_amplifier.hpp:26
        I(cpphdl_n918, cpphdl_n914) <+ cpphdl_channel(V(cpphdl_n910, cpphdl_n914), V(cpphdl_n918, cpphdl_n914), 0.0074999999999999997, 0.69999999999999996, 1.0);
        // device 566, IC IC97, analog/basic/nmos_resistor_amplifier.hpp:27
        I(cpphdl_n915, cpphdl_n913) <+ V(cpphdl_n915, cpphdl_n913) / 100.0;
        // device 567, IC IC97, analog/basic/nmos_resistor_amplifier.hpp:28
        I(cpphdl_n915, cpphdl_n914) <+ V(cpphdl_n915, cpphdl_n914) / 100.0;
        // device 568, IC IC97, analog/basic/nmos_resistor_amplifier.hpp:29
        I(Vss, cpphdl_n915) <+ V(Vss, cpphdl_n915) / 300.0;
        // device 569, IC IC97, analog/basic/nmos_resistor_amplifier.hpp:30
        I(cpphdl_n919, Vdd) <+ 2.9999999999999998e-13 * ddt(V(cpphdl_n919, Vdd)); // Bench initial voltage = 0.0 V.
        // device 570, IC IC97, analog/basic/nmos_resistor_amplifier.hpp:31
        I(cpphdl_n918, Vdd) <+ 2.9999999999999998e-13 * ddt(V(cpphdl_n918, Vdd)); // Bench initial voltage = 0.0 V.
        // device 571, IC IC97, analog/basic/nmos_resistor_amplifier.hpp:32
        I(cpphdl_n915, Vss) <+ 4e-14 * ddt(V(cpphdl_n915, Vss)); // Bench initial voltage = 0.0 V.
        // device 572, IC IC97, analog/basic/nmos_resistor_amplifier.hpp:34
        I(cpphdl_n909, cpphdl_n913) <+ 2e-14 * ddt(V(cpphdl_n909, cpphdl_n913)); // Bench initial voltage = 0.0 V.
        // device 573, IC IC97, analog/basic/nmos_resistor_amplifier.hpp:35
        I(cpphdl_n910, cpphdl_n914) <+ 2e-14 * ddt(V(cpphdl_n910, cpphdl_n914)); // Bench initial voltage = 0.0 V.
        // device 574, IC IC97, analog/basic/nmos_resistor_amplifier.hpp:36
        I(cpphdl_n909, cpphdl_n919) <+ 2.9999999999999998e-15 * ddt(V(cpphdl_n909, cpphdl_n919)); // Bench initial voltage = 0.0 V.
        // device 575, IC IC97, analog/basic/nmos_resistor_amplifier.hpp:37
        I(cpphdl_n910, cpphdl_n918) <+ 2.9999999999999998e-15 * ddt(V(cpphdl_n910, cpphdl_n918)); // Bench initial voltage = 0.0 V.
        // device 576, IC IC98, analog/basic/strongarm_comparator.hpp:28
        I(cpphdl_n923, cpphdl_n925) <+ cpphdl_channel(V(cpphdl_n918, cpphdl_n925), V(cpphdl_n923, cpphdl_n925), 0.0080000000000000002, 0.69999999999999996, 1.0);
        // device 577, IC IC98, analog/basic/strongarm_comparator.hpp:29
        I(cpphdl_n924, cpphdl_n925) <+ cpphdl_channel(V(cpphdl_n919, cpphdl_n925), V(cpphdl_n924, cpphdl_n925), 0.0080000000000000002, 0.69999999999999996, 1.0);
        // device 578, IC IC98, analog/basic/strongarm_comparator.hpp:30
        I(cpphdl_n925, Vss) <+ cpphdl_channel(V(EVALUATE, Vss), V(cpphdl_n925, Vss), 0.0080000000000000002, 0.69999999999999996, 1.0);
        // device 579, IC IC98, analog/basic/strongarm_comparator.hpp:33
        I(cpphdl_n938, cpphdl_n923) <+ cpphdl_channel(V(cpphdl_n942, cpphdl_n923), V(cpphdl_n938, cpphdl_n923), 0.0040000000000000001, 0.69999999999999996, 1.0);
        // device 580, IC IC98, analog/basic/strongarm_comparator.hpp:34
        I(cpphdl_n942, cpphdl_n924) <+ cpphdl_channel(V(cpphdl_n938, cpphdl_n924), V(cpphdl_n942, cpphdl_n924), 0.0040000000000000001, 0.69999999999999996, 1.0);
        // device 581, IC IC98, analog/basic/strongarm_comparator.hpp:35
        I(cpphdl_n942, Vdd) <+ cpphdl_channel(V(cpphdl_n938, Vdd), V(cpphdl_n942, Vdd), 0.002, 0.69999999999999996, -1.0);
        // device 582, IC IC98, analog/basic/strongarm_comparator.hpp:36
        I(cpphdl_n938, Vdd) <+ cpphdl_channel(V(cpphdl_n942, Vdd), V(cpphdl_n938, Vdd), 0.002, 0.69999999999999996, -1.0);
        // device 583, IC IC98, analog/basic/strongarm_comparator.hpp:38
        I(cpphdl_n923, Vdd) <+ cpphdl_channel(V(EVALUATE, Vdd), V(cpphdl_n923, Vdd), 0.002, 0.69999999999999996, -1.0);
        // device 584, IC IC98, analog/basic/strongarm_comparator.hpp:39
        I(cpphdl_n924, Vdd) <+ cpphdl_channel(V(EVALUATE, Vdd), V(cpphdl_n924, Vdd), 0.002, 0.69999999999999996, -1.0);
        // device 585, IC IC98, analog/basic/strongarm_comparator.hpp:40
        I(cpphdl_n942, Vdd) <+ cpphdl_channel(V(EVALUATE, Vdd), V(cpphdl_n942, Vdd), 0.002, 0.69999999999999996, -1.0);
        // device 586, IC IC98, analog/basic/strongarm_comparator.hpp:41
        I(cpphdl_n938, Vdd) <+ cpphdl_channel(V(EVALUATE, Vdd), V(cpphdl_n938, Vdd), 0.002, 0.69999999999999996, -1.0);
        // device 587, IC IC98, analog/basic/strongarm_comparator.hpp:42
        I(cpphdl_n923, Vss) <+ 2.9999999999999998e-14 * ddt(V(cpphdl_n923, Vss)); // Bench initial voltage = 0.0 V.
        // device 588, IC IC98, analog/basic/strongarm_comparator.hpp:43
        I(cpphdl_n924, Vss) <+ 2.9999999999999998e-14 * ddt(V(cpphdl_n924, Vss)); // Bench initial voltage = 0.0 V.
        // device 589, IC IC98, analog/basic/strongarm_comparator.hpp:44
        I(cpphdl_n925, Vss) <+ 2.9999999999999998e-14 * ddt(V(cpphdl_n925, Vss)); // Bench initial voltage = 0.0 V.
        // device 590, IC IC98, analog/basic/strongarm_comparator.hpp:45
        I(cpphdl_n942, Vss) <+ 5.0000000000000002e-14 * ddt(V(cpphdl_n942, Vss)); // Bench initial voltage = 0.0 V.
        // device 591, IC IC98, analog/basic/strongarm_comparator.hpp:46
        I(cpphdl_n938, Vss) <+ 5.0000000000000002e-14 * ddt(V(cpphdl_n938, Vss)); // Bench initial voltage = 0.0 V.
        // device 592, IC IC98, analog/basic/strongarm_comparator.hpp:47
        I(cpphdl_n918, cpphdl_n925) <+ 2e-14 * ddt(V(cpphdl_n918, cpphdl_n925)); // Bench initial voltage = 0.0 V.
        // device 593, IC IC98, analog/basic/strongarm_comparator.hpp:48
        I(cpphdl_n919, cpphdl_n925) <+ 2e-14 * ddt(V(cpphdl_n919, cpphdl_n925)); // Bench initial voltage = 0.0 V.
        // device 594, IC IC98, analog/basic/strongarm_comparator.hpp:49
        I(cpphdl_n918, cpphdl_n923) <+ 2.9999999999999998e-15 * ddt(V(cpphdl_n918, cpphdl_n923)); // Bench initial voltage = 0.0 V.
        // device 595, IC IC98, analog/basic/strongarm_comparator.hpp:50
        I(cpphdl_n919, cpphdl_n924) <+ 2.9999999999999998e-15 * ddt(V(cpphdl_n919, cpphdl_n924)); // Bench initial voltage = 0.0 V.
        // device 596, IC IC100, analog/basic/inverter.hpp:11
        I(cpphdl_n946, Vdd) <+ cpphdl_channel(V(cpphdl_n938, Vdd), V(cpphdl_n946, Vdd), 0.001, 0.69999999999999996, -1.0);
        // device 597, IC IC100, analog/basic/inverter.hpp:12
        I(cpphdl_n946, Vss) <+ cpphdl_channel(V(cpphdl_n938, Vss), V(cpphdl_n946, Vss), 0.001, 0.69999999999999996, 1.0);
        // device 598, IC IC102, analog/basic/inverter.hpp:11
        I(cpphdl_n960, Vdd) <+ cpphdl_channel(V(cpphdl_n946, Vdd), V(cpphdl_n960, Vdd), 0.0040000000000000001, 0.69999999999999996, -1.0);
        // device 599, IC IC102, analog/basic/inverter.hpp:12
        I(cpphdl_n960, Vss) <+ cpphdl_channel(V(cpphdl_n946, Vss), V(cpphdl_n960, Vss), 0.0040000000000000001, 0.69999999999999996, 1.0);
        // device 600, IC IC99, analog/basic/buffered_nand_latch.hpp:34
        I(cpphdl_n938, Vss) <+ 2.0000000000000002e-15 * ddt(V(cpphdl_n938, Vss)); // Bench initial voltage = 0.0 V.
        // device 601, IC IC99, analog/basic/buffered_nand_latch.hpp:35
        I(cpphdl_n938, cpphdl_n946) <+ 1.0000000000000001e-15 * ddt(V(cpphdl_n938, cpphdl_n946)); // Bench initial voltage = 0.0 V.
        // device 602, IC IC99, analog/basic/buffered_nand_latch.hpp:36
        I(cpphdl_n946, Vss) <+ 5e-15 * ddt(V(cpphdl_n946, Vss)); // Bench initial voltage = 0.0 V.
        // device 603, IC IC99, analog/basic/buffered_nand_latch.hpp:37
        I(cpphdl_n946, Vss) <+ 8.0000000000000006e-15 * ddt(V(cpphdl_n946, Vss)); // Bench initial voltage = 0.0 V.
        // device 604, IC IC99, analog/basic/buffered_nand_latch.hpp:38
        I(cpphdl_n960, Vss) <+ 1e-14 * ddt(V(cpphdl_n960, Vss)); // Bench initial voltage = 0.0 V.
        // device 605, IC IC101, analog/basic/inverter.hpp:11
        I(cpphdl_n950, Vdd) <+ cpphdl_channel(V(cpphdl_n942, Vdd), V(cpphdl_n950, Vdd), 0.001, 0.69999999999999996, -1.0);
        // device 606, IC IC101, analog/basic/inverter.hpp:12
        I(cpphdl_n950, Vss) <+ cpphdl_channel(V(cpphdl_n942, Vss), V(cpphdl_n950, Vss), 0.001, 0.69999999999999996, 1.0);
        // device 607, IC IC103, analog/basic/inverter.hpp:11
        I(cpphdl_n966, Vdd) <+ cpphdl_channel(V(cpphdl_n950, Vdd), V(cpphdl_n966, Vdd), 0.0040000000000000001, 0.69999999999999996, -1.0);
        // device 608, IC IC103, analog/basic/inverter.hpp:12
        I(cpphdl_n966, Vss) <+ cpphdl_channel(V(cpphdl_n950, Vss), V(cpphdl_n966, Vss), 0.0040000000000000001, 0.69999999999999996, 1.0);
        // device 609, IC IC99, analog/basic/buffered_nand_latch.hpp:34
        I(cpphdl_n942, Vss) <+ 2.0000000000000002e-15 * ddt(V(cpphdl_n942, Vss)); // Bench initial voltage = 0.0 V.
        // device 610, IC IC99, analog/basic/buffered_nand_latch.hpp:35
        I(cpphdl_n942, cpphdl_n950) <+ 1.0000000000000001e-15 * ddt(V(cpphdl_n942, cpphdl_n950)); // Bench initial voltage = 0.0 V.
        // device 611, IC IC99, analog/basic/buffered_nand_latch.hpp:36
        I(cpphdl_n950, Vss) <+ 5e-15 * ddt(V(cpphdl_n950, Vss)); // Bench initial voltage = 0.0 V.
        // device 612, IC IC99, analog/basic/buffered_nand_latch.hpp:37
        I(cpphdl_n950, Vss) <+ 8.0000000000000006e-15 * ddt(V(cpphdl_n950, Vss)); // Bench initial voltage = 0.0 V.
        // device 613, IC IC99, analog/basic/buffered_nand_latch.hpp:38
        I(cpphdl_n966, Vss) <+ 1e-14 * ddt(V(cpphdl_n966, Vss)); // Bench initial voltage = 0.0 V.
        // device 614, IC IC105, analog/basic/cmos_logic.hpp:17
        I(cpphdl_n2293, Vss) <+ 5.0000000000000002e-14 * ddt(V(cpphdl_n2293, Vss)); // Bench initial voltage = 0.0 V.
        // device 615, IC IC105, analog/basic/cmos_logic.hpp:18
        I(cpphdl_n2293, Vdd) <+ cpphdl_channel(V(cpphdl_n960, Vdd), V(cpphdl_n2293, Vdd), 0.01, 0.69999999999999996, -1.0);
        // device 616, IC IC105, analog/basic/cmos_logic.hpp:19
        I(cpphdl_n2293, Vdd) <+ cpphdl_channel(V(cpphdl_n968, Vdd), V(cpphdl_n2293, Vdd), 0.01, 0.69999999999999996, -1.0);
        // device 617, IC IC105, analog/basic/cmos_logic.hpp:20
        I(cpphdl_n2293, cpphdl_n963) <+ cpphdl_channel(V(cpphdl_n960, cpphdl_n963), V(cpphdl_n2293, cpphdl_n963), 0.01, 0.69999999999999996, 1.0);
        // device 618, IC IC105, analog/basic/cmos_logic.hpp:21
        I(cpphdl_n963, Vss) <+ cpphdl_channel(V(cpphdl_n968, Vss), V(cpphdl_n963, Vss), 0.01, 0.69999999999999996, 1.0);
        // device 619, IC IC105, analog/basic/cmos_logic.hpp:27
        I(cpphdl_n963, Vss) <+ 1e-14 * ddt(V(cpphdl_n963, Vss)); // Bench initial voltage = 0.0 V.
        // device 620, IC IC106, analog/basic/cmos_logic.hpp:17
        I(cpphdl_n968, Vss) <+ 5.0000000000000002e-14 * ddt(V(cpphdl_n968, Vss)); // Bench initial voltage = 0.0 V.
        // device 621, IC IC106, analog/basic/cmos_logic.hpp:18
        I(cpphdl_n968, Vdd) <+ cpphdl_channel(V(cpphdl_n966, Vdd), V(cpphdl_n968, Vdd), 0.01, 0.69999999999999996, -1.0);
        // device 622, IC IC106, analog/basic/cmos_logic.hpp:19
        I(cpphdl_n968, Vdd) <+ cpphdl_channel(V(cpphdl_n2293, Vdd), V(cpphdl_n968, Vdd), 0.01, 0.69999999999999996, -1.0);
        // device 623, IC IC106, analog/basic/cmos_logic.hpp:20
        I(cpphdl_n968, cpphdl_n969) <+ cpphdl_channel(V(cpphdl_n966, cpphdl_n969), V(cpphdl_n968, cpphdl_n969), 0.01, 0.69999999999999996, 1.0);
        // device 624, IC IC106, analog/basic/cmos_logic.hpp:21
        I(cpphdl_n969, Vss) <+ cpphdl_channel(V(cpphdl_n2293, Vss), V(cpphdl_n969, Vss), 0.01, 0.69999999999999996, 1.0);
        // device 625, IC IC106, analog/basic/cmos_logic.hpp:27
        I(cpphdl_n969, Vss) <+ 1e-14 * ddt(V(cpphdl_n969, Vss)); // Bench initial voltage = 0.0 V.
        // device 626, IC IC104, analog/basic/nand_latch.hpp:36
        I(cpphdl_n960, Vss) <+ 2.9999999999999998e-15 * ddt(V(cpphdl_n960, Vss)); // Bench initial voltage = 0.0 V.
        // device 627, IC IC104, analog/basic/nand_latch.hpp:37
        I(cpphdl_n966, Vss) <+ 2.9999999999999998e-15 * ddt(V(cpphdl_n966, Vss)); // Bench initial voltage = 0.0 V.
        // device 628, IC IC107, analog/basic/inverter.hpp:11
        I(cpphdl_n974, Vdd) <+ cpphdl_channel(V(CLEAR, Vdd), V(cpphdl_n974, Vdd), 0.01, 0.69999999999999996, -1.0);
        // device 629, IC IC107, analog/basic/inverter.hpp:12
        I(cpphdl_n974, Vss) <+ cpphdl_channel(V(CLEAR, Vss), V(cpphdl_n974, Vss), 0.01, 0.69999999999999996, 1.0);
        // device 630, IC IC104, analog/basic/nand_latch.hpp:58
        I(cpphdl_n974, Vss) <+ 2.9999999999999998e-15 * ddt(V(cpphdl_n974, Vss)); // Bench initial voltage = 0.0 V.
        // device 631, IC IC104, analog/basic/nand_latch.hpp:59
        I(cpphdl_n2293, Vss) <+ cpphdl_channel(V(CLEAR, Vss), V(cpphdl_n2293, Vss), 0.050000000000000003, 0.69999999999999996, 1.0);
        // device 632, IC IC104, analog/basic/nand_latch.hpp:60
        I(cpphdl_n968, Vdd) <+ cpphdl_channel(V(cpphdl_n974, Vdd), V(cpphdl_n968, Vdd), 0.050000000000000003, 0.69999999999999996, -1.0);
        // device 633, IC IC110, analog/basic/inverter.hpp:11
        I(cpphdl_n998, Vdd) <+ cpphdl_channel(V(TRACK4, Vdd), V(cpphdl_n998, Vdd), 0.0040000000000000001, 0.69999999999999996, -1.0);
        // device 634, IC IC110, analog/basic/inverter.hpp:12
        I(cpphdl_n998, Vss) <+ cpphdl_channel(V(TRACK4, Vss), V(cpphdl_n998, Vss), 0.0040000000000000001, 0.69999999999999996, 1.0);
        // device 635, IC IC109, analog/basic/mos_track_hold.hpp:31
        I(cpphdl_n998, Vss) <+ 2e-14 * ddt(V(cpphdl_n998, Vss)); // Bench initial voltage = 0.0 V.
        // device 636, IC IC109, analog/basic/mos_track_hold.hpp:32
        I(cpphdl_n2136, cpphdl_n1052) <+ cpphdl_channel(V(TRACK4, cpphdl_n1052), V(cpphdl_n2136, cpphdl_n1052), 0.029999999999999999, 0.69999999999999996, 1.0);
        // device 637, IC IC109, analog/basic/mos_track_hold.hpp:33
        I(cpphdl_n1052, cpphdl_n2136) <+ cpphdl_channel(V(cpphdl_n998, cpphdl_n2136), V(cpphdl_n1052, cpphdl_n2136), 0.014999999999999999, 0.69999999999999996, -1.0);
        // device 638, IC IC109, analog/basic/mos_track_hold.hpp:37
        I(cpphdl_n1052, cpphdl_n1052) <+ cpphdl_channel(V(cpphdl_n998, cpphdl_n1052), V(cpphdl_n1052, cpphdl_n1052), 0.016, 0.69999999999999996, 1.0);
        // device 639, IC IC109, analog/basic/mos_track_hold.hpp:38
        I(cpphdl_n1052, cpphdl_n1052) <+ cpphdl_channel(V(TRACK4, cpphdl_n1052), V(cpphdl_n1052, cpphdl_n1052), 0.0083999999999999995, 0.69999999999999996, -1.0);
        // device 640, IC IC109, analog/basic/mos_track_hold.hpp:39
        I(cpphdl_n1052, Vss) <+ 1.5000000000000001e-12 * ddt(V(cpphdl_n1052, Vss)); // Bench initial voltage = 0.0 V.
        // device 641, IC IC109, analog/basic/mos_track_hold.hpp:42
        I(TRACK4, cpphdl_n1052) <+ 2.0000000000000002e-15 * ddt(V(TRACK4, cpphdl_n1052)); // Bench initial voltage = -0.0 V.
        // device 642, IC IC109, analog/basic/mos_track_hold.hpp:43
        I(cpphdl_n998, cpphdl_n1052) <+ 2.0000000000000002e-15 * ddt(V(cpphdl_n998, cpphdl_n1052)); // Bench initial voltage = 0.0 V.
        // device 643, IC IC109, analog/basic/mos_track_hold.hpp:44
        I(cpphdl_n2136, cpphdl_n1052) <+ 1.0000000000000001e-15 * ddt(V(cpphdl_n2136, cpphdl_n1052)); // Bench initial voltage = 0.0 V.
        // device 644, IC IC112, analog/basic/inverter.hpp:11
        I(cpphdl_n1013, Vdd) <+ cpphdl_channel(V(BIT_N4_0, Vdd), V(cpphdl_n1013, Vdd), 0.080000000000000002, 0.69999999999999996, -1.0);
        // device 645, IC IC112, analog/basic/inverter.hpp:12
        I(cpphdl_n1013, Vss) <+ cpphdl_channel(V(BIT_N4_0, Vss), V(cpphdl_n1013, Vss), 0.080000000000000002, 0.69999999999999996, 1.0);
        // device 646, IC IC111, analog/basic/mos_r2r_dac.hpp:27
        I(cpphdl_n1013, Vss) <+ 2.9999999999999998e-15 * ddt(V(cpphdl_n1013, Vss)); // Bench initial voltage = 0.0 V.
        // device 647, IC IC111, analog/basic/mos_r2r_dac.hpp:28
        I(cpphdl_n1013, cpphdl_n1042) <+ V(cpphdl_n1013, cpphdl_n1042) / 2000.0;
        // device 648, IC IC111, analog/basic/mos_r2r_dac.hpp:29
        I(cpphdl_n1042, Vss) <+ 2.9999999999999998e-15 * ddt(V(cpphdl_n1042, Vss)); // Bench initial voltage = 0.0 V.
        // device 649, IC IC113, analog/basic/inverter.hpp:11
        I(cpphdl_n1017, Vdd) <+ cpphdl_channel(V(BIT_N4_1, Vdd), V(cpphdl_n1017, Vdd), 0.080000000000000002, 0.69999999999999996, -1.0);
        // device 650, IC IC113, analog/basic/inverter.hpp:12
        I(cpphdl_n1017, Vss) <+ cpphdl_channel(V(BIT_N4_1, Vss), V(cpphdl_n1017, Vss), 0.080000000000000002, 0.69999999999999996, 1.0);
        // device 651, IC IC111, analog/basic/mos_r2r_dac.hpp:27
        I(cpphdl_n1017, Vss) <+ 2.9999999999999998e-15 * ddt(V(cpphdl_n1017, Vss)); // Bench initial voltage = 0.0 V.
        // device 652, IC IC111, analog/basic/mos_r2r_dac.hpp:28
        I(cpphdl_n1017, cpphdl_n1043) <+ V(cpphdl_n1017, cpphdl_n1043) / 2000.0;
        // device 653, IC IC111, analog/basic/mos_r2r_dac.hpp:29
        I(cpphdl_n1043, Vss) <+ 2.9999999999999998e-15 * ddt(V(cpphdl_n1043, Vss)); // Bench initial voltage = 0.0 V.
        // device 654, IC IC111, analog/basic/mos_r2r_dac.hpp:31
        I(cpphdl_n1042, cpphdl_n1043) <+ V(cpphdl_n1042, cpphdl_n1043) / 1000.0;
        // device 655, IC IC114, analog/basic/inverter.hpp:11
        I(cpphdl_n1021, Vdd) <+ cpphdl_channel(V(BIT_N4_2, Vdd), V(cpphdl_n1021, Vdd), 0.080000000000000002, 0.69999999999999996, -1.0);
        // device 656, IC IC114, analog/basic/inverter.hpp:12
        I(cpphdl_n1021, Vss) <+ cpphdl_channel(V(BIT_N4_2, Vss), V(cpphdl_n1021, Vss), 0.080000000000000002, 0.69999999999999996, 1.0);
        // device 657, IC IC111, analog/basic/mos_r2r_dac.hpp:27
        I(cpphdl_n1021, Vss) <+ 2.9999999999999998e-15 * ddt(V(cpphdl_n1021, Vss)); // Bench initial voltage = 0.0 V.
        // device 658, IC IC111, analog/basic/mos_r2r_dac.hpp:28
        I(cpphdl_n1021, cpphdl_n1044) <+ V(cpphdl_n1021, cpphdl_n1044) / 2000.0;
        // device 659, IC IC111, analog/basic/mos_r2r_dac.hpp:29
        I(cpphdl_n1044, Vss) <+ 2.9999999999999998e-15 * ddt(V(cpphdl_n1044, Vss)); // Bench initial voltage = 0.0 V.
        // device 660, IC IC111, analog/basic/mos_r2r_dac.hpp:31
        I(cpphdl_n1043, cpphdl_n1044) <+ V(cpphdl_n1043, cpphdl_n1044) / 1000.0;
        // device 661, IC IC115, analog/basic/inverter.hpp:11
        I(cpphdl_n1025, Vdd) <+ cpphdl_channel(V(BIT_N4_3, Vdd), V(cpphdl_n1025, Vdd), 0.080000000000000002, 0.69999999999999996, -1.0);
        // device 662, IC IC115, analog/basic/inverter.hpp:12
        I(cpphdl_n1025, Vss) <+ cpphdl_channel(V(BIT_N4_3, Vss), V(cpphdl_n1025, Vss), 0.080000000000000002, 0.69999999999999996, 1.0);
        // device 663, IC IC111, analog/basic/mos_r2r_dac.hpp:27
        I(cpphdl_n1025, Vss) <+ 2.9999999999999998e-15 * ddt(V(cpphdl_n1025, Vss)); // Bench initial voltage = 0.0 V.
        // device 664, IC IC111, analog/basic/mos_r2r_dac.hpp:28
        I(cpphdl_n1025, cpphdl_n1045) <+ V(cpphdl_n1025, cpphdl_n1045) / 2000.0;
        // device 665, IC IC111, analog/basic/mos_r2r_dac.hpp:29
        I(cpphdl_n1045, Vss) <+ 2.9999999999999998e-15 * ddt(V(cpphdl_n1045, Vss)); // Bench initial voltage = 0.0 V.
        // device 666, IC IC111, analog/basic/mos_r2r_dac.hpp:31
        I(cpphdl_n1044, cpphdl_n1045) <+ V(cpphdl_n1044, cpphdl_n1045) / 1000.0;
        // device 667, IC IC116, analog/basic/inverter.hpp:11
        I(cpphdl_n1029, Vdd) <+ cpphdl_channel(V(BIT_N4_4, Vdd), V(cpphdl_n1029, Vdd), 0.080000000000000002, 0.69999999999999996, -1.0);
        // device 668, IC IC116, analog/basic/inverter.hpp:12
        I(cpphdl_n1029, Vss) <+ cpphdl_channel(V(BIT_N4_4, Vss), V(cpphdl_n1029, Vss), 0.080000000000000002, 0.69999999999999996, 1.0);
        // device 669, IC IC111, analog/basic/mos_r2r_dac.hpp:27
        I(cpphdl_n1029, Vss) <+ 2.9999999999999998e-15 * ddt(V(cpphdl_n1029, Vss)); // Bench initial voltage = 0.0 V.
        // device 670, IC IC111, analog/basic/mos_r2r_dac.hpp:28
        I(cpphdl_n1029, cpphdl_n1046) <+ V(cpphdl_n1029, cpphdl_n1046) / 2000.0;
        // device 671, IC IC111, analog/basic/mos_r2r_dac.hpp:29
        I(cpphdl_n1046, Vss) <+ 2.9999999999999998e-15 * ddt(V(cpphdl_n1046, Vss)); // Bench initial voltage = 0.0 V.
        // device 672, IC IC111, analog/basic/mos_r2r_dac.hpp:31
        I(cpphdl_n1045, cpphdl_n1046) <+ V(cpphdl_n1045, cpphdl_n1046) / 1000.0;
        // device 673, IC IC117, analog/basic/inverter.hpp:11
        I(cpphdl_n1033, Vdd) <+ cpphdl_channel(V(BIT_N4_5, Vdd), V(cpphdl_n1033, Vdd), 0.080000000000000002, 0.69999999999999996, -1.0);
        // device 674, IC IC117, analog/basic/inverter.hpp:12
        I(cpphdl_n1033, Vss) <+ cpphdl_channel(V(BIT_N4_5, Vss), V(cpphdl_n1033, Vss), 0.080000000000000002, 0.69999999999999996, 1.0);
        // device 675, IC IC111, analog/basic/mos_r2r_dac.hpp:27
        I(cpphdl_n1033, Vss) <+ 2.9999999999999998e-15 * ddt(V(cpphdl_n1033, Vss)); // Bench initial voltage = 0.0 V.
        // device 676, IC IC111, analog/basic/mos_r2r_dac.hpp:28
        I(cpphdl_n1033, cpphdl_n1047) <+ V(cpphdl_n1033, cpphdl_n1047) / 2000.0;
        // device 677, IC IC111, analog/basic/mos_r2r_dac.hpp:29
        I(cpphdl_n1047, Vss) <+ 2.9999999999999998e-15 * ddt(V(cpphdl_n1047, Vss)); // Bench initial voltage = 0.0 V.
        // device 678, IC IC111, analog/basic/mos_r2r_dac.hpp:31
        I(cpphdl_n1046, cpphdl_n1047) <+ V(cpphdl_n1046, cpphdl_n1047) / 1000.0;
        // device 679, IC IC118, analog/basic/inverter.hpp:11
        I(cpphdl_n1037, Vdd) <+ cpphdl_channel(V(BIT_N4_6, Vdd), V(cpphdl_n1037, Vdd), 0.080000000000000002, 0.69999999999999996, -1.0);
        // device 680, IC IC118, analog/basic/inverter.hpp:12
        I(cpphdl_n1037, Vss) <+ cpphdl_channel(V(BIT_N4_6, Vss), V(cpphdl_n1037, Vss), 0.080000000000000002, 0.69999999999999996, 1.0);
        // device 681, IC IC111, analog/basic/mos_r2r_dac.hpp:27
        I(cpphdl_n1037, Vss) <+ 2.9999999999999998e-15 * ddt(V(cpphdl_n1037, Vss)); // Bench initial voltage = 0.0 V.
        // device 682, IC IC111, analog/basic/mos_r2r_dac.hpp:28
        I(cpphdl_n1037, cpphdl_n1048) <+ V(cpphdl_n1037, cpphdl_n1048) / 2000.0;
        // device 683, IC IC111, analog/basic/mos_r2r_dac.hpp:29
        I(cpphdl_n1048, Vss) <+ 2.9999999999999998e-15 * ddt(V(cpphdl_n1048, Vss)); // Bench initial voltage = 0.0 V.
        // device 684, IC IC111, analog/basic/mos_r2r_dac.hpp:31
        I(cpphdl_n1047, cpphdl_n1048) <+ V(cpphdl_n1047, cpphdl_n1048) / 1000.0;
        // device 685, IC IC119, analog/basic/inverter.hpp:11
        I(cpphdl_n1041, Vdd) <+ cpphdl_channel(V(BIT_N4_7, Vdd), V(cpphdl_n1041, Vdd), 0.080000000000000002, 0.69999999999999996, -1.0);
        // device 686, IC IC119, analog/basic/inverter.hpp:12
        I(cpphdl_n1041, Vss) <+ cpphdl_channel(V(BIT_N4_7, Vss), V(cpphdl_n1041, Vss), 0.080000000000000002, 0.69999999999999996, 1.0);
        // device 687, IC IC111, analog/basic/mos_r2r_dac.hpp:27
        I(cpphdl_n1041, Vss) <+ 2.9999999999999998e-15 * ddt(V(cpphdl_n1041, Vss)); // Bench initial voltage = 0.0 V.
        // device 688, IC IC111, analog/basic/mos_r2r_dac.hpp:28
        I(cpphdl_n1041, cpphdl_n1053) <+ V(cpphdl_n1041, cpphdl_n1053) / 2000.0;
        // device 689, IC IC111, analog/basic/mos_r2r_dac.hpp:29
        I(cpphdl_n1053, Vss) <+ 2.9999999999999998e-15 * ddt(V(cpphdl_n1053, Vss)); // Bench initial voltage = 0.0 V.
        // device 690, IC IC111, analog/basic/mos_r2r_dac.hpp:31
        I(cpphdl_n1048, cpphdl_n1053) <+ V(cpphdl_n1048, cpphdl_n1053) / 1000.0;
        // device 691, IC IC111, analog/basic/mos_r2r_dac.hpp:33
        I(Vss, cpphdl_n1042) <+ V(Vss, cpphdl_n1042) / 2000.0;
        // device 692, IC IC120, analog/basic/nmos_resistor_amplifier.hpp:23
        I(Vdd, cpphdl_n1062) <+ V(Vdd, cpphdl_n1062) / 1000.0;
        // device 693, IC IC120, analog/basic/nmos_resistor_amplifier.hpp:24
        I(Vdd, cpphdl_n1061) <+ V(Vdd, cpphdl_n1061) / 1000.0;
        // device 694, IC IC120, analog/basic/nmos_resistor_amplifier.hpp:25
        I(cpphdl_n1062, cpphdl_n1056) <+ cpphdl_channel(V(cpphdl_n1052, cpphdl_n1056), V(cpphdl_n1062, cpphdl_n1056), 0.0074999999999999997, 0.69999999999999996, 1.0);
        // device 695, IC IC120, analog/basic/nmos_resistor_amplifier.hpp:26
        I(cpphdl_n1061, cpphdl_n1057) <+ cpphdl_channel(V(cpphdl_n1053, cpphdl_n1057), V(cpphdl_n1061, cpphdl_n1057), 0.0074999999999999997, 0.69999999999999996, 1.0);
        // device 696, IC IC120, analog/basic/nmos_resistor_amplifier.hpp:27
        I(cpphdl_n1058, cpphdl_n1056) <+ V(cpphdl_n1058, cpphdl_n1056) / 100.0;
        // device 697, IC IC120, analog/basic/nmos_resistor_amplifier.hpp:28
        I(cpphdl_n1058, cpphdl_n1057) <+ V(cpphdl_n1058, cpphdl_n1057) / 100.0;
        // device 698, IC IC120, analog/basic/nmos_resistor_amplifier.hpp:29
        I(Vss, cpphdl_n1058) <+ V(Vss, cpphdl_n1058) / 300.0;
        // device 699, IC IC120, analog/basic/nmos_resistor_amplifier.hpp:30
        I(cpphdl_n1062, Vdd) <+ 2.9999999999999998e-13 * ddt(V(cpphdl_n1062, Vdd)); // Bench initial voltage = 0.0 V.
        // device 700, IC IC120, analog/basic/nmos_resistor_amplifier.hpp:31
        I(cpphdl_n1061, Vdd) <+ 2.9999999999999998e-13 * ddt(V(cpphdl_n1061, Vdd)); // Bench initial voltage = 0.0 V.
        // device 701, IC IC120, analog/basic/nmos_resistor_amplifier.hpp:32
        I(cpphdl_n1058, Vss) <+ 4e-14 * ddt(V(cpphdl_n1058, Vss)); // Bench initial voltage = 0.0 V.
        // device 702, IC IC120, analog/basic/nmos_resistor_amplifier.hpp:34
        I(cpphdl_n1052, cpphdl_n1056) <+ 2e-14 * ddt(V(cpphdl_n1052, cpphdl_n1056)); // Bench initial voltage = 0.0 V.
        // device 703, IC IC120, analog/basic/nmos_resistor_amplifier.hpp:35
        I(cpphdl_n1053, cpphdl_n1057) <+ 2e-14 * ddt(V(cpphdl_n1053, cpphdl_n1057)); // Bench initial voltage = 0.0 V.
        // device 704, IC IC120, analog/basic/nmos_resistor_amplifier.hpp:36
        I(cpphdl_n1052, cpphdl_n1062) <+ 2.9999999999999998e-15 * ddt(V(cpphdl_n1052, cpphdl_n1062)); // Bench initial voltage = 0.0 V.
        // device 705, IC IC120, analog/basic/nmos_resistor_amplifier.hpp:37
        I(cpphdl_n1053, cpphdl_n1061) <+ 2.9999999999999998e-15 * ddt(V(cpphdl_n1053, cpphdl_n1061)); // Bench initial voltage = 0.0 V.
        // device 706, IC IC121, analog/basic/strongarm_comparator.hpp:28
        I(cpphdl_n1066, cpphdl_n1068) <+ cpphdl_channel(V(cpphdl_n1061, cpphdl_n1068), V(cpphdl_n1066, cpphdl_n1068), 0.0080000000000000002, 0.69999999999999996, 1.0);
        // device 707, IC IC121, analog/basic/strongarm_comparator.hpp:29
        I(cpphdl_n1067, cpphdl_n1068) <+ cpphdl_channel(V(cpphdl_n1062, cpphdl_n1068), V(cpphdl_n1067, cpphdl_n1068), 0.0080000000000000002, 0.69999999999999996, 1.0);
        // device 708, IC IC121, analog/basic/strongarm_comparator.hpp:30
        I(cpphdl_n1068, Vss) <+ cpphdl_channel(V(EVALUATE, Vss), V(cpphdl_n1068, Vss), 0.0080000000000000002, 0.69999999999999996, 1.0);
        // device 709, IC IC121, analog/basic/strongarm_comparator.hpp:33
        I(cpphdl_n1081, cpphdl_n1066) <+ cpphdl_channel(V(cpphdl_n1085, cpphdl_n1066), V(cpphdl_n1081, cpphdl_n1066), 0.0040000000000000001, 0.69999999999999996, 1.0);
        // device 710, IC IC121, analog/basic/strongarm_comparator.hpp:34
        I(cpphdl_n1085, cpphdl_n1067) <+ cpphdl_channel(V(cpphdl_n1081, cpphdl_n1067), V(cpphdl_n1085, cpphdl_n1067), 0.0040000000000000001, 0.69999999999999996, 1.0);
        // device 711, IC IC121, analog/basic/strongarm_comparator.hpp:35
        I(cpphdl_n1085, Vdd) <+ cpphdl_channel(V(cpphdl_n1081, Vdd), V(cpphdl_n1085, Vdd), 0.002, 0.69999999999999996, -1.0);
        // device 712, IC IC121, analog/basic/strongarm_comparator.hpp:36
        I(cpphdl_n1081, Vdd) <+ cpphdl_channel(V(cpphdl_n1085, Vdd), V(cpphdl_n1081, Vdd), 0.002, 0.69999999999999996, -1.0);
        // device 713, IC IC121, analog/basic/strongarm_comparator.hpp:38
        I(cpphdl_n1066, Vdd) <+ cpphdl_channel(V(EVALUATE, Vdd), V(cpphdl_n1066, Vdd), 0.002, 0.69999999999999996, -1.0);
        // device 714, IC IC121, analog/basic/strongarm_comparator.hpp:39
        I(cpphdl_n1067, Vdd) <+ cpphdl_channel(V(EVALUATE, Vdd), V(cpphdl_n1067, Vdd), 0.002, 0.69999999999999996, -1.0);
        // device 715, IC IC121, analog/basic/strongarm_comparator.hpp:40
        I(cpphdl_n1085, Vdd) <+ cpphdl_channel(V(EVALUATE, Vdd), V(cpphdl_n1085, Vdd), 0.002, 0.69999999999999996, -1.0);
        // device 716, IC IC121, analog/basic/strongarm_comparator.hpp:41
        I(cpphdl_n1081, Vdd) <+ cpphdl_channel(V(EVALUATE, Vdd), V(cpphdl_n1081, Vdd), 0.002, 0.69999999999999996, -1.0);
        // device 717, IC IC121, analog/basic/strongarm_comparator.hpp:42
        I(cpphdl_n1066, Vss) <+ 2.9999999999999998e-14 * ddt(V(cpphdl_n1066, Vss)); // Bench initial voltage = 0.0 V.
        // device 718, IC IC121, analog/basic/strongarm_comparator.hpp:43
        I(cpphdl_n1067, Vss) <+ 2.9999999999999998e-14 * ddt(V(cpphdl_n1067, Vss)); // Bench initial voltage = 0.0 V.
        // device 719, IC IC121, analog/basic/strongarm_comparator.hpp:44
        I(cpphdl_n1068, Vss) <+ 2.9999999999999998e-14 * ddt(V(cpphdl_n1068, Vss)); // Bench initial voltage = 0.0 V.
        // device 720, IC IC121, analog/basic/strongarm_comparator.hpp:45
        I(cpphdl_n1085, Vss) <+ 5.0000000000000002e-14 * ddt(V(cpphdl_n1085, Vss)); // Bench initial voltage = 0.0 V.
        // device 721, IC IC121, analog/basic/strongarm_comparator.hpp:46
        I(cpphdl_n1081, Vss) <+ 5.0000000000000002e-14 * ddt(V(cpphdl_n1081, Vss)); // Bench initial voltage = 0.0 V.
        // device 722, IC IC121, analog/basic/strongarm_comparator.hpp:47
        I(cpphdl_n1061, cpphdl_n1068) <+ 2e-14 * ddt(V(cpphdl_n1061, cpphdl_n1068)); // Bench initial voltage = 0.0 V.
        // device 723, IC IC121, analog/basic/strongarm_comparator.hpp:48
        I(cpphdl_n1062, cpphdl_n1068) <+ 2e-14 * ddt(V(cpphdl_n1062, cpphdl_n1068)); // Bench initial voltage = 0.0 V.
        // device 724, IC IC121, analog/basic/strongarm_comparator.hpp:49
        I(cpphdl_n1061, cpphdl_n1066) <+ 2.9999999999999998e-15 * ddt(V(cpphdl_n1061, cpphdl_n1066)); // Bench initial voltage = 0.0 V.
        // device 725, IC IC121, analog/basic/strongarm_comparator.hpp:50
        I(cpphdl_n1062, cpphdl_n1067) <+ 2.9999999999999998e-15 * ddt(V(cpphdl_n1062, cpphdl_n1067)); // Bench initial voltage = 0.0 V.
        // device 726, IC IC123, analog/basic/inverter.hpp:11
        I(cpphdl_n1089, Vdd) <+ cpphdl_channel(V(cpphdl_n1081, Vdd), V(cpphdl_n1089, Vdd), 0.001, 0.69999999999999996, -1.0);
        // device 727, IC IC123, analog/basic/inverter.hpp:12
        I(cpphdl_n1089, Vss) <+ cpphdl_channel(V(cpphdl_n1081, Vss), V(cpphdl_n1089, Vss), 0.001, 0.69999999999999996, 1.0);
        // device 728, IC IC125, analog/basic/inverter.hpp:11
        I(cpphdl_n1103, Vdd) <+ cpphdl_channel(V(cpphdl_n1089, Vdd), V(cpphdl_n1103, Vdd), 0.0040000000000000001, 0.69999999999999996, -1.0);
        // device 729, IC IC125, analog/basic/inverter.hpp:12
        I(cpphdl_n1103, Vss) <+ cpphdl_channel(V(cpphdl_n1089, Vss), V(cpphdl_n1103, Vss), 0.0040000000000000001, 0.69999999999999996, 1.0);
        // device 730, IC IC122, analog/basic/buffered_nand_latch.hpp:34
        I(cpphdl_n1081, Vss) <+ 2.0000000000000002e-15 * ddt(V(cpphdl_n1081, Vss)); // Bench initial voltage = 0.0 V.
        // device 731, IC IC122, analog/basic/buffered_nand_latch.hpp:35
        I(cpphdl_n1081, cpphdl_n1089) <+ 1.0000000000000001e-15 * ddt(V(cpphdl_n1081, cpphdl_n1089)); // Bench initial voltage = 0.0 V.
        // device 732, IC IC122, analog/basic/buffered_nand_latch.hpp:36
        I(cpphdl_n1089, Vss) <+ 5e-15 * ddt(V(cpphdl_n1089, Vss)); // Bench initial voltage = 0.0 V.
        // device 733, IC IC122, analog/basic/buffered_nand_latch.hpp:37
        I(cpphdl_n1089, Vss) <+ 8.0000000000000006e-15 * ddt(V(cpphdl_n1089, Vss)); // Bench initial voltage = 0.0 V.
        // device 734, IC IC122, analog/basic/buffered_nand_latch.hpp:38
        I(cpphdl_n1103, Vss) <+ 1e-14 * ddt(V(cpphdl_n1103, Vss)); // Bench initial voltage = 0.0 V.
        // device 735, IC IC124, analog/basic/inverter.hpp:11
        I(cpphdl_n1093, Vdd) <+ cpphdl_channel(V(cpphdl_n1085, Vdd), V(cpphdl_n1093, Vdd), 0.001, 0.69999999999999996, -1.0);
        // device 736, IC IC124, analog/basic/inverter.hpp:12
        I(cpphdl_n1093, Vss) <+ cpphdl_channel(V(cpphdl_n1085, Vss), V(cpphdl_n1093, Vss), 0.001, 0.69999999999999996, 1.0);
        // device 737, IC IC126, analog/basic/inverter.hpp:11
        I(cpphdl_n1109, Vdd) <+ cpphdl_channel(V(cpphdl_n1093, Vdd), V(cpphdl_n1109, Vdd), 0.0040000000000000001, 0.69999999999999996, -1.0);
        // device 738, IC IC126, analog/basic/inverter.hpp:12
        I(cpphdl_n1109, Vss) <+ cpphdl_channel(V(cpphdl_n1093, Vss), V(cpphdl_n1109, Vss), 0.0040000000000000001, 0.69999999999999996, 1.0);
        // device 739, IC IC122, analog/basic/buffered_nand_latch.hpp:34
        I(cpphdl_n1085, Vss) <+ 2.0000000000000002e-15 * ddt(V(cpphdl_n1085, Vss)); // Bench initial voltage = 0.0 V.
        // device 740, IC IC122, analog/basic/buffered_nand_latch.hpp:35
        I(cpphdl_n1085, cpphdl_n1093) <+ 1.0000000000000001e-15 * ddt(V(cpphdl_n1085, cpphdl_n1093)); // Bench initial voltage = 0.0 V.
        // device 741, IC IC122, analog/basic/buffered_nand_latch.hpp:36
        I(cpphdl_n1093, Vss) <+ 5e-15 * ddt(V(cpphdl_n1093, Vss)); // Bench initial voltage = 0.0 V.
        // device 742, IC IC122, analog/basic/buffered_nand_latch.hpp:37
        I(cpphdl_n1093, Vss) <+ 8.0000000000000006e-15 * ddt(V(cpphdl_n1093, Vss)); // Bench initial voltage = 0.0 V.
        // device 743, IC IC122, analog/basic/buffered_nand_latch.hpp:38
        I(cpphdl_n1109, Vss) <+ 1e-14 * ddt(V(cpphdl_n1109, Vss)); // Bench initial voltage = 0.0 V.
        // device 744, IC IC128, analog/basic/cmos_logic.hpp:17
        I(cpphdl_n2298, Vss) <+ 5.0000000000000002e-14 * ddt(V(cpphdl_n2298, Vss)); // Bench initial voltage = 0.0 V.
        // device 745, IC IC128, analog/basic/cmos_logic.hpp:18
        I(cpphdl_n2298, Vdd) <+ cpphdl_channel(V(cpphdl_n1103, Vdd), V(cpphdl_n2298, Vdd), 0.01, 0.69999999999999996, -1.0);
        // device 746, IC IC128, analog/basic/cmos_logic.hpp:19
        I(cpphdl_n2298, Vdd) <+ cpphdl_channel(V(cpphdl_n1111, Vdd), V(cpphdl_n2298, Vdd), 0.01, 0.69999999999999996, -1.0);
        // device 747, IC IC128, analog/basic/cmos_logic.hpp:20
        I(cpphdl_n2298, cpphdl_n1106) <+ cpphdl_channel(V(cpphdl_n1103, cpphdl_n1106), V(cpphdl_n2298, cpphdl_n1106), 0.01, 0.69999999999999996, 1.0);
        // device 748, IC IC128, analog/basic/cmos_logic.hpp:21
        I(cpphdl_n1106, Vss) <+ cpphdl_channel(V(cpphdl_n1111, Vss), V(cpphdl_n1106, Vss), 0.01, 0.69999999999999996, 1.0);
        // device 749, IC IC128, analog/basic/cmos_logic.hpp:27
        I(cpphdl_n1106, Vss) <+ 1e-14 * ddt(V(cpphdl_n1106, Vss)); // Bench initial voltage = 0.0 V.
        // device 750, IC IC129, analog/basic/cmos_logic.hpp:17
        I(cpphdl_n1111, Vss) <+ 5.0000000000000002e-14 * ddt(V(cpphdl_n1111, Vss)); // Bench initial voltage = 0.0 V.
        // device 751, IC IC129, analog/basic/cmos_logic.hpp:18
        I(cpphdl_n1111, Vdd) <+ cpphdl_channel(V(cpphdl_n1109, Vdd), V(cpphdl_n1111, Vdd), 0.01, 0.69999999999999996, -1.0);
        // device 752, IC IC129, analog/basic/cmos_logic.hpp:19
        I(cpphdl_n1111, Vdd) <+ cpphdl_channel(V(cpphdl_n2298, Vdd), V(cpphdl_n1111, Vdd), 0.01, 0.69999999999999996, -1.0);
        // device 753, IC IC129, analog/basic/cmos_logic.hpp:20
        I(cpphdl_n1111, cpphdl_n1112) <+ cpphdl_channel(V(cpphdl_n1109, cpphdl_n1112), V(cpphdl_n1111, cpphdl_n1112), 0.01, 0.69999999999999996, 1.0);
        // device 754, IC IC129, analog/basic/cmos_logic.hpp:21
        I(cpphdl_n1112, Vss) <+ cpphdl_channel(V(cpphdl_n2298, Vss), V(cpphdl_n1112, Vss), 0.01, 0.69999999999999996, 1.0);
        // device 755, IC IC129, analog/basic/cmos_logic.hpp:27
        I(cpphdl_n1112, Vss) <+ 1e-14 * ddt(V(cpphdl_n1112, Vss)); // Bench initial voltage = 0.0 V.
        // device 756, IC IC127, analog/basic/nand_latch.hpp:36
        I(cpphdl_n1103, Vss) <+ 2.9999999999999998e-15 * ddt(V(cpphdl_n1103, Vss)); // Bench initial voltage = 0.0 V.
        // device 757, IC IC127, analog/basic/nand_latch.hpp:37
        I(cpphdl_n1109, Vss) <+ 2.9999999999999998e-15 * ddt(V(cpphdl_n1109, Vss)); // Bench initial voltage = 0.0 V.
        // device 758, IC IC130, analog/basic/inverter.hpp:11
        I(cpphdl_n1117, Vdd) <+ cpphdl_channel(V(CLEAR, Vdd), V(cpphdl_n1117, Vdd), 0.01, 0.69999999999999996, -1.0);
        // device 759, IC IC130, analog/basic/inverter.hpp:12
        I(cpphdl_n1117, Vss) <+ cpphdl_channel(V(CLEAR, Vss), V(cpphdl_n1117, Vss), 0.01, 0.69999999999999996, 1.0);
        // device 760, IC IC127, analog/basic/nand_latch.hpp:58
        I(cpphdl_n1117, Vss) <+ 2.9999999999999998e-15 * ddt(V(cpphdl_n1117, Vss)); // Bench initial voltage = 0.0 V.
        // device 761, IC IC127, analog/basic/nand_latch.hpp:59
        I(cpphdl_n2298, Vss) <+ cpphdl_channel(V(CLEAR, Vss), V(cpphdl_n2298, Vss), 0.050000000000000003, 0.69999999999999996, 1.0);
        // device 762, IC IC127, analog/basic/nand_latch.hpp:60
        I(cpphdl_n1111, Vdd) <+ cpphdl_channel(V(cpphdl_n1117, Vdd), V(cpphdl_n1111, Vdd), 0.050000000000000003, 0.69999999999999996, -1.0);
        // device 763, IC IC133, analog/basic/inverter.hpp:11
        I(cpphdl_n1141, Vdd) <+ cpphdl_channel(V(TRACK5, Vdd), V(cpphdl_n1141, Vdd), 0.0040000000000000001, 0.69999999999999996, -1.0);
        // device 764, IC IC133, analog/basic/inverter.hpp:12
        I(cpphdl_n1141, Vss) <+ cpphdl_channel(V(TRACK5, Vss), V(cpphdl_n1141, Vss), 0.0040000000000000001, 0.69999999999999996, 1.0);
        // device 765, IC IC132, analog/basic/mos_track_hold.hpp:31
        I(cpphdl_n1141, Vss) <+ 2e-14 * ddt(V(cpphdl_n1141, Vss)); // Bench initial voltage = 0.0 V.
        // device 766, IC IC132, analog/basic/mos_track_hold.hpp:32
        I(cpphdl_n2136, cpphdl_n1195) <+ cpphdl_channel(V(TRACK5, cpphdl_n1195), V(cpphdl_n2136, cpphdl_n1195), 0.029999999999999999, 0.69999999999999996, 1.0);
        // device 767, IC IC132, analog/basic/mos_track_hold.hpp:33
        I(cpphdl_n1195, cpphdl_n2136) <+ cpphdl_channel(V(cpphdl_n1141, cpphdl_n2136), V(cpphdl_n1195, cpphdl_n2136), 0.014999999999999999, 0.69999999999999996, -1.0);
        // device 768, IC IC132, analog/basic/mos_track_hold.hpp:37
        I(cpphdl_n1195, cpphdl_n1195) <+ cpphdl_channel(V(cpphdl_n1141, cpphdl_n1195), V(cpphdl_n1195, cpphdl_n1195), 0.016, 0.69999999999999996, 1.0);
        // device 769, IC IC132, analog/basic/mos_track_hold.hpp:38
        I(cpphdl_n1195, cpphdl_n1195) <+ cpphdl_channel(V(TRACK5, cpphdl_n1195), V(cpphdl_n1195, cpphdl_n1195), 0.0083999999999999995, 0.69999999999999996, -1.0);
        // device 770, IC IC132, analog/basic/mos_track_hold.hpp:39
        I(cpphdl_n1195, Vss) <+ 1.5000000000000001e-12 * ddt(V(cpphdl_n1195, Vss)); // Bench initial voltage = 0.0 V.
        // device 771, IC IC132, analog/basic/mos_track_hold.hpp:42
        I(TRACK5, cpphdl_n1195) <+ 2.0000000000000002e-15 * ddt(V(TRACK5, cpphdl_n1195)); // Bench initial voltage = -0.0 V.
        // device 772, IC IC132, analog/basic/mos_track_hold.hpp:43
        I(cpphdl_n1141, cpphdl_n1195) <+ 2.0000000000000002e-15 * ddt(V(cpphdl_n1141, cpphdl_n1195)); // Bench initial voltage = 0.0 V.
        // device 773, IC IC132, analog/basic/mos_track_hold.hpp:44
        I(cpphdl_n2136, cpphdl_n1195) <+ 1.0000000000000001e-15 * ddt(V(cpphdl_n2136, cpphdl_n1195)); // Bench initial voltage = 0.0 V.
        // device 774, IC IC135, analog/basic/inverter.hpp:11
        I(cpphdl_n1156, Vdd) <+ cpphdl_channel(V(BIT_N5_0, Vdd), V(cpphdl_n1156, Vdd), 0.080000000000000002, 0.69999999999999996, -1.0);
        // device 775, IC IC135, analog/basic/inverter.hpp:12
        I(cpphdl_n1156, Vss) <+ cpphdl_channel(V(BIT_N5_0, Vss), V(cpphdl_n1156, Vss), 0.080000000000000002, 0.69999999999999996, 1.0);
        // device 776, IC IC134, analog/basic/mos_r2r_dac.hpp:27
        I(cpphdl_n1156, Vss) <+ 2.9999999999999998e-15 * ddt(V(cpphdl_n1156, Vss)); // Bench initial voltage = 0.0 V.
        // device 777, IC IC134, analog/basic/mos_r2r_dac.hpp:28
        I(cpphdl_n1156, cpphdl_n1185) <+ V(cpphdl_n1156, cpphdl_n1185) / 2000.0;
        // device 778, IC IC134, analog/basic/mos_r2r_dac.hpp:29
        I(cpphdl_n1185, Vss) <+ 2.9999999999999998e-15 * ddt(V(cpphdl_n1185, Vss)); // Bench initial voltage = 0.0 V.
        // device 779, IC IC136, analog/basic/inverter.hpp:11
        I(cpphdl_n1160, Vdd) <+ cpphdl_channel(V(BIT_N5_1, Vdd), V(cpphdl_n1160, Vdd), 0.080000000000000002, 0.69999999999999996, -1.0);
        // device 780, IC IC136, analog/basic/inverter.hpp:12
        I(cpphdl_n1160, Vss) <+ cpphdl_channel(V(BIT_N5_1, Vss), V(cpphdl_n1160, Vss), 0.080000000000000002, 0.69999999999999996, 1.0);
        // device 781, IC IC134, analog/basic/mos_r2r_dac.hpp:27
        I(cpphdl_n1160, Vss) <+ 2.9999999999999998e-15 * ddt(V(cpphdl_n1160, Vss)); // Bench initial voltage = 0.0 V.
        // device 782, IC IC134, analog/basic/mos_r2r_dac.hpp:28
        I(cpphdl_n1160, cpphdl_n1186) <+ V(cpphdl_n1160, cpphdl_n1186) / 2000.0;
        // device 783, IC IC134, analog/basic/mos_r2r_dac.hpp:29
        I(cpphdl_n1186, Vss) <+ 2.9999999999999998e-15 * ddt(V(cpphdl_n1186, Vss)); // Bench initial voltage = 0.0 V.
        // device 784, IC IC134, analog/basic/mos_r2r_dac.hpp:31
        I(cpphdl_n1185, cpphdl_n1186) <+ V(cpphdl_n1185, cpphdl_n1186) / 1000.0;
        // device 785, IC IC137, analog/basic/inverter.hpp:11
        I(cpphdl_n1164, Vdd) <+ cpphdl_channel(V(BIT_N5_2, Vdd), V(cpphdl_n1164, Vdd), 0.080000000000000002, 0.69999999999999996, -1.0);
        // device 786, IC IC137, analog/basic/inverter.hpp:12
        I(cpphdl_n1164, Vss) <+ cpphdl_channel(V(BIT_N5_2, Vss), V(cpphdl_n1164, Vss), 0.080000000000000002, 0.69999999999999996, 1.0);
        // device 787, IC IC134, analog/basic/mos_r2r_dac.hpp:27
        I(cpphdl_n1164, Vss) <+ 2.9999999999999998e-15 * ddt(V(cpphdl_n1164, Vss)); // Bench initial voltage = 0.0 V.
        // device 788, IC IC134, analog/basic/mos_r2r_dac.hpp:28
        I(cpphdl_n1164, cpphdl_n1187) <+ V(cpphdl_n1164, cpphdl_n1187) / 2000.0;
        // device 789, IC IC134, analog/basic/mos_r2r_dac.hpp:29
        I(cpphdl_n1187, Vss) <+ 2.9999999999999998e-15 * ddt(V(cpphdl_n1187, Vss)); // Bench initial voltage = 0.0 V.
        // device 790, IC IC134, analog/basic/mos_r2r_dac.hpp:31
        I(cpphdl_n1186, cpphdl_n1187) <+ V(cpphdl_n1186, cpphdl_n1187) / 1000.0;
        // device 791, IC IC138, analog/basic/inverter.hpp:11
        I(cpphdl_n1168, Vdd) <+ cpphdl_channel(V(BIT_N5_3, Vdd), V(cpphdl_n1168, Vdd), 0.080000000000000002, 0.69999999999999996, -1.0);
        // device 792, IC IC138, analog/basic/inverter.hpp:12
        I(cpphdl_n1168, Vss) <+ cpphdl_channel(V(BIT_N5_3, Vss), V(cpphdl_n1168, Vss), 0.080000000000000002, 0.69999999999999996, 1.0);
        // device 793, IC IC134, analog/basic/mos_r2r_dac.hpp:27
        I(cpphdl_n1168, Vss) <+ 2.9999999999999998e-15 * ddt(V(cpphdl_n1168, Vss)); // Bench initial voltage = 0.0 V.
        // device 794, IC IC134, analog/basic/mos_r2r_dac.hpp:28
        I(cpphdl_n1168, cpphdl_n1188) <+ V(cpphdl_n1168, cpphdl_n1188) / 2000.0;
        // device 795, IC IC134, analog/basic/mos_r2r_dac.hpp:29
        I(cpphdl_n1188, Vss) <+ 2.9999999999999998e-15 * ddt(V(cpphdl_n1188, Vss)); // Bench initial voltage = 0.0 V.
        // device 796, IC IC134, analog/basic/mos_r2r_dac.hpp:31
        I(cpphdl_n1187, cpphdl_n1188) <+ V(cpphdl_n1187, cpphdl_n1188) / 1000.0;
        // device 797, IC IC139, analog/basic/inverter.hpp:11
        I(cpphdl_n1172, Vdd) <+ cpphdl_channel(V(BIT_N5_4, Vdd), V(cpphdl_n1172, Vdd), 0.080000000000000002, 0.69999999999999996, -1.0);
        // device 798, IC IC139, analog/basic/inverter.hpp:12
        I(cpphdl_n1172, Vss) <+ cpphdl_channel(V(BIT_N5_4, Vss), V(cpphdl_n1172, Vss), 0.080000000000000002, 0.69999999999999996, 1.0);
        // device 799, IC IC134, analog/basic/mos_r2r_dac.hpp:27
        I(cpphdl_n1172, Vss) <+ 2.9999999999999998e-15 * ddt(V(cpphdl_n1172, Vss)); // Bench initial voltage = 0.0 V.
        // device 800, IC IC134, analog/basic/mos_r2r_dac.hpp:28
        I(cpphdl_n1172, cpphdl_n1189) <+ V(cpphdl_n1172, cpphdl_n1189) / 2000.0;
        // device 801, IC IC134, analog/basic/mos_r2r_dac.hpp:29
        I(cpphdl_n1189, Vss) <+ 2.9999999999999998e-15 * ddt(V(cpphdl_n1189, Vss)); // Bench initial voltage = 0.0 V.
        // device 802, IC IC134, analog/basic/mos_r2r_dac.hpp:31
        I(cpphdl_n1188, cpphdl_n1189) <+ V(cpphdl_n1188, cpphdl_n1189) / 1000.0;
        // device 803, IC IC140, analog/basic/inverter.hpp:11
        I(cpphdl_n1176, Vdd) <+ cpphdl_channel(V(BIT_N5_5, Vdd), V(cpphdl_n1176, Vdd), 0.080000000000000002, 0.69999999999999996, -1.0);
        // device 804, IC IC140, analog/basic/inverter.hpp:12
        I(cpphdl_n1176, Vss) <+ cpphdl_channel(V(BIT_N5_5, Vss), V(cpphdl_n1176, Vss), 0.080000000000000002, 0.69999999999999996, 1.0);
        // device 805, IC IC134, analog/basic/mos_r2r_dac.hpp:27
        I(cpphdl_n1176, Vss) <+ 2.9999999999999998e-15 * ddt(V(cpphdl_n1176, Vss)); // Bench initial voltage = 0.0 V.
        // device 806, IC IC134, analog/basic/mos_r2r_dac.hpp:28
        I(cpphdl_n1176, cpphdl_n1190) <+ V(cpphdl_n1176, cpphdl_n1190) / 2000.0;
        // device 807, IC IC134, analog/basic/mos_r2r_dac.hpp:29
        I(cpphdl_n1190, Vss) <+ 2.9999999999999998e-15 * ddt(V(cpphdl_n1190, Vss)); // Bench initial voltage = 0.0 V.
        // device 808, IC IC134, analog/basic/mos_r2r_dac.hpp:31
        I(cpphdl_n1189, cpphdl_n1190) <+ V(cpphdl_n1189, cpphdl_n1190) / 1000.0;
        // device 809, IC IC141, analog/basic/inverter.hpp:11
        I(cpphdl_n1180, Vdd) <+ cpphdl_channel(V(BIT_N5_6, Vdd), V(cpphdl_n1180, Vdd), 0.080000000000000002, 0.69999999999999996, -1.0);
        // device 810, IC IC141, analog/basic/inverter.hpp:12
        I(cpphdl_n1180, Vss) <+ cpphdl_channel(V(BIT_N5_6, Vss), V(cpphdl_n1180, Vss), 0.080000000000000002, 0.69999999999999996, 1.0);
        // device 811, IC IC134, analog/basic/mos_r2r_dac.hpp:27
        I(cpphdl_n1180, Vss) <+ 2.9999999999999998e-15 * ddt(V(cpphdl_n1180, Vss)); // Bench initial voltage = 0.0 V.
        // device 812, IC IC134, analog/basic/mos_r2r_dac.hpp:28
        I(cpphdl_n1180, cpphdl_n1191) <+ V(cpphdl_n1180, cpphdl_n1191) / 2000.0;
        // device 813, IC IC134, analog/basic/mos_r2r_dac.hpp:29
        I(cpphdl_n1191, Vss) <+ 2.9999999999999998e-15 * ddt(V(cpphdl_n1191, Vss)); // Bench initial voltage = 0.0 V.
        // device 814, IC IC134, analog/basic/mos_r2r_dac.hpp:31
        I(cpphdl_n1190, cpphdl_n1191) <+ V(cpphdl_n1190, cpphdl_n1191) / 1000.0;
        // device 815, IC IC142, analog/basic/inverter.hpp:11
        I(cpphdl_n1184, Vdd) <+ cpphdl_channel(V(BIT_N5_7, Vdd), V(cpphdl_n1184, Vdd), 0.080000000000000002, 0.69999999999999996, -1.0);
        // device 816, IC IC142, analog/basic/inverter.hpp:12
        I(cpphdl_n1184, Vss) <+ cpphdl_channel(V(BIT_N5_7, Vss), V(cpphdl_n1184, Vss), 0.080000000000000002, 0.69999999999999996, 1.0);
        // device 817, IC IC134, analog/basic/mos_r2r_dac.hpp:27
        I(cpphdl_n1184, Vss) <+ 2.9999999999999998e-15 * ddt(V(cpphdl_n1184, Vss)); // Bench initial voltage = 0.0 V.
        // device 818, IC IC134, analog/basic/mos_r2r_dac.hpp:28
        I(cpphdl_n1184, cpphdl_n1196) <+ V(cpphdl_n1184, cpphdl_n1196) / 2000.0;
        // device 819, IC IC134, analog/basic/mos_r2r_dac.hpp:29
        I(cpphdl_n1196, Vss) <+ 2.9999999999999998e-15 * ddt(V(cpphdl_n1196, Vss)); // Bench initial voltage = 0.0 V.
        // device 820, IC IC134, analog/basic/mos_r2r_dac.hpp:31
        I(cpphdl_n1191, cpphdl_n1196) <+ V(cpphdl_n1191, cpphdl_n1196) / 1000.0;
        // device 821, IC IC134, analog/basic/mos_r2r_dac.hpp:33
        I(Vss, cpphdl_n1185) <+ V(Vss, cpphdl_n1185) / 2000.0;
        // device 822, IC IC143, analog/basic/nmos_resistor_amplifier.hpp:23
        I(Vdd, cpphdl_n1205) <+ V(Vdd, cpphdl_n1205) / 1000.0;
        // device 823, IC IC143, analog/basic/nmos_resistor_amplifier.hpp:24
        I(Vdd, cpphdl_n1204) <+ V(Vdd, cpphdl_n1204) / 1000.0;
        // device 824, IC IC143, analog/basic/nmos_resistor_amplifier.hpp:25
        I(cpphdl_n1205, cpphdl_n1199) <+ cpphdl_channel(V(cpphdl_n1195, cpphdl_n1199), V(cpphdl_n1205, cpphdl_n1199), 0.0074999999999999997, 0.69999999999999996, 1.0);
        // device 825, IC IC143, analog/basic/nmos_resistor_amplifier.hpp:26
        I(cpphdl_n1204, cpphdl_n1200) <+ cpphdl_channel(V(cpphdl_n1196, cpphdl_n1200), V(cpphdl_n1204, cpphdl_n1200), 0.0074999999999999997, 0.69999999999999996, 1.0);
        // device 826, IC IC143, analog/basic/nmos_resistor_amplifier.hpp:27
        I(cpphdl_n1201, cpphdl_n1199) <+ V(cpphdl_n1201, cpphdl_n1199) / 100.0;
        // device 827, IC IC143, analog/basic/nmos_resistor_amplifier.hpp:28
        I(cpphdl_n1201, cpphdl_n1200) <+ V(cpphdl_n1201, cpphdl_n1200) / 100.0;
        // device 828, IC IC143, analog/basic/nmos_resistor_amplifier.hpp:29
        I(Vss, cpphdl_n1201) <+ V(Vss, cpphdl_n1201) / 300.0;
        // device 829, IC IC143, analog/basic/nmos_resistor_amplifier.hpp:30
        I(cpphdl_n1205, Vdd) <+ 2.9999999999999998e-13 * ddt(V(cpphdl_n1205, Vdd)); // Bench initial voltage = 0.0 V.
        // device 830, IC IC143, analog/basic/nmos_resistor_amplifier.hpp:31
        I(cpphdl_n1204, Vdd) <+ 2.9999999999999998e-13 * ddt(V(cpphdl_n1204, Vdd)); // Bench initial voltage = 0.0 V.
        // device 831, IC IC143, analog/basic/nmos_resistor_amplifier.hpp:32
        I(cpphdl_n1201, Vss) <+ 4e-14 * ddt(V(cpphdl_n1201, Vss)); // Bench initial voltage = 0.0 V.
        // device 832, IC IC143, analog/basic/nmos_resistor_amplifier.hpp:34
        I(cpphdl_n1195, cpphdl_n1199) <+ 2e-14 * ddt(V(cpphdl_n1195, cpphdl_n1199)); // Bench initial voltage = 0.0 V.
        // device 833, IC IC143, analog/basic/nmos_resistor_amplifier.hpp:35
        I(cpphdl_n1196, cpphdl_n1200) <+ 2e-14 * ddt(V(cpphdl_n1196, cpphdl_n1200)); // Bench initial voltage = 0.0 V.
        // device 834, IC IC143, analog/basic/nmos_resistor_amplifier.hpp:36
        I(cpphdl_n1195, cpphdl_n1205) <+ 2.9999999999999998e-15 * ddt(V(cpphdl_n1195, cpphdl_n1205)); // Bench initial voltage = 0.0 V.
        // device 835, IC IC143, analog/basic/nmos_resistor_amplifier.hpp:37
        I(cpphdl_n1196, cpphdl_n1204) <+ 2.9999999999999998e-15 * ddt(V(cpphdl_n1196, cpphdl_n1204)); // Bench initial voltage = 0.0 V.
        // device 836, IC IC144, analog/basic/strongarm_comparator.hpp:28
        I(cpphdl_n1209, cpphdl_n1211) <+ cpphdl_channel(V(cpphdl_n1204, cpphdl_n1211), V(cpphdl_n1209, cpphdl_n1211), 0.0080000000000000002, 0.69999999999999996, 1.0);
        // device 837, IC IC144, analog/basic/strongarm_comparator.hpp:29
        I(cpphdl_n1210, cpphdl_n1211) <+ cpphdl_channel(V(cpphdl_n1205, cpphdl_n1211), V(cpphdl_n1210, cpphdl_n1211), 0.0080000000000000002, 0.69999999999999996, 1.0);
        // device 838, IC IC144, analog/basic/strongarm_comparator.hpp:30
        I(cpphdl_n1211, Vss) <+ cpphdl_channel(V(EVALUATE, Vss), V(cpphdl_n1211, Vss), 0.0080000000000000002, 0.69999999999999996, 1.0);
        // device 839, IC IC144, analog/basic/strongarm_comparator.hpp:33
        I(cpphdl_n1224, cpphdl_n1209) <+ cpphdl_channel(V(cpphdl_n1228, cpphdl_n1209), V(cpphdl_n1224, cpphdl_n1209), 0.0040000000000000001, 0.69999999999999996, 1.0);
        // device 840, IC IC144, analog/basic/strongarm_comparator.hpp:34
        I(cpphdl_n1228, cpphdl_n1210) <+ cpphdl_channel(V(cpphdl_n1224, cpphdl_n1210), V(cpphdl_n1228, cpphdl_n1210), 0.0040000000000000001, 0.69999999999999996, 1.0);
        // device 841, IC IC144, analog/basic/strongarm_comparator.hpp:35
        I(cpphdl_n1228, Vdd) <+ cpphdl_channel(V(cpphdl_n1224, Vdd), V(cpphdl_n1228, Vdd), 0.002, 0.69999999999999996, -1.0);
        // device 842, IC IC144, analog/basic/strongarm_comparator.hpp:36
        I(cpphdl_n1224, Vdd) <+ cpphdl_channel(V(cpphdl_n1228, Vdd), V(cpphdl_n1224, Vdd), 0.002, 0.69999999999999996, -1.0);
        // device 843, IC IC144, analog/basic/strongarm_comparator.hpp:38
        I(cpphdl_n1209, Vdd) <+ cpphdl_channel(V(EVALUATE, Vdd), V(cpphdl_n1209, Vdd), 0.002, 0.69999999999999996, -1.0);
        // device 844, IC IC144, analog/basic/strongarm_comparator.hpp:39
        I(cpphdl_n1210, Vdd) <+ cpphdl_channel(V(EVALUATE, Vdd), V(cpphdl_n1210, Vdd), 0.002, 0.69999999999999996, -1.0);
        // device 845, IC IC144, analog/basic/strongarm_comparator.hpp:40
        I(cpphdl_n1228, Vdd) <+ cpphdl_channel(V(EVALUATE, Vdd), V(cpphdl_n1228, Vdd), 0.002, 0.69999999999999996, -1.0);
        // device 846, IC IC144, analog/basic/strongarm_comparator.hpp:41
        I(cpphdl_n1224, Vdd) <+ cpphdl_channel(V(EVALUATE, Vdd), V(cpphdl_n1224, Vdd), 0.002, 0.69999999999999996, -1.0);
        // device 847, IC IC144, analog/basic/strongarm_comparator.hpp:42
        I(cpphdl_n1209, Vss) <+ 2.9999999999999998e-14 * ddt(V(cpphdl_n1209, Vss)); // Bench initial voltage = 0.0 V.
        // device 848, IC IC144, analog/basic/strongarm_comparator.hpp:43
        I(cpphdl_n1210, Vss) <+ 2.9999999999999998e-14 * ddt(V(cpphdl_n1210, Vss)); // Bench initial voltage = 0.0 V.
        // device 849, IC IC144, analog/basic/strongarm_comparator.hpp:44
        I(cpphdl_n1211, Vss) <+ 2.9999999999999998e-14 * ddt(V(cpphdl_n1211, Vss)); // Bench initial voltage = 0.0 V.
        // device 850, IC IC144, analog/basic/strongarm_comparator.hpp:45
        I(cpphdl_n1228, Vss) <+ 5.0000000000000002e-14 * ddt(V(cpphdl_n1228, Vss)); // Bench initial voltage = 0.0 V.
        // device 851, IC IC144, analog/basic/strongarm_comparator.hpp:46
        I(cpphdl_n1224, Vss) <+ 5.0000000000000002e-14 * ddt(V(cpphdl_n1224, Vss)); // Bench initial voltage = 0.0 V.
        // device 852, IC IC144, analog/basic/strongarm_comparator.hpp:47
        I(cpphdl_n1204, cpphdl_n1211) <+ 2e-14 * ddt(V(cpphdl_n1204, cpphdl_n1211)); // Bench initial voltage = 0.0 V.
        // device 853, IC IC144, analog/basic/strongarm_comparator.hpp:48
        I(cpphdl_n1205, cpphdl_n1211) <+ 2e-14 * ddt(V(cpphdl_n1205, cpphdl_n1211)); // Bench initial voltage = 0.0 V.
        // device 854, IC IC144, analog/basic/strongarm_comparator.hpp:49
        I(cpphdl_n1204, cpphdl_n1209) <+ 2.9999999999999998e-15 * ddt(V(cpphdl_n1204, cpphdl_n1209)); // Bench initial voltage = 0.0 V.
        // device 855, IC IC144, analog/basic/strongarm_comparator.hpp:50
        I(cpphdl_n1205, cpphdl_n1210) <+ 2.9999999999999998e-15 * ddt(V(cpphdl_n1205, cpphdl_n1210)); // Bench initial voltage = 0.0 V.
        // device 856, IC IC146, analog/basic/inverter.hpp:11
        I(cpphdl_n1232, Vdd) <+ cpphdl_channel(V(cpphdl_n1224, Vdd), V(cpphdl_n1232, Vdd), 0.001, 0.69999999999999996, -1.0);
        // device 857, IC IC146, analog/basic/inverter.hpp:12
        I(cpphdl_n1232, Vss) <+ cpphdl_channel(V(cpphdl_n1224, Vss), V(cpphdl_n1232, Vss), 0.001, 0.69999999999999996, 1.0);
        // device 858, IC IC148, analog/basic/inverter.hpp:11
        I(cpphdl_n1246, Vdd) <+ cpphdl_channel(V(cpphdl_n1232, Vdd), V(cpphdl_n1246, Vdd), 0.0040000000000000001, 0.69999999999999996, -1.0);
        // device 859, IC IC148, analog/basic/inverter.hpp:12
        I(cpphdl_n1246, Vss) <+ cpphdl_channel(V(cpphdl_n1232, Vss), V(cpphdl_n1246, Vss), 0.0040000000000000001, 0.69999999999999996, 1.0);
        // device 860, IC IC145, analog/basic/buffered_nand_latch.hpp:34
        I(cpphdl_n1224, Vss) <+ 2.0000000000000002e-15 * ddt(V(cpphdl_n1224, Vss)); // Bench initial voltage = 0.0 V.
        // device 861, IC IC145, analog/basic/buffered_nand_latch.hpp:35
        I(cpphdl_n1224, cpphdl_n1232) <+ 1.0000000000000001e-15 * ddt(V(cpphdl_n1224, cpphdl_n1232)); // Bench initial voltage = 0.0 V.
        // device 862, IC IC145, analog/basic/buffered_nand_latch.hpp:36
        I(cpphdl_n1232, Vss) <+ 5e-15 * ddt(V(cpphdl_n1232, Vss)); // Bench initial voltage = 0.0 V.
        // device 863, IC IC145, analog/basic/buffered_nand_latch.hpp:37
        I(cpphdl_n1232, Vss) <+ 8.0000000000000006e-15 * ddt(V(cpphdl_n1232, Vss)); // Bench initial voltage = 0.0 V.
        // device 864, IC IC145, analog/basic/buffered_nand_latch.hpp:38
        I(cpphdl_n1246, Vss) <+ 1e-14 * ddt(V(cpphdl_n1246, Vss)); // Bench initial voltage = 0.0 V.
        // device 865, IC IC147, analog/basic/inverter.hpp:11
        I(cpphdl_n1236, Vdd) <+ cpphdl_channel(V(cpphdl_n1228, Vdd), V(cpphdl_n1236, Vdd), 0.001, 0.69999999999999996, -1.0);
        // device 866, IC IC147, analog/basic/inverter.hpp:12
        I(cpphdl_n1236, Vss) <+ cpphdl_channel(V(cpphdl_n1228, Vss), V(cpphdl_n1236, Vss), 0.001, 0.69999999999999996, 1.0);
        // device 867, IC IC149, analog/basic/inverter.hpp:11
        I(cpphdl_n1252, Vdd) <+ cpphdl_channel(V(cpphdl_n1236, Vdd), V(cpphdl_n1252, Vdd), 0.0040000000000000001, 0.69999999999999996, -1.0);
        // device 868, IC IC149, analog/basic/inverter.hpp:12
        I(cpphdl_n1252, Vss) <+ cpphdl_channel(V(cpphdl_n1236, Vss), V(cpphdl_n1252, Vss), 0.0040000000000000001, 0.69999999999999996, 1.0);
        // device 869, IC IC145, analog/basic/buffered_nand_latch.hpp:34
        I(cpphdl_n1228, Vss) <+ 2.0000000000000002e-15 * ddt(V(cpphdl_n1228, Vss)); // Bench initial voltage = 0.0 V.
        // device 870, IC IC145, analog/basic/buffered_nand_latch.hpp:35
        I(cpphdl_n1228, cpphdl_n1236) <+ 1.0000000000000001e-15 * ddt(V(cpphdl_n1228, cpphdl_n1236)); // Bench initial voltage = 0.0 V.
        // device 871, IC IC145, analog/basic/buffered_nand_latch.hpp:36
        I(cpphdl_n1236, Vss) <+ 5e-15 * ddt(V(cpphdl_n1236, Vss)); // Bench initial voltage = 0.0 V.
        // device 872, IC IC145, analog/basic/buffered_nand_latch.hpp:37
        I(cpphdl_n1236, Vss) <+ 8.0000000000000006e-15 * ddt(V(cpphdl_n1236, Vss)); // Bench initial voltage = 0.0 V.
        // device 873, IC IC145, analog/basic/buffered_nand_latch.hpp:38
        I(cpphdl_n1252, Vss) <+ 1e-14 * ddt(V(cpphdl_n1252, Vss)); // Bench initial voltage = 0.0 V.
        // device 874, IC IC151, analog/basic/cmos_logic.hpp:17
        I(cpphdl_n2303, Vss) <+ 5.0000000000000002e-14 * ddt(V(cpphdl_n2303, Vss)); // Bench initial voltage = 0.0 V.
        // device 875, IC IC151, analog/basic/cmos_logic.hpp:18
        I(cpphdl_n2303, Vdd) <+ cpphdl_channel(V(cpphdl_n1246, Vdd), V(cpphdl_n2303, Vdd), 0.01, 0.69999999999999996, -1.0);
        // device 876, IC IC151, analog/basic/cmos_logic.hpp:19
        I(cpphdl_n2303, Vdd) <+ cpphdl_channel(V(cpphdl_n1254, Vdd), V(cpphdl_n2303, Vdd), 0.01, 0.69999999999999996, -1.0);
        // device 877, IC IC151, analog/basic/cmos_logic.hpp:20
        I(cpphdl_n2303, cpphdl_n1249) <+ cpphdl_channel(V(cpphdl_n1246, cpphdl_n1249), V(cpphdl_n2303, cpphdl_n1249), 0.01, 0.69999999999999996, 1.0);
        // device 878, IC IC151, analog/basic/cmos_logic.hpp:21
        I(cpphdl_n1249, Vss) <+ cpphdl_channel(V(cpphdl_n1254, Vss), V(cpphdl_n1249, Vss), 0.01, 0.69999999999999996, 1.0);
        // device 879, IC IC151, analog/basic/cmos_logic.hpp:27
        I(cpphdl_n1249, Vss) <+ 1e-14 * ddt(V(cpphdl_n1249, Vss)); // Bench initial voltage = 0.0 V.
        // device 880, IC IC152, analog/basic/cmos_logic.hpp:17
        I(cpphdl_n1254, Vss) <+ 5.0000000000000002e-14 * ddt(V(cpphdl_n1254, Vss)); // Bench initial voltage = 0.0 V.
        // device 881, IC IC152, analog/basic/cmos_logic.hpp:18
        I(cpphdl_n1254, Vdd) <+ cpphdl_channel(V(cpphdl_n1252, Vdd), V(cpphdl_n1254, Vdd), 0.01, 0.69999999999999996, -1.0);
        // device 882, IC IC152, analog/basic/cmos_logic.hpp:19
        I(cpphdl_n1254, Vdd) <+ cpphdl_channel(V(cpphdl_n2303, Vdd), V(cpphdl_n1254, Vdd), 0.01, 0.69999999999999996, -1.0);
        // device 883, IC IC152, analog/basic/cmos_logic.hpp:20
        I(cpphdl_n1254, cpphdl_n1255) <+ cpphdl_channel(V(cpphdl_n1252, cpphdl_n1255), V(cpphdl_n1254, cpphdl_n1255), 0.01, 0.69999999999999996, 1.0);
        // device 884, IC IC152, analog/basic/cmos_logic.hpp:21
        I(cpphdl_n1255, Vss) <+ cpphdl_channel(V(cpphdl_n2303, Vss), V(cpphdl_n1255, Vss), 0.01, 0.69999999999999996, 1.0);
        // device 885, IC IC152, analog/basic/cmos_logic.hpp:27
        I(cpphdl_n1255, Vss) <+ 1e-14 * ddt(V(cpphdl_n1255, Vss)); // Bench initial voltage = 0.0 V.
        // device 886, IC IC150, analog/basic/nand_latch.hpp:36
        I(cpphdl_n1246, Vss) <+ 2.9999999999999998e-15 * ddt(V(cpphdl_n1246, Vss)); // Bench initial voltage = 0.0 V.
        // device 887, IC IC150, analog/basic/nand_latch.hpp:37
        I(cpphdl_n1252, Vss) <+ 2.9999999999999998e-15 * ddt(V(cpphdl_n1252, Vss)); // Bench initial voltage = 0.0 V.
        // device 888, IC IC153, analog/basic/inverter.hpp:11
        I(cpphdl_n1260, Vdd) <+ cpphdl_channel(V(CLEAR, Vdd), V(cpphdl_n1260, Vdd), 0.01, 0.69999999999999996, -1.0);
        // device 889, IC IC153, analog/basic/inverter.hpp:12
        I(cpphdl_n1260, Vss) <+ cpphdl_channel(V(CLEAR, Vss), V(cpphdl_n1260, Vss), 0.01, 0.69999999999999996, 1.0);
        // device 890, IC IC150, analog/basic/nand_latch.hpp:58
        I(cpphdl_n1260, Vss) <+ 2.9999999999999998e-15 * ddt(V(cpphdl_n1260, Vss)); // Bench initial voltage = 0.0 V.
        // device 891, IC IC150, analog/basic/nand_latch.hpp:59
        I(cpphdl_n2303, Vss) <+ cpphdl_channel(V(CLEAR, Vss), V(cpphdl_n2303, Vss), 0.050000000000000003, 0.69999999999999996, 1.0);
        // device 892, IC IC150, analog/basic/nand_latch.hpp:60
        I(cpphdl_n1254, Vdd) <+ cpphdl_channel(V(cpphdl_n1260, Vdd), V(cpphdl_n1254, Vdd), 0.050000000000000003, 0.69999999999999996, -1.0);
        // device 893, IC IC156, analog/basic/inverter.hpp:11
        I(cpphdl_n1284, Vdd) <+ cpphdl_channel(V(TRACK6, Vdd), V(cpphdl_n1284, Vdd), 0.0040000000000000001, 0.69999999999999996, -1.0);
        // device 894, IC IC156, analog/basic/inverter.hpp:12
        I(cpphdl_n1284, Vss) <+ cpphdl_channel(V(TRACK6, Vss), V(cpphdl_n1284, Vss), 0.0040000000000000001, 0.69999999999999996, 1.0);
        // device 895, IC IC155, analog/basic/mos_track_hold.hpp:31
        I(cpphdl_n1284, Vss) <+ 2e-14 * ddt(V(cpphdl_n1284, Vss)); // Bench initial voltage = 0.0 V.
        // device 896, IC IC155, analog/basic/mos_track_hold.hpp:32
        I(cpphdl_n2136, cpphdl_n1338) <+ cpphdl_channel(V(TRACK6, cpphdl_n1338), V(cpphdl_n2136, cpphdl_n1338), 0.029999999999999999, 0.69999999999999996, 1.0);
        // device 897, IC IC155, analog/basic/mos_track_hold.hpp:33
        I(cpphdl_n1338, cpphdl_n2136) <+ cpphdl_channel(V(cpphdl_n1284, cpphdl_n2136), V(cpphdl_n1338, cpphdl_n2136), 0.014999999999999999, 0.69999999999999996, -1.0);
        // device 898, IC IC155, analog/basic/mos_track_hold.hpp:37
        I(cpphdl_n1338, cpphdl_n1338) <+ cpphdl_channel(V(cpphdl_n1284, cpphdl_n1338), V(cpphdl_n1338, cpphdl_n1338), 0.016, 0.69999999999999996, 1.0);
        // device 899, IC IC155, analog/basic/mos_track_hold.hpp:38
        I(cpphdl_n1338, cpphdl_n1338) <+ cpphdl_channel(V(TRACK6, cpphdl_n1338), V(cpphdl_n1338, cpphdl_n1338), 0.0083999999999999995, 0.69999999999999996, -1.0);
        // device 900, IC IC155, analog/basic/mos_track_hold.hpp:39
        I(cpphdl_n1338, Vss) <+ 1.5000000000000001e-12 * ddt(V(cpphdl_n1338, Vss)); // Bench initial voltage = 0.0 V.
        // device 901, IC IC155, analog/basic/mos_track_hold.hpp:42
        I(TRACK6, cpphdl_n1338) <+ 2.0000000000000002e-15 * ddt(V(TRACK6, cpphdl_n1338)); // Bench initial voltage = -0.0 V.
        // device 902, IC IC155, analog/basic/mos_track_hold.hpp:43
        I(cpphdl_n1284, cpphdl_n1338) <+ 2.0000000000000002e-15 * ddt(V(cpphdl_n1284, cpphdl_n1338)); // Bench initial voltage = 0.0 V.
        // device 903, IC IC155, analog/basic/mos_track_hold.hpp:44
        I(cpphdl_n2136, cpphdl_n1338) <+ 1.0000000000000001e-15 * ddt(V(cpphdl_n2136, cpphdl_n1338)); // Bench initial voltage = 0.0 V.
        // device 904, IC IC158, analog/basic/inverter.hpp:11
        I(cpphdl_n1299, Vdd) <+ cpphdl_channel(V(BIT_N6_0, Vdd), V(cpphdl_n1299, Vdd), 0.080000000000000002, 0.69999999999999996, -1.0);
        // device 905, IC IC158, analog/basic/inverter.hpp:12
        I(cpphdl_n1299, Vss) <+ cpphdl_channel(V(BIT_N6_0, Vss), V(cpphdl_n1299, Vss), 0.080000000000000002, 0.69999999999999996, 1.0);
        // device 906, IC IC157, analog/basic/mos_r2r_dac.hpp:27
        I(cpphdl_n1299, Vss) <+ 2.9999999999999998e-15 * ddt(V(cpphdl_n1299, Vss)); // Bench initial voltage = 0.0 V.
        // device 907, IC IC157, analog/basic/mos_r2r_dac.hpp:28
        I(cpphdl_n1299, cpphdl_n1328) <+ V(cpphdl_n1299, cpphdl_n1328) / 2000.0;
        // device 908, IC IC157, analog/basic/mos_r2r_dac.hpp:29
        I(cpphdl_n1328, Vss) <+ 2.9999999999999998e-15 * ddt(V(cpphdl_n1328, Vss)); // Bench initial voltage = 0.0 V.
        // device 909, IC IC159, analog/basic/inverter.hpp:11
        I(cpphdl_n1303, Vdd) <+ cpphdl_channel(V(BIT_N6_1, Vdd), V(cpphdl_n1303, Vdd), 0.080000000000000002, 0.69999999999999996, -1.0);
        // device 910, IC IC159, analog/basic/inverter.hpp:12
        I(cpphdl_n1303, Vss) <+ cpphdl_channel(V(BIT_N6_1, Vss), V(cpphdl_n1303, Vss), 0.080000000000000002, 0.69999999999999996, 1.0);
        // device 911, IC IC157, analog/basic/mos_r2r_dac.hpp:27
        I(cpphdl_n1303, Vss) <+ 2.9999999999999998e-15 * ddt(V(cpphdl_n1303, Vss)); // Bench initial voltage = 0.0 V.
        // device 912, IC IC157, analog/basic/mos_r2r_dac.hpp:28
        I(cpphdl_n1303, cpphdl_n1329) <+ V(cpphdl_n1303, cpphdl_n1329) / 2000.0;
        // device 913, IC IC157, analog/basic/mos_r2r_dac.hpp:29
        I(cpphdl_n1329, Vss) <+ 2.9999999999999998e-15 * ddt(V(cpphdl_n1329, Vss)); // Bench initial voltage = 0.0 V.
        // device 914, IC IC157, analog/basic/mos_r2r_dac.hpp:31
        I(cpphdl_n1328, cpphdl_n1329) <+ V(cpphdl_n1328, cpphdl_n1329) / 1000.0;
        // device 915, IC IC160, analog/basic/inverter.hpp:11
        I(cpphdl_n1307, Vdd) <+ cpphdl_channel(V(BIT_N6_2, Vdd), V(cpphdl_n1307, Vdd), 0.080000000000000002, 0.69999999999999996, -1.0);
        // device 916, IC IC160, analog/basic/inverter.hpp:12
        I(cpphdl_n1307, Vss) <+ cpphdl_channel(V(BIT_N6_2, Vss), V(cpphdl_n1307, Vss), 0.080000000000000002, 0.69999999999999996, 1.0);
        // device 917, IC IC157, analog/basic/mos_r2r_dac.hpp:27
        I(cpphdl_n1307, Vss) <+ 2.9999999999999998e-15 * ddt(V(cpphdl_n1307, Vss)); // Bench initial voltage = 0.0 V.
        // device 918, IC IC157, analog/basic/mos_r2r_dac.hpp:28
        I(cpphdl_n1307, cpphdl_n1330) <+ V(cpphdl_n1307, cpphdl_n1330) / 2000.0;
        // device 919, IC IC157, analog/basic/mos_r2r_dac.hpp:29
        I(cpphdl_n1330, Vss) <+ 2.9999999999999998e-15 * ddt(V(cpphdl_n1330, Vss)); // Bench initial voltage = 0.0 V.
        // device 920, IC IC157, analog/basic/mos_r2r_dac.hpp:31
        I(cpphdl_n1329, cpphdl_n1330) <+ V(cpphdl_n1329, cpphdl_n1330) / 1000.0;
        // device 921, IC IC161, analog/basic/inverter.hpp:11
        I(cpphdl_n1311, Vdd) <+ cpphdl_channel(V(BIT_N6_3, Vdd), V(cpphdl_n1311, Vdd), 0.080000000000000002, 0.69999999999999996, -1.0);
        // device 922, IC IC161, analog/basic/inverter.hpp:12
        I(cpphdl_n1311, Vss) <+ cpphdl_channel(V(BIT_N6_3, Vss), V(cpphdl_n1311, Vss), 0.080000000000000002, 0.69999999999999996, 1.0);
        // device 923, IC IC157, analog/basic/mos_r2r_dac.hpp:27
        I(cpphdl_n1311, Vss) <+ 2.9999999999999998e-15 * ddt(V(cpphdl_n1311, Vss)); // Bench initial voltage = 0.0 V.
        // device 924, IC IC157, analog/basic/mos_r2r_dac.hpp:28
        I(cpphdl_n1311, cpphdl_n1331) <+ V(cpphdl_n1311, cpphdl_n1331) / 2000.0;
        // device 925, IC IC157, analog/basic/mos_r2r_dac.hpp:29
        I(cpphdl_n1331, Vss) <+ 2.9999999999999998e-15 * ddt(V(cpphdl_n1331, Vss)); // Bench initial voltage = 0.0 V.
        // device 926, IC IC157, analog/basic/mos_r2r_dac.hpp:31
        I(cpphdl_n1330, cpphdl_n1331) <+ V(cpphdl_n1330, cpphdl_n1331) / 1000.0;
        // device 927, IC IC162, analog/basic/inverter.hpp:11
        I(cpphdl_n1315, Vdd) <+ cpphdl_channel(V(BIT_N6_4, Vdd), V(cpphdl_n1315, Vdd), 0.080000000000000002, 0.69999999999999996, -1.0);
        // device 928, IC IC162, analog/basic/inverter.hpp:12
        I(cpphdl_n1315, Vss) <+ cpphdl_channel(V(BIT_N6_4, Vss), V(cpphdl_n1315, Vss), 0.080000000000000002, 0.69999999999999996, 1.0);
        // device 929, IC IC157, analog/basic/mos_r2r_dac.hpp:27
        I(cpphdl_n1315, Vss) <+ 2.9999999999999998e-15 * ddt(V(cpphdl_n1315, Vss)); // Bench initial voltage = 0.0 V.
        // device 930, IC IC157, analog/basic/mos_r2r_dac.hpp:28
        I(cpphdl_n1315, cpphdl_n1332) <+ V(cpphdl_n1315, cpphdl_n1332) / 2000.0;
        // device 931, IC IC157, analog/basic/mos_r2r_dac.hpp:29
        I(cpphdl_n1332, Vss) <+ 2.9999999999999998e-15 * ddt(V(cpphdl_n1332, Vss)); // Bench initial voltage = 0.0 V.
        // device 932, IC IC157, analog/basic/mos_r2r_dac.hpp:31
        I(cpphdl_n1331, cpphdl_n1332) <+ V(cpphdl_n1331, cpphdl_n1332) / 1000.0;
        // device 933, IC IC163, analog/basic/inverter.hpp:11
        I(cpphdl_n1319, Vdd) <+ cpphdl_channel(V(BIT_N6_5, Vdd), V(cpphdl_n1319, Vdd), 0.080000000000000002, 0.69999999999999996, -1.0);
        // device 934, IC IC163, analog/basic/inverter.hpp:12
        I(cpphdl_n1319, Vss) <+ cpphdl_channel(V(BIT_N6_5, Vss), V(cpphdl_n1319, Vss), 0.080000000000000002, 0.69999999999999996, 1.0);
        // device 935, IC IC157, analog/basic/mos_r2r_dac.hpp:27
        I(cpphdl_n1319, Vss) <+ 2.9999999999999998e-15 * ddt(V(cpphdl_n1319, Vss)); // Bench initial voltage = 0.0 V.
        // device 936, IC IC157, analog/basic/mos_r2r_dac.hpp:28
        I(cpphdl_n1319, cpphdl_n1333) <+ V(cpphdl_n1319, cpphdl_n1333) / 2000.0;
        // device 937, IC IC157, analog/basic/mos_r2r_dac.hpp:29
        I(cpphdl_n1333, Vss) <+ 2.9999999999999998e-15 * ddt(V(cpphdl_n1333, Vss)); // Bench initial voltage = 0.0 V.
        // device 938, IC IC157, analog/basic/mos_r2r_dac.hpp:31
        I(cpphdl_n1332, cpphdl_n1333) <+ V(cpphdl_n1332, cpphdl_n1333) / 1000.0;
        // device 939, IC IC164, analog/basic/inverter.hpp:11
        I(cpphdl_n1323, Vdd) <+ cpphdl_channel(V(BIT_N6_6, Vdd), V(cpphdl_n1323, Vdd), 0.080000000000000002, 0.69999999999999996, -1.0);
        // device 940, IC IC164, analog/basic/inverter.hpp:12
        I(cpphdl_n1323, Vss) <+ cpphdl_channel(V(BIT_N6_6, Vss), V(cpphdl_n1323, Vss), 0.080000000000000002, 0.69999999999999996, 1.0);
        // device 941, IC IC157, analog/basic/mos_r2r_dac.hpp:27
        I(cpphdl_n1323, Vss) <+ 2.9999999999999998e-15 * ddt(V(cpphdl_n1323, Vss)); // Bench initial voltage = 0.0 V.
        // device 942, IC IC157, analog/basic/mos_r2r_dac.hpp:28
        I(cpphdl_n1323, cpphdl_n1334) <+ V(cpphdl_n1323, cpphdl_n1334) / 2000.0;
        // device 943, IC IC157, analog/basic/mos_r2r_dac.hpp:29
        I(cpphdl_n1334, Vss) <+ 2.9999999999999998e-15 * ddt(V(cpphdl_n1334, Vss)); // Bench initial voltage = 0.0 V.
        // device 944, IC IC157, analog/basic/mos_r2r_dac.hpp:31
        I(cpphdl_n1333, cpphdl_n1334) <+ V(cpphdl_n1333, cpphdl_n1334) / 1000.0;
        // device 945, IC IC165, analog/basic/inverter.hpp:11
        I(cpphdl_n1327, Vdd) <+ cpphdl_channel(V(BIT_N6_7, Vdd), V(cpphdl_n1327, Vdd), 0.080000000000000002, 0.69999999999999996, -1.0);
        // device 946, IC IC165, analog/basic/inverter.hpp:12
        I(cpphdl_n1327, Vss) <+ cpphdl_channel(V(BIT_N6_7, Vss), V(cpphdl_n1327, Vss), 0.080000000000000002, 0.69999999999999996, 1.0);
        // device 947, IC IC157, analog/basic/mos_r2r_dac.hpp:27
        I(cpphdl_n1327, Vss) <+ 2.9999999999999998e-15 * ddt(V(cpphdl_n1327, Vss)); // Bench initial voltage = 0.0 V.
        // device 948, IC IC157, analog/basic/mos_r2r_dac.hpp:28
        I(cpphdl_n1327, cpphdl_n1339) <+ V(cpphdl_n1327, cpphdl_n1339) / 2000.0;
        // device 949, IC IC157, analog/basic/mos_r2r_dac.hpp:29
        I(cpphdl_n1339, Vss) <+ 2.9999999999999998e-15 * ddt(V(cpphdl_n1339, Vss)); // Bench initial voltage = 0.0 V.
        // device 950, IC IC157, analog/basic/mos_r2r_dac.hpp:31
        I(cpphdl_n1334, cpphdl_n1339) <+ V(cpphdl_n1334, cpphdl_n1339) / 1000.0;
        // device 951, IC IC157, analog/basic/mos_r2r_dac.hpp:33
        I(Vss, cpphdl_n1328) <+ V(Vss, cpphdl_n1328) / 2000.0;
        // device 952, IC IC166, analog/basic/nmos_resistor_amplifier.hpp:23
        I(Vdd, cpphdl_n1348) <+ V(Vdd, cpphdl_n1348) / 1000.0;
        // device 953, IC IC166, analog/basic/nmos_resistor_amplifier.hpp:24
        I(Vdd, cpphdl_n1347) <+ V(Vdd, cpphdl_n1347) / 1000.0;
        // device 954, IC IC166, analog/basic/nmos_resistor_amplifier.hpp:25
        I(cpphdl_n1348, cpphdl_n1342) <+ cpphdl_channel(V(cpphdl_n1338, cpphdl_n1342), V(cpphdl_n1348, cpphdl_n1342), 0.0074999999999999997, 0.69999999999999996, 1.0);
        // device 955, IC IC166, analog/basic/nmos_resistor_amplifier.hpp:26
        I(cpphdl_n1347, cpphdl_n1343) <+ cpphdl_channel(V(cpphdl_n1339, cpphdl_n1343), V(cpphdl_n1347, cpphdl_n1343), 0.0074999999999999997, 0.69999999999999996, 1.0);
        // device 956, IC IC166, analog/basic/nmos_resistor_amplifier.hpp:27
        I(cpphdl_n1344, cpphdl_n1342) <+ V(cpphdl_n1344, cpphdl_n1342) / 100.0;
        // device 957, IC IC166, analog/basic/nmos_resistor_amplifier.hpp:28
        I(cpphdl_n1344, cpphdl_n1343) <+ V(cpphdl_n1344, cpphdl_n1343) / 100.0;
        // device 958, IC IC166, analog/basic/nmos_resistor_amplifier.hpp:29
        I(Vss, cpphdl_n1344) <+ V(Vss, cpphdl_n1344) / 300.0;
        // device 959, IC IC166, analog/basic/nmos_resistor_amplifier.hpp:30
        I(cpphdl_n1348, Vdd) <+ 2.9999999999999998e-13 * ddt(V(cpphdl_n1348, Vdd)); // Bench initial voltage = 0.0 V.
        // device 960, IC IC166, analog/basic/nmos_resistor_amplifier.hpp:31
        I(cpphdl_n1347, Vdd) <+ 2.9999999999999998e-13 * ddt(V(cpphdl_n1347, Vdd)); // Bench initial voltage = 0.0 V.
        // device 961, IC IC166, analog/basic/nmos_resistor_amplifier.hpp:32
        I(cpphdl_n1344, Vss) <+ 4e-14 * ddt(V(cpphdl_n1344, Vss)); // Bench initial voltage = 0.0 V.
        // device 962, IC IC166, analog/basic/nmos_resistor_amplifier.hpp:34
        I(cpphdl_n1338, cpphdl_n1342) <+ 2e-14 * ddt(V(cpphdl_n1338, cpphdl_n1342)); // Bench initial voltage = 0.0 V.
        // device 963, IC IC166, analog/basic/nmos_resistor_amplifier.hpp:35
        I(cpphdl_n1339, cpphdl_n1343) <+ 2e-14 * ddt(V(cpphdl_n1339, cpphdl_n1343)); // Bench initial voltage = 0.0 V.
        // device 964, IC IC166, analog/basic/nmos_resistor_amplifier.hpp:36
        I(cpphdl_n1338, cpphdl_n1348) <+ 2.9999999999999998e-15 * ddt(V(cpphdl_n1338, cpphdl_n1348)); // Bench initial voltage = 0.0 V.
        // device 965, IC IC166, analog/basic/nmos_resistor_amplifier.hpp:37
        I(cpphdl_n1339, cpphdl_n1347) <+ 2.9999999999999998e-15 * ddt(V(cpphdl_n1339, cpphdl_n1347)); // Bench initial voltage = 0.0 V.
        // device 966, IC IC167, analog/basic/strongarm_comparator.hpp:28
        I(cpphdl_n1352, cpphdl_n1354) <+ cpphdl_channel(V(cpphdl_n1347, cpphdl_n1354), V(cpphdl_n1352, cpphdl_n1354), 0.0080000000000000002, 0.69999999999999996, 1.0);
        // device 967, IC IC167, analog/basic/strongarm_comparator.hpp:29
        I(cpphdl_n1353, cpphdl_n1354) <+ cpphdl_channel(V(cpphdl_n1348, cpphdl_n1354), V(cpphdl_n1353, cpphdl_n1354), 0.0080000000000000002, 0.69999999999999996, 1.0);
        // device 968, IC IC167, analog/basic/strongarm_comparator.hpp:30
        I(cpphdl_n1354, Vss) <+ cpphdl_channel(V(EVALUATE, Vss), V(cpphdl_n1354, Vss), 0.0080000000000000002, 0.69999999999999996, 1.0);
        // device 969, IC IC167, analog/basic/strongarm_comparator.hpp:33
        I(cpphdl_n1367, cpphdl_n1352) <+ cpphdl_channel(V(cpphdl_n1371, cpphdl_n1352), V(cpphdl_n1367, cpphdl_n1352), 0.0040000000000000001, 0.69999999999999996, 1.0);
        // device 970, IC IC167, analog/basic/strongarm_comparator.hpp:34
        I(cpphdl_n1371, cpphdl_n1353) <+ cpphdl_channel(V(cpphdl_n1367, cpphdl_n1353), V(cpphdl_n1371, cpphdl_n1353), 0.0040000000000000001, 0.69999999999999996, 1.0);
        // device 971, IC IC167, analog/basic/strongarm_comparator.hpp:35
        I(cpphdl_n1371, Vdd) <+ cpphdl_channel(V(cpphdl_n1367, Vdd), V(cpphdl_n1371, Vdd), 0.002, 0.69999999999999996, -1.0);
        // device 972, IC IC167, analog/basic/strongarm_comparator.hpp:36
        I(cpphdl_n1367, Vdd) <+ cpphdl_channel(V(cpphdl_n1371, Vdd), V(cpphdl_n1367, Vdd), 0.002, 0.69999999999999996, -1.0);
        // device 973, IC IC167, analog/basic/strongarm_comparator.hpp:38
        I(cpphdl_n1352, Vdd) <+ cpphdl_channel(V(EVALUATE, Vdd), V(cpphdl_n1352, Vdd), 0.002, 0.69999999999999996, -1.0);
        // device 974, IC IC167, analog/basic/strongarm_comparator.hpp:39
        I(cpphdl_n1353, Vdd) <+ cpphdl_channel(V(EVALUATE, Vdd), V(cpphdl_n1353, Vdd), 0.002, 0.69999999999999996, -1.0);
        // device 975, IC IC167, analog/basic/strongarm_comparator.hpp:40
        I(cpphdl_n1371, Vdd) <+ cpphdl_channel(V(EVALUATE, Vdd), V(cpphdl_n1371, Vdd), 0.002, 0.69999999999999996, -1.0);
        // device 976, IC IC167, analog/basic/strongarm_comparator.hpp:41
        I(cpphdl_n1367, Vdd) <+ cpphdl_channel(V(EVALUATE, Vdd), V(cpphdl_n1367, Vdd), 0.002, 0.69999999999999996, -1.0);
        // device 977, IC IC167, analog/basic/strongarm_comparator.hpp:42
        I(cpphdl_n1352, Vss) <+ 2.9999999999999998e-14 * ddt(V(cpphdl_n1352, Vss)); // Bench initial voltage = 0.0 V.
        // device 978, IC IC167, analog/basic/strongarm_comparator.hpp:43
        I(cpphdl_n1353, Vss) <+ 2.9999999999999998e-14 * ddt(V(cpphdl_n1353, Vss)); // Bench initial voltage = 0.0 V.
        // device 979, IC IC167, analog/basic/strongarm_comparator.hpp:44
        I(cpphdl_n1354, Vss) <+ 2.9999999999999998e-14 * ddt(V(cpphdl_n1354, Vss)); // Bench initial voltage = 0.0 V.
        // device 980, IC IC167, analog/basic/strongarm_comparator.hpp:45
        I(cpphdl_n1371, Vss) <+ 5.0000000000000002e-14 * ddt(V(cpphdl_n1371, Vss)); // Bench initial voltage = 0.0 V.
        // device 981, IC IC167, analog/basic/strongarm_comparator.hpp:46
        I(cpphdl_n1367, Vss) <+ 5.0000000000000002e-14 * ddt(V(cpphdl_n1367, Vss)); // Bench initial voltage = 0.0 V.
        // device 982, IC IC167, analog/basic/strongarm_comparator.hpp:47
        I(cpphdl_n1347, cpphdl_n1354) <+ 2e-14 * ddt(V(cpphdl_n1347, cpphdl_n1354)); // Bench initial voltage = 0.0 V.
        // device 983, IC IC167, analog/basic/strongarm_comparator.hpp:48
        I(cpphdl_n1348, cpphdl_n1354) <+ 2e-14 * ddt(V(cpphdl_n1348, cpphdl_n1354)); // Bench initial voltage = 0.0 V.
        // device 984, IC IC167, analog/basic/strongarm_comparator.hpp:49
        I(cpphdl_n1347, cpphdl_n1352) <+ 2.9999999999999998e-15 * ddt(V(cpphdl_n1347, cpphdl_n1352)); // Bench initial voltage = 0.0 V.
        // device 985, IC IC167, analog/basic/strongarm_comparator.hpp:50
        I(cpphdl_n1348, cpphdl_n1353) <+ 2.9999999999999998e-15 * ddt(V(cpphdl_n1348, cpphdl_n1353)); // Bench initial voltage = 0.0 V.
        // device 986, IC IC169, analog/basic/inverter.hpp:11
        I(cpphdl_n1375, Vdd) <+ cpphdl_channel(V(cpphdl_n1367, Vdd), V(cpphdl_n1375, Vdd), 0.001, 0.69999999999999996, -1.0);
        // device 987, IC IC169, analog/basic/inverter.hpp:12
        I(cpphdl_n1375, Vss) <+ cpphdl_channel(V(cpphdl_n1367, Vss), V(cpphdl_n1375, Vss), 0.001, 0.69999999999999996, 1.0);
        // device 988, IC IC171, analog/basic/inverter.hpp:11
        I(cpphdl_n1389, Vdd) <+ cpphdl_channel(V(cpphdl_n1375, Vdd), V(cpphdl_n1389, Vdd), 0.0040000000000000001, 0.69999999999999996, -1.0);
        // device 989, IC IC171, analog/basic/inverter.hpp:12
        I(cpphdl_n1389, Vss) <+ cpphdl_channel(V(cpphdl_n1375, Vss), V(cpphdl_n1389, Vss), 0.0040000000000000001, 0.69999999999999996, 1.0);
        // device 990, IC IC168, analog/basic/buffered_nand_latch.hpp:34
        I(cpphdl_n1367, Vss) <+ 2.0000000000000002e-15 * ddt(V(cpphdl_n1367, Vss)); // Bench initial voltage = 0.0 V.
        // device 991, IC IC168, analog/basic/buffered_nand_latch.hpp:35
        I(cpphdl_n1367, cpphdl_n1375) <+ 1.0000000000000001e-15 * ddt(V(cpphdl_n1367, cpphdl_n1375)); // Bench initial voltage = 0.0 V.
        // device 992, IC IC168, analog/basic/buffered_nand_latch.hpp:36
        I(cpphdl_n1375, Vss) <+ 5e-15 * ddt(V(cpphdl_n1375, Vss)); // Bench initial voltage = 0.0 V.
        // device 993, IC IC168, analog/basic/buffered_nand_latch.hpp:37
        I(cpphdl_n1375, Vss) <+ 8.0000000000000006e-15 * ddt(V(cpphdl_n1375, Vss)); // Bench initial voltage = 0.0 V.
        // device 994, IC IC168, analog/basic/buffered_nand_latch.hpp:38
        I(cpphdl_n1389, Vss) <+ 1e-14 * ddt(V(cpphdl_n1389, Vss)); // Bench initial voltage = 0.0 V.
        // device 995, IC IC170, analog/basic/inverter.hpp:11
        I(cpphdl_n1379, Vdd) <+ cpphdl_channel(V(cpphdl_n1371, Vdd), V(cpphdl_n1379, Vdd), 0.001, 0.69999999999999996, -1.0);
        // device 996, IC IC170, analog/basic/inverter.hpp:12
        I(cpphdl_n1379, Vss) <+ cpphdl_channel(V(cpphdl_n1371, Vss), V(cpphdl_n1379, Vss), 0.001, 0.69999999999999996, 1.0);
        // device 997, IC IC172, analog/basic/inverter.hpp:11
        I(cpphdl_n1395, Vdd) <+ cpphdl_channel(V(cpphdl_n1379, Vdd), V(cpphdl_n1395, Vdd), 0.0040000000000000001, 0.69999999999999996, -1.0);
        // device 998, IC IC172, analog/basic/inverter.hpp:12
        I(cpphdl_n1395, Vss) <+ cpphdl_channel(V(cpphdl_n1379, Vss), V(cpphdl_n1395, Vss), 0.0040000000000000001, 0.69999999999999996, 1.0);
        // device 999, IC IC168, analog/basic/buffered_nand_latch.hpp:34
        I(cpphdl_n1371, Vss) <+ 2.0000000000000002e-15 * ddt(V(cpphdl_n1371, Vss)); // Bench initial voltage = 0.0 V.
        // device 1000, IC IC168, analog/basic/buffered_nand_latch.hpp:35
        I(cpphdl_n1371, cpphdl_n1379) <+ 1.0000000000000001e-15 * ddt(V(cpphdl_n1371, cpphdl_n1379)); // Bench initial voltage = 0.0 V.
        // device 1001, IC IC168, analog/basic/buffered_nand_latch.hpp:36
        I(cpphdl_n1379, Vss) <+ 5e-15 * ddt(V(cpphdl_n1379, Vss)); // Bench initial voltage = 0.0 V.
        // device 1002, IC IC168, analog/basic/buffered_nand_latch.hpp:37
        I(cpphdl_n1379, Vss) <+ 8.0000000000000006e-15 * ddt(V(cpphdl_n1379, Vss)); // Bench initial voltage = 0.0 V.
        // device 1003, IC IC168, analog/basic/buffered_nand_latch.hpp:38
        I(cpphdl_n1395, Vss) <+ 1e-14 * ddt(V(cpphdl_n1395, Vss)); // Bench initial voltage = 0.0 V.
        // device 1004, IC IC174, analog/basic/cmos_logic.hpp:17
        I(cpphdl_n2308, Vss) <+ 5.0000000000000002e-14 * ddt(V(cpphdl_n2308, Vss)); // Bench initial voltage = 0.0 V.
        // device 1005, IC IC174, analog/basic/cmos_logic.hpp:18
        I(cpphdl_n2308, Vdd) <+ cpphdl_channel(V(cpphdl_n1389, Vdd), V(cpphdl_n2308, Vdd), 0.01, 0.69999999999999996, -1.0);
        // device 1006, IC IC174, analog/basic/cmos_logic.hpp:19
        I(cpphdl_n2308, Vdd) <+ cpphdl_channel(V(cpphdl_n1397, Vdd), V(cpphdl_n2308, Vdd), 0.01, 0.69999999999999996, -1.0);
        // device 1007, IC IC174, analog/basic/cmos_logic.hpp:20
        I(cpphdl_n2308, cpphdl_n1392) <+ cpphdl_channel(V(cpphdl_n1389, cpphdl_n1392), V(cpphdl_n2308, cpphdl_n1392), 0.01, 0.69999999999999996, 1.0);
        // device 1008, IC IC174, analog/basic/cmos_logic.hpp:21
        I(cpphdl_n1392, Vss) <+ cpphdl_channel(V(cpphdl_n1397, Vss), V(cpphdl_n1392, Vss), 0.01, 0.69999999999999996, 1.0);
        // device 1009, IC IC174, analog/basic/cmos_logic.hpp:27
        I(cpphdl_n1392, Vss) <+ 1e-14 * ddt(V(cpphdl_n1392, Vss)); // Bench initial voltage = 0.0 V.
        // device 1010, IC IC175, analog/basic/cmos_logic.hpp:17
        I(cpphdl_n1397, Vss) <+ 5.0000000000000002e-14 * ddt(V(cpphdl_n1397, Vss)); // Bench initial voltage = 0.0 V.
        // device 1011, IC IC175, analog/basic/cmos_logic.hpp:18
        I(cpphdl_n1397, Vdd) <+ cpphdl_channel(V(cpphdl_n1395, Vdd), V(cpphdl_n1397, Vdd), 0.01, 0.69999999999999996, -1.0);
        // device 1012, IC IC175, analog/basic/cmos_logic.hpp:19
        I(cpphdl_n1397, Vdd) <+ cpphdl_channel(V(cpphdl_n2308, Vdd), V(cpphdl_n1397, Vdd), 0.01, 0.69999999999999996, -1.0);
        // device 1013, IC IC175, analog/basic/cmos_logic.hpp:20
        I(cpphdl_n1397, cpphdl_n1398) <+ cpphdl_channel(V(cpphdl_n1395, cpphdl_n1398), V(cpphdl_n1397, cpphdl_n1398), 0.01, 0.69999999999999996, 1.0);
        // device 1014, IC IC175, analog/basic/cmos_logic.hpp:21
        I(cpphdl_n1398, Vss) <+ cpphdl_channel(V(cpphdl_n2308, Vss), V(cpphdl_n1398, Vss), 0.01, 0.69999999999999996, 1.0);
        // device 1015, IC IC175, analog/basic/cmos_logic.hpp:27
        I(cpphdl_n1398, Vss) <+ 1e-14 * ddt(V(cpphdl_n1398, Vss)); // Bench initial voltage = 0.0 V.
        // device 1016, IC IC173, analog/basic/nand_latch.hpp:36
        I(cpphdl_n1389, Vss) <+ 2.9999999999999998e-15 * ddt(V(cpphdl_n1389, Vss)); // Bench initial voltage = 0.0 V.
        // device 1017, IC IC173, analog/basic/nand_latch.hpp:37
        I(cpphdl_n1395, Vss) <+ 2.9999999999999998e-15 * ddt(V(cpphdl_n1395, Vss)); // Bench initial voltage = 0.0 V.
        // device 1018, IC IC176, analog/basic/inverter.hpp:11
        I(cpphdl_n1403, Vdd) <+ cpphdl_channel(V(CLEAR, Vdd), V(cpphdl_n1403, Vdd), 0.01, 0.69999999999999996, -1.0);
        // device 1019, IC IC176, analog/basic/inverter.hpp:12
        I(cpphdl_n1403, Vss) <+ cpphdl_channel(V(CLEAR, Vss), V(cpphdl_n1403, Vss), 0.01, 0.69999999999999996, 1.0);
        // device 1020, IC IC173, analog/basic/nand_latch.hpp:58
        I(cpphdl_n1403, Vss) <+ 2.9999999999999998e-15 * ddt(V(cpphdl_n1403, Vss)); // Bench initial voltage = 0.0 V.
        // device 1021, IC IC173, analog/basic/nand_latch.hpp:59
        I(cpphdl_n2308, Vss) <+ cpphdl_channel(V(CLEAR, Vss), V(cpphdl_n2308, Vss), 0.050000000000000003, 0.69999999999999996, 1.0);
        // device 1022, IC IC173, analog/basic/nand_latch.hpp:60
        I(cpphdl_n1397, Vdd) <+ cpphdl_channel(V(cpphdl_n1403, Vdd), V(cpphdl_n1397, Vdd), 0.050000000000000003, 0.69999999999999996, -1.0);
        // device 1023, IC IC179, analog/basic/inverter.hpp:11
        I(cpphdl_n1427, Vdd) <+ cpphdl_channel(V(TRACK7, Vdd), V(cpphdl_n1427, Vdd), 0.0040000000000000001, 0.69999999999999996, -1.0);
        // device 1024, IC IC179, analog/basic/inverter.hpp:12
        I(cpphdl_n1427, Vss) <+ cpphdl_channel(V(TRACK7, Vss), V(cpphdl_n1427, Vss), 0.0040000000000000001, 0.69999999999999996, 1.0);
        // device 1025, IC IC178, analog/basic/mos_track_hold.hpp:31
        I(cpphdl_n1427, Vss) <+ 2e-14 * ddt(V(cpphdl_n1427, Vss)); // Bench initial voltage = 0.0 V.
        // device 1026, IC IC178, analog/basic/mos_track_hold.hpp:32
        I(cpphdl_n2136, cpphdl_n1481) <+ cpphdl_channel(V(TRACK7, cpphdl_n1481), V(cpphdl_n2136, cpphdl_n1481), 0.029999999999999999, 0.69999999999999996, 1.0);
        // device 1027, IC IC178, analog/basic/mos_track_hold.hpp:33
        I(cpphdl_n1481, cpphdl_n2136) <+ cpphdl_channel(V(cpphdl_n1427, cpphdl_n2136), V(cpphdl_n1481, cpphdl_n2136), 0.014999999999999999, 0.69999999999999996, -1.0);
        // device 1028, IC IC178, analog/basic/mos_track_hold.hpp:37
        I(cpphdl_n1481, cpphdl_n1481) <+ cpphdl_channel(V(cpphdl_n1427, cpphdl_n1481), V(cpphdl_n1481, cpphdl_n1481), 0.016, 0.69999999999999996, 1.0);
        // device 1029, IC IC178, analog/basic/mos_track_hold.hpp:38
        I(cpphdl_n1481, cpphdl_n1481) <+ cpphdl_channel(V(TRACK7, cpphdl_n1481), V(cpphdl_n1481, cpphdl_n1481), 0.0083999999999999995, 0.69999999999999996, -1.0);
        // device 1030, IC IC178, analog/basic/mos_track_hold.hpp:39
        I(cpphdl_n1481, Vss) <+ 1.5000000000000001e-12 * ddt(V(cpphdl_n1481, Vss)); // Bench initial voltage = 0.0 V.
        // device 1031, IC IC178, analog/basic/mos_track_hold.hpp:42
        I(TRACK7, cpphdl_n1481) <+ 2.0000000000000002e-15 * ddt(V(TRACK7, cpphdl_n1481)); // Bench initial voltage = -0.0 V.
        // device 1032, IC IC178, analog/basic/mos_track_hold.hpp:43
        I(cpphdl_n1427, cpphdl_n1481) <+ 2.0000000000000002e-15 * ddt(V(cpphdl_n1427, cpphdl_n1481)); // Bench initial voltage = 0.0 V.
        // device 1033, IC IC178, analog/basic/mos_track_hold.hpp:44
        I(cpphdl_n2136, cpphdl_n1481) <+ 1.0000000000000001e-15 * ddt(V(cpphdl_n2136, cpphdl_n1481)); // Bench initial voltage = 0.0 V.
        // device 1034, IC IC181, analog/basic/inverter.hpp:11
        I(cpphdl_n1442, Vdd) <+ cpphdl_channel(V(BIT_N7_0, Vdd), V(cpphdl_n1442, Vdd), 0.080000000000000002, 0.69999999999999996, -1.0);
        // device 1035, IC IC181, analog/basic/inverter.hpp:12
        I(cpphdl_n1442, Vss) <+ cpphdl_channel(V(BIT_N7_0, Vss), V(cpphdl_n1442, Vss), 0.080000000000000002, 0.69999999999999996, 1.0);
        // device 1036, IC IC180, analog/basic/mos_r2r_dac.hpp:27
        I(cpphdl_n1442, Vss) <+ 2.9999999999999998e-15 * ddt(V(cpphdl_n1442, Vss)); // Bench initial voltage = 0.0 V.
        // device 1037, IC IC180, analog/basic/mos_r2r_dac.hpp:28
        I(cpphdl_n1442, cpphdl_n1471) <+ V(cpphdl_n1442, cpphdl_n1471) / 2000.0;
        // device 1038, IC IC180, analog/basic/mos_r2r_dac.hpp:29
        I(cpphdl_n1471, Vss) <+ 2.9999999999999998e-15 * ddt(V(cpphdl_n1471, Vss)); // Bench initial voltage = 0.0 V.
        // device 1039, IC IC182, analog/basic/inverter.hpp:11
        I(cpphdl_n1446, Vdd) <+ cpphdl_channel(V(BIT_N7_1, Vdd), V(cpphdl_n1446, Vdd), 0.080000000000000002, 0.69999999999999996, -1.0);
        // device 1040, IC IC182, analog/basic/inverter.hpp:12
        I(cpphdl_n1446, Vss) <+ cpphdl_channel(V(BIT_N7_1, Vss), V(cpphdl_n1446, Vss), 0.080000000000000002, 0.69999999999999996, 1.0);
        // device 1041, IC IC180, analog/basic/mos_r2r_dac.hpp:27
        I(cpphdl_n1446, Vss) <+ 2.9999999999999998e-15 * ddt(V(cpphdl_n1446, Vss)); // Bench initial voltage = 0.0 V.
        // device 1042, IC IC180, analog/basic/mos_r2r_dac.hpp:28
        I(cpphdl_n1446, cpphdl_n1472) <+ V(cpphdl_n1446, cpphdl_n1472) / 2000.0;
        // device 1043, IC IC180, analog/basic/mos_r2r_dac.hpp:29
        I(cpphdl_n1472, Vss) <+ 2.9999999999999998e-15 * ddt(V(cpphdl_n1472, Vss)); // Bench initial voltage = 0.0 V.
        // device 1044, IC IC180, analog/basic/mos_r2r_dac.hpp:31
        I(cpphdl_n1471, cpphdl_n1472) <+ V(cpphdl_n1471, cpphdl_n1472) / 1000.0;
        // device 1045, IC IC183, analog/basic/inverter.hpp:11
        I(cpphdl_n1450, Vdd) <+ cpphdl_channel(V(BIT_N7_2, Vdd), V(cpphdl_n1450, Vdd), 0.080000000000000002, 0.69999999999999996, -1.0);
        // device 1046, IC IC183, analog/basic/inverter.hpp:12
        I(cpphdl_n1450, Vss) <+ cpphdl_channel(V(BIT_N7_2, Vss), V(cpphdl_n1450, Vss), 0.080000000000000002, 0.69999999999999996, 1.0);
        // device 1047, IC IC180, analog/basic/mos_r2r_dac.hpp:27
        I(cpphdl_n1450, Vss) <+ 2.9999999999999998e-15 * ddt(V(cpphdl_n1450, Vss)); // Bench initial voltage = 0.0 V.
        // device 1048, IC IC180, analog/basic/mos_r2r_dac.hpp:28
        I(cpphdl_n1450, cpphdl_n1473) <+ V(cpphdl_n1450, cpphdl_n1473) / 2000.0;
        // device 1049, IC IC180, analog/basic/mos_r2r_dac.hpp:29
        I(cpphdl_n1473, Vss) <+ 2.9999999999999998e-15 * ddt(V(cpphdl_n1473, Vss)); // Bench initial voltage = 0.0 V.
        // device 1050, IC IC180, analog/basic/mos_r2r_dac.hpp:31
        I(cpphdl_n1472, cpphdl_n1473) <+ V(cpphdl_n1472, cpphdl_n1473) / 1000.0;
        // device 1051, IC IC184, analog/basic/inverter.hpp:11
        I(cpphdl_n1454, Vdd) <+ cpphdl_channel(V(BIT_N7_3, Vdd), V(cpphdl_n1454, Vdd), 0.080000000000000002, 0.69999999999999996, -1.0);
        // device 1052, IC IC184, analog/basic/inverter.hpp:12
        I(cpphdl_n1454, Vss) <+ cpphdl_channel(V(BIT_N7_3, Vss), V(cpphdl_n1454, Vss), 0.080000000000000002, 0.69999999999999996, 1.0);
        // device 1053, IC IC180, analog/basic/mos_r2r_dac.hpp:27
        I(cpphdl_n1454, Vss) <+ 2.9999999999999998e-15 * ddt(V(cpphdl_n1454, Vss)); // Bench initial voltage = 0.0 V.
        // device 1054, IC IC180, analog/basic/mos_r2r_dac.hpp:28
        I(cpphdl_n1454, cpphdl_n1474) <+ V(cpphdl_n1454, cpphdl_n1474) / 2000.0;
        // device 1055, IC IC180, analog/basic/mos_r2r_dac.hpp:29
        I(cpphdl_n1474, Vss) <+ 2.9999999999999998e-15 * ddt(V(cpphdl_n1474, Vss)); // Bench initial voltage = 0.0 V.
        // device 1056, IC IC180, analog/basic/mos_r2r_dac.hpp:31
        I(cpphdl_n1473, cpphdl_n1474) <+ V(cpphdl_n1473, cpphdl_n1474) / 1000.0;
        // device 1057, IC IC185, analog/basic/inverter.hpp:11
        I(cpphdl_n1458, Vdd) <+ cpphdl_channel(V(BIT_N7_4, Vdd), V(cpphdl_n1458, Vdd), 0.080000000000000002, 0.69999999999999996, -1.0);
        // device 1058, IC IC185, analog/basic/inverter.hpp:12
        I(cpphdl_n1458, Vss) <+ cpphdl_channel(V(BIT_N7_4, Vss), V(cpphdl_n1458, Vss), 0.080000000000000002, 0.69999999999999996, 1.0);
        // device 1059, IC IC180, analog/basic/mos_r2r_dac.hpp:27
        I(cpphdl_n1458, Vss) <+ 2.9999999999999998e-15 * ddt(V(cpphdl_n1458, Vss)); // Bench initial voltage = 0.0 V.
        // device 1060, IC IC180, analog/basic/mos_r2r_dac.hpp:28
        I(cpphdl_n1458, cpphdl_n1475) <+ V(cpphdl_n1458, cpphdl_n1475) / 2000.0;
        // device 1061, IC IC180, analog/basic/mos_r2r_dac.hpp:29
        I(cpphdl_n1475, Vss) <+ 2.9999999999999998e-15 * ddt(V(cpphdl_n1475, Vss)); // Bench initial voltage = 0.0 V.
        // device 1062, IC IC180, analog/basic/mos_r2r_dac.hpp:31
        I(cpphdl_n1474, cpphdl_n1475) <+ V(cpphdl_n1474, cpphdl_n1475) / 1000.0;
        // device 1063, IC IC186, analog/basic/inverter.hpp:11
        I(cpphdl_n1462, Vdd) <+ cpphdl_channel(V(BIT_N7_5, Vdd), V(cpphdl_n1462, Vdd), 0.080000000000000002, 0.69999999999999996, -1.0);
        // device 1064, IC IC186, analog/basic/inverter.hpp:12
        I(cpphdl_n1462, Vss) <+ cpphdl_channel(V(BIT_N7_5, Vss), V(cpphdl_n1462, Vss), 0.080000000000000002, 0.69999999999999996, 1.0);
        // device 1065, IC IC180, analog/basic/mos_r2r_dac.hpp:27
        I(cpphdl_n1462, Vss) <+ 2.9999999999999998e-15 * ddt(V(cpphdl_n1462, Vss)); // Bench initial voltage = 0.0 V.
        // device 1066, IC IC180, analog/basic/mos_r2r_dac.hpp:28
        I(cpphdl_n1462, cpphdl_n1476) <+ V(cpphdl_n1462, cpphdl_n1476) / 2000.0;
        // device 1067, IC IC180, analog/basic/mos_r2r_dac.hpp:29
        I(cpphdl_n1476, Vss) <+ 2.9999999999999998e-15 * ddt(V(cpphdl_n1476, Vss)); // Bench initial voltage = 0.0 V.
        // device 1068, IC IC180, analog/basic/mos_r2r_dac.hpp:31
        I(cpphdl_n1475, cpphdl_n1476) <+ V(cpphdl_n1475, cpphdl_n1476) / 1000.0;
        // device 1069, IC IC187, analog/basic/inverter.hpp:11
        I(cpphdl_n1466, Vdd) <+ cpphdl_channel(V(BIT_N7_6, Vdd), V(cpphdl_n1466, Vdd), 0.080000000000000002, 0.69999999999999996, -1.0);
        // device 1070, IC IC187, analog/basic/inverter.hpp:12
        I(cpphdl_n1466, Vss) <+ cpphdl_channel(V(BIT_N7_6, Vss), V(cpphdl_n1466, Vss), 0.080000000000000002, 0.69999999999999996, 1.0);
        // device 1071, IC IC180, analog/basic/mos_r2r_dac.hpp:27
        I(cpphdl_n1466, Vss) <+ 2.9999999999999998e-15 * ddt(V(cpphdl_n1466, Vss)); // Bench initial voltage = 0.0 V.
        // device 1072, IC IC180, analog/basic/mos_r2r_dac.hpp:28
        I(cpphdl_n1466, cpphdl_n1477) <+ V(cpphdl_n1466, cpphdl_n1477) / 2000.0;
        // device 1073, IC IC180, analog/basic/mos_r2r_dac.hpp:29
        I(cpphdl_n1477, Vss) <+ 2.9999999999999998e-15 * ddt(V(cpphdl_n1477, Vss)); // Bench initial voltage = 0.0 V.
        // device 1074, IC IC180, analog/basic/mos_r2r_dac.hpp:31
        I(cpphdl_n1476, cpphdl_n1477) <+ V(cpphdl_n1476, cpphdl_n1477) / 1000.0;
        // device 1075, IC IC188, analog/basic/inverter.hpp:11
        I(cpphdl_n1470, Vdd) <+ cpphdl_channel(V(BIT_N7_7, Vdd), V(cpphdl_n1470, Vdd), 0.080000000000000002, 0.69999999999999996, -1.0);
        // device 1076, IC IC188, analog/basic/inverter.hpp:12
        I(cpphdl_n1470, Vss) <+ cpphdl_channel(V(BIT_N7_7, Vss), V(cpphdl_n1470, Vss), 0.080000000000000002, 0.69999999999999996, 1.0);
        // device 1077, IC IC180, analog/basic/mos_r2r_dac.hpp:27
        I(cpphdl_n1470, Vss) <+ 2.9999999999999998e-15 * ddt(V(cpphdl_n1470, Vss)); // Bench initial voltage = 0.0 V.
        // device 1078, IC IC180, analog/basic/mos_r2r_dac.hpp:28
        I(cpphdl_n1470, cpphdl_n1482) <+ V(cpphdl_n1470, cpphdl_n1482) / 2000.0;
        // device 1079, IC IC180, analog/basic/mos_r2r_dac.hpp:29
        I(cpphdl_n1482, Vss) <+ 2.9999999999999998e-15 * ddt(V(cpphdl_n1482, Vss)); // Bench initial voltage = 0.0 V.
        // device 1080, IC IC180, analog/basic/mos_r2r_dac.hpp:31
        I(cpphdl_n1477, cpphdl_n1482) <+ V(cpphdl_n1477, cpphdl_n1482) / 1000.0;
        // device 1081, IC IC180, analog/basic/mos_r2r_dac.hpp:33
        I(Vss, cpphdl_n1471) <+ V(Vss, cpphdl_n1471) / 2000.0;
        // device 1082, IC IC189, analog/basic/nmos_resistor_amplifier.hpp:23
        I(Vdd, cpphdl_n1491) <+ V(Vdd, cpphdl_n1491) / 1000.0;
        // device 1083, IC IC189, analog/basic/nmos_resistor_amplifier.hpp:24
        I(Vdd, cpphdl_n1490) <+ V(Vdd, cpphdl_n1490) / 1000.0;
        // device 1084, IC IC189, analog/basic/nmos_resistor_amplifier.hpp:25
        I(cpphdl_n1491, cpphdl_n1485) <+ cpphdl_channel(V(cpphdl_n1481, cpphdl_n1485), V(cpphdl_n1491, cpphdl_n1485), 0.0074999999999999997, 0.69999999999999996, 1.0);
        // device 1085, IC IC189, analog/basic/nmos_resistor_amplifier.hpp:26
        I(cpphdl_n1490, cpphdl_n1486) <+ cpphdl_channel(V(cpphdl_n1482, cpphdl_n1486), V(cpphdl_n1490, cpphdl_n1486), 0.0074999999999999997, 0.69999999999999996, 1.0);
        // device 1086, IC IC189, analog/basic/nmos_resistor_amplifier.hpp:27
        I(cpphdl_n1487, cpphdl_n1485) <+ V(cpphdl_n1487, cpphdl_n1485) / 100.0;
        // device 1087, IC IC189, analog/basic/nmos_resistor_amplifier.hpp:28
        I(cpphdl_n1487, cpphdl_n1486) <+ V(cpphdl_n1487, cpphdl_n1486) / 100.0;
        // device 1088, IC IC189, analog/basic/nmos_resistor_amplifier.hpp:29
        I(Vss, cpphdl_n1487) <+ V(Vss, cpphdl_n1487) / 300.0;
        // device 1089, IC IC189, analog/basic/nmos_resistor_amplifier.hpp:30
        I(cpphdl_n1491, Vdd) <+ 2.9999999999999998e-13 * ddt(V(cpphdl_n1491, Vdd)); // Bench initial voltage = 0.0 V.
        // device 1090, IC IC189, analog/basic/nmos_resistor_amplifier.hpp:31
        I(cpphdl_n1490, Vdd) <+ 2.9999999999999998e-13 * ddt(V(cpphdl_n1490, Vdd)); // Bench initial voltage = 0.0 V.
        // device 1091, IC IC189, analog/basic/nmos_resistor_amplifier.hpp:32
        I(cpphdl_n1487, Vss) <+ 4e-14 * ddt(V(cpphdl_n1487, Vss)); // Bench initial voltage = 0.0 V.
        // device 1092, IC IC189, analog/basic/nmos_resistor_amplifier.hpp:34
        I(cpphdl_n1481, cpphdl_n1485) <+ 2e-14 * ddt(V(cpphdl_n1481, cpphdl_n1485)); // Bench initial voltage = 0.0 V.
        // device 1093, IC IC189, analog/basic/nmos_resistor_amplifier.hpp:35
        I(cpphdl_n1482, cpphdl_n1486) <+ 2e-14 * ddt(V(cpphdl_n1482, cpphdl_n1486)); // Bench initial voltage = 0.0 V.
        // device 1094, IC IC189, analog/basic/nmos_resistor_amplifier.hpp:36
        I(cpphdl_n1481, cpphdl_n1491) <+ 2.9999999999999998e-15 * ddt(V(cpphdl_n1481, cpphdl_n1491)); // Bench initial voltage = 0.0 V.
        // device 1095, IC IC189, analog/basic/nmos_resistor_amplifier.hpp:37
        I(cpphdl_n1482, cpphdl_n1490) <+ 2.9999999999999998e-15 * ddt(V(cpphdl_n1482, cpphdl_n1490)); // Bench initial voltage = 0.0 V.
        // device 1096, IC IC190, analog/basic/strongarm_comparator.hpp:28
        I(cpphdl_n1495, cpphdl_n1497) <+ cpphdl_channel(V(cpphdl_n1490, cpphdl_n1497), V(cpphdl_n1495, cpphdl_n1497), 0.0080000000000000002, 0.69999999999999996, 1.0);
        // device 1097, IC IC190, analog/basic/strongarm_comparator.hpp:29
        I(cpphdl_n1496, cpphdl_n1497) <+ cpphdl_channel(V(cpphdl_n1491, cpphdl_n1497), V(cpphdl_n1496, cpphdl_n1497), 0.0080000000000000002, 0.69999999999999996, 1.0);
        // device 1098, IC IC190, analog/basic/strongarm_comparator.hpp:30
        I(cpphdl_n1497, Vss) <+ cpphdl_channel(V(EVALUATE, Vss), V(cpphdl_n1497, Vss), 0.0080000000000000002, 0.69999999999999996, 1.0);
        // device 1099, IC IC190, analog/basic/strongarm_comparator.hpp:33
        I(cpphdl_n1510, cpphdl_n1495) <+ cpphdl_channel(V(cpphdl_n1514, cpphdl_n1495), V(cpphdl_n1510, cpphdl_n1495), 0.0040000000000000001, 0.69999999999999996, 1.0);
        // device 1100, IC IC190, analog/basic/strongarm_comparator.hpp:34
        I(cpphdl_n1514, cpphdl_n1496) <+ cpphdl_channel(V(cpphdl_n1510, cpphdl_n1496), V(cpphdl_n1514, cpphdl_n1496), 0.0040000000000000001, 0.69999999999999996, 1.0);
        // device 1101, IC IC190, analog/basic/strongarm_comparator.hpp:35
        I(cpphdl_n1514, Vdd) <+ cpphdl_channel(V(cpphdl_n1510, Vdd), V(cpphdl_n1514, Vdd), 0.002, 0.69999999999999996, -1.0);
        // device 1102, IC IC190, analog/basic/strongarm_comparator.hpp:36
        I(cpphdl_n1510, Vdd) <+ cpphdl_channel(V(cpphdl_n1514, Vdd), V(cpphdl_n1510, Vdd), 0.002, 0.69999999999999996, -1.0);
        // device 1103, IC IC190, analog/basic/strongarm_comparator.hpp:38
        I(cpphdl_n1495, Vdd) <+ cpphdl_channel(V(EVALUATE, Vdd), V(cpphdl_n1495, Vdd), 0.002, 0.69999999999999996, -1.0);
        // device 1104, IC IC190, analog/basic/strongarm_comparator.hpp:39
        I(cpphdl_n1496, Vdd) <+ cpphdl_channel(V(EVALUATE, Vdd), V(cpphdl_n1496, Vdd), 0.002, 0.69999999999999996, -1.0);
        // device 1105, IC IC190, analog/basic/strongarm_comparator.hpp:40
        I(cpphdl_n1514, Vdd) <+ cpphdl_channel(V(EVALUATE, Vdd), V(cpphdl_n1514, Vdd), 0.002, 0.69999999999999996, -1.0);
        // device 1106, IC IC190, analog/basic/strongarm_comparator.hpp:41
        I(cpphdl_n1510, Vdd) <+ cpphdl_channel(V(EVALUATE, Vdd), V(cpphdl_n1510, Vdd), 0.002, 0.69999999999999996, -1.0);
        // device 1107, IC IC190, analog/basic/strongarm_comparator.hpp:42
        I(cpphdl_n1495, Vss) <+ 2.9999999999999998e-14 * ddt(V(cpphdl_n1495, Vss)); // Bench initial voltage = 0.0 V.
        // device 1108, IC IC190, analog/basic/strongarm_comparator.hpp:43
        I(cpphdl_n1496, Vss) <+ 2.9999999999999998e-14 * ddt(V(cpphdl_n1496, Vss)); // Bench initial voltage = 0.0 V.
        // device 1109, IC IC190, analog/basic/strongarm_comparator.hpp:44
        I(cpphdl_n1497, Vss) <+ 2.9999999999999998e-14 * ddt(V(cpphdl_n1497, Vss)); // Bench initial voltage = 0.0 V.
        // device 1110, IC IC190, analog/basic/strongarm_comparator.hpp:45
        I(cpphdl_n1514, Vss) <+ 5.0000000000000002e-14 * ddt(V(cpphdl_n1514, Vss)); // Bench initial voltage = 0.0 V.
        // device 1111, IC IC190, analog/basic/strongarm_comparator.hpp:46
        I(cpphdl_n1510, Vss) <+ 5.0000000000000002e-14 * ddt(V(cpphdl_n1510, Vss)); // Bench initial voltage = 0.0 V.
        // device 1112, IC IC190, analog/basic/strongarm_comparator.hpp:47
        I(cpphdl_n1490, cpphdl_n1497) <+ 2e-14 * ddt(V(cpphdl_n1490, cpphdl_n1497)); // Bench initial voltage = 0.0 V.
        // device 1113, IC IC190, analog/basic/strongarm_comparator.hpp:48
        I(cpphdl_n1491, cpphdl_n1497) <+ 2e-14 * ddt(V(cpphdl_n1491, cpphdl_n1497)); // Bench initial voltage = 0.0 V.
        // device 1114, IC IC190, analog/basic/strongarm_comparator.hpp:49
        I(cpphdl_n1490, cpphdl_n1495) <+ 2.9999999999999998e-15 * ddt(V(cpphdl_n1490, cpphdl_n1495)); // Bench initial voltage = 0.0 V.
        // device 1115, IC IC190, analog/basic/strongarm_comparator.hpp:50
        I(cpphdl_n1491, cpphdl_n1496) <+ 2.9999999999999998e-15 * ddt(V(cpphdl_n1491, cpphdl_n1496)); // Bench initial voltage = 0.0 V.
        // device 1116, IC IC192, analog/basic/inverter.hpp:11
        I(cpphdl_n1518, Vdd) <+ cpphdl_channel(V(cpphdl_n1510, Vdd), V(cpphdl_n1518, Vdd), 0.001, 0.69999999999999996, -1.0);
        // device 1117, IC IC192, analog/basic/inverter.hpp:12
        I(cpphdl_n1518, Vss) <+ cpphdl_channel(V(cpphdl_n1510, Vss), V(cpphdl_n1518, Vss), 0.001, 0.69999999999999996, 1.0);
        // device 1118, IC IC194, analog/basic/inverter.hpp:11
        I(cpphdl_n1532, Vdd) <+ cpphdl_channel(V(cpphdl_n1518, Vdd), V(cpphdl_n1532, Vdd), 0.0040000000000000001, 0.69999999999999996, -1.0);
        // device 1119, IC IC194, analog/basic/inverter.hpp:12
        I(cpphdl_n1532, Vss) <+ cpphdl_channel(V(cpphdl_n1518, Vss), V(cpphdl_n1532, Vss), 0.0040000000000000001, 0.69999999999999996, 1.0);
        // device 1120, IC IC191, analog/basic/buffered_nand_latch.hpp:34
        I(cpphdl_n1510, Vss) <+ 2.0000000000000002e-15 * ddt(V(cpphdl_n1510, Vss)); // Bench initial voltage = 0.0 V.
        // device 1121, IC IC191, analog/basic/buffered_nand_latch.hpp:35
        I(cpphdl_n1510, cpphdl_n1518) <+ 1.0000000000000001e-15 * ddt(V(cpphdl_n1510, cpphdl_n1518)); // Bench initial voltage = 0.0 V.
        // device 1122, IC IC191, analog/basic/buffered_nand_latch.hpp:36
        I(cpphdl_n1518, Vss) <+ 5e-15 * ddt(V(cpphdl_n1518, Vss)); // Bench initial voltage = 0.0 V.
        // device 1123, IC IC191, analog/basic/buffered_nand_latch.hpp:37
        I(cpphdl_n1518, Vss) <+ 8.0000000000000006e-15 * ddt(V(cpphdl_n1518, Vss)); // Bench initial voltage = 0.0 V.
        // device 1124, IC IC191, analog/basic/buffered_nand_latch.hpp:38
        I(cpphdl_n1532, Vss) <+ 1e-14 * ddt(V(cpphdl_n1532, Vss)); // Bench initial voltage = 0.0 V.
        // device 1125, IC IC193, analog/basic/inverter.hpp:11
        I(cpphdl_n1522, Vdd) <+ cpphdl_channel(V(cpphdl_n1514, Vdd), V(cpphdl_n1522, Vdd), 0.001, 0.69999999999999996, -1.0);
        // device 1126, IC IC193, analog/basic/inverter.hpp:12
        I(cpphdl_n1522, Vss) <+ cpphdl_channel(V(cpphdl_n1514, Vss), V(cpphdl_n1522, Vss), 0.001, 0.69999999999999996, 1.0);
        // device 1127, IC IC195, analog/basic/inverter.hpp:11
        I(cpphdl_n1538, Vdd) <+ cpphdl_channel(V(cpphdl_n1522, Vdd), V(cpphdl_n1538, Vdd), 0.0040000000000000001, 0.69999999999999996, -1.0);
        // device 1128, IC IC195, analog/basic/inverter.hpp:12
        I(cpphdl_n1538, Vss) <+ cpphdl_channel(V(cpphdl_n1522, Vss), V(cpphdl_n1538, Vss), 0.0040000000000000001, 0.69999999999999996, 1.0);
        // device 1129, IC IC191, analog/basic/buffered_nand_latch.hpp:34
        I(cpphdl_n1514, Vss) <+ 2.0000000000000002e-15 * ddt(V(cpphdl_n1514, Vss)); // Bench initial voltage = 0.0 V.
        // device 1130, IC IC191, analog/basic/buffered_nand_latch.hpp:35
        I(cpphdl_n1514, cpphdl_n1522) <+ 1.0000000000000001e-15 * ddt(V(cpphdl_n1514, cpphdl_n1522)); // Bench initial voltage = 0.0 V.
        // device 1131, IC IC191, analog/basic/buffered_nand_latch.hpp:36
        I(cpphdl_n1522, Vss) <+ 5e-15 * ddt(V(cpphdl_n1522, Vss)); // Bench initial voltage = 0.0 V.
        // device 1132, IC IC191, analog/basic/buffered_nand_latch.hpp:37
        I(cpphdl_n1522, Vss) <+ 8.0000000000000006e-15 * ddt(V(cpphdl_n1522, Vss)); // Bench initial voltage = 0.0 V.
        // device 1133, IC IC191, analog/basic/buffered_nand_latch.hpp:38
        I(cpphdl_n1538, Vss) <+ 1e-14 * ddt(V(cpphdl_n1538, Vss)); // Bench initial voltage = 0.0 V.
        // device 1134, IC IC197, analog/basic/cmos_logic.hpp:17
        I(cpphdl_n2313, Vss) <+ 5.0000000000000002e-14 * ddt(V(cpphdl_n2313, Vss)); // Bench initial voltage = 0.0 V.
        // device 1135, IC IC197, analog/basic/cmos_logic.hpp:18
        I(cpphdl_n2313, Vdd) <+ cpphdl_channel(V(cpphdl_n1532, Vdd), V(cpphdl_n2313, Vdd), 0.01, 0.69999999999999996, -1.0);
        // device 1136, IC IC197, analog/basic/cmos_logic.hpp:19
        I(cpphdl_n2313, Vdd) <+ cpphdl_channel(V(cpphdl_n1540, Vdd), V(cpphdl_n2313, Vdd), 0.01, 0.69999999999999996, -1.0);
        // device 1137, IC IC197, analog/basic/cmos_logic.hpp:20
        I(cpphdl_n2313, cpphdl_n1535) <+ cpphdl_channel(V(cpphdl_n1532, cpphdl_n1535), V(cpphdl_n2313, cpphdl_n1535), 0.01, 0.69999999999999996, 1.0);
        // device 1138, IC IC197, analog/basic/cmos_logic.hpp:21
        I(cpphdl_n1535, Vss) <+ cpphdl_channel(V(cpphdl_n1540, Vss), V(cpphdl_n1535, Vss), 0.01, 0.69999999999999996, 1.0);
        // device 1139, IC IC197, analog/basic/cmos_logic.hpp:27
        I(cpphdl_n1535, Vss) <+ 1e-14 * ddt(V(cpphdl_n1535, Vss)); // Bench initial voltage = 0.0 V.
        // device 1140, IC IC198, analog/basic/cmos_logic.hpp:17
        I(cpphdl_n1540, Vss) <+ 5.0000000000000002e-14 * ddt(V(cpphdl_n1540, Vss)); // Bench initial voltage = 0.0 V.
        // device 1141, IC IC198, analog/basic/cmos_logic.hpp:18
        I(cpphdl_n1540, Vdd) <+ cpphdl_channel(V(cpphdl_n1538, Vdd), V(cpphdl_n1540, Vdd), 0.01, 0.69999999999999996, -1.0);
        // device 1142, IC IC198, analog/basic/cmos_logic.hpp:19
        I(cpphdl_n1540, Vdd) <+ cpphdl_channel(V(cpphdl_n2313, Vdd), V(cpphdl_n1540, Vdd), 0.01, 0.69999999999999996, -1.0);
        // device 1143, IC IC198, analog/basic/cmos_logic.hpp:20
        I(cpphdl_n1540, cpphdl_n1541) <+ cpphdl_channel(V(cpphdl_n1538, cpphdl_n1541), V(cpphdl_n1540, cpphdl_n1541), 0.01, 0.69999999999999996, 1.0);
        // device 1144, IC IC198, analog/basic/cmos_logic.hpp:21
        I(cpphdl_n1541, Vss) <+ cpphdl_channel(V(cpphdl_n2313, Vss), V(cpphdl_n1541, Vss), 0.01, 0.69999999999999996, 1.0);
        // device 1145, IC IC198, analog/basic/cmos_logic.hpp:27
        I(cpphdl_n1541, Vss) <+ 1e-14 * ddt(V(cpphdl_n1541, Vss)); // Bench initial voltage = 0.0 V.
        // device 1146, IC IC196, analog/basic/nand_latch.hpp:36
        I(cpphdl_n1532, Vss) <+ 2.9999999999999998e-15 * ddt(V(cpphdl_n1532, Vss)); // Bench initial voltage = 0.0 V.
        // device 1147, IC IC196, analog/basic/nand_latch.hpp:37
        I(cpphdl_n1538, Vss) <+ 2.9999999999999998e-15 * ddt(V(cpphdl_n1538, Vss)); // Bench initial voltage = 0.0 V.
        // device 1148, IC IC199, analog/basic/inverter.hpp:11
        I(cpphdl_n1546, Vdd) <+ cpphdl_channel(V(CLEAR, Vdd), V(cpphdl_n1546, Vdd), 0.01, 0.69999999999999996, -1.0);
        // device 1149, IC IC199, analog/basic/inverter.hpp:12
        I(cpphdl_n1546, Vss) <+ cpphdl_channel(V(CLEAR, Vss), V(cpphdl_n1546, Vss), 0.01, 0.69999999999999996, 1.0);
        // device 1150, IC IC196, analog/basic/nand_latch.hpp:58
        I(cpphdl_n1546, Vss) <+ 2.9999999999999998e-15 * ddt(V(cpphdl_n1546, Vss)); // Bench initial voltage = 0.0 V.
        // device 1151, IC IC196, analog/basic/nand_latch.hpp:59
        I(cpphdl_n2313, Vss) <+ cpphdl_channel(V(CLEAR, Vss), V(cpphdl_n2313, Vss), 0.050000000000000003, 0.69999999999999996, 1.0);
        // device 1152, IC IC196, analog/basic/nand_latch.hpp:60
        I(cpphdl_n1540, Vdd) <+ cpphdl_channel(V(cpphdl_n1546, Vdd), V(cpphdl_n1540, Vdd), 0.050000000000000003, 0.69999999999999996, -1.0);
        // device 1153, IC IC202, analog/basic/inverter.hpp:11
        I(cpphdl_n1570, Vdd) <+ cpphdl_channel(V(TRACK8, Vdd), V(cpphdl_n1570, Vdd), 0.0040000000000000001, 0.69999999999999996, -1.0);
        // device 1154, IC IC202, analog/basic/inverter.hpp:12
        I(cpphdl_n1570, Vss) <+ cpphdl_channel(V(TRACK8, Vss), V(cpphdl_n1570, Vss), 0.0040000000000000001, 0.69999999999999996, 1.0);
        // device 1155, IC IC201, analog/basic/mos_track_hold.hpp:31
        I(cpphdl_n1570, Vss) <+ 2e-14 * ddt(V(cpphdl_n1570, Vss)); // Bench initial voltage = 0.0 V.
        // device 1156, IC IC201, analog/basic/mos_track_hold.hpp:32
        I(cpphdl_n2136, cpphdl_n1624) <+ cpphdl_channel(V(TRACK8, cpphdl_n1624), V(cpphdl_n2136, cpphdl_n1624), 0.029999999999999999, 0.69999999999999996, 1.0);
        // device 1157, IC IC201, analog/basic/mos_track_hold.hpp:33
        I(cpphdl_n1624, cpphdl_n2136) <+ cpphdl_channel(V(cpphdl_n1570, cpphdl_n2136), V(cpphdl_n1624, cpphdl_n2136), 0.014999999999999999, 0.69999999999999996, -1.0);
        // device 1158, IC IC201, analog/basic/mos_track_hold.hpp:37
        I(cpphdl_n1624, cpphdl_n1624) <+ cpphdl_channel(V(cpphdl_n1570, cpphdl_n1624), V(cpphdl_n1624, cpphdl_n1624), 0.016, 0.69999999999999996, 1.0);
        // device 1159, IC IC201, analog/basic/mos_track_hold.hpp:38
        I(cpphdl_n1624, cpphdl_n1624) <+ cpphdl_channel(V(TRACK8, cpphdl_n1624), V(cpphdl_n1624, cpphdl_n1624), 0.0083999999999999995, 0.69999999999999996, -1.0);
        // device 1160, IC IC201, analog/basic/mos_track_hold.hpp:39
        I(cpphdl_n1624, Vss) <+ 1.5000000000000001e-12 * ddt(V(cpphdl_n1624, Vss)); // Bench initial voltage = 0.0 V.
        // device 1161, IC IC201, analog/basic/mos_track_hold.hpp:42
        I(TRACK8, cpphdl_n1624) <+ 2.0000000000000002e-15 * ddt(V(TRACK8, cpphdl_n1624)); // Bench initial voltage = -0.0 V.
        // device 1162, IC IC201, analog/basic/mos_track_hold.hpp:43
        I(cpphdl_n1570, cpphdl_n1624) <+ 2.0000000000000002e-15 * ddt(V(cpphdl_n1570, cpphdl_n1624)); // Bench initial voltage = 0.0 V.
        // device 1163, IC IC201, analog/basic/mos_track_hold.hpp:44
        I(cpphdl_n2136, cpphdl_n1624) <+ 1.0000000000000001e-15 * ddt(V(cpphdl_n2136, cpphdl_n1624)); // Bench initial voltage = 0.0 V.
        // device 1164, IC IC204, analog/basic/inverter.hpp:11
        I(cpphdl_n1585, Vdd) <+ cpphdl_channel(V(BIT_N8_0, Vdd), V(cpphdl_n1585, Vdd), 0.080000000000000002, 0.69999999999999996, -1.0);
        // device 1165, IC IC204, analog/basic/inverter.hpp:12
        I(cpphdl_n1585, Vss) <+ cpphdl_channel(V(BIT_N8_0, Vss), V(cpphdl_n1585, Vss), 0.080000000000000002, 0.69999999999999996, 1.0);
        // device 1166, IC IC203, analog/basic/mos_r2r_dac.hpp:27
        I(cpphdl_n1585, Vss) <+ 2.9999999999999998e-15 * ddt(V(cpphdl_n1585, Vss)); // Bench initial voltage = 0.0 V.
        // device 1167, IC IC203, analog/basic/mos_r2r_dac.hpp:28
        I(cpphdl_n1585, cpphdl_n1614) <+ V(cpphdl_n1585, cpphdl_n1614) / 2000.0;
        // device 1168, IC IC203, analog/basic/mos_r2r_dac.hpp:29
        I(cpphdl_n1614, Vss) <+ 2.9999999999999998e-15 * ddt(V(cpphdl_n1614, Vss)); // Bench initial voltage = 0.0 V.
        // device 1169, IC IC205, analog/basic/inverter.hpp:11
        I(cpphdl_n1589, Vdd) <+ cpphdl_channel(V(BIT_N8_1, Vdd), V(cpphdl_n1589, Vdd), 0.080000000000000002, 0.69999999999999996, -1.0);
        // device 1170, IC IC205, analog/basic/inverter.hpp:12
        I(cpphdl_n1589, Vss) <+ cpphdl_channel(V(BIT_N8_1, Vss), V(cpphdl_n1589, Vss), 0.080000000000000002, 0.69999999999999996, 1.0);
        // device 1171, IC IC203, analog/basic/mos_r2r_dac.hpp:27
        I(cpphdl_n1589, Vss) <+ 2.9999999999999998e-15 * ddt(V(cpphdl_n1589, Vss)); // Bench initial voltage = 0.0 V.
        // device 1172, IC IC203, analog/basic/mos_r2r_dac.hpp:28
        I(cpphdl_n1589, cpphdl_n1615) <+ V(cpphdl_n1589, cpphdl_n1615) / 2000.0;
        // device 1173, IC IC203, analog/basic/mos_r2r_dac.hpp:29
        I(cpphdl_n1615, Vss) <+ 2.9999999999999998e-15 * ddt(V(cpphdl_n1615, Vss)); // Bench initial voltage = 0.0 V.
        // device 1174, IC IC203, analog/basic/mos_r2r_dac.hpp:31
        I(cpphdl_n1614, cpphdl_n1615) <+ V(cpphdl_n1614, cpphdl_n1615) / 1000.0;
        // device 1175, IC IC206, analog/basic/inverter.hpp:11
        I(cpphdl_n1593, Vdd) <+ cpphdl_channel(V(BIT_N8_2, Vdd), V(cpphdl_n1593, Vdd), 0.080000000000000002, 0.69999999999999996, -1.0);
        // device 1176, IC IC206, analog/basic/inverter.hpp:12
        I(cpphdl_n1593, Vss) <+ cpphdl_channel(V(BIT_N8_2, Vss), V(cpphdl_n1593, Vss), 0.080000000000000002, 0.69999999999999996, 1.0);
        // device 1177, IC IC203, analog/basic/mos_r2r_dac.hpp:27
        I(cpphdl_n1593, Vss) <+ 2.9999999999999998e-15 * ddt(V(cpphdl_n1593, Vss)); // Bench initial voltage = 0.0 V.
        // device 1178, IC IC203, analog/basic/mos_r2r_dac.hpp:28
        I(cpphdl_n1593, cpphdl_n1616) <+ V(cpphdl_n1593, cpphdl_n1616) / 2000.0;
        // device 1179, IC IC203, analog/basic/mos_r2r_dac.hpp:29
        I(cpphdl_n1616, Vss) <+ 2.9999999999999998e-15 * ddt(V(cpphdl_n1616, Vss)); // Bench initial voltage = 0.0 V.
        // device 1180, IC IC203, analog/basic/mos_r2r_dac.hpp:31
        I(cpphdl_n1615, cpphdl_n1616) <+ V(cpphdl_n1615, cpphdl_n1616) / 1000.0;
        // device 1181, IC IC207, analog/basic/inverter.hpp:11
        I(cpphdl_n1597, Vdd) <+ cpphdl_channel(V(BIT_N8_3, Vdd), V(cpphdl_n1597, Vdd), 0.080000000000000002, 0.69999999999999996, -1.0);
        // device 1182, IC IC207, analog/basic/inverter.hpp:12
        I(cpphdl_n1597, Vss) <+ cpphdl_channel(V(BIT_N8_3, Vss), V(cpphdl_n1597, Vss), 0.080000000000000002, 0.69999999999999996, 1.0);
        // device 1183, IC IC203, analog/basic/mos_r2r_dac.hpp:27
        I(cpphdl_n1597, Vss) <+ 2.9999999999999998e-15 * ddt(V(cpphdl_n1597, Vss)); // Bench initial voltage = 0.0 V.
        // device 1184, IC IC203, analog/basic/mos_r2r_dac.hpp:28
        I(cpphdl_n1597, cpphdl_n1617) <+ V(cpphdl_n1597, cpphdl_n1617) / 2000.0;
        // device 1185, IC IC203, analog/basic/mos_r2r_dac.hpp:29
        I(cpphdl_n1617, Vss) <+ 2.9999999999999998e-15 * ddt(V(cpphdl_n1617, Vss)); // Bench initial voltage = 0.0 V.
        // device 1186, IC IC203, analog/basic/mos_r2r_dac.hpp:31
        I(cpphdl_n1616, cpphdl_n1617) <+ V(cpphdl_n1616, cpphdl_n1617) / 1000.0;
        // device 1187, IC IC208, analog/basic/inverter.hpp:11
        I(cpphdl_n1601, Vdd) <+ cpphdl_channel(V(BIT_N8_4, Vdd), V(cpphdl_n1601, Vdd), 0.080000000000000002, 0.69999999999999996, -1.0);
        // device 1188, IC IC208, analog/basic/inverter.hpp:12
        I(cpphdl_n1601, Vss) <+ cpphdl_channel(V(BIT_N8_4, Vss), V(cpphdl_n1601, Vss), 0.080000000000000002, 0.69999999999999996, 1.0);
        // device 1189, IC IC203, analog/basic/mos_r2r_dac.hpp:27
        I(cpphdl_n1601, Vss) <+ 2.9999999999999998e-15 * ddt(V(cpphdl_n1601, Vss)); // Bench initial voltage = 0.0 V.
        // device 1190, IC IC203, analog/basic/mos_r2r_dac.hpp:28
        I(cpphdl_n1601, cpphdl_n1618) <+ V(cpphdl_n1601, cpphdl_n1618) / 2000.0;
        // device 1191, IC IC203, analog/basic/mos_r2r_dac.hpp:29
        I(cpphdl_n1618, Vss) <+ 2.9999999999999998e-15 * ddt(V(cpphdl_n1618, Vss)); // Bench initial voltage = 0.0 V.
        // device 1192, IC IC203, analog/basic/mos_r2r_dac.hpp:31
        I(cpphdl_n1617, cpphdl_n1618) <+ V(cpphdl_n1617, cpphdl_n1618) / 1000.0;
        // device 1193, IC IC209, analog/basic/inverter.hpp:11
        I(cpphdl_n1605, Vdd) <+ cpphdl_channel(V(BIT_N8_5, Vdd), V(cpphdl_n1605, Vdd), 0.080000000000000002, 0.69999999999999996, -1.0);
        // device 1194, IC IC209, analog/basic/inverter.hpp:12
        I(cpphdl_n1605, Vss) <+ cpphdl_channel(V(BIT_N8_5, Vss), V(cpphdl_n1605, Vss), 0.080000000000000002, 0.69999999999999996, 1.0);
        // device 1195, IC IC203, analog/basic/mos_r2r_dac.hpp:27
        I(cpphdl_n1605, Vss) <+ 2.9999999999999998e-15 * ddt(V(cpphdl_n1605, Vss)); // Bench initial voltage = 0.0 V.
        // device 1196, IC IC203, analog/basic/mos_r2r_dac.hpp:28
        I(cpphdl_n1605, cpphdl_n1619) <+ V(cpphdl_n1605, cpphdl_n1619) / 2000.0;
        // device 1197, IC IC203, analog/basic/mos_r2r_dac.hpp:29
        I(cpphdl_n1619, Vss) <+ 2.9999999999999998e-15 * ddt(V(cpphdl_n1619, Vss)); // Bench initial voltage = 0.0 V.
        // device 1198, IC IC203, analog/basic/mos_r2r_dac.hpp:31
        I(cpphdl_n1618, cpphdl_n1619) <+ V(cpphdl_n1618, cpphdl_n1619) / 1000.0;
        // device 1199, IC IC210, analog/basic/inverter.hpp:11
        I(cpphdl_n1609, Vdd) <+ cpphdl_channel(V(BIT_N8_6, Vdd), V(cpphdl_n1609, Vdd), 0.080000000000000002, 0.69999999999999996, -1.0);
        // device 1200, IC IC210, analog/basic/inverter.hpp:12
        I(cpphdl_n1609, Vss) <+ cpphdl_channel(V(BIT_N8_6, Vss), V(cpphdl_n1609, Vss), 0.080000000000000002, 0.69999999999999996, 1.0);
        // device 1201, IC IC203, analog/basic/mos_r2r_dac.hpp:27
        I(cpphdl_n1609, Vss) <+ 2.9999999999999998e-15 * ddt(V(cpphdl_n1609, Vss)); // Bench initial voltage = 0.0 V.
        // device 1202, IC IC203, analog/basic/mos_r2r_dac.hpp:28
        I(cpphdl_n1609, cpphdl_n1620) <+ V(cpphdl_n1609, cpphdl_n1620) / 2000.0;
        // device 1203, IC IC203, analog/basic/mos_r2r_dac.hpp:29
        I(cpphdl_n1620, Vss) <+ 2.9999999999999998e-15 * ddt(V(cpphdl_n1620, Vss)); // Bench initial voltage = 0.0 V.
        // device 1204, IC IC203, analog/basic/mos_r2r_dac.hpp:31
        I(cpphdl_n1619, cpphdl_n1620) <+ V(cpphdl_n1619, cpphdl_n1620) / 1000.0;
        // device 1205, IC IC211, analog/basic/inverter.hpp:11
        I(cpphdl_n1613, Vdd) <+ cpphdl_channel(V(BIT_N8_7, Vdd), V(cpphdl_n1613, Vdd), 0.080000000000000002, 0.69999999999999996, -1.0);
        // device 1206, IC IC211, analog/basic/inverter.hpp:12
        I(cpphdl_n1613, Vss) <+ cpphdl_channel(V(BIT_N8_7, Vss), V(cpphdl_n1613, Vss), 0.080000000000000002, 0.69999999999999996, 1.0);
        // device 1207, IC IC203, analog/basic/mos_r2r_dac.hpp:27
        I(cpphdl_n1613, Vss) <+ 2.9999999999999998e-15 * ddt(V(cpphdl_n1613, Vss)); // Bench initial voltage = 0.0 V.
        // device 1208, IC IC203, analog/basic/mos_r2r_dac.hpp:28
        I(cpphdl_n1613, cpphdl_n1625) <+ V(cpphdl_n1613, cpphdl_n1625) / 2000.0;
        // device 1209, IC IC203, analog/basic/mos_r2r_dac.hpp:29
        I(cpphdl_n1625, Vss) <+ 2.9999999999999998e-15 * ddt(V(cpphdl_n1625, Vss)); // Bench initial voltage = 0.0 V.
        // device 1210, IC IC203, analog/basic/mos_r2r_dac.hpp:31
        I(cpphdl_n1620, cpphdl_n1625) <+ V(cpphdl_n1620, cpphdl_n1625) / 1000.0;
        // device 1211, IC IC203, analog/basic/mos_r2r_dac.hpp:33
        I(Vss, cpphdl_n1614) <+ V(Vss, cpphdl_n1614) / 2000.0;
        // device 1212, IC IC212, analog/basic/nmos_resistor_amplifier.hpp:23
        I(Vdd, cpphdl_n1634) <+ V(Vdd, cpphdl_n1634) / 1000.0;
        // device 1213, IC IC212, analog/basic/nmos_resistor_amplifier.hpp:24
        I(Vdd, cpphdl_n1633) <+ V(Vdd, cpphdl_n1633) / 1000.0;
        // device 1214, IC IC212, analog/basic/nmos_resistor_amplifier.hpp:25
        I(cpphdl_n1634, cpphdl_n1628) <+ cpphdl_channel(V(cpphdl_n1624, cpphdl_n1628), V(cpphdl_n1634, cpphdl_n1628), 0.0074999999999999997, 0.69999999999999996, 1.0);
        // device 1215, IC IC212, analog/basic/nmos_resistor_amplifier.hpp:26
        I(cpphdl_n1633, cpphdl_n1629) <+ cpphdl_channel(V(cpphdl_n1625, cpphdl_n1629), V(cpphdl_n1633, cpphdl_n1629), 0.0074999999999999997, 0.69999999999999996, 1.0);
        // device 1216, IC IC212, analog/basic/nmos_resistor_amplifier.hpp:27
        I(cpphdl_n1630, cpphdl_n1628) <+ V(cpphdl_n1630, cpphdl_n1628) / 100.0;
        // device 1217, IC IC212, analog/basic/nmos_resistor_amplifier.hpp:28
        I(cpphdl_n1630, cpphdl_n1629) <+ V(cpphdl_n1630, cpphdl_n1629) / 100.0;
        // device 1218, IC IC212, analog/basic/nmos_resistor_amplifier.hpp:29
        I(Vss, cpphdl_n1630) <+ V(Vss, cpphdl_n1630) / 300.0;
        // device 1219, IC IC212, analog/basic/nmos_resistor_amplifier.hpp:30
        I(cpphdl_n1634, Vdd) <+ 2.9999999999999998e-13 * ddt(V(cpphdl_n1634, Vdd)); // Bench initial voltage = 0.0 V.
        // device 1220, IC IC212, analog/basic/nmos_resistor_amplifier.hpp:31
        I(cpphdl_n1633, Vdd) <+ 2.9999999999999998e-13 * ddt(V(cpphdl_n1633, Vdd)); // Bench initial voltage = 0.0 V.
        // device 1221, IC IC212, analog/basic/nmos_resistor_amplifier.hpp:32
        I(cpphdl_n1630, Vss) <+ 4e-14 * ddt(V(cpphdl_n1630, Vss)); // Bench initial voltage = 0.0 V.
        // device 1222, IC IC212, analog/basic/nmos_resistor_amplifier.hpp:34
        I(cpphdl_n1624, cpphdl_n1628) <+ 2e-14 * ddt(V(cpphdl_n1624, cpphdl_n1628)); // Bench initial voltage = 0.0 V.
        // device 1223, IC IC212, analog/basic/nmos_resistor_amplifier.hpp:35
        I(cpphdl_n1625, cpphdl_n1629) <+ 2e-14 * ddt(V(cpphdl_n1625, cpphdl_n1629)); // Bench initial voltage = 0.0 V.
        // device 1224, IC IC212, analog/basic/nmos_resistor_amplifier.hpp:36
        I(cpphdl_n1624, cpphdl_n1634) <+ 2.9999999999999998e-15 * ddt(V(cpphdl_n1624, cpphdl_n1634)); // Bench initial voltage = 0.0 V.
        // device 1225, IC IC212, analog/basic/nmos_resistor_amplifier.hpp:37
        I(cpphdl_n1625, cpphdl_n1633) <+ 2.9999999999999998e-15 * ddt(V(cpphdl_n1625, cpphdl_n1633)); // Bench initial voltage = 0.0 V.
        // device 1226, IC IC213, analog/basic/strongarm_comparator.hpp:28
        I(cpphdl_n1638, cpphdl_n1640) <+ cpphdl_channel(V(cpphdl_n1633, cpphdl_n1640), V(cpphdl_n1638, cpphdl_n1640), 0.0080000000000000002, 0.69999999999999996, 1.0);
        // device 1227, IC IC213, analog/basic/strongarm_comparator.hpp:29
        I(cpphdl_n1639, cpphdl_n1640) <+ cpphdl_channel(V(cpphdl_n1634, cpphdl_n1640), V(cpphdl_n1639, cpphdl_n1640), 0.0080000000000000002, 0.69999999999999996, 1.0);
        // device 1228, IC IC213, analog/basic/strongarm_comparator.hpp:30
        I(cpphdl_n1640, Vss) <+ cpphdl_channel(V(EVALUATE, Vss), V(cpphdl_n1640, Vss), 0.0080000000000000002, 0.69999999999999996, 1.0);
        // device 1229, IC IC213, analog/basic/strongarm_comparator.hpp:33
        I(cpphdl_n1653, cpphdl_n1638) <+ cpphdl_channel(V(cpphdl_n1657, cpphdl_n1638), V(cpphdl_n1653, cpphdl_n1638), 0.0040000000000000001, 0.69999999999999996, 1.0);
        // device 1230, IC IC213, analog/basic/strongarm_comparator.hpp:34
        I(cpphdl_n1657, cpphdl_n1639) <+ cpphdl_channel(V(cpphdl_n1653, cpphdl_n1639), V(cpphdl_n1657, cpphdl_n1639), 0.0040000000000000001, 0.69999999999999996, 1.0);
        // device 1231, IC IC213, analog/basic/strongarm_comparator.hpp:35
        I(cpphdl_n1657, Vdd) <+ cpphdl_channel(V(cpphdl_n1653, Vdd), V(cpphdl_n1657, Vdd), 0.002, 0.69999999999999996, -1.0);
        // device 1232, IC IC213, analog/basic/strongarm_comparator.hpp:36
        I(cpphdl_n1653, Vdd) <+ cpphdl_channel(V(cpphdl_n1657, Vdd), V(cpphdl_n1653, Vdd), 0.002, 0.69999999999999996, -1.0);
        // device 1233, IC IC213, analog/basic/strongarm_comparator.hpp:38
        I(cpphdl_n1638, Vdd) <+ cpphdl_channel(V(EVALUATE, Vdd), V(cpphdl_n1638, Vdd), 0.002, 0.69999999999999996, -1.0);
        // device 1234, IC IC213, analog/basic/strongarm_comparator.hpp:39
        I(cpphdl_n1639, Vdd) <+ cpphdl_channel(V(EVALUATE, Vdd), V(cpphdl_n1639, Vdd), 0.002, 0.69999999999999996, -1.0);
        // device 1235, IC IC213, analog/basic/strongarm_comparator.hpp:40
        I(cpphdl_n1657, Vdd) <+ cpphdl_channel(V(EVALUATE, Vdd), V(cpphdl_n1657, Vdd), 0.002, 0.69999999999999996, -1.0);
        // device 1236, IC IC213, analog/basic/strongarm_comparator.hpp:41
        I(cpphdl_n1653, Vdd) <+ cpphdl_channel(V(EVALUATE, Vdd), V(cpphdl_n1653, Vdd), 0.002, 0.69999999999999996, -1.0);
        // device 1237, IC IC213, analog/basic/strongarm_comparator.hpp:42
        I(cpphdl_n1638, Vss) <+ 2.9999999999999998e-14 * ddt(V(cpphdl_n1638, Vss)); // Bench initial voltage = 0.0 V.
        // device 1238, IC IC213, analog/basic/strongarm_comparator.hpp:43
        I(cpphdl_n1639, Vss) <+ 2.9999999999999998e-14 * ddt(V(cpphdl_n1639, Vss)); // Bench initial voltage = 0.0 V.
        // device 1239, IC IC213, analog/basic/strongarm_comparator.hpp:44
        I(cpphdl_n1640, Vss) <+ 2.9999999999999998e-14 * ddt(V(cpphdl_n1640, Vss)); // Bench initial voltage = 0.0 V.
        // device 1240, IC IC213, analog/basic/strongarm_comparator.hpp:45
        I(cpphdl_n1657, Vss) <+ 5.0000000000000002e-14 * ddt(V(cpphdl_n1657, Vss)); // Bench initial voltage = 0.0 V.
        // device 1241, IC IC213, analog/basic/strongarm_comparator.hpp:46
        I(cpphdl_n1653, Vss) <+ 5.0000000000000002e-14 * ddt(V(cpphdl_n1653, Vss)); // Bench initial voltage = 0.0 V.
        // device 1242, IC IC213, analog/basic/strongarm_comparator.hpp:47
        I(cpphdl_n1633, cpphdl_n1640) <+ 2e-14 * ddt(V(cpphdl_n1633, cpphdl_n1640)); // Bench initial voltage = 0.0 V.
        // device 1243, IC IC213, analog/basic/strongarm_comparator.hpp:48
        I(cpphdl_n1634, cpphdl_n1640) <+ 2e-14 * ddt(V(cpphdl_n1634, cpphdl_n1640)); // Bench initial voltage = 0.0 V.
        // device 1244, IC IC213, analog/basic/strongarm_comparator.hpp:49
        I(cpphdl_n1633, cpphdl_n1638) <+ 2.9999999999999998e-15 * ddt(V(cpphdl_n1633, cpphdl_n1638)); // Bench initial voltage = 0.0 V.
        // device 1245, IC IC213, analog/basic/strongarm_comparator.hpp:50
        I(cpphdl_n1634, cpphdl_n1639) <+ 2.9999999999999998e-15 * ddt(V(cpphdl_n1634, cpphdl_n1639)); // Bench initial voltage = 0.0 V.
        // device 1246, IC IC215, analog/basic/inverter.hpp:11
        I(cpphdl_n1661, Vdd) <+ cpphdl_channel(V(cpphdl_n1653, Vdd), V(cpphdl_n1661, Vdd), 0.001, 0.69999999999999996, -1.0);
        // device 1247, IC IC215, analog/basic/inverter.hpp:12
        I(cpphdl_n1661, Vss) <+ cpphdl_channel(V(cpphdl_n1653, Vss), V(cpphdl_n1661, Vss), 0.001, 0.69999999999999996, 1.0);
        // device 1248, IC IC217, analog/basic/inverter.hpp:11
        I(cpphdl_n1675, Vdd) <+ cpphdl_channel(V(cpphdl_n1661, Vdd), V(cpphdl_n1675, Vdd), 0.0040000000000000001, 0.69999999999999996, -1.0);
        // device 1249, IC IC217, analog/basic/inverter.hpp:12
        I(cpphdl_n1675, Vss) <+ cpphdl_channel(V(cpphdl_n1661, Vss), V(cpphdl_n1675, Vss), 0.0040000000000000001, 0.69999999999999996, 1.0);
        // device 1250, IC IC214, analog/basic/buffered_nand_latch.hpp:34
        I(cpphdl_n1653, Vss) <+ 2.0000000000000002e-15 * ddt(V(cpphdl_n1653, Vss)); // Bench initial voltage = 0.0 V.
        // device 1251, IC IC214, analog/basic/buffered_nand_latch.hpp:35
        I(cpphdl_n1653, cpphdl_n1661) <+ 1.0000000000000001e-15 * ddt(V(cpphdl_n1653, cpphdl_n1661)); // Bench initial voltage = 0.0 V.
        // device 1252, IC IC214, analog/basic/buffered_nand_latch.hpp:36
        I(cpphdl_n1661, Vss) <+ 5e-15 * ddt(V(cpphdl_n1661, Vss)); // Bench initial voltage = 0.0 V.
        // device 1253, IC IC214, analog/basic/buffered_nand_latch.hpp:37
        I(cpphdl_n1661, Vss) <+ 8.0000000000000006e-15 * ddt(V(cpphdl_n1661, Vss)); // Bench initial voltage = 0.0 V.
        // device 1254, IC IC214, analog/basic/buffered_nand_latch.hpp:38
        I(cpphdl_n1675, Vss) <+ 1e-14 * ddt(V(cpphdl_n1675, Vss)); // Bench initial voltage = 0.0 V.
        // device 1255, IC IC216, analog/basic/inverter.hpp:11
        I(cpphdl_n1665, Vdd) <+ cpphdl_channel(V(cpphdl_n1657, Vdd), V(cpphdl_n1665, Vdd), 0.001, 0.69999999999999996, -1.0);
        // device 1256, IC IC216, analog/basic/inverter.hpp:12
        I(cpphdl_n1665, Vss) <+ cpphdl_channel(V(cpphdl_n1657, Vss), V(cpphdl_n1665, Vss), 0.001, 0.69999999999999996, 1.0);
        // device 1257, IC IC218, analog/basic/inverter.hpp:11
        I(cpphdl_n1681, Vdd) <+ cpphdl_channel(V(cpphdl_n1665, Vdd), V(cpphdl_n1681, Vdd), 0.0040000000000000001, 0.69999999999999996, -1.0);
        // device 1258, IC IC218, analog/basic/inverter.hpp:12
        I(cpphdl_n1681, Vss) <+ cpphdl_channel(V(cpphdl_n1665, Vss), V(cpphdl_n1681, Vss), 0.0040000000000000001, 0.69999999999999996, 1.0);
        // device 1259, IC IC214, analog/basic/buffered_nand_latch.hpp:34
        I(cpphdl_n1657, Vss) <+ 2.0000000000000002e-15 * ddt(V(cpphdl_n1657, Vss)); // Bench initial voltage = 0.0 V.
        // device 1260, IC IC214, analog/basic/buffered_nand_latch.hpp:35
        I(cpphdl_n1657, cpphdl_n1665) <+ 1.0000000000000001e-15 * ddt(V(cpphdl_n1657, cpphdl_n1665)); // Bench initial voltage = 0.0 V.
        // device 1261, IC IC214, analog/basic/buffered_nand_latch.hpp:36
        I(cpphdl_n1665, Vss) <+ 5e-15 * ddt(V(cpphdl_n1665, Vss)); // Bench initial voltage = 0.0 V.
        // device 1262, IC IC214, analog/basic/buffered_nand_latch.hpp:37
        I(cpphdl_n1665, Vss) <+ 8.0000000000000006e-15 * ddt(V(cpphdl_n1665, Vss)); // Bench initial voltage = 0.0 V.
        // device 1263, IC IC214, analog/basic/buffered_nand_latch.hpp:38
        I(cpphdl_n1681, Vss) <+ 1e-14 * ddt(V(cpphdl_n1681, Vss)); // Bench initial voltage = 0.0 V.
        // device 1264, IC IC220, analog/basic/cmos_logic.hpp:17
        I(cpphdl_n2318, Vss) <+ 5.0000000000000002e-14 * ddt(V(cpphdl_n2318, Vss)); // Bench initial voltage = 0.0 V.
        // device 1265, IC IC220, analog/basic/cmos_logic.hpp:18
        I(cpphdl_n2318, Vdd) <+ cpphdl_channel(V(cpphdl_n1675, Vdd), V(cpphdl_n2318, Vdd), 0.01, 0.69999999999999996, -1.0);
        // device 1266, IC IC220, analog/basic/cmos_logic.hpp:19
        I(cpphdl_n2318, Vdd) <+ cpphdl_channel(V(cpphdl_n1683, Vdd), V(cpphdl_n2318, Vdd), 0.01, 0.69999999999999996, -1.0);
        // device 1267, IC IC220, analog/basic/cmos_logic.hpp:20
        I(cpphdl_n2318, cpphdl_n1678) <+ cpphdl_channel(V(cpphdl_n1675, cpphdl_n1678), V(cpphdl_n2318, cpphdl_n1678), 0.01, 0.69999999999999996, 1.0);
        // device 1268, IC IC220, analog/basic/cmos_logic.hpp:21
        I(cpphdl_n1678, Vss) <+ cpphdl_channel(V(cpphdl_n1683, Vss), V(cpphdl_n1678, Vss), 0.01, 0.69999999999999996, 1.0);
        // device 1269, IC IC220, analog/basic/cmos_logic.hpp:27
        I(cpphdl_n1678, Vss) <+ 1e-14 * ddt(V(cpphdl_n1678, Vss)); // Bench initial voltage = 0.0 V.
        // device 1270, IC IC221, analog/basic/cmos_logic.hpp:17
        I(cpphdl_n1683, Vss) <+ 5.0000000000000002e-14 * ddt(V(cpphdl_n1683, Vss)); // Bench initial voltage = 0.0 V.
        // device 1271, IC IC221, analog/basic/cmos_logic.hpp:18
        I(cpphdl_n1683, Vdd) <+ cpphdl_channel(V(cpphdl_n1681, Vdd), V(cpphdl_n1683, Vdd), 0.01, 0.69999999999999996, -1.0);
        // device 1272, IC IC221, analog/basic/cmos_logic.hpp:19
        I(cpphdl_n1683, Vdd) <+ cpphdl_channel(V(cpphdl_n2318, Vdd), V(cpphdl_n1683, Vdd), 0.01, 0.69999999999999996, -1.0);
        // device 1273, IC IC221, analog/basic/cmos_logic.hpp:20
        I(cpphdl_n1683, cpphdl_n1684) <+ cpphdl_channel(V(cpphdl_n1681, cpphdl_n1684), V(cpphdl_n1683, cpphdl_n1684), 0.01, 0.69999999999999996, 1.0);
        // device 1274, IC IC221, analog/basic/cmos_logic.hpp:21
        I(cpphdl_n1684, Vss) <+ cpphdl_channel(V(cpphdl_n2318, Vss), V(cpphdl_n1684, Vss), 0.01, 0.69999999999999996, 1.0);
        // device 1275, IC IC221, analog/basic/cmos_logic.hpp:27
        I(cpphdl_n1684, Vss) <+ 1e-14 * ddt(V(cpphdl_n1684, Vss)); // Bench initial voltage = 0.0 V.
        // device 1276, IC IC219, analog/basic/nand_latch.hpp:36
        I(cpphdl_n1675, Vss) <+ 2.9999999999999998e-15 * ddt(V(cpphdl_n1675, Vss)); // Bench initial voltage = 0.0 V.
        // device 1277, IC IC219, analog/basic/nand_latch.hpp:37
        I(cpphdl_n1681, Vss) <+ 2.9999999999999998e-15 * ddt(V(cpphdl_n1681, Vss)); // Bench initial voltage = 0.0 V.
        // device 1278, IC IC222, analog/basic/inverter.hpp:11
        I(cpphdl_n1689, Vdd) <+ cpphdl_channel(V(CLEAR, Vdd), V(cpphdl_n1689, Vdd), 0.01, 0.69999999999999996, -1.0);
        // device 1279, IC IC222, analog/basic/inverter.hpp:12
        I(cpphdl_n1689, Vss) <+ cpphdl_channel(V(CLEAR, Vss), V(cpphdl_n1689, Vss), 0.01, 0.69999999999999996, 1.0);
        // device 1280, IC IC219, analog/basic/nand_latch.hpp:58
        I(cpphdl_n1689, Vss) <+ 2.9999999999999998e-15 * ddt(V(cpphdl_n1689, Vss)); // Bench initial voltage = 0.0 V.
        // device 1281, IC IC219, analog/basic/nand_latch.hpp:59
        I(cpphdl_n2318, Vss) <+ cpphdl_channel(V(CLEAR, Vss), V(cpphdl_n2318, Vss), 0.050000000000000003, 0.69999999999999996, 1.0);
        // device 1282, IC IC219, analog/basic/nand_latch.hpp:60
        I(cpphdl_n1683, Vdd) <+ cpphdl_channel(V(cpphdl_n1689, Vdd), V(cpphdl_n1683, Vdd), 0.050000000000000003, 0.69999999999999996, -1.0);
        // device 1283, IC IC225, analog/basic/inverter.hpp:11
        I(cpphdl_n1713, Vdd) <+ cpphdl_channel(V(TRACK9, Vdd), V(cpphdl_n1713, Vdd), 0.0040000000000000001, 0.69999999999999996, -1.0);
        // device 1284, IC IC225, analog/basic/inverter.hpp:12
        I(cpphdl_n1713, Vss) <+ cpphdl_channel(V(TRACK9, Vss), V(cpphdl_n1713, Vss), 0.0040000000000000001, 0.69999999999999996, 1.0);
        // device 1285, IC IC224, analog/basic/mos_track_hold.hpp:31
        I(cpphdl_n1713, Vss) <+ 2e-14 * ddt(V(cpphdl_n1713, Vss)); // Bench initial voltage = 0.0 V.
        // device 1286, IC IC224, analog/basic/mos_track_hold.hpp:32
        I(cpphdl_n2136, cpphdl_n1767) <+ cpphdl_channel(V(TRACK9, cpphdl_n1767), V(cpphdl_n2136, cpphdl_n1767), 0.029999999999999999, 0.69999999999999996, 1.0);
        // device 1287, IC IC224, analog/basic/mos_track_hold.hpp:33
        I(cpphdl_n1767, cpphdl_n2136) <+ cpphdl_channel(V(cpphdl_n1713, cpphdl_n2136), V(cpphdl_n1767, cpphdl_n2136), 0.014999999999999999, 0.69999999999999996, -1.0);
        // device 1288, IC IC224, analog/basic/mos_track_hold.hpp:37
        I(cpphdl_n1767, cpphdl_n1767) <+ cpphdl_channel(V(cpphdl_n1713, cpphdl_n1767), V(cpphdl_n1767, cpphdl_n1767), 0.016, 0.69999999999999996, 1.0);
        // device 1289, IC IC224, analog/basic/mos_track_hold.hpp:38
        I(cpphdl_n1767, cpphdl_n1767) <+ cpphdl_channel(V(TRACK9, cpphdl_n1767), V(cpphdl_n1767, cpphdl_n1767), 0.0083999999999999995, 0.69999999999999996, -1.0);
        // device 1290, IC IC224, analog/basic/mos_track_hold.hpp:39
        I(cpphdl_n1767, Vss) <+ 1.5000000000000001e-12 * ddt(V(cpphdl_n1767, Vss)); // Bench initial voltage = 0.0 V.
        // device 1291, IC IC224, analog/basic/mos_track_hold.hpp:42
        I(TRACK9, cpphdl_n1767) <+ 2.0000000000000002e-15 * ddt(V(TRACK9, cpphdl_n1767)); // Bench initial voltage = -0.0 V.
        // device 1292, IC IC224, analog/basic/mos_track_hold.hpp:43
        I(cpphdl_n1713, cpphdl_n1767) <+ 2.0000000000000002e-15 * ddt(V(cpphdl_n1713, cpphdl_n1767)); // Bench initial voltage = 0.0 V.
        // device 1293, IC IC224, analog/basic/mos_track_hold.hpp:44
        I(cpphdl_n2136, cpphdl_n1767) <+ 1.0000000000000001e-15 * ddt(V(cpphdl_n2136, cpphdl_n1767)); // Bench initial voltage = 0.0 V.
        // device 1294, IC IC227, analog/basic/inverter.hpp:11
        I(cpphdl_n1728, Vdd) <+ cpphdl_channel(V(BIT_N9_0, Vdd), V(cpphdl_n1728, Vdd), 0.080000000000000002, 0.69999999999999996, -1.0);
        // device 1295, IC IC227, analog/basic/inverter.hpp:12
        I(cpphdl_n1728, Vss) <+ cpphdl_channel(V(BIT_N9_0, Vss), V(cpphdl_n1728, Vss), 0.080000000000000002, 0.69999999999999996, 1.0);
        // device 1296, IC IC226, analog/basic/mos_r2r_dac.hpp:27
        I(cpphdl_n1728, Vss) <+ 2.9999999999999998e-15 * ddt(V(cpphdl_n1728, Vss)); // Bench initial voltage = 0.0 V.
        // device 1297, IC IC226, analog/basic/mos_r2r_dac.hpp:28
        I(cpphdl_n1728, cpphdl_n1757) <+ V(cpphdl_n1728, cpphdl_n1757) / 2000.0;
        // device 1298, IC IC226, analog/basic/mos_r2r_dac.hpp:29
        I(cpphdl_n1757, Vss) <+ 2.9999999999999998e-15 * ddt(V(cpphdl_n1757, Vss)); // Bench initial voltage = 0.0 V.
        // device 1299, IC IC228, analog/basic/inverter.hpp:11
        I(cpphdl_n1732, Vdd) <+ cpphdl_channel(V(BIT_N9_1, Vdd), V(cpphdl_n1732, Vdd), 0.080000000000000002, 0.69999999999999996, -1.0);
        // device 1300, IC IC228, analog/basic/inverter.hpp:12
        I(cpphdl_n1732, Vss) <+ cpphdl_channel(V(BIT_N9_1, Vss), V(cpphdl_n1732, Vss), 0.080000000000000002, 0.69999999999999996, 1.0);
        // device 1301, IC IC226, analog/basic/mos_r2r_dac.hpp:27
        I(cpphdl_n1732, Vss) <+ 2.9999999999999998e-15 * ddt(V(cpphdl_n1732, Vss)); // Bench initial voltage = 0.0 V.
        // device 1302, IC IC226, analog/basic/mos_r2r_dac.hpp:28
        I(cpphdl_n1732, cpphdl_n1758) <+ V(cpphdl_n1732, cpphdl_n1758) / 2000.0;
        // device 1303, IC IC226, analog/basic/mos_r2r_dac.hpp:29
        I(cpphdl_n1758, Vss) <+ 2.9999999999999998e-15 * ddt(V(cpphdl_n1758, Vss)); // Bench initial voltage = 0.0 V.
        // device 1304, IC IC226, analog/basic/mos_r2r_dac.hpp:31
        I(cpphdl_n1757, cpphdl_n1758) <+ V(cpphdl_n1757, cpphdl_n1758) / 1000.0;
        // device 1305, IC IC229, analog/basic/inverter.hpp:11
        I(cpphdl_n1736, Vdd) <+ cpphdl_channel(V(BIT_N9_2, Vdd), V(cpphdl_n1736, Vdd), 0.080000000000000002, 0.69999999999999996, -1.0);
        // device 1306, IC IC229, analog/basic/inverter.hpp:12
        I(cpphdl_n1736, Vss) <+ cpphdl_channel(V(BIT_N9_2, Vss), V(cpphdl_n1736, Vss), 0.080000000000000002, 0.69999999999999996, 1.0);
        // device 1307, IC IC226, analog/basic/mos_r2r_dac.hpp:27
        I(cpphdl_n1736, Vss) <+ 2.9999999999999998e-15 * ddt(V(cpphdl_n1736, Vss)); // Bench initial voltage = 0.0 V.
        // device 1308, IC IC226, analog/basic/mos_r2r_dac.hpp:28
        I(cpphdl_n1736, cpphdl_n1759) <+ V(cpphdl_n1736, cpphdl_n1759) / 2000.0;
        // device 1309, IC IC226, analog/basic/mos_r2r_dac.hpp:29
        I(cpphdl_n1759, Vss) <+ 2.9999999999999998e-15 * ddt(V(cpphdl_n1759, Vss)); // Bench initial voltage = 0.0 V.
        // device 1310, IC IC226, analog/basic/mos_r2r_dac.hpp:31
        I(cpphdl_n1758, cpphdl_n1759) <+ V(cpphdl_n1758, cpphdl_n1759) / 1000.0;
        // device 1311, IC IC230, analog/basic/inverter.hpp:11
        I(cpphdl_n1740, Vdd) <+ cpphdl_channel(V(BIT_N9_3, Vdd), V(cpphdl_n1740, Vdd), 0.080000000000000002, 0.69999999999999996, -1.0);
        // device 1312, IC IC230, analog/basic/inverter.hpp:12
        I(cpphdl_n1740, Vss) <+ cpphdl_channel(V(BIT_N9_3, Vss), V(cpphdl_n1740, Vss), 0.080000000000000002, 0.69999999999999996, 1.0);
        // device 1313, IC IC226, analog/basic/mos_r2r_dac.hpp:27
        I(cpphdl_n1740, Vss) <+ 2.9999999999999998e-15 * ddt(V(cpphdl_n1740, Vss)); // Bench initial voltage = 0.0 V.
        // device 1314, IC IC226, analog/basic/mos_r2r_dac.hpp:28
        I(cpphdl_n1740, cpphdl_n1760) <+ V(cpphdl_n1740, cpphdl_n1760) / 2000.0;
        // device 1315, IC IC226, analog/basic/mos_r2r_dac.hpp:29
        I(cpphdl_n1760, Vss) <+ 2.9999999999999998e-15 * ddt(V(cpphdl_n1760, Vss)); // Bench initial voltage = 0.0 V.
        // device 1316, IC IC226, analog/basic/mos_r2r_dac.hpp:31
        I(cpphdl_n1759, cpphdl_n1760) <+ V(cpphdl_n1759, cpphdl_n1760) / 1000.0;
        // device 1317, IC IC231, analog/basic/inverter.hpp:11
        I(cpphdl_n1744, Vdd) <+ cpphdl_channel(V(BIT_N9_4, Vdd), V(cpphdl_n1744, Vdd), 0.080000000000000002, 0.69999999999999996, -1.0);
        // device 1318, IC IC231, analog/basic/inverter.hpp:12
        I(cpphdl_n1744, Vss) <+ cpphdl_channel(V(BIT_N9_4, Vss), V(cpphdl_n1744, Vss), 0.080000000000000002, 0.69999999999999996, 1.0);
        // device 1319, IC IC226, analog/basic/mos_r2r_dac.hpp:27
        I(cpphdl_n1744, Vss) <+ 2.9999999999999998e-15 * ddt(V(cpphdl_n1744, Vss)); // Bench initial voltage = 0.0 V.
        // device 1320, IC IC226, analog/basic/mos_r2r_dac.hpp:28
        I(cpphdl_n1744, cpphdl_n1761) <+ V(cpphdl_n1744, cpphdl_n1761) / 2000.0;
        // device 1321, IC IC226, analog/basic/mos_r2r_dac.hpp:29
        I(cpphdl_n1761, Vss) <+ 2.9999999999999998e-15 * ddt(V(cpphdl_n1761, Vss)); // Bench initial voltage = 0.0 V.
        // device 1322, IC IC226, analog/basic/mos_r2r_dac.hpp:31
        I(cpphdl_n1760, cpphdl_n1761) <+ V(cpphdl_n1760, cpphdl_n1761) / 1000.0;
        // device 1323, IC IC232, analog/basic/inverter.hpp:11
        I(cpphdl_n1748, Vdd) <+ cpphdl_channel(V(BIT_N9_5, Vdd), V(cpphdl_n1748, Vdd), 0.080000000000000002, 0.69999999999999996, -1.0);
        // device 1324, IC IC232, analog/basic/inverter.hpp:12
        I(cpphdl_n1748, Vss) <+ cpphdl_channel(V(BIT_N9_5, Vss), V(cpphdl_n1748, Vss), 0.080000000000000002, 0.69999999999999996, 1.0);
        // device 1325, IC IC226, analog/basic/mos_r2r_dac.hpp:27
        I(cpphdl_n1748, Vss) <+ 2.9999999999999998e-15 * ddt(V(cpphdl_n1748, Vss)); // Bench initial voltage = 0.0 V.
        // device 1326, IC IC226, analog/basic/mos_r2r_dac.hpp:28
        I(cpphdl_n1748, cpphdl_n1762) <+ V(cpphdl_n1748, cpphdl_n1762) / 2000.0;
        // device 1327, IC IC226, analog/basic/mos_r2r_dac.hpp:29
        I(cpphdl_n1762, Vss) <+ 2.9999999999999998e-15 * ddt(V(cpphdl_n1762, Vss)); // Bench initial voltage = 0.0 V.
        // device 1328, IC IC226, analog/basic/mos_r2r_dac.hpp:31
        I(cpphdl_n1761, cpphdl_n1762) <+ V(cpphdl_n1761, cpphdl_n1762) / 1000.0;
        // device 1329, IC IC233, analog/basic/inverter.hpp:11
        I(cpphdl_n1752, Vdd) <+ cpphdl_channel(V(BIT_N9_6, Vdd), V(cpphdl_n1752, Vdd), 0.080000000000000002, 0.69999999999999996, -1.0);
        // device 1330, IC IC233, analog/basic/inverter.hpp:12
        I(cpphdl_n1752, Vss) <+ cpphdl_channel(V(BIT_N9_6, Vss), V(cpphdl_n1752, Vss), 0.080000000000000002, 0.69999999999999996, 1.0);
        // device 1331, IC IC226, analog/basic/mos_r2r_dac.hpp:27
        I(cpphdl_n1752, Vss) <+ 2.9999999999999998e-15 * ddt(V(cpphdl_n1752, Vss)); // Bench initial voltage = 0.0 V.
        // device 1332, IC IC226, analog/basic/mos_r2r_dac.hpp:28
        I(cpphdl_n1752, cpphdl_n1763) <+ V(cpphdl_n1752, cpphdl_n1763) / 2000.0;
        // device 1333, IC IC226, analog/basic/mos_r2r_dac.hpp:29
        I(cpphdl_n1763, Vss) <+ 2.9999999999999998e-15 * ddt(V(cpphdl_n1763, Vss)); // Bench initial voltage = 0.0 V.
        // device 1334, IC IC226, analog/basic/mos_r2r_dac.hpp:31
        I(cpphdl_n1762, cpphdl_n1763) <+ V(cpphdl_n1762, cpphdl_n1763) / 1000.0;
        // device 1335, IC IC234, analog/basic/inverter.hpp:11
        I(cpphdl_n1756, Vdd) <+ cpphdl_channel(V(BIT_N9_7, Vdd), V(cpphdl_n1756, Vdd), 0.080000000000000002, 0.69999999999999996, -1.0);
        // device 1336, IC IC234, analog/basic/inverter.hpp:12
        I(cpphdl_n1756, Vss) <+ cpphdl_channel(V(BIT_N9_7, Vss), V(cpphdl_n1756, Vss), 0.080000000000000002, 0.69999999999999996, 1.0);
        // device 1337, IC IC226, analog/basic/mos_r2r_dac.hpp:27
        I(cpphdl_n1756, Vss) <+ 2.9999999999999998e-15 * ddt(V(cpphdl_n1756, Vss)); // Bench initial voltage = 0.0 V.
        // device 1338, IC IC226, analog/basic/mos_r2r_dac.hpp:28
        I(cpphdl_n1756, cpphdl_n1768) <+ V(cpphdl_n1756, cpphdl_n1768) / 2000.0;
        // device 1339, IC IC226, analog/basic/mos_r2r_dac.hpp:29
        I(cpphdl_n1768, Vss) <+ 2.9999999999999998e-15 * ddt(V(cpphdl_n1768, Vss)); // Bench initial voltage = 0.0 V.
        // device 1340, IC IC226, analog/basic/mos_r2r_dac.hpp:31
        I(cpphdl_n1763, cpphdl_n1768) <+ V(cpphdl_n1763, cpphdl_n1768) / 1000.0;
        // device 1341, IC IC226, analog/basic/mos_r2r_dac.hpp:33
        I(Vss, cpphdl_n1757) <+ V(Vss, cpphdl_n1757) / 2000.0;
        // device 1342, IC IC235, analog/basic/nmos_resistor_amplifier.hpp:23
        I(Vdd, cpphdl_n1777) <+ V(Vdd, cpphdl_n1777) / 1000.0;
        // device 1343, IC IC235, analog/basic/nmos_resistor_amplifier.hpp:24
        I(Vdd, cpphdl_n1776) <+ V(Vdd, cpphdl_n1776) / 1000.0;
        // device 1344, IC IC235, analog/basic/nmos_resistor_amplifier.hpp:25
        I(cpphdl_n1777, cpphdl_n1771) <+ cpphdl_channel(V(cpphdl_n1767, cpphdl_n1771), V(cpphdl_n1777, cpphdl_n1771), 0.0074999999999999997, 0.69999999999999996, 1.0);
        // device 1345, IC IC235, analog/basic/nmos_resistor_amplifier.hpp:26
        I(cpphdl_n1776, cpphdl_n1772) <+ cpphdl_channel(V(cpphdl_n1768, cpphdl_n1772), V(cpphdl_n1776, cpphdl_n1772), 0.0074999999999999997, 0.69999999999999996, 1.0);
        // device 1346, IC IC235, analog/basic/nmos_resistor_amplifier.hpp:27
        I(cpphdl_n1773, cpphdl_n1771) <+ V(cpphdl_n1773, cpphdl_n1771) / 100.0;
        // device 1347, IC IC235, analog/basic/nmos_resistor_amplifier.hpp:28
        I(cpphdl_n1773, cpphdl_n1772) <+ V(cpphdl_n1773, cpphdl_n1772) / 100.0;
        // device 1348, IC IC235, analog/basic/nmos_resistor_amplifier.hpp:29
        I(Vss, cpphdl_n1773) <+ V(Vss, cpphdl_n1773) / 300.0;
        // device 1349, IC IC235, analog/basic/nmos_resistor_amplifier.hpp:30
        I(cpphdl_n1777, Vdd) <+ 2.9999999999999998e-13 * ddt(V(cpphdl_n1777, Vdd)); // Bench initial voltage = 0.0 V.
        // device 1350, IC IC235, analog/basic/nmos_resistor_amplifier.hpp:31
        I(cpphdl_n1776, Vdd) <+ 2.9999999999999998e-13 * ddt(V(cpphdl_n1776, Vdd)); // Bench initial voltage = 0.0 V.
        // device 1351, IC IC235, analog/basic/nmos_resistor_amplifier.hpp:32
        I(cpphdl_n1773, Vss) <+ 4e-14 * ddt(V(cpphdl_n1773, Vss)); // Bench initial voltage = 0.0 V.
        // device 1352, IC IC235, analog/basic/nmos_resistor_amplifier.hpp:34
        I(cpphdl_n1767, cpphdl_n1771) <+ 2e-14 * ddt(V(cpphdl_n1767, cpphdl_n1771)); // Bench initial voltage = 0.0 V.
        // device 1353, IC IC235, analog/basic/nmos_resistor_amplifier.hpp:35
        I(cpphdl_n1768, cpphdl_n1772) <+ 2e-14 * ddt(V(cpphdl_n1768, cpphdl_n1772)); // Bench initial voltage = 0.0 V.
        // device 1354, IC IC235, analog/basic/nmos_resistor_amplifier.hpp:36
        I(cpphdl_n1767, cpphdl_n1777) <+ 2.9999999999999998e-15 * ddt(V(cpphdl_n1767, cpphdl_n1777)); // Bench initial voltage = 0.0 V.
        // device 1355, IC IC235, analog/basic/nmos_resistor_amplifier.hpp:37
        I(cpphdl_n1768, cpphdl_n1776) <+ 2.9999999999999998e-15 * ddt(V(cpphdl_n1768, cpphdl_n1776)); // Bench initial voltage = 0.0 V.
        // device 1356, IC IC236, analog/basic/strongarm_comparator.hpp:28
        I(cpphdl_n1781, cpphdl_n1783) <+ cpphdl_channel(V(cpphdl_n1776, cpphdl_n1783), V(cpphdl_n1781, cpphdl_n1783), 0.0080000000000000002, 0.69999999999999996, 1.0);
        // device 1357, IC IC236, analog/basic/strongarm_comparator.hpp:29
        I(cpphdl_n1782, cpphdl_n1783) <+ cpphdl_channel(V(cpphdl_n1777, cpphdl_n1783), V(cpphdl_n1782, cpphdl_n1783), 0.0080000000000000002, 0.69999999999999996, 1.0);
        // device 1358, IC IC236, analog/basic/strongarm_comparator.hpp:30
        I(cpphdl_n1783, Vss) <+ cpphdl_channel(V(EVALUATE, Vss), V(cpphdl_n1783, Vss), 0.0080000000000000002, 0.69999999999999996, 1.0);
        // device 1359, IC IC236, analog/basic/strongarm_comparator.hpp:33
        I(cpphdl_n1796, cpphdl_n1781) <+ cpphdl_channel(V(cpphdl_n1800, cpphdl_n1781), V(cpphdl_n1796, cpphdl_n1781), 0.0040000000000000001, 0.69999999999999996, 1.0);
        // device 1360, IC IC236, analog/basic/strongarm_comparator.hpp:34
        I(cpphdl_n1800, cpphdl_n1782) <+ cpphdl_channel(V(cpphdl_n1796, cpphdl_n1782), V(cpphdl_n1800, cpphdl_n1782), 0.0040000000000000001, 0.69999999999999996, 1.0);
        // device 1361, IC IC236, analog/basic/strongarm_comparator.hpp:35
        I(cpphdl_n1800, Vdd) <+ cpphdl_channel(V(cpphdl_n1796, Vdd), V(cpphdl_n1800, Vdd), 0.002, 0.69999999999999996, -1.0);
        // device 1362, IC IC236, analog/basic/strongarm_comparator.hpp:36
        I(cpphdl_n1796, Vdd) <+ cpphdl_channel(V(cpphdl_n1800, Vdd), V(cpphdl_n1796, Vdd), 0.002, 0.69999999999999996, -1.0);
        // device 1363, IC IC236, analog/basic/strongarm_comparator.hpp:38
        I(cpphdl_n1781, Vdd) <+ cpphdl_channel(V(EVALUATE, Vdd), V(cpphdl_n1781, Vdd), 0.002, 0.69999999999999996, -1.0);
        // device 1364, IC IC236, analog/basic/strongarm_comparator.hpp:39
        I(cpphdl_n1782, Vdd) <+ cpphdl_channel(V(EVALUATE, Vdd), V(cpphdl_n1782, Vdd), 0.002, 0.69999999999999996, -1.0);
        // device 1365, IC IC236, analog/basic/strongarm_comparator.hpp:40
        I(cpphdl_n1800, Vdd) <+ cpphdl_channel(V(EVALUATE, Vdd), V(cpphdl_n1800, Vdd), 0.002, 0.69999999999999996, -1.0);
        // device 1366, IC IC236, analog/basic/strongarm_comparator.hpp:41
        I(cpphdl_n1796, Vdd) <+ cpphdl_channel(V(EVALUATE, Vdd), V(cpphdl_n1796, Vdd), 0.002, 0.69999999999999996, -1.0);
        // device 1367, IC IC236, analog/basic/strongarm_comparator.hpp:42
        I(cpphdl_n1781, Vss) <+ 2.9999999999999998e-14 * ddt(V(cpphdl_n1781, Vss)); // Bench initial voltage = 0.0 V.
        // device 1368, IC IC236, analog/basic/strongarm_comparator.hpp:43
        I(cpphdl_n1782, Vss) <+ 2.9999999999999998e-14 * ddt(V(cpphdl_n1782, Vss)); // Bench initial voltage = 0.0 V.
        // device 1369, IC IC236, analog/basic/strongarm_comparator.hpp:44
        I(cpphdl_n1783, Vss) <+ 2.9999999999999998e-14 * ddt(V(cpphdl_n1783, Vss)); // Bench initial voltage = 0.0 V.
        // device 1370, IC IC236, analog/basic/strongarm_comparator.hpp:45
        I(cpphdl_n1800, Vss) <+ 5.0000000000000002e-14 * ddt(V(cpphdl_n1800, Vss)); // Bench initial voltage = 0.0 V.
        // device 1371, IC IC236, analog/basic/strongarm_comparator.hpp:46
        I(cpphdl_n1796, Vss) <+ 5.0000000000000002e-14 * ddt(V(cpphdl_n1796, Vss)); // Bench initial voltage = 0.0 V.
        // device 1372, IC IC236, analog/basic/strongarm_comparator.hpp:47
        I(cpphdl_n1776, cpphdl_n1783) <+ 2e-14 * ddt(V(cpphdl_n1776, cpphdl_n1783)); // Bench initial voltage = 0.0 V.
        // device 1373, IC IC236, analog/basic/strongarm_comparator.hpp:48
        I(cpphdl_n1777, cpphdl_n1783) <+ 2e-14 * ddt(V(cpphdl_n1777, cpphdl_n1783)); // Bench initial voltage = 0.0 V.
        // device 1374, IC IC236, analog/basic/strongarm_comparator.hpp:49
        I(cpphdl_n1776, cpphdl_n1781) <+ 2.9999999999999998e-15 * ddt(V(cpphdl_n1776, cpphdl_n1781)); // Bench initial voltage = 0.0 V.
        // device 1375, IC IC236, analog/basic/strongarm_comparator.hpp:50
        I(cpphdl_n1777, cpphdl_n1782) <+ 2.9999999999999998e-15 * ddt(V(cpphdl_n1777, cpphdl_n1782)); // Bench initial voltage = 0.0 V.
        // device 1376, IC IC238, analog/basic/inverter.hpp:11
        I(cpphdl_n1804, Vdd) <+ cpphdl_channel(V(cpphdl_n1796, Vdd), V(cpphdl_n1804, Vdd), 0.001, 0.69999999999999996, -1.0);
        // device 1377, IC IC238, analog/basic/inverter.hpp:12
        I(cpphdl_n1804, Vss) <+ cpphdl_channel(V(cpphdl_n1796, Vss), V(cpphdl_n1804, Vss), 0.001, 0.69999999999999996, 1.0);
        // device 1378, IC IC240, analog/basic/inverter.hpp:11
        I(cpphdl_n1818, Vdd) <+ cpphdl_channel(V(cpphdl_n1804, Vdd), V(cpphdl_n1818, Vdd), 0.0040000000000000001, 0.69999999999999996, -1.0);
        // device 1379, IC IC240, analog/basic/inverter.hpp:12
        I(cpphdl_n1818, Vss) <+ cpphdl_channel(V(cpphdl_n1804, Vss), V(cpphdl_n1818, Vss), 0.0040000000000000001, 0.69999999999999996, 1.0);
        // device 1380, IC IC237, analog/basic/buffered_nand_latch.hpp:34
        I(cpphdl_n1796, Vss) <+ 2.0000000000000002e-15 * ddt(V(cpphdl_n1796, Vss)); // Bench initial voltage = 0.0 V.
        // device 1381, IC IC237, analog/basic/buffered_nand_latch.hpp:35
        I(cpphdl_n1796, cpphdl_n1804) <+ 1.0000000000000001e-15 * ddt(V(cpphdl_n1796, cpphdl_n1804)); // Bench initial voltage = 0.0 V.
        // device 1382, IC IC237, analog/basic/buffered_nand_latch.hpp:36
        I(cpphdl_n1804, Vss) <+ 5e-15 * ddt(V(cpphdl_n1804, Vss)); // Bench initial voltage = 0.0 V.
        // device 1383, IC IC237, analog/basic/buffered_nand_latch.hpp:37
        I(cpphdl_n1804, Vss) <+ 8.0000000000000006e-15 * ddt(V(cpphdl_n1804, Vss)); // Bench initial voltage = 0.0 V.
        // device 1384, IC IC237, analog/basic/buffered_nand_latch.hpp:38
        I(cpphdl_n1818, Vss) <+ 1e-14 * ddt(V(cpphdl_n1818, Vss)); // Bench initial voltage = 0.0 V.
        // device 1385, IC IC239, analog/basic/inverter.hpp:11
        I(cpphdl_n1808, Vdd) <+ cpphdl_channel(V(cpphdl_n1800, Vdd), V(cpphdl_n1808, Vdd), 0.001, 0.69999999999999996, -1.0);
        // device 1386, IC IC239, analog/basic/inverter.hpp:12
        I(cpphdl_n1808, Vss) <+ cpphdl_channel(V(cpphdl_n1800, Vss), V(cpphdl_n1808, Vss), 0.001, 0.69999999999999996, 1.0);
        // device 1387, IC IC241, analog/basic/inverter.hpp:11
        I(cpphdl_n1824, Vdd) <+ cpphdl_channel(V(cpphdl_n1808, Vdd), V(cpphdl_n1824, Vdd), 0.0040000000000000001, 0.69999999999999996, -1.0);
        // device 1388, IC IC241, analog/basic/inverter.hpp:12
        I(cpphdl_n1824, Vss) <+ cpphdl_channel(V(cpphdl_n1808, Vss), V(cpphdl_n1824, Vss), 0.0040000000000000001, 0.69999999999999996, 1.0);
        // device 1389, IC IC237, analog/basic/buffered_nand_latch.hpp:34
        I(cpphdl_n1800, Vss) <+ 2.0000000000000002e-15 * ddt(V(cpphdl_n1800, Vss)); // Bench initial voltage = 0.0 V.
        // device 1390, IC IC237, analog/basic/buffered_nand_latch.hpp:35
        I(cpphdl_n1800, cpphdl_n1808) <+ 1.0000000000000001e-15 * ddt(V(cpphdl_n1800, cpphdl_n1808)); // Bench initial voltage = 0.0 V.
        // device 1391, IC IC237, analog/basic/buffered_nand_latch.hpp:36
        I(cpphdl_n1808, Vss) <+ 5e-15 * ddt(V(cpphdl_n1808, Vss)); // Bench initial voltage = 0.0 V.
        // device 1392, IC IC237, analog/basic/buffered_nand_latch.hpp:37
        I(cpphdl_n1808, Vss) <+ 8.0000000000000006e-15 * ddt(V(cpphdl_n1808, Vss)); // Bench initial voltage = 0.0 V.
        // device 1393, IC IC237, analog/basic/buffered_nand_latch.hpp:38
        I(cpphdl_n1824, Vss) <+ 1e-14 * ddt(V(cpphdl_n1824, Vss)); // Bench initial voltage = 0.0 V.
        // device 1394, IC IC243, analog/basic/cmos_logic.hpp:17
        I(cpphdl_n2323, Vss) <+ 5.0000000000000002e-14 * ddt(V(cpphdl_n2323, Vss)); // Bench initial voltage = 0.0 V.
        // device 1395, IC IC243, analog/basic/cmos_logic.hpp:18
        I(cpphdl_n2323, Vdd) <+ cpphdl_channel(V(cpphdl_n1818, Vdd), V(cpphdl_n2323, Vdd), 0.01, 0.69999999999999996, -1.0);
        // device 1396, IC IC243, analog/basic/cmos_logic.hpp:19
        I(cpphdl_n2323, Vdd) <+ cpphdl_channel(V(cpphdl_n1826, Vdd), V(cpphdl_n2323, Vdd), 0.01, 0.69999999999999996, -1.0);
        // device 1397, IC IC243, analog/basic/cmos_logic.hpp:20
        I(cpphdl_n2323, cpphdl_n1821) <+ cpphdl_channel(V(cpphdl_n1818, cpphdl_n1821), V(cpphdl_n2323, cpphdl_n1821), 0.01, 0.69999999999999996, 1.0);
        // device 1398, IC IC243, analog/basic/cmos_logic.hpp:21
        I(cpphdl_n1821, Vss) <+ cpphdl_channel(V(cpphdl_n1826, Vss), V(cpphdl_n1821, Vss), 0.01, 0.69999999999999996, 1.0);
        // device 1399, IC IC243, analog/basic/cmos_logic.hpp:27
        I(cpphdl_n1821, Vss) <+ 1e-14 * ddt(V(cpphdl_n1821, Vss)); // Bench initial voltage = 0.0 V.
        // device 1400, IC IC244, analog/basic/cmos_logic.hpp:17
        I(cpphdl_n1826, Vss) <+ 5.0000000000000002e-14 * ddt(V(cpphdl_n1826, Vss)); // Bench initial voltage = 0.0 V.
        // device 1401, IC IC244, analog/basic/cmos_logic.hpp:18
        I(cpphdl_n1826, Vdd) <+ cpphdl_channel(V(cpphdl_n1824, Vdd), V(cpphdl_n1826, Vdd), 0.01, 0.69999999999999996, -1.0);
        // device 1402, IC IC244, analog/basic/cmos_logic.hpp:19
        I(cpphdl_n1826, Vdd) <+ cpphdl_channel(V(cpphdl_n2323, Vdd), V(cpphdl_n1826, Vdd), 0.01, 0.69999999999999996, -1.0);
        // device 1403, IC IC244, analog/basic/cmos_logic.hpp:20
        I(cpphdl_n1826, cpphdl_n1827) <+ cpphdl_channel(V(cpphdl_n1824, cpphdl_n1827), V(cpphdl_n1826, cpphdl_n1827), 0.01, 0.69999999999999996, 1.0);
        // device 1404, IC IC244, analog/basic/cmos_logic.hpp:21
        I(cpphdl_n1827, Vss) <+ cpphdl_channel(V(cpphdl_n2323, Vss), V(cpphdl_n1827, Vss), 0.01, 0.69999999999999996, 1.0);
        // device 1405, IC IC244, analog/basic/cmos_logic.hpp:27
        I(cpphdl_n1827, Vss) <+ 1e-14 * ddt(V(cpphdl_n1827, Vss)); // Bench initial voltage = 0.0 V.
        // device 1406, IC IC242, analog/basic/nand_latch.hpp:36
        I(cpphdl_n1818, Vss) <+ 2.9999999999999998e-15 * ddt(V(cpphdl_n1818, Vss)); // Bench initial voltage = 0.0 V.
        // device 1407, IC IC242, analog/basic/nand_latch.hpp:37
        I(cpphdl_n1824, Vss) <+ 2.9999999999999998e-15 * ddt(V(cpphdl_n1824, Vss)); // Bench initial voltage = 0.0 V.
        // device 1408, IC IC245, analog/basic/inverter.hpp:11
        I(cpphdl_n1832, Vdd) <+ cpphdl_channel(V(CLEAR, Vdd), V(cpphdl_n1832, Vdd), 0.01, 0.69999999999999996, -1.0);
        // device 1409, IC IC245, analog/basic/inverter.hpp:12
        I(cpphdl_n1832, Vss) <+ cpphdl_channel(V(CLEAR, Vss), V(cpphdl_n1832, Vss), 0.01, 0.69999999999999996, 1.0);
        // device 1410, IC IC242, analog/basic/nand_latch.hpp:58
        I(cpphdl_n1832, Vss) <+ 2.9999999999999998e-15 * ddt(V(cpphdl_n1832, Vss)); // Bench initial voltage = 0.0 V.
        // device 1411, IC IC242, analog/basic/nand_latch.hpp:59
        I(cpphdl_n2323, Vss) <+ cpphdl_channel(V(CLEAR, Vss), V(cpphdl_n2323, Vss), 0.050000000000000003, 0.69999999999999996, 1.0);
        // device 1412, IC IC242, analog/basic/nand_latch.hpp:60
        I(cpphdl_n1826, Vdd) <+ cpphdl_channel(V(cpphdl_n1832, Vdd), V(cpphdl_n1826, Vdd), 0.050000000000000003, 0.69999999999999996, -1.0);
        // device 1413, IC IC248, analog/basic/inverter.hpp:11
        I(cpphdl_n1856, Vdd) <+ cpphdl_channel(V(TRACK10, Vdd), V(cpphdl_n1856, Vdd), 0.0040000000000000001, 0.69999999999999996, -1.0);
        // device 1414, IC IC248, analog/basic/inverter.hpp:12
        I(cpphdl_n1856, Vss) <+ cpphdl_channel(V(TRACK10, Vss), V(cpphdl_n1856, Vss), 0.0040000000000000001, 0.69999999999999996, 1.0);
        // device 1415, IC IC247, analog/basic/mos_track_hold.hpp:31
        I(cpphdl_n1856, Vss) <+ 2e-14 * ddt(V(cpphdl_n1856, Vss)); // Bench initial voltage = 0.0 V.
        // device 1416, IC IC247, analog/basic/mos_track_hold.hpp:32
        I(cpphdl_n2136, cpphdl_n1910) <+ cpphdl_channel(V(TRACK10, cpphdl_n1910), V(cpphdl_n2136, cpphdl_n1910), 0.029999999999999999, 0.69999999999999996, 1.0);
        // device 1417, IC IC247, analog/basic/mos_track_hold.hpp:33
        I(cpphdl_n1910, cpphdl_n2136) <+ cpphdl_channel(V(cpphdl_n1856, cpphdl_n2136), V(cpphdl_n1910, cpphdl_n2136), 0.014999999999999999, 0.69999999999999996, -1.0);
        // device 1418, IC IC247, analog/basic/mos_track_hold.hpp:37
        I(cpphdl_n1910, cpphdl_n1910) <+ cpphdl_channel(V(cpphdl_n1856, cpphdl_n1910), V(cpphdl_n1910, cpphdl_n1910), 0.016, 0.69999999999999996, 1.0);
        // device 1419, IC IC247, analog/basic/mos_track_hold.hpp:38
        I(cpphdl_n1910, cpphdl_n1910) <+ cpphdl_channel(V(TRACK10, cpphdl_n1910), V(cpphdl_n1910, cpphdl_n1910), 0.0083999999999999995, 0.69999999999999996, -1.0);
        // device 1420, IC IC247, analog/basic/mos_track_hold.hpp:39
        I(cpphdl_n1910, Vss) <+ 1.5000000000000001e-12 * ddt(V(cpphdl_n1910, Vss)); // Bench initial voltage = 0.0 V.
        // device 1421, IC IC247, analog/basic/mos_track_hold.hpp:42
        I(TRACK10, cpphdl_n1910) <+ 2.0000000000000002e-15 * ddt(V(TRACK10, cpphdl_n1910)); // Bench initial voltage = -0.0 V.
        // device 1422, IC IC247, analog/basic/mos_track_hold.hpp:43
        I(cpphdl_n1856, cpphdl_n1910) <+ 2.0000000000000002e-15 * ddt(V(cpphdl_n1856, cpphdl_n1910)); // Bench initial voltage = 0.0 V.
        // device 1423, IC IC247, analog/basic/mos_track_hold.hpp:44
        I(cpphdl_n2136, cpphdl_n1910) <+ 1.0000000000000001e-15 * ddt(V(cpphdl_n2136, cpphdl_n1910)); // Bench initial voltage = 0.0 V.
        // device 1424, IC IC250, analog/basic/inverter.hpp:11
        I(cpphdl_n1871, Vdd) <+ cpphdl_channel(V(BIT_N10_0, Vdd), V(cpphdl_n1871, Vdd), 0.080000000000000002, 0.69999999999999996, -1.0);
        // device 1425, IC IC250, analog/basic/inverter.hpp:12
        I(cpphdl_n1871, Vss) <+ cpphdl_channel(V(BIT_N10_0, Vss), V(cpphdl_n1871, Vss), 0.080000000000000002, 0.69999999999999996, 1.0);
        // device 1426, IC IC249, analog/basic/mos_r2r_dac.hpp:27
        I(cpphdl_n1871, Vss) <+ 2.9999999999999998e-15 * ddt(V(cpphdl_n1871, Vss)); // Bench initial voltage = 0.0 V.
        // device 1427, IC IC249, analog/basic/mos_r2r_dac.hpp:28
        I(cpphdl_n1871, cpphdl_n1900) <+ V(cpphdl_n1871, cpphdl_n1900) / 2000.0;
        // device 1428, IC IC249, analog/basic/mos_r2r_dac.hpp:29
        I(cpphdl_n1900, Vss) <+ 2.9999999999999998e-15 * ddt(V(cpphdl_n1900, Vss)); // Bench initial voltage = 0.0 V.
        // device 1429, IC IC251, analog/basic/inverter.hpp:11
        I(cpphdl_n1875, Vdd) <+ cpphdl_channel(V(BIT_N10_1, Vdd), V(cpphdl_n1875, Vdd), 0.080000000000000002, 0.69999999999999996, -1.0);
        // device 1430, IC IC251, analog/basic/inverter.hpp:12
        I(cpphdl_n1875, Vss) <+ cpphdl_channel(V(BIT_N10_1, Vss), V(cpphdl_n1875, Vss), 0.080000000000000002, 0.69999999999999996, 1.0);
        // device 1431, IC IC249, analog/basic/mos_r2r_dac.hpp:27
        I(cpphdl_n1875, Vss) <+ 2.9999999999999998e-15 * ddt(V(cpphdl_n1875, Vss)); // Bench initial voltage = 0.0 V.
        // device 1432, IC IC249, analog/basic/mos_r2r_dac.hpp:28
        I(cpphdl_n1875, cpphdl_n1901) <+ V(cpphdl_n1875, cpphdl_n1901) / 2000.0;
        // device 1433, IC IC249, analog/basic/mos_r2r_dac.hpp:29
        I(cpphdl_n1901, Vss) <+ 2.9999999999999998e-15 * ddt(V(cpphdl_n1901, Vss)); // Bench initial voltage = 0.0 V.
        // device 1434, IC IC249, analog/basic/mos_r2r_dac.hpp:31
        I(cpphdl_n1900, cpphdl_n1901) <+ V(cpphdl_n1900, cpphdl_n1901) / 1000.0;
        // device 1435, IC IC252, analog/basic/inverter.hpp:11
        I(cpphdl_n1879, Vdd) <+ cpphdl_channel(V(BIT_N10_2, Vdd), V(cpphdl_n1879, Vdd), 0.080000000000000002, 0.69999999999999996, -1.0);
        // device 1436, IC IC252, analog/basic/inverter.hpp:12
        I(cpphdl_n1879, Vss) <+ cpphdl_channel(V(BIT_N10_2, Vss), V(cpphdl_n1879, Vss), 0.080000000000000002, 0.69999999999999996, 1.0);
        // device 1437, IC IC249, analog/basic/mos_r2r_dac.hpp:27
        I(cpphdl_n1879, Vss) <+ 2.9999999999999998e-15 * ddt(V(cpphdl_n1879, Vss)); // Bench initial voltage = 0.0 V.
        // device 1438, IC IC249, analog/basic/mos_r2r_dac.hpp:28
        I(cpphdl_n1879, cpphdl_n1902) <+ V(cpphdl_n1879, cpphdl_n1902) / 2000.0;
        // device 1439, IC IC249, analog/basic/mos_r2r_dac.hpp:29
        I(cpphdl_n1902, Vss) <+ 2.9999999999999998e-15 * ddt(V(cpphdl_n1902, Vss)); // Bench initial voltage = 0.0 V.
        // device 1440, IC IC249, analog/basic/mos_r2r_dac.hpp:31
        I(cpphdl_n1901, cpphdl_n1902) <+ V(cpphdl_n1901, cpphdl_n1902) / 1000.0;
        // device 1441, IC IC253, analog/basic/inverter.hpp:11
        I(cpphdl_n1883, Vdd) <+ cpphdl_channel(V(BIT_N10_3, Vdd), V(cpphdl_n1883, Vdd), 0.080000000000000002, 0.69999999999999996, -1.0);
        // device 1442, IC IC253, analog/basic/inverter.hpp:12
        I(cpphdl_n1883, Vss) <+ cpphdl_channel(V(BIT_N10_3, Vss), V(cpphdl_n1883, Vss), 0.080000000000000002, 0.69999999999999996, 1.0);
        // device 1443, IC IC249, analog/basic/mos_r2r_dac.hpp:27
        I(cpphdl_n1883, Vss) <+ 2.9999999999999998e-15 * ddt(V(cpphdl_n1883, Vss)); // Bench initial voltage = 0.0 V.
        // device 1444, IC IC249, analog/basic/mos_r2r_dac.hpp:28
        I(cpphdl_n1883, cpphdl_n1903) <+ V(cpphdl_n1883, cpphdl_n1903) / 2000.0;
        // device 1445, IC IC249, analog/basic/mos_r2r_dac.hpp:29
        I(cpphdl_n1903, Vss) <+ 2.9999999999999998e-15 * ddt(V(cpphdl_n1903, Vss)); // Bench initial voltage = 0.0 V.
        // device 1446, IC IC249, analog/basic/mos_r2r_dac.hpp:31
        I(cpphdl_n1902, cpphdl_n1903) <+ V(cpphdl_n1902, cpphdl_n1903) / 1000.0;
        // device 1447, IC IC254, analog/basic/inverter.hpp:11
        I(cpphdl_n1887, Vdd) <+ cpphdl_channel(V(BIT_N10_4, Vdd), V(cpphdl_n1887, Vdd), 0.080000000000000002, 0.69999999999999996, -1.0);
        // device 1448, IC IC254, analog/basic/inverter.hpp:12
        I(cpphdl_n1887, Vss) <+ cpphdl_channel(V(BIT_N10_4, Vss), V(cpphdl_n1887, Vss), 0.080000000000000002, 0.69999999999999996, 1.0);
        // device 1449, IC IC249, analog/basic/mos_r2r_dac.hpp:27
        I(cpphdl_n1887, Vss) <+ 2.9999999999999998e-15 * ddt(V(cpphdl_n1887, Vss)); // Bench initial voltage = 0.0 V.
        // device 1450, IC IC249, analog/basic/mos_r2r_dac.hpp:28
        I(cpphdl_n1887, cpphdl_n1904) <+ V(cpphdl_n1887, cpphdl_n1904) / 2000.0;
        // device 1451, IC IC249, analog/basic/mos_r2r_dac.hpp:29
        I(cpphdl_n1904, Vss) <+ 2.9999999999999998e-15 * ddt(V(cpphdl_n1904, Vss)); // Bench initial voltage = 0.0 V.
        // device 1452, IC IC249, analog/basic/mos_r2r_dac.hpp:31
        I(cpphdl_n1903, cpphdl_n1904) <+ V(cpphdl_n1903, cpphdl_n1904) / 1000.0;
        // device 1453, IC IC255, analog/basic/inverter.hpp:11
        I(cpphdl_n1891, Vdd) <+ cpphdl_channel(V(BIT_N10_5, Vdd), V(cpphdl_n1891, Vdd), 0.080000000000000002, 0.69999999999999996, -1.0);
        // device 1454, IC IC255, analog/basic/inverter.hpp:12
        I(cpphdl_n1891, Vss) <+ cpphdl_channel(V(BIT_N10_5, Vss), V(cpphdl_n1891, Vss), 0.080000000000000002, 0.69999999999999996, 1.0);
        // device 1455, IC IC249, analog/basic/mos_r2r_dac.hpp:27
        I(cpphdl_n1891, Vss) <+ 2.9999999999999998e-15 * ddt(V(cpphdl_n1891, Vss)); // Bench initial voltage = 0.0 V.
        // device 1456, IC IC249, analog/basic/mos_r2r_dac.hpp:28
        I(cpphdl_n1891, cpphdl_n1905) <+ V(cpphdl_n1891, cpphdl_n1905) / 2000.0;
        // device 1457, IC IC249, analog/basic/mos_r2r_dac.hpp:29
        I(cpphdl_n1905, Vss) <+ 2.9999999999999998e-15 * ddt(V(cpphdl_n1905, Vss)); // Bench initial voltage = 0.0 V.
        // device 1458, IC IC249, analog/basic/mos_r2r_dac.hpp:31
        I(cpphdl_n1904, cpphdl_n1905) <+ V(cpphdl_n1904, cpphdl_n1905) / 1000.0;
        // device 1459, IC IC256, analog/basic/inverter.hpp:11
        I(cpphdl_n1895, Vdd) <+ cpphdl_channel(V(BIT_N10_6, Vdd), V(cpphdl_n1895, Vdd), 0.080000000000000002, 0.69999999999999996, -1.0);
        // device 1460, IC IC256, analog/basic/inverter.hpp:12
        I(cpphdl_n1895, Vss) <+ cpphdl_channel(V(BIT_N10_6, Vss), V(cpphdl_n1895, Vss), 0.080000000000000002, 0.69999999999999996, 1.0);
        // device 1461, IC IC249, analog/basic/mos_r2r_dac.hpp:27
        I(cpphdl_n1895, Vss) <+ 2.9999999999999998e-15 * ddt(V(cpphdl_n1895, Vss)); // Bench initial voltage = 0.0 V.
        // device 1462, IC IC249, analog/basic/mos_r2r_dac.hpp:28
        I(cpphdl_n1895, cpphdl_n1906) <+ V(cpphdl_n1895, cpphdl_n1906) / 2000.0;
        // device 1463, IC IC249, analog/basic/mos_r2r_dac.hpp:29
        I(cpphdl_n1906, Vss) <+ 2.9999999999999998e-15 * ddt(V(cpphdl_n1906, Vss)); // Bench initial voltage = 0.0 V.
        // device 1464, IC IC249, analog/basic/mos_r2r_dac.hpp:31
        I(cpphdl_n1905, cpphdl_n1906) <+ V(cpphdl_n1905, cpphdl_n1906) / 1000.0;
        // device 1465, IC IC257, analog/basic/inverter.hpp:11
        I(cpphdl_n1899, Vdd) <+ cpphdl_channel(V(BIT_N10_7, Vdd), V(cpphdl_n1899, Vdd), 0.080000000000000002, 0.69999999999999996, -1.0);
        // device 1466, IC IC257, analog/basic/inverter.hpp:12
        I(cpphdl_n1899, Vss) <+ cpphdl_channel(V(BIT_N10_7, Vss), V(cpphdl_n1899, Vss), 0.080000000000000002, 0.69999999999999996, 1.0);
        // device 1467, IC IC249, analog/basic/mos_r2r_dac.hpp:27
        I(cpphdl_n1899, Vss) <+ 2.9999999999999998e-15 * ddt(V(cpphdl_n1899, Vss)); // Bench initial voltage = 0.0 V.
        // device 1468, IC IC249, analog/basic/mos_r2r_dac.hpp:28
        I(cpphdl_n1899, cpphdl_n1911) <+ V(cpphdl_n1899, cpphdl_n1911) / 2000.0;
        // device 1469, IC IC249, analog/basic/mos_r2r_dac.hpp:29
        I(cpphdl_n1911, Vss) <+ 2.9999999999999998e-15 * ddt(V(cpphdl_n1911, Vss)); // Bench initial voltage = 0.0 V.
        // device 1470, IC IC249, analog/basic/mos_r2r_dac.hpp:31
        I(cpphdl_n1906, cpphdl_n1911) <+ V(cpphdl_n1906, cpphdl_n1911) / 1000.0;
        // device 1471, IC IC249, analog/basic/mos_r2r_dac.hpp:33
        I(Vss, cpphdl_n1900) <+ V(Vss, cpphdl_n1900) / 2000.0;
        // device 1472, IC IC258, analog/basic/nmos_resistor_amplifier.hpp:23
        I(Vdd, cpphdl_n1920) <+ V(Vdd, cpphdl_n1920) / 1000.0;
        // device 1473, IC IC258, analog/basic/nmos_resistor_amplifier.hpp:24
        I(Vdd, cpphdl_n1919) <+ V(Vdd, cpphdl_n1919) / 1000.0;
        // device 1474, IC IC258, analog/basic/nmos_resistor_amplifier.hpp:25
        I(cpphdl_n1920, cpphdl_n1914) <+ cpphdl_channel(V(cpphdl_n1910, cpphdl_n1914), V(cpphdl_n1920, cpphdl_n1914), 0.0074999999999999997, 0.69999999999999996, 1.0);
        // device 1475, IC IC258, analog/basic/nmos_resistor_amplifier.hpp:26
        I(cpphdl_n1919, cpphdl_n1915) <+ cpphdl_channel(V(cpphdl_n1911, cpphdl_n1915), V(cpphdl_n1919, cpphdl_n1915), 0.0074999999999999997, 0.69999999999999996, 1.0);
        // device 1476, IC IC258, analog/basic/nmos_resistor_amplifier.hpp:27
        I(cpphdl_n1916, cpphdl_n1914) <+ V(cpphdl_n1916, cpphdl_n1914) / 100.0;
        // device 1477, IC IC258, analog/basic/nmos_resistor_amplifier.hpp:28
        I(cpphdl_n1916, cpphdl_n1915) <+ V(cpphdl_n1916, cpphdl_n1915) / 100.0;
        // device 1478, IC IC258, analog/basic/nmos_resistor_amplifier.hpp:29
        I(Vss, cpphdl_n1916) <+ V(Vss, cpphdl_n1916) / 300.0;
        // device 1479, IC IC258, analog/basic/nmos_resistor_amplifier.hpp:30
        I(cpphdl_n1920, Vdd) <+ 2.9999999999999998e-13 * ddt(V(cpphdl_n1920, Vdd)); // Bench initial voltage = 0.0 V.
        // device 1480, IC IC258, analog/basic/nmos_resistor_amplifier.hpp:31
        I(cpphdl_n1919, Vdd) <+ 2.9999999999999998e-13 * ddt(V(cpphdl_n1919, Vdd)); // Bench initial voltage = 0.0 V.
        // device 1481, IC IC258, analog/basic/nmos_resistor_amplifier.hpp:32
        I(cpphdl_n1916, Vss) <+ 4e-14 * ddt(V(cpphdl_n1916, Vss)); // Bench initial voltage = 0.0 V.
        // device 1482, IC IC258, analog/basic/nmos_resistor_amplifier.hpp:34
        I(cpphdl_n1910, cpphdl_n1914) <+ 2e-14 * ddt(V(cpphdl_n1910, cpphdl_n1914)); // Bench initial voltage = 0.0 V.
        // device 1483, IC IC258, analog/basic/nmos_resistor_amplifier.hpp:35
        I(cpphdl_n1911, cpphdl_n1915) <+ 2e-14 * ddt(V(cpphdl_n1911, cpphdl_n1915)); // Bench initial voltage = 0.0 V.
        // device 1484, IC IC258, analog/basic/nmos_resistor_amplifier.hpp:36
        I(cpphdl_n1910, cpphdl_n1920) <+ 2.9999999999999998e-15 * ddt(V(cpphdl_n1910, cpphdl_n1920)); // Bench initial voltage = 0.0 V.
        // device 1485, IC IC258, analog/basic/nmos_resistor_amplifier.hpp:37
        I(cpphdl_n1911, cpphdl_n1919) <+ 2.9999999999999998e-15 * ddt(V(cpphdl_n1911, cpphdl_n1919)); // Bench initial voltage = 0.0 V.
        // device 1486, IC IC259, analog/basic/strongarm_comparator.hpp:28
        I(cpphdl_n1924, cpphdl_n1926) <+ cpphdl_channel(V(cpphdl_n1919, cpphdl_n1926), V(cpphdl_n1924, cpphdl_n1926), 0.0080000000000000002, 0.69999999999999996, 1.0);
        // device 1487, IC IC259, analog/basic/strongarm_comparator.hpp:29
        I(cpphdl_n1925, cpphdl_n1926) <+ cpphdl_channel(V(cpphdl_n1920, cpphdl_n1926), V(cpphdl_n1925, cpphdl_n1926), 0.0080000000000000002, 0.69999999999999996, 1.0);
        // device 1488, IC IC259, analog/basic/strongarm_comparator.hpp:30
        I(cpphdl_n1926, Vss) <+ cpphdl_channel(V(EVALUATE, Vss), V(cpphdl_n1926, Vss), 0.0080000000000000002, 0.69999999999999996, 1.0);
        // device 1489, IC IC259, analog/basic/strongarm_comparator.hpp:33
        I(cpphdl_n1939, cpphdl_n1924) <+ cpphdl_channel(V(cpphdl_n1943, cpphdl_n1924), V(cpphdl_n1939, cpphdl_n1924), 0.0040000000000000001, 0.69999999999999996, 1.0);
        // device 1490, IC IC259, analog/basic/strongarm_comparator.hpp:34
        I(cpphdl_n1943, cpphdl_n1925) <+ cpphdl_channel(V(cpphdl_n1939, cpphdl_n1925), V(cpphdl_n1943, cpphdl_n1925), 0.0040000000000000001, 0.69999999999999996, 1.0);
        // device 1491, IC IC259, analog/basic/strongarm_comparator.hpp:35
        I(cpphdl_n1943, Vdd) <+ cpphdl_channel(V(cpphdl_n1939, Vdd), V(cpphdl_n1943, Vdd), 0.002, 0.69999999999999996, -1.0);
        // device 1492, IC IC259, analog/basic/strongarm_comparator.hpp:36
        I(cpphdl_n1939, Vdd) <+ cpphdl_channel(V(cpphdl_n1943, Vdd), V(cpphdl_n1939, Vdd), 0.002, 0.69999999999999996, -1.0);
        // device 1493, IC IC259, analog/basic/strongarm_comparator.hpp:38
        I(cpphdl_n1924, Vdd) <+ cpphdl_channel(V(EVALUATE, Vdd), V(cpphdl_n1924, Vdd), 0.002, 0.69999999999999996, -1.0);
        // device 1494, IC IC259, analog/basic/strongarm_comparator.hpp:39
        I(cpphdl_n1925, Vdd) <+ cpphdl_channel(V(EVALUATE, Vdd), V(cpphdl_n1925, Vdd), 0.002, 0.69999999999999996, -1.0);
        // device 1495, IC IC259, analog/basic/strongarm_comparator.hpp:40
        I(cpphdl_n1943, Vdd) <+ cpphdl_channel(V(EVALUATE, Vdd), V(cpphdl_n1943, Vdd), 0.002, 0.69999999999999996, -1.0);
        // device 1496, IC IC259, analog/basic/strongarm_comparator.hpp:41
        I(cpphdl_n1939, Vdd) <+ cpphdl_channel(V(EVALUATE, Vdd), V(cpphdl_n1939, Vdd), 0.002, 0.69999999999999996, -1.0);
        // device 1497, IC IC259, analog/basic/strongarm_comparator.hpp:42
        I(cpphdl_n1924, Vss) <+ 2.9999999999999998e-14 * ddt(V(cpphdl_n1924, Vss)); // Bench initial voltage = 0.0 V.
        // device 1498, IC IC259, analog/basic/strongarm_comparator.hpp:43
        I(cpphdl_n1925, Vss) <+ 2.9999999999999998e-14 * ddt(V(cpphdl_n1925, Vss)); // Bench initial voltage = 0.0 V.
        // device 1499, IC IC259, analog/basic/strongarm_comparator.hpp:44
        I(cpphdl_n1926, Vss) <+ 2.9999999999999998e-14 * ddt(V(cpphdl_n1926, Vss)); // Bench initial voltage = 0.0 V.
        // device 1500, IC IC259, analog/basic/strongarm_comparator.hpp:45
        I(cpphdl_n1943, Vss) <+ 5.0000000000000002e-14 * ddt(V(cpphdl_n1943, Vss)); // Bench initial voltage = 0.0 V.
        // device 1501, IC IC259, analog/basic/strongarm_comparator.hpp:46
        I(cpphdl_n1939, Vss) <+ 5.0000000000000002e-14 * ddt(V(cpphdl_n1939, Vss)); // Bench initial voltage = 0.0 V.
        // device 1502, IC IC259, analog/basic/strongarm_comparator.hpp:47
        I(cpphdl_n1919, cpphdl_n1926) <+ 2e-14 * ddt(V(cpphdl_n1919, cpphdl_n1926)); // Bench initial voltage = 0.0 V.
        // device 1503, IC IC259, analog/basic/strongarm_comparator.hpp:48
        I(cpphdl_n1920, cpphdl_n1926) <+ 2e-14 * ddt(V(cpphdl_n1920, cpphdl_n1926)); // Bench initial voltage = 0.0 V.
        // device 1504, IC IC259, analog/basic/strongarm_comparator.hpp:49
        I(cpphdl_n1919, cpphdl_n1924) <+ 2.9999999999999998e-15 * ddt(V(cpphdl_n1919, cpphdl_n1924)); // Bench initial voltage = 0.0 V.
        // device 1505, IC IC259, analog/basic/strongarm_comparator.hpp:50
        I(cpphdl_n1920, cpphdl_n1925) <+ 2.9999999999999998e-15 * ddt(V(cpphdl_n1920, cpphdl_n1925)); // Bench initial voltage = 0.0 V.
        // device 1506, IC IC261, analog/basic/inverter.hpp:11
        I(cpphdl_n1947, Vdd) <+ cpphdl_channel(V(cpphdl_n1939, Vdd), V(cpphdl_n1947, Vdd), 0.001, 0.69999999999999996, -1.0);
        // device 1507, IC IC261, analog/basic/inverter.hpp:12
        I(cpphdl_n1947, Vss) <+ cpphdl_channel(V(cpphdl_n1939, Vss), V(cpphdl_n1947, Vss), 0.001, 0.69999999999999996, 1.0);
        // device 1508, IC IC263, analog/basic/inverter.hpp:11
        I(cpphdl_n1961, Vdd) <+ cpphdl_channel(V(cpphdl_n1947, Vdd), V(cpphdl_n1961, Vdd), 0.0040000000000000001, 0.69999999999999996, -1.0);
        // device 1509, IC IC263, analog/basic/inverter.hpp:12
        I(cpphdl_n1961, Vss) <+ cpphdl_channel(V(cpphdl_n1947, Vss), V(cpphdl_n1961, Vss), 0.0040000000000000001, 0.69999999999999996, 1.0);
        // device 1510, IC IC260, analog/basic/buffered_nand_latch.hpp:34
        I(cpphdl_n1939, Vss) <+ 2.0000000000000002e-15 * ddt(V(cpphdl_n1939, Vss)); // Bench initial voltage = 0.0 V.
        // device 1511, IC IC260, analog/basic/buffered_nand_latch.hpp:35
        I(cpphdl_n1939, cpphdl_n1947) <+ 1.0000000000000001e-15 * ddt(V(cpphdl_n1939, cpphdl_n1947)); // Bench initial voltage = 0.0 V.
        // device 1512, IC IC260, analog/basic/buffered_nand_latch.hpp:36
        I(cpphdl_n1947, Vss) <+ 5e-15 * ddt(V(cpphdl_n1947, Vss)); // Bench initial voltage = 0.0 V.
        // device 1513, IC IC260, analog/basic/buffered_nand_latch.hpp:37
        I(cpphdl_n1947, Vss) <+ 8.0000000000000006e-15 * ddt(V(cpphdl_n1947, Vss)); // Bench initial voltage = 0.0 V.
        // device 1514, IC IC260, analog/basic/buffered_nand_latch.hpp:38
        I(cpphdl_n1961, Vss) <+ 1e-14 * ddt(V(cpphdl_n1961, Vss)); // Bench initial voltage = 0.0 V.
        // device 1515, IC IC262, analog/basic/inverter.hpp:11
        I(cpphdl_n1951, Vdd) <+ cpphdl_channel(V(cpphdl_n1943, Vdd), V(cpphdl_n1951, Vdd), 0.001, 0.69999999999999996, -1.0);
        // device 1516, IC IC262, analog/basic/inverter.hpp:12
        I(cpphdl_n1951, Vss) <+ cpphdl_channel(V(cpphdl_n1943, Vss), V(cpphdl_n1951, Vss), 0.001, 0.69999999999999996, 1.0);
        // device 1517, IC IC264, analog/basic/inverter.hpp:11
        I(cpphdl_n1967, Vdd) <+ cpphdl_channel(V(cpphdl_n1951, Vdd), V(cpphdl_n1967, Vdd), 0.0040000000000000001, 0.69999999999999996, -1.0);
        // device 1518, IC IC264, analog/basic/inverter.hpp:12
        I(cpphdl_n1967, Vss) <+ cpphdl_channel(V(cpphdl_n1951, Vss), V(cpphdl_n1967, Vss), 0.0040000000000000001, 0.69999999999999996, 1.0);
        // device 1519, IC IC260, analog/basic/buffered_nand_latch.hpp:34
        I(cpphdl_n1943, Vss) <+ 2.0000000000000002e-15 * ddt(V(cpphdl_n1943, Vss)); // Bench initial voltage = 0.0 V.
        // device 1520, IC IC260, analog/basic/buffered_nand_latch.hpp:35
        I(cpphdl_n1943, cpphdl_n1951) <+ 1.0000000000000001e-15 * ddt(V(cpphdl_n1943, cpphdl_n1951)); // Bench initial voltage = 0.0 V.
        // device 1521, IC IC260, analog/basic/buffered_nand_latch.hpp:36
        I(cpphdl_n1951, Vss) <+ 5e-15 * ddt(V(cpphdl_n1951, Vss)); // Bench initial voltage = 0.0 V.
        // device 1522, IC IC260, analog/basic/buffered_nand_latch.hpp:37
        I(cpphdl_n1951, Vss) <+ 8.0000000000000006e-15 * ddt(V(cpphdl_n1951, Vss)); // Bench initial voltage = 0.0 V.
        // device 1523, IC IC260, analog/basic/buffered_nand_latch.hpp:38
        I(cpphdl_n1967, Vss) <+ 1e-14 * ddt(V(cpphdl_n1967, Vss)); // Bench initial voltage = 0.0 V.
        // device 1524, IC IC266, analog/basic/cmos_logic.hpp:17
        I(cpphdl_n2328, Vss) <+ 5.0000000000000002e-14 * ddt(V(cpphdl_n2328, Vss)); // Bench initial voltage = 0.0 V.
        // device 1525, IC IC266, analog/basic/cmos_logic.hpp:18
        I(cpphdl_n2328, Vdd) <+ cpphdl_channel(V(cpphdl_n1961, Vdd), V(cpphdl_n2328, Vdd), 0.01, 0.69999999999999996, -1.0);
        // device 1526, IC IC266, analog/basic/cmos_logic.hpp:19
        I(cpphdl_n2328, Vdd) <+ cpphdl_channel(V(cpphdl_n1969, Vdd), V(cpphdl_n2328, Vdd), 0.01, 0.69999999999999996, -1.0);
        // device 1527, IC IC266, analog/basic/cmos_logic.hpp:20
        I(cpphdl_n2328, cpphdl_n1964) <+ cpphdl_channel(V(cpphdl_n1961, cpphdl_n1964), V(cpphdl_n2328, cpphdl_n1964), 0.01, 0.69999999999999996, 1.0);
        // device 1528, IC IC266, analog/basic/cmos_logic.hpp:21
        I(cpphdl_n1964, Vss) <+ cpphdl_channel(V(cpphdl_n1969, Vss), V(cpphdl_n1964, Vss), 0.01, 0.69999999999999996, 1.0);
        // device 1529, IC IC266, analog/basic/cmos_logic.hpp:27
        I(cpphdl_n1964, Vss) <+ 1e-14 * ddt(V(cpphdl_n1964, Vss)); // Bench initial voltage = 0.0 V.
        // device 1530, IC IC267, analog/basic/cmos_logic.hpp:17
        I(cpphdl_n1969, Vss) <+ 5.0000000000000002e-14 * ddt(V(cpphdl_n1969, Vss)); // Bench initial voltage = 0.0 V.
        // device 1531, IC IC267, analog/basic/cmos_logic.hpp:18
        I(cpphdl_n1969, Vdd) <+ cpphdl_channel(V(cpphdl_n1967, Vdd), V(cpphdl_n1969, Vdd), 0.01, 0.69999999999999996, -1.0);
        // device 1532, IC IC267, analog/basic/cmos_logic.hpp:19
        I(cpphdl_n1969, Vdd) <+ cpphdl_channel(V(cpphdl_n2328, Vdd), V(cpphdl_n1969, Vdd), 0.01, 0.69999999999999996, -1.0);
        // device 1533, IC IC267, analog/basic/cmos_logic.hpp:20
        I(cpphdl_n1969, cpphdl_n1970) <+ cpphdl_channel(V(cpphdl_n1967, cpphdl_n1970), V(cpphdl_n1969, cpphdl_n1970), 0.01, 0.69999999999999996, 1.0);
        // device 1534, IC IC267, analog/basic/cmos_logic.hpp:21
        I(cpphdl_n1970, Vss) <+ cpphdl_channel(V(cpphdl_n2328, Vss), V(cpphdl_n1970, Vss), 0.01, 0.69999999999999996, 1.0);
        // device 1535, IC IC267, analog/basic/cmos_logic.hpp:27
        I(cpphdl_n1970, Vss) <+ 1e-14 * ddt(V(cpphdl_n1970, Vss)); // Bench initial voltage = 0.0 V.
        // device 1536, IC IC265, analog/basic/nand_latch.hpp:36
        I(cpphdl_n1961, Vss) <+ 2.9999999999999998e-15 * ddt(V(cpphdl_n1961, Vss)); // Bench initial voltage = 0.0 V.
        // device 1537, IC IC265, analog/basic/nand_latch.hpp:37
        I(cpphdl_n1967, Vss) <+ 2.9999999999999998e-15 * ddt(V(cpphdl_n1967, Vss)); // Bench initial voltage = 0.0 V.
        // device 1538, IC IC268, analog/basic/inverter.hpp:11
        I(cpphdl_n1975, Vdd) <+ cpphdl_channel(V(CLEAR, Vdd), V(cpphdl_n1975, Vdd), 0.01, 0.69999999999999996, -1.0);
        // device 1539, IC IC268, analog/basic/inverter.hpp:12
        I(cpphdl_n1975, Vss) <+ cpphdl_channel(V(CLEAR, Vss), V(cpphdl_n1975, Vss), 0.01, 0.69999999999999996, 1.0);
        // device 1540, IC IC265, analog/basic/nand_latch.hpp:58
        I(cpphdl_n1975, Vss) <+ 2.9999999999999998e-15 * ddt(V(cpphdl_n1975, Vss)); // Bench initial voltage = 0.0 V.
        // device 1541, IC IC265, analog/basic/nand_latch.hpp:59
        I(cpphdl_n2328, Vss) <+ cpphdl_channel(V(CLEAR, Vss), V(cpphdl_n2328, Vss), 0.050000000000000003, 0.69999999999999996, 1.0);
        // device 1542, IC IC265, analog/basic/nand_latch.hpp:60
        I(cpphdl_n1969, Vdd) <+ cpphdl_channel(V(cpphdl_n1975, Vdd), V(cpphdl_n1969, Vdd), 0.050000000000000003, 0.69999999999999996, -1.0);
        // device 1543, IC IC271, analog/basic/inverter.hpp:11
        I(cpphdl_n1999, Vdd) <+ cpphdl_channel(V(TRACK11, Vdd), V(cpphdl_n1999, Vdd), 0.0040000000000000001, 0.69999999999999996, -1.0);
        // device 1544, IC IC271, analog/basic/inverter.hpp:12
        I(cpphdl_n1999, Vss) <+ cpphdl_channel(V(TRACK11, Vss), V(cpphdl_n1999, Vss), 0.0040000000000000001, 0.69999999999999996, 1.0);
        // device 1545, IC IC270, analog/basic/mos_track_hold.hpp:31
        I(cpphdl_n1999, Vss) <+ 2e-14 * ddt(V(cpphdl_n1999, Vss)); // Bench initial voltage = 0.0 V.
        // device 1546, IC IC270, analog/basic/mos_track_hold.hpp:32
        I(cpphdl_n2136, cpphdl_n2053) <+ cpphdl_channel(V(TRACK11, cpphdl_n2053), V(cpphdl_n2136, cpphdl_n2053), 0.029999999999999999, 0.69999999999999996, 1.0);
        // device 1547, IC IC270, analog/basic/mos_track_hold.hpp:33
        I(cpphdl_n2053, cpphdl_n2136) <+ cpphdl_channel(V(cpphdl_n1999, cpphdl_n2136), V(cpphdl_n2053, cpphdl_n2136), 0.014999999999999999, 0.69999999999999996, -1.0);
        // device 1548, IC IC270, analog/basic/mos_track_hold.hpp:37
        I(cpphdl_n2053, cpphdl_n2053) <+ cpphdl_channel(V(cpphdl_n1999, cpphdl_n2053), V(cpphdl_n2053, cpphdl_n2053), 0.016, 0.69999999999999996, 1.0);
        // device 1549, IC IC270, analog/basic/mos_track_hold.hpp:38
        I(cpphdl_n2053, cpphdl_n2053) <+ cpphdl_channel(V(TRACK11, cpphdl_n2053), V(cpphdl_n2053, cpphdl_n2053), 0.0083999999999999995, 0.69999999999999996, -1.0);
        // device 1550, IC IC270, analog/basic/mos_track_hold.hpp:39
        I(cpphdl_n2053, Vss) <+ 1.5000000000000001e-12 * ddt(V(cpphdl_n2053, Vss)); // Bench initial voltage = 0.0 V.
        // device 1551, IC IC270, analog/basic/mos_track_hold.hpp:42
        I(TRACK11, cpphdl_n2053) <+ 2.0000000000000002e-15 * ddt(V(TRACK11, cpphdl_n2053)); // Bench initial voltage = -0.0 V.
        // device 1552, IC IC270, analog/basic/mos_track_hold.hpp:43
        I(cpphdl_n1999, cpphdl_n2053) <+ 2.0000000000000002e-15 * ddt(V(cpphdl_n1999, cpphdl_n2053)); // Bench initial voltage = 0.0 V.
        // device 1553, IC IC270, analog/basic/mos_track_hold.hpp:44
        I(cpphdl_n2136, cpphdl_n2053) <+ 1.0000000000000001e-15 * ddt(V(cpphdl_n2136, cpphdl_n2053)); // Bench initial voltage = 0.0 V.
        // device 1554, IC IC273, analog/basic/inverter.hpp:11
        I(cpphdl_n2014, Vdd) <+ cpphdl_channel(V(BIT_N11_0, Vdd), V(cpphdl_n2014, Vdd), 0.080000000000000002, 0.69999999999999996, -1.0);
        // device 1555, IC IC273, analog/basic/inverter.hpp:12
        I(cpphdl_n2014, Vss) <+ cpphdl_channel(V(BIT_N11_0, Vss), V(cpphdl_n2014, Vss), 0.080000000000000002, 0.69999999999999996, 1.0);
        // device 1556, IC IC272, analog/basic/mos_r2r_dac.hpp:27
        I(cpphdl_n2014, Vss) <+ 2.9999999999999998e-15 * ddt(V(cpphdl_n2014, Vss)); // Bench initial voltage = 0.0 V.
        // device 1557, IC IC272, analog/basic/mos_r2r_dac.hpp:28
        I(cpphdl_n2014, cpphdl_n2043) <+ V(cpphdl_n2014, cpphdl_n2043) / 2000.0;
        // device 1558, IC IC272, analog/basic/mos_r2r_dac.hpp:29
        I(cpphdl_n2043, Vss) <+ 2.9999999999999998e-15 * ddt(V(cpphdl_n2043, Vss)); // Bench initial voltage = 0.0 V.
        // device 1559, IC IC274, analog/basic/inverter.hpp:11
        I(cpphdl_n2018, Vdd) <+ cpphdl_channel(V(BIT_N11_1, Vdd), V(cpphdl_n2018, Vdd), 0.080000000000000002, 0.69999999999999996, -1.0);
        // device 1560, IC IC274, analog/basic/inverter.hpp:12
        I(cpphdl_n2018, Vss) <+ cpphdl_channel(V(BIT_N11_1, Vss), V(cpphdl_n2018, Vss), 0.080000000000000002, 0.69999999999999996, 1.0);
        // device 1561, IC IC272, analog/basic/mos_r2r_dac.hpp:27
        I(cpphdl_n2018, Vss) <+ 2.9999999999999998e-15 * ddt(V(cpphdl_n2018, Vss)); // Bench initial voltage = 0.0 V.
        // device 1562, IC IC272, analog/basic/mos_r2r_dac.hpp:28
        I(cpphdl_n2018, cpphdl_n2044) <+ V(cpphdl_n2018, cpphdl_n2044) / 2000.0;
        // device 1563, IC IC272, analog/basic/mos_r2r_dac.hpp:29
        I(cpphdl_n2044, Vss) <+ 2.9999999999999998e-15 * ddt(V(cpphdl_n2044, Vss)); // Bench initial voltage = 0.0 V.
        // device 1564, IC IC272, analog/basic/mos_r2r_dac.hpp:31
        I(cpphdl_n2043, cpphdl_n2044) <+ V(cpphdl_n2043, cpphdl_n2044) / 1000.0;
        // device 1565, IC IC275, analog/basic/inverter.hpp:11
        I(cpphdl_n2022, Vdd) <+ cpphdl_channel(V(BIT_N11_2, Vdd), V(cpphdl_n2022, Vdd), 0.080000000000000002, 0.69999999999999996, -1.0);
        // device 1566, IC IC275, analog/basic/inverter.hpp:12
        I(cpphdl_n2022, Vss) <+ cpphdl_channel(V(BIT_N11_2, Vss), V(cpphdl_n2022, Vss), 0.080000000000000002, 0.69999999999999996, 1.0);
        // device 1567, IC IC272, analog/basic/mos_r2r_dac.hpp:27
        I(cpphdl_n2022, Vss) <+ 2.9999999999999998e-15 * ddt(V(cpphdl_n2022, Vss)); // Bench initial voltage = 0.0 V.
        // device 1568, IC IC272, analog/basic/mos_r2r_dac.hpp:28
        I(cpphdl_n2022, cpphdl_n2045) <+ V(cpphdl_n2022, cpphdl_n2045) / 2000.0;
        // device 1569, IC IC272, analog/basic/mos_r2r_dac.hpp:29
        I(cpphdl_n2045, Vss) <+ 2.9999999999999998e-15 * ddt(V(cpphdl_n2045, Vss)); // Bench initial voltage = 0.0 V.
        // device 1570, IC IC272, analog/basic/mos_r2r_dac.hpp:31
        I(cpphdl_n2044, cpphdl_n2045) <+ V(cpphdl_n2044, cpphdl_n2045) / 1000.0;
        // device 1571, IC IC276, analog/basic/inverter.hpp:11
        I(cpphdl_n2026, Vdd) <+ cpphdl_channel(V(BIT_N11_3, Vdd), V(cpphdl_n2026, Vdd), 0.080000000000000002, 0.69999999999999996, -1.0);
        // device 1572, IC IC276, analog/basic/inverter.hpp:12
        I(cpphdl_n2026, Vss) <+ cpphdl_channel(V(BIT_N11_3, Vss), V(cpphdl_n2026, Vss), 0.080000000000000002, 0.69999999999999996, 1.0);
        // device 1573, IC IC272, analog/basic/mos_r2r_dac.hpp:27
        I(cpphdl_n2026, Vss) <+ 2.9999999999999998e-15 * ddt(V(cpphdl_n2026, Vss)); // Bench initial voltage = 0.0 V.
        // device 1574, IC IC272, analog/basic/mos_r2r_dac.hpp:28
        I(cpphdl_n2026, cpphdl_n2046) <+ V(cpphdl_n2026, cpphdl_n2046) / 2000.0;
        // device 1575, IC IC272, analog/basic/mos_r2r_dac.hpp:29
        I(cpphdl_n2046, Vss) <+ 2.9999999999999998e-15 * ddt(V(cpphdl_n2046, Vss)); // Bench initial voltage = 0.0 V.
        // device 1576, IC IC272, analog/basic/mos_r2r_dac.hpp:31
        I(cpphdl_n2045, cpphdl_n2046) <+ V(cpphdl_n2045, cpphdl_n2046) / 1000.0;
        // device 1577, IC IC277, analog/basic/inverter.hpp:11
        I(cpphdl_n2030, Vdd) <+ cpphdl_channel(V(BIT_N11_4, Vdd), V(cpphdl_n2030, Vdd), 0.080000000000000002, 0.69999999999999996, -1.0);
        // device 1578, IC IC277, analog/basic/inverter.hpp:12
        I(cpphdl_n2030, Vss) <+ cpphdl_channel(V(BIT_N11_4, Vss), V(cpphdl_n2030, Vss), 0.080000000000000002, 0.69999999999999996, 1.0);
        // device 1579, IC IC272, analog/basic/mos_r2r_dac.hpp:27
        I(cpphdl_n2030, Vss) <+ 2.9999999999999998e-15 * ddt(V(cpphdl_n2030, Vss)); // Bench initial voltage = 0.0 V.
        // device 1580, IC IC272, analog/basic/mos_r2r_dac.hpp:28
        I(cpphdl_n2030, cpphdl_n2047) <+ V(cpphdl_n2030, cpphdl_n2047) / 2000.0;
        // device 1581, IC IC272, analog/basic/mos_r2r_dac.hpp:29
        I(cpphdl_n2047, Vss) <+ 2.9999999999999998e-15 * ddt(V(cpphdl_n2047, Vss)); // Bench initial voltage = 0.0 V.
        // device 1582, IC IC272, analog/basic/mos_r2r_dac.hpp:31
        I(cpphdl_n2046, cpphdl_n2047) <+ V(cpphdl_n2046, cpphdl_n2047) / 1000.0;
        // device 1583, IC IC278, analog/basic/inverter.hpp:11
        I(cpphdl_n2034, Vdd) <+ cpphdl_channel(V(BIT_N11_5, Vdd), V(cpphdl_n2034, Vdd), 0.080000000000000002, 0.69999999999999996, -1.0);
        // device 1584, IC IC278, analog/basic/inverter.hpp:12
        I(cpphdl_n2034, Vss) <+ cpphdl_channel(V(BIT_N11_5, Vss), V(cpphdl_n2034, Vss), 0.080000000000000002, 0.69999999999999996, 1.0);
        // device 1585, IC IC272, analog/basic/mos_r2r_dac.hpp:27
        I(cpphdl_n2034, Vss) <+ 2.9999999999999998e-15 * ddt(V(cpphdl_n2034, Vss)); // Bench initial voltage = 0.0 V.
        // device 1586, IC IC272, analog/basic/mos_r2r_dac.hpp:28
        I(cpphdl_n2034, cpphdl_n2048) <+ V(cpphdl_n2034, cpphdl_n2048) / 2000.0;
        // device 1587, IC IC272, analog/basic/mos_r2r_dac.hpp:29
        I(cpphdl_n2048, Vss) <+ 2.9999999999999998e-15 * ddt(V(cpphdl_n2048, Vss)); // Bench initial voltage = 0.0 V.
        // device 1588, IC IC272, analog/basic/mos_r2r_dac.hpp:31
        I(cpphdl_n2047, cpphdl_n2048) <+ V(cpphdl_n2047, cpphdl_n2048) / 1000.0;
        // device 1589, IC IC279, analog/basic/inverter.hpp:11
        I(cpphdl_n2038, Vdd) <+ cpphdl_channel(V(BIT_N11_6, Vdd), V(cpphdl_n2038, Vdd), 0.080000000000000002, 0.69999999999999996, -1.0);
        // device 1590, IC IC279, analog/basic/inverter.hpp:12
        I(cpphdl_n2038, Vss) <+ cpphdl_channel(V(BIT_N11_6, Vss), V(cpphdl_n2038, Vss), 0.080000000000000002, 0.69999999999999996, 1.0);
        // device 1591, IC IC272, analog/basic/mos_r2r_dac.hpp:27
        I(cpphdl_n2038, Vss) <+ 2.9999999999999998e-15 * ddt(V(cpphdl_n2038, Vss)); // Bench initial voltage = 0.0 V.
        // device 1592, IC IC272, analog/basic/mos_r2r_dac.hpp:28
        I(cpphdl_n2038, cpphdl_n2049) <+ V(cpphdl_n2038, cpphdl_n2049) / 2000.0;
        // device 1593, IC IC272, analog/basic/mos_r2r_dac.hpp:29
        I(cpphdl_n2049, Vss) <+ 2.9999999999999998e-15 * ddt(V(cpphdl_n2049, Vss)); // Bench initial voltage = 0.0 V.
        // device 1594, IC IC272, analog/basic/mos_r2r_dac.hpp:31
        I(cpphdl_n2048, cpphdl_n2049) <+ V(cpphdl_n2048, cpphdl_n2049) / 1000.0;
        // device 1595, IC IC280, analog/basic/inverter.hpp:11
        I(cpphdl_n2042, Vdd) <+ cpphdl_channel(V(BIT_N11_7, Vdd), V(cpphdl_n2042, Vdd), 0.080000000000000002, 0.69999999999999996, -1.0);
        // device 1596, IC IC280, analog/basic/inverter.hpp:12
        I(cpphdl_n2042, Vss) <+ cpphdl_channel(V(BIT_N11_7, Vss), V(cpphdl_n2042, Vss), 0.080000000000000002, 0.69999999999999996, 1.0);
        // device 1597, IC IC272, analog/basic/mos_r2r_dac.hpp:27
        I(cpphdl_n2042, Vss) <+ 2.9999999999999998e-15 * ddt(V(cpphdl_n2042, Vss)); // Bench initial voltage = 0.0 V.
        // device 1598, IC IC272, analog/basic/mos_r2r_dac.hpp:28
        I(cpphdl_n2042, cpphdl_n2054) <+ V(cpphdl_n2042, cpphdl_n2054) / 2000.0;
        // device 1599, IC IC272, analog/basic/mos_r2r_dac.hpp:29
        I(cpphdl_n2054, Vss) <+ 2.9999999999999998e-15 * ddt(V(cpphdl_n2054, Vss)); // Bench initial voltage = 0.0 V.
        // device 1600, IC IC272, analog/basic/mos_r2r_dac.hpp:31
        I(cpphdl_n2049, cpphdl_n2054) <+ V(cpphdl_n2049, cpphdl_n2054) / 1000.0;
        // device 1601, IC IC272, analog/basic/mos_r2r_dac.hpp:33
        I(Vss, cpphdl_n2043) <+ V(Vss, cpphdl_n2043) / 2000.0;
        // device 1602, IC IC281, analog/basic/nmos_resistor_amplifier.hpp:23
        I(Vdd, cpphdl_n2063) <+ V(Vdd, cpphdl_n2063) / 1000.0;
        // device 1603, IC IC281, analog/basic/nmos_resistor_amplifier.hpp:24
        I(Vdd, cpphdl_n2062) <+ V(Vdd, cpphdl_n2062) / 1000.0;
        // device 1604, IC IC281, analog/basic/nmos_resistor_amplifier.hpp:25
        I(cpphdl_n2063, cpphdl_n2057) <+ cpphdl_channel(V(cpphdl_n2053, cpphdl_n2057), V(cpphdl_n2063, cpphdl_n2057), 0.0074999999999999997, 0.69999999999999996, 1.0);
        // device 1605, IC IC281, analog/basic/nmos_resistor_amplifier.hpp:26
        I(cpphdl_n2062, cpphdl_n2058) <+ cpphdl_channel(V(cpphdl_n2054, cpphdl_n2058), V(cpphdl_n2062, cpphdl_n2058), 0.0074999999999999997, 0.69999999999999996, 1.0);
        // device 1606, IC IC281, analog/basic/nmos_resistor_amplifier.hpp:27
        I(cpphdl_n2059, cpphdl_n2057) <+ V(cpphdl_n2059, cpphdl_n2057) / 100.0;
        // device 1607, IC IC281, analog/basic/nmos_resistor_amplifier.hpp:28
        I(cpphdl_n2059, cpphdl_n2058) <+ V(cpphdl_n2059, cpphdl_n2058) / 100.0;
        // device 1608, IC IC281, analog/basic/nmos_resistor_amplifier.hpp:29
        I(Vss, cpphdl_n2059) <+ V(Vss, cpphdl_n2059) / 300.0;
        // device 1609, IC IC281, analog/basic/nmos_resistor_amplifier.hpp:30
        I(cpphdl_n2063, Vdd) <+ 2.9999999999999998e-13 * ddt(V(cpphdl_n2063, Vdd)); // Bench initial voltage = 0.0 V.
        // device 1610, IC IC281, analog/basic/nmos_resistor_amplifier.hpp:31
        I(cpphdl_n2062, Vdd) <+ 2.9999999999999998e-13 * ddt(V(cpphdl_n2062, Vdd)); // Bench initial voltage = 0.0 V.
        // device 1611, IC IC281, analog/basic/nmos_resistor_amplifier.hpp:32
        I(cpphdl_n2059, Vss) <+ 4e-14 * ddt(V(cpphdl_n2059, Vss)); // Bench initial voltage = 0.0 V.
        // device 1612, IC IC281, analog/basic/nmos_resistor_amplifier.hpp:34
        I(cpphdl_n2053, cpphdl_n2057) <+ 2e-14 * ddt(V(cpphdl_n2053, cpphdl_n2057)); // Bench initial voltage = 0.0 V.
        // device 1613, IC IC281, analog/basic/nmos_resistor_amplifier.hpp:35
        I(cpphdl_n2054, cpphdl_n2058) <+ 2e-14 * ddt(V(cpphdl_n2054, cpphdl_n2058)); // Bench initial voltage = 0.0 V.
        // device 1614, IC IC281, analog/basic/nmos_resistor_amplifier.hpp:36
        I(cpphdl_n2053, cpphdl_n2063) <+ 2.9999999999999998e-15 * ddt(V(cpphdl_n2053, cpphdl_n2063)); // Bench initial voltage = 0.0 V.
        // device 1615, IC IC281, analog/basic/nmos_resistor_amplifier.hpp:37
        I(cpphdl_n2054, cpphdl_n2062) <+ 2.9999999999999998e-15 * ddt(V(cpphdl_n2054, cpphdl_n2062)); // Bench initial voltage = 0.0 V.
        // device 1616, IC IC282, analog/basic/strongarm_comparator.hpp:28
        I(cpphdl_n2067, cpphdl_n2069) <+ cpphdl_channel(V(cpphdl_n2062, cpphdl_n2069), V(cpphdl_n2067, cpphdl_n2069), 0.0080000000000000002, 0.69999999999999996, 1.0);
        // device 1617, IC IC282, analog/basic/strongarm_comparator.hpp:29
        I(cpphdl_n2068, cpphdl_n2069) <+ cpphdl_channel(V(cpphdl_n2063, cpphdl_n2069), V(cpphdl_n2068, cpphdl_n2069), 0.0080000000000000002, 0.69999999999999996, 1.0);
        // device 1618, IC IC282, analog/basic/strongarm_comparator.hpp:30
        I(cpphdl_n2069, Vss) <+ cpphdl_channel(V(EVALUATE, Vss), V(cpphdl_n2069, Vss), 0.0080000000000000002, 0.69999999999999996, 1.0);
        // device 1619, IC IC282, analog/basic/strongarm_comparator.hpp:33
        I(cpphdl_n2082, cpphdl_n2067) <+ cpphdl_channel(V(cpphdl_n2086, cpphdl_n2067), V(cpphdl_n2082, cpphdl_n2067), 0.0040000000000000001, 0.69999999999999996, 1.0);
        // device 1620, IC IC282, analog/basic/strongarm_comparator.hpp:34
        I(cpphdl_n2086, cpphdl_n2068) <+ cpphdl_channel(V(cpphdl_n2082, cpphdl_n2068), V(cpphdl_n2086, cpphdl_n2068), 0.0040000000000000001, 0.69999999999999996, 1.0);
        // device 1621, IC IC282, analog/basic/strongarm_comparator.hpp:35
        I(cpphdl_n2086, Vdd) <+ cpphdl_channel(V(cpphdl_n2082, Vdd), V(cpphdl_n2086, Vdd), 0.002, 0.69999999999999996, -1.0);
        // device 1622, IC IC282, analog/basic/strongarm_comparator.hpp:36
        I(cpphdl_n2082, Vdd) <+ cpphdl_channel(V(cpphdl_n2086, Vdd), V(cpphdl_n2082, Vdd), 0.002, 0.69999999999999996, -1.0);
        // device 1623, IC IC282, analog/basic/strongarm_comparator.hpp:38
        I(cpphdl_n2067, Vdd) <+ cpphdl_channel(V(EVALUATE, Vdd), V(cpphdl_n2067, Vdd), 0.002, 0.69999999999999996, -1.0);
        // device 1624, IC IC282, analog/basic/strongarm_comparator.hpp:39
        I(cpphdl_n2068, Vdd) <+ cpphdl_channel(V(EVALUATE, Vdd), V(cpphdl_n2068, Vdd), 0.002, 0.69999999999999996, -1.0);
        // device 1625, IC IC282, analog/basic/strongarm_comparator.hpp:40
        I(cpphdl_n2086, Vdd) <+ cpphdl_channel(V(EVALUATE, Vdd), V(cpphdl_n2086, Vdd), 0.002, 0.69999999999999996, -1.0);
        // device 1626, IC IC282, analog/basic/strongarm_comparator.hpp:41
        I(cpphdl_n2082, Vdd) <+ cpphdl_channel(V(EVALUATE, Vdd), V(cpphdl_n2082, Vdd), 0.002, 0.69999999999999996, -1.0);
        // device 1627, IC IC282, analog/basic/strongarm_comparator.hpp:42
        I(cpphdl_n2067, Vss) <+ 2.9999999999999998e-14 * ddt(V(cpphdl_n2067, Vss)); // Bench initial voltage = 0.0 V.
        // device 1628, IC IC282, analog/basic/strongarm_comparator.hpp:43
        I(cpphdl_n2068, Vss) <+ 2.9999999999999998e-14 * ddt(V(cpphdl_n2068, Vss)); // Bench initial voltage = 0.0 V.
        // device 1629, IC IC282, analog/basic/strongarm_comparator.hpp:44
        I(cpphdl_n2069, Vss) <+ 2.9999999999999998e-14 * ddt(V(cpphdl_n2069, Vss)); // Bench initial voltage = 0.0 V.
        // device 1630, IC IC282, analog/basic/strongarm_comparator.hpp:45
        I(cpphdl_n2086, Vss) <+ 5.0000000000000002e-14 * ddt(V(cpphdl_n2086, Vss)); // Bench initial voltage = 0.0 V.
        // device 1631, IC IC282, analog/basic/strongarm_comparator.hpp:46
        I(cpphdl_n2082, Vss) <+ 5.0000000000000002e-14 * ddt(V(cpphdl_n2082, Vss)); // Bench initial voltage = 0.0 V.
        // device 1632, IC IC282, analog/basic/strongarm_comparator.hpp:47
        I(cpphdl_n2062, cpphdl_n2069) <+ 2e-14 * ddt(V(cpphdl_n2062, cpphdl_n2069)); // Bench initial voltage = 0.0 V.
        // device 1633, IC IC282, analog/basic/strongarm_comparator.hpp:48
        I(cpphdl_n2063, cpphdl_n2069) <+ 2e-14 * ddt(V(cpphdl_n2063, cpphdl_n2069)); // Bench initial voltage = 0.0 V.
        // device 1634, IC IC282, analog/basic/strongarm_comparator.hpp:49
        I(cpphdl_n2062, cpphdl_n2067) <+ 2.9999999999999998e-15 * ddt(V(cpphdl_n2062, cpphdl_n2067)); // Bench initial voltage = 0.0 V.
        // device 1635, IC IC282, analog/basic/strongarm_comparator.hpp:50
        I(cpphdl_n2063, cpphdl_n2068) <+ 2.9999999999999998e-15 * ddt(V(cpphdl_n2063, cpphdl_n2068)); // Bench initial voltage = 0.0 V.
        // device 1636, IC IC284, analog/basic/inverter.hpp:11
        I(cpphdl_n2090, Vdd) <+ cpphdl_channel(V(cpphdl_n2082, Vdd), V(cpphdl_n2090, Vdd), 0.001, 0.69999999999999996, -1.0);
        // device 1637, IC IC284, analog/basic/inverter.hpp:12
        I(cpphdl_n2090, Vss) <+ cpphdl_channel(V(cpphdl_n2082, Vss), V(cpphdl_n2090, Vss), 0.001, 0.69999999999999996, 1.0);
        // device 1638, IC IC286, analog/basic/inverter.hpp:11
        I(cpphdl_n2104, Vdd) <+ cpphdl_channel(V(cpphdl_n2090, Vdd), V(cpphdl_n2104, Vdd), 0.0040000000000000001, 0.69999999999999996, -1.0);
        // device 1639, IC IC286, analog/basic/inverter.hpp:12
        I(cpphdl_n2104, Vss) <+ cpphdl_channel(V(cpphdl_n2090, Vss), V(cpphdl_n2104, Vss), 0.0040000000000000001, 0.69999999999999996, 1.0);
        // device 1640, IC IC283, analog/basic/buffered_nand_latch.hpp:34
        I(cpphdl_n2082, Vss) <+ 2.0000000000000002e-15 * ddt(V(cpphdl_n2082, Vss)); // Bench initial voltage = 0.0 V.
        // device 1641, IC IC283, analog/basic/buffered_nand_latch.hpp:35
        I(cpphdl_n2082, cpphdl_n2090) <+ 1.0000000000000001e-15 * ddt(V(cpphdl_n2082, cpphdl_n2090)); // Bench initial voltage = 0.0 V.
        // device 1642, IC IC283, analog/basic/buffered_nand_latch.hpp:36
        I(cpphdl_n2090, Vss) <+ 5e-15 * ddt(V(cpphdl_n2090, Vss)); // Bench initial voltage = 0.0 V.
        // device 1643, IC IC283, analog/basic/buffered_nand_latch.hpp:37
        I(cpphdl_n2090, Vss) <+ 8.0000000000000006e-15 * ddt(V(cpphdl_n2090, Vss)); // Bench initial voltage = 0.0 V.
        // device 1644, IC IC283, analog/basic/buffered_nand_latch.hpp:38
        I(cpphdl_n2104, Vss) <+ 1e-14 * ddt(V(cpphdl_n2104, Vss)); // Bench initial voltage = 0.0 V.
        // device 1645, IC IC285, analog/basic/inverter.hpp:11
        I(cpphdl_n2094, Vdd) <+ cpphdl_channel(V(cpphdl_n2086, Vdd), V(cpphdl_n2094, Vdd), 0.001, 0.69999999999999996, -1.0);
        // device 1646, IC IC285, analog/basic/inverter.hpp:12
        I(cpphdl_n2094, Vss) <+ cpphdl_channel(V(cpphdl_n2086, Vss), V(cpphdl_n2094, Vss), 0.001, 0.69999999999999996, 1.0);
        // device 1647, IC IC287, analog/basic/inverter.hpp:11
        I(cpphdl_n2110, Vdd) <+ cpphdl_channel(V(cpphdl_n2094, Vdd), V(cpphdl_n2110, Vdd), 0.0040000000000000001, 0.69999999999999996, -1.0);
        // device 1648, IC IC287, analog/basic/inverter.hpp:12
        I(cpphdl_n2110, Vss) <+ cpphdl_channel(V(cpphdl_n2094, Vss), V(cpphdl_n2110, Vss), 0.0040000000000000001, 0.69999999999999996, 1.0);
        // device 1649, IC IC283, analog/basic/buffered_nand_latch.hpp:34
        I(cpphdl_n2086, Vss) <+ 2.0000000000000002e-15 * ddt(V(cpphdl_n2086, Vss)); // Bench initial voltage = 0.0 V.
        // device 1650, IC IC283, analog/basic/buffered_nand_latch.hpp:35
        I(cpphdl_n2086, cpphdl_n2094) <+ 1.0000000000000001e-15 * ddt(V(cpphdl_n2086, cpphdl_n2094)); // Bench initial voltage = 0.0 V.
        // device 1651, IC IC283, analog/basic/buffered_nand_latch.hpp:36
        I(cpphdl_n2094, Vss) <+ 5e-15 * ddt(V(cpphdl_n2094, Vss)); // Bench initial voltage = 0.0 V.
        // device 1652, IC IC283, analog/basic/buffered_nand_latch.hpp:37
        I(cpphdl_n2094, Vss) <+ 8.0000000000000006e-15 * ddt(V(cpphdl_n2094, Vss)); // Bench initial voltage = 0.0 V.
        // device 1653, IC IC283, analog/basic/buffered_nand_latch.hpp:38
        I(cpphdl_n2110, Vss) <+ 1e-14 * ddt(V(cpphdl_n2110, Vss)); // Bench initial voltage = 0.0 V.
        // device 1654, IC IC289, analog/basic/cmos_logic.hpp:17
        I(cpphdl_n2333, Vss) <+ 5.0000000000000002e-14 * ddt(V(cpphdl_n2333, Vss)); // Bench initial voltage = 0.0 V.
        // device 1655, IC IC289, analog/basic/cmos_logic.hpp:18
        I(cpphdl_n2333, Vdd) <+ cpphdl_channel(V(cpphdl_n2104, Vdd), V(cpphdl_n2333, Vdd), 0.01, 0.69999999999999996, -1.0);
        // device 1656, IC IC289, analog/basic/cmos_logic.hpp:19
        I(cpphdl_n2333, Vdd) <+ cpphdl_channel(V(cpphdl_n2112, Vdd), V(cpphdl_n2333, Vdd), 0.01, 0.69999999999999996, -1.0);
        // device 1657, IC IC289, analog/basic/cmos_logic.hpp:20
        I(cpphdl_n2333, cpphdl_n2107) <+ cpphdl_channel(V(cpphdl_n2104, cpphdl_n2107), V(cpphdl_n2333, cpphdl_n2107), 0.01, 0.69999999999999996, 1.0);
        // device 1658, IC IC289, analog/basic/cmos_logic.hpp:21
        I(cpphdl_n2107, Vss) <+ cpphdl_channel(V(cpphdl_n2112, Vss), V(cpphdl_n2107, Vss), 0.01, 0.69999999999999996, 1.0);
        // device 1659, IC IC289, analog/basic/cmos_logic.hpp:27
        I(cpphdl_n2107, Vss) <+ 1e-14 * ddt(V(cpphdl_n2107, Vss)); // Bench initial voltage = 0.0 V.
        // device 1660, IC IC290, analog/basic/cmos_logic.hpp:17
        I(cpphdl_n2112, Vss) <+ 5.0000000000000002e-14 * ddt(V(cpphdl_n2112, Vss)); // Bench initial voltage = 0.0 V.
        // device 1661, IC IC290, analog/basic/cmos_logic.hpp:18
        I(cpphdl_n2112, Vdd) <+ cpphdl_channel(V(cpphdl_n2110, Vdd), V(cpphdl_n2112, Vdd), 0.01, 0.69999999999999996, -1.0);
        // device 1662, IC IC290, analog/basic/cmos_logic.hpp:19
        I(cpphdl_n2112, Vdd) <+ cpphdl_channel(V(cpphdl_n2333, Vdd), V(cpphdl_n2112, Vdd), 0.01, 0.69999999999999996, -1.0);
        // device 1663, IC IC290, analog/basic/cmos_logic.hpp:20
        I(cpphdl_n2112, cpphdl_n2113) <+ cpphdl_channel(V(cpphdl_n2110, cpphdl_n2113), V(cpphdl_n2112, cpphdl_n2113), 0.01, 0.69999999999999996, 1.0);
        // device 1664, IC IC290, analog/basic/cmos_logic.hpp:21
        I(cpphdl_n2113, Vss) <+ cpphdl_channel(V(cpphdl_n2333, Vss), V(cpphdl_n2113, Vss), 0.01, 0.69999999999999996, 1.0);
        // device 1665, IC IC290, analog/basic/cmos_logic.hpp:27
        I(cpphdl_n2113, Vss) <+ 1e-14 * ddt(V(cpphdl_n2113, Vss)); // Bench initial voltage = 0.0 V.
        // device 1666, IC IC288, analog/basic/nand_latch.hpp:36
        I(cpphdl_n2104, Vss) <+ 2.9999999999999998e-15 * ddt(V(cpphdl_n2104, Vss)); // Bench initial voltage = 0.0 V.
        // device 1667, IC IC288, analog/basic/nand_latch.hpp:37
        I(cpphdl_n2110, Vss) <+ 2.9999999999999998e-15 * ddt(V(cpphdl_n2110, Vss)); // Bench initial voltage = 0.0 V.
        // device 1668, IC IC291, analog/basic/inverter.hpp:11
        I(cpphdl_n2118, Vdd) <+ cpphdl_channel(V(CLEAR, Vdd), V(cpphdl_n2118, Vdd), 0.01, 0.69999999999999996, -1.0);
        // device 1669, IC IC291, analog/basic/inverter.hpp:12
        I(cpphdl_n2118, Vss) <+ cpphdl_channel(V(CLEAR, Vss), V(cpphdl_n2118, Vss), 0.01, 0.69999999999999996, 1.0);
        // device 1670, IC IC288, analog/basic/nand_latch.hpp:58
        I(cpphdl_n2118, Vss) <+ 2.9999999999999998e-15 * ddt(V(cpphdl_n2118, Vss)); // Bench initial voltage = 0.0 V.
        // device 1671, IC IC288, analog/basic/nand_latch.hpp:59
        I(cpphdl_n2333, Vss) <+ cpphdl_channel(V(CLEAR, Vss), V(cpphdl_n2333, Vss), 0.050000000000000003, 0.69999999999999996, 1.0);
        // device 1672, IC IC288, analog/basic/nand_latch.hpp:60
        I(cpphdl_n2112, Vdd) <+ cpphdl_channel(V(cpphdl_n2118, Vdd), V(cpphdl_n2112, Vdd), 0.050000000000000003, 0.69999999999999996, -1.0);
        // device 1673, IC IC294, analog/basic/inverter.hpp:11
        I(cpphdl_n2142, Vdd) <+ cpphdl_channel(V(TRACK12, Vdd), V(cpphdl_n2142, Vdd), 0.0040000000000000001, 0.69999999999999996, -1.0);
        // device 1674, IC IC294, analog/basic/inverter.hpp:12
        I(cpphdl_n2142, Vss) <+ cpphdl_channel(V(TRACK12, Vss), V(cpphdl_n2142, Vss), 0.0040000000000000001, 0.69999999999999996, 1.0);
        // device 1675, IC IC293, analog/basic/mos_track_hold.hpp:31
        I(cpphdl_n2142, Vss) <+ 2e-14 * ddt(V(cpphdl_n2142, Vss)); // Bench initial voltage = 0.0 V.
        // device 1676, IC IC293, analog/basic/mos_track_hold.hpp:32
        I(cpphdl_n2136, cpphdl_n2196) <+ cpphdl_channel(V(TRACK12, cpphdl_n2196), V(cpphdl_n2136, cpphdl_n2196), 0.029999999999999999, 0.69999999999999996, 1.0);
        // device 1677, IC IC293, analog/basic/mos_track_hold.hpp:33
        I(cpphdl_n2196, cpphdl_n2136) <+ cpphdl_channel(V(cpphdl_n2142, cpphdl_n2136), V(cpphdl_n2196, cpphdl_n2136), 0.014999999999999999, 0.69999999999999996, -1.0);
        // device 1678, IC IC293, analog/basic/mos_track_hold.hpp:37
        I(cpphdl_n2196, cpphdl_n2196) <+ cpphdl_channel(V(cpphdl_n2142, cpphdl_n2196), V(cpphdl_n2196, cpphdl_n2196), 0.016, 0.69999999999999996, 1.0);
        // device 1679, IC IC293, analog/basic/mos_track_hold.hpp:38
        I(cpphdl_n2196, cpphdl_n2196) <+ cpphdl_channel(V(TRACK12, cpphdl_n2196), V(cpphdl_n2196, cpphdl_n2196), 0.0083999999999999995, 0.69999999999999996, -1.0);
        // device 1680, IC IC293, analog/basic/mos_track_hold.hpp:39
        I(cpphdl_n2196, Vss) <+ 1.5000000000000001e-12 * ddt(V(cpphdl_n2196, Vss)); // Bench initial voltage = 0.0 V.
        // device 1681, IC IC293, analog/basic/mos_track_hold.hpp:42
        I(TRACK12, cpphdl_n2196) <+ 2.0000000000000002e-15 * ddt(V(TRACK12, cpphdl_n2196)); // Bench initial voltage = -0.0 V.
        // device 1682, IC IC293, analog/basic/mos_track_hold.hpp:43
        I(cpphdl_n2142, cpphdl_n2196) <+ 2.0000000000000002e-15 * ddt(V(cpphdl_n2142, cpphdl_n2196)); // Bench initial voltage = 0.0 V.
        // device 1683, IC IC293, analog/basic/mos_track_hold.hpp:44
        I(cpphdl_n2136, cpphdl_n2196) <+ 1.0000000000000001e-15 * ddt(V(cpphdl_n2136, cpphdl_n2196)); // Bench initial voltage = 0.0 V.
        // device 1684, IC IC296, analog/basic/inverter.hpp:11
        I(cpphdl_n2157, Vdd) <+ cpphdl_channel(V(BIT_N12_0, Vdd), V(cpphdl_n2157, Vdd), 0.080000000000000002, 0.69999999999999996, -1.0);
        // device 1685, IC IC296, analog/basic/inverter.hpp:12
        I(cpphdl_n2157, Vss) <+ cpphdl_channel(V(BIT_N12_0, Vss), V(cpphdl_n2157, Vss), 0.080000000000000002, 0.69999999999999996, 1.0);
        // device 1686, IC IC295, analog/basic/mos_r2r_dac.hpp:27
        I(cpphdl_n2157, Vss) <+ 2.9999999999999998e-15 * ddt(V(cpphdl_n2157, Vss)); // Bench initial voltage = 0.0 V.
        // device 1687, IC IC295, analog/basic/mos_r2r_dac.hpp:28
        I(cpphdl_n2157, cpphdl_n2186) <+ V(cpphdl_n2157, cpphdl_n2186) / 2000.0;
        // device 1688, IC IC295, analog/basic/mos_r2r_dac.hpp:29
        I(cpphdl_n2186, Vss) <+ 2.9999999999999998e-15 * ddt(V(cpphdl_n2186, Vss)); // Bench initial voltage = 0.0 V.
        // device 1689, IC IC297, analog/basic/inverter.hpp:11
        I(cpphdl_n2161, Vdd) <+ cpphdl_channel(V(BIT_N12_1, Vdd), V(cpphdl_n2161, Vdd), 0.080000000000000002, 0.69999999999999996, -1.0);
        // device 1690, IC IC297, analog/basic/inverter.hpp:12
        I(cpphdl_n2161, Vss) <+ cpphdl_channel(V(BIT_N12_1, Vss), V(cpphdl_n2161, Vss), 0.080000000000000002, 0.69999999999999996, 1.0);
        // device 1691, IC IC295, analog/basic/mos_r2r_dac.hpp:27
        I(cpphdl_n2161, Vss) <+ 2.9999999999999998e-15 * ddt(V(cpphdl_n2161, Vss)); // Bench initial voltage = 0.0 V.
        // device 1692, IC IC295, analog/basic/mos_r2r_dac.hpp:28
        I(cpphdl_n2161, cpphdl_n2187) <+ V(cpphdl_n2161, cpphdl_n2187) / 2000.0;
        // device 1693, IC IC295, analog/basic/mos_r2r_dac.hpp:29
        I(cpphdl_n2187, Vss) <+ 2.9999999999999998e-15 * ddt(V(cpphdl_n2187, Vss)); // Bench initial voltage = 0.0 V.
        // device 1694, IC IC295, analog/basic/mos_r2r_dac.hpp:31
        I(cpphdl_n2186, cpphdl_n2187) <+ V(cpphdl_n2186, cpphdl_n2187) / 1000.0;
        // device 1695, IC IC298, analog/basic/inverter.hpp:11
        I(cpphdl_n2165, Vdd) <+ cpphdl_channel(V(BIT_N12_2, Vdd), V(cpphdl_n2165, Vdd), 0.080000000000000002, 0.69999999999999996, -1.0);
        // device 1696, IC IC298, analog/basic/inverter.hpp:12
        I(cpphdl_n2165, Vss) <+ cpphdl_channel(V(BIT_N12_2, Vss), V(cpphdl_n2165, Vss), 0.080000000000000002, 0.69999999999999996, 1.0);
        // device 1697, IC IC295, analog/basic/mos_r2r_dac.hpp:27
        I(cpphdl_n2165, Vss) <+ 2.9999999999999998e-15 * ddt(V(cpphdl_n2165, Vss)); // Bench initial voltage = 0.0 V.
        // device 1698, IC IC295, analog/basic/mos_r2r_dac.hpp:28
        I(cpphdl_n2165, cpphdl_n2188) <+ V(cpphdl_n2165, cpphdl_n2188) / 2000.0;
        // device 1699, IC IC295, analog/basic/mos_r2r_dac.hpp:29
        I(cpphdl_n2188, Vss) <+ 2.9999999999999998e-15 * ddt(V(cpphdl_n2188, Vss)); // Bench initial voltage = 0.0 V.
        // device 1700, IC IC295, analog/basic/mos_r2r_dac.hpp:31
        I(cpphdl_n2187, cpphdl_n2188) <+ V(cpphdl_n2187, cpphdl_n2188) / 1000.0;
        // device 1701, IC IC299, analog/basic/inverter.hpp:11
        I(cpphdl_n2169, Vdd) <+ cpphdl_channel(V(BIT_N12_3, Vdd), V(cpphdl_n2169, Vdd), 0.080000000000000002, 0.69999999999999996, -1.0);
        // device 1702, IC IC299, analog/basic/inverter.hpp:12
        I(cpphdl_n2169, Vss) <+ cpphdl_channel(V(BIT_N12_3, Vss), V(cpphdl_n2169, Vss), 0.080000000000000002, 0.69999999999999996, 1.0);
        // device 1703, IC IC295, analog/basic/mos_r2r_dac.hpp:27
        I(cpphdl_n2169, Vss) <+ 2.9999999999999998e-15 * ddt(V(cpphdl_n2169, Vss)); // Bench initial voltage = 0.0 V.
        // device 1704, IC IC295, analog/basic/mos_r2r_dac.hpp:28
        I(cpphdl_n2169, cpphdl_n2189) <+ V(cpphdl_n2169, cpphdl_n2189) / 2000.0;
        // device 1705, IC IC295, analog/basic/mos_r2r_dac.hpp:29
        I(cpphdl_n2189, Vss) <+ 2.9999999999999998e-15 * ddt(V(cpphdl_n2189, Vss)); // Bench initial voltage = 0.0 V.
        // device 1706, IC IC295, analog/basic/mos_r2r_dac.hpp:31
        I(cpphdl_n2188, cpphdl_n2189) <+ V(cpphdl_n2188, cpphdl_n2189) / 1000.0;
        // device 1707, IC IC300, analog/basic/inverter.hpp:11
        I(cpphdl_n2173, Vdd) <+ cpphdl_channel(V(BIT_N12_4, Vdd), V(cpphdl_n2173, Vdd), 0.080000000000000002, 0.69999999999999996, -1.0);
        // device 1708, IC IC300, analog/basic/inverter.hpp:12
        I(cpphdl_n2173, Vss) <+ cpphdl_channel(V(BIT_N12_4, Vss), V(cpphdl_n2173, Vss), 0.080000000000000002, 0.69999999999999996, 1.0);
        // device 1709, IC IC295, analog/basic/mos_r2r_dac.hpp:27
        I(cpphdl_n2173, Vss) <+ 2.9999999999999998e-15 * ddt(V(cpphdl_n2173, Vss)); // Bench initial voltage = 0.0 V.
        // device 1710, IC IC295, analog/basic/mos_r2r_dac.hpp:28
        I(cpphdl_n2173, cpphdl_n2190) <+ V(cpphdl_n2173, cpphdl_n2190) / 2000.0;
        // device 1711, IC IC295, analog/basic/mos_r2r_dac.hpp:29
        I(cpphdl_n2190, Vss) <+ 2.9999999999999998e-15 * ddt(V(cpphdl_n2190, Vss)); // Bench initial voltage = 0.0 V.
        // device 1712, IC IC295, analog/basic/mos_r2r_dac.hpp:31
        I(cpphdl_n2189, cpphdl_n2190) <+ V(cpphdl_n2189, cpphdl_n2190) / 1000.0;
        // device 1713, IC IC301, analog/basic/inverter.hpp:11
        I(cpphdl_n2177, Vdd) <+ cpphdl_channel(V(BIT_N12_5, Vdd), V(cpphdl_n2177, Vdd), 0.080000000000000002, 0.69999999999999996, -1.0);
        // device 1714, IC IC301, analog/basic/inverter.hpp:12
        I(cpphdl_n2177, Vss) <+ cpphdl_channel(V(BIT_N12_5, Vss), V(cpphdl_n2177, Vss), 0.080000000000000002, 0.69999999999999996, 1.0);
        // device 1715, IC IC295, analog/basic/mos_r2r_dac.hpp:27
        I(cpphdl_n2177, Vss) <+ 2.9999999999999998e-15 * ddt(V(cpphdl_n2177, Vss)); // Bench initial voltage = 0.0 V.
        // device 1716, IC IC295, analog/basic/mos_r2r_dac.hpp:28
        I(cpphdl_n2177, cpphdl_n2191) <+ V(cpphdl_n2177, cpphdl_n2191) / 2000.0;
        // device 1717, IC IC295, analog/basic/mos_r2r_dac.hpp:29
        I(cpphdl_n2191, Vss) <+ 2.9999999999999998e-15 * ddt(V(cpphdl_n2191, Vss)); // Bench initial voltage = 0.0 V.
        // device 1718, IC IC295, analog/basic/mos_r2r_dac.hpp:31
        I(cpphdl_n2190, cpphdl_n2191) <+ V(cpphdl_n2190, cpphdl_n2191) / 1000.0;
        // device 1719, IC IC302, analog/basic/inverter.hpp:11
        I(cpphdl_n2181, Vdd) <+ cpphdl_channel(V(BIT_N12_6, Vdd), V(cpphdl_n2181, Vdd), 0.080000000000000002, 0.69999999999999996, -1.0);
        // device 1720, IC IC302, analog/basic/inverter.hpp:12
        I(cpphdl_n2181, Vss) <+ cpphdl_channel(V(BIT_N12_6, Vss), V(cpphdl_n2181, Vss), 0.080000000000000002, 0.69999999999999996, 1.0);
        // device 1721, IC IC295, analog/basic/mos_r2r_dac.hpp:27
        I(cpphdl_n2181, Vss) <+ 2.9999999999999998e-15 * ddt(V(cpphdl_n2181, Vss)); // Bench initial voltage = 0.0 V.
        // device 1722, IC IC295, analog/basic/mos_r2r_dac.hpp:28
        I(cpphdl_n2181, cpphdl_n2192) <+ V(cpphdl_n2181, cpphdl_n2192) / 2000.0;
        // device 1723, IC IC295, analog/basic/mos_r2r_dac.hpp:29
        I(cpphdl_n2192, Vss) <+ 2.9999999999999998e-15 * ddt(V(cpphdl_n2192, Vss)); // Bench initial voltage = 0.0 V.
        // device 1724, IC IC295, analog/basic/mos_r2r_dac.hpp:31
        I(cpphdl_n2191, cpphdl_n2192) <+ V(cpphdl_n2191, cpphdl_n2192) / 1000.0;
        // device 1725, IC IC303, analog/basic/inverter.hpp:11
        I(cpphdl_n2185, Vdd) <+ cpphdl_channel(V(BIT_N12_7, Vdd), V(cpphdl_n2185, Vdd), 0.080000000000000002, 0.69999999999999996, -1.0);
        // device 1726, IC IC303, analog/basic/inverter.hpp:12
        I(cpphdl_n2185, Vss) <+ cpphdl_channel(V(BIT_N12_7, Vss), V(cpphdl_n2185, Vss), 0.080000000000000002, 0.69999999999999996, 1.0);
        // device 1727, IC IC295, analog/basic/mos_r2r_dac.hpp:27
        I(cpphdl_n2185, Vss) <+ 2.9999999999999998e-15 * ddt(V(cpphdl_n2185, Vss)); // Bench initial voltage = 0.0 V.
        // device 1728, IC IC295, analog/basic/mos_r2r_dac.hpp:28
        I(cpphdl_n2185, cpphdl_n2197) <+ V(cpphdl_n2185, cpphdl_n2197) / 2000.0;
        // device 1729, IC IC295, analog/basic/mos_r2r_dac.hpp:29
        I(cpphdl_n2197, Vss) <+ 2.9999999999999998e-15 * ddt(V(cpphdl_n2197, Vss)); // Bench initial voltage = 0.0 V.
        // device 1730, IC IC295, analog/basic/mos_r2r_dac.hpp:31
        I(cpphdl_n2192, cpphdl_n2197) <+ V(cpphdl_n2192, cpphdl_n2197) / 1000.0;
        // device 1731, IC IC295, analog/basic/mos_r2r_dac.hpp:33
        I(Vss, cpphdl_n2186) <+ V(Vss, cpphdl_n2186) / 2000.0;
        // device 1732, IC IC304, analog/basic/nmos_resistor_amplifier.hpp:23
        I(Vdd, cpphdl_n2206) <+ V(Vdd, cpphdl_n2206) / 1000.0;
        // device 1733, IC IC304, analog/basic/nmos_resistor_amplifier.hpp:24
        I(Vdd, cpphdl_n2205) <+ V(Vdd, cpphdl_n2205) / 1000.0;
        // device 1734, IC IC304, analog/basic/nmos_resistor_amplifier.hpp:25
        I(cpphdl_n2206, cpphdl_n2200) <+ cpphdl_channel(V(cpphdl_n2196, cpphdl_n2200), V(cpphdl_n2206, cpphdl_n2200), 0.0074999999999999997, 0.69999999999999996, 1.0);
        // device 1735, IC IC304, analog/basic/nmos_resistor_amplifier.hpp:26
        I(cpphdl_n2205, cpphdl_n2201) <+ cpphdl_channel(V(cpphdl_n2197, cpphdl_n2201), V(cpphdl_n2205, cpphdl_n2201), 0.0074999999999999997, 0.69999999999999996, 1.0);
        // device 1736, IC IC304, analog/basic/nmos_resistor_amplifier.hpp:27
        I(cpphdl_n2202, cpphdl_n2200) <+ V(cpphdl_n2202, cpphdl_n2200) / 100.0;
        // device 1737, IC IC304, analog/basic/nmos_resistor_amplifier.hpp:28
        I(cpphdl_n2202, cpphdl_n2201) <+ V(cpphdl_n2202, cpphdl_n2201) / 100.0;
        // device 1738, IC IC304, analog/basic/nmos_resistor_amplifier.hpp:29
        I(Vss, cpphdl_n2202) <+ V(Vss, cpphdl_n2202) / 300.0;
        // device 1739, IC IC304, analog/basic/nmos_resistor_amplifier.hpp:30
        I(cpphdl_n2206, Vdd) <+ 2.9999999999999998e-13 * ddt(V(cpphdl_n2206, Vdd)); // Bench initial voltage = 0.0 V.
        // device 1740, IC IC304, analog/basic/nmos_resistor_amplifier.hpp:31
        I(cpphdl_n2205, Vdd) <+ 2.9999999999999998e-13 * ddt(V(cpphdl_n2205, Vdd)); // Bench initial voltage = 0.0 V.
        // device 1741, IC IC304, analog/basic/nmos_resistor_amplifier.hpp:32
        I(cpphdl_n2202, Vss) <+ 4e-14 * ddt(V(cpphdl_n2202, Vss)); // Bench initial voltage = 0.0 V.
        // device 1742, IC IC304, analog/basic/nmos_resistor_amplifier.hpp:34
        I(cpphdl_n2196, cpphdl_n2200) <+ 2e-14 * ddt(V(cpphdl_n2196, cpphdl_n2200)); // Bench initial voltage = 0.0 V.
        // device 1743, IC IC304, analog/basic/nmos_resistor_amplifier.hpp:35
        I(cpphdl_n2197, cpphdl_n2201) <+ 2e-14 * ddt(V(cpphdl_n2197, cpphdl_n2201)); // Bench initial voltage = 0.0 V.
        // device 1744, IC IC304, analog/basic/nmos_resistor_amplifier.hpp:36
        I(cpphdl_n2196, cpphdl_n2206) <+ 2.9999999999999998e-15 * ddt(V(cpphdl_n2196, cpphdl_n2206)); // Bench initial voltage = 0.0 V.
        // device 1745, IC IC304, analog/basic/nmos_resistor_amplifier.hpp:37
        I(cpphdl_n2197, cpphdl_n2205) <+ 2.9999999999999998e-15 * ddt(V(cpphdl_n2197, cpphdl_n2205)); // Bench initial voltage = 0.0 V.
        // device 1746, IC IC305, analog/basic/strongarm_comparator.hpp:28
        I(cpphdl_n2210, cpphdl_n2212) <+ cpphdl_channel(V(cpphdl_n2205, cpphdl_n2212), V(cpphdl_n2210, cpphdl_n2212), 0.0080000000000000002, 0.69999999999999996, 1.0);
        // device 1747, IC IC305, analog/basic/strongarm_comparator.hpp:29
        I(cpphdl_n2211, cpphdl_n2212) <+ cpphdl_channel(V(cpphdl_n2206, cpphdl_n2212), V(cpphdl_n2211, cpphdl_n2212), 0.0080000000000000002, 0.69999999999999996, 1.0);
        // device 1748, IC IC305, analog/basic/strongarm_comparator.hpp:30
        I(cpphdl_n2212, Vss) <+ cpphdl_channel(V(EVALUATE, Vss), V(cpphdl_n2212, Vss), 0.0080000000000000002, 0.69999999999999996, 1.0);
        // device 1749, IC IC305, analog/basic/strongarm_comparator.hpp:33
        I(cpphdl_n2225, cpphdl_n2210) <+ cpphdl_channel(V(cpphdl_n2229, cpphdl_n2210), V(cpphdl_n2225, cpphdl_n2210), 0.0040000000000000001, 0.69999999999999996, 1.0);
        // device 1750, IC IC305, analog/basic/strongarm_comparator.hpp:34
        I(cpphdl_n2229, cpphdl_n2211) <+ cpphdl_channel(V(cpphdl_n2225, cpphdl_n2211), V(cpphdl_n2229, cpphdl_n2211), 0.0040000000000000001, 0.69999999999999996, 1.0);
        // device 1751, IC IC305, analog/basic/strongarm_comparator.hpp:35
        I(cpphdl_n2229, Vdd) <+ cpphdl_channel(V(cpphdl_n2225, Vdd), V(cpphdl_n2229, Vdd), 0.002, 0.69999999999999996, -1.0);
        // device 1752, IC IC305, analog/basic/strongarm_comparator.hpp:36
        I(cpphdl_n2225, Vdd) <+ cpphdl_channel(V(cpphdl_n2229, Vdd), V(cpphdl_n2225, Vdd), 0.002, 0.69999999999999996, -1.0);
        // device 1753, IC IC305, analog/basic/strongarm_comparator.hpp:38
        I(cpphdl_n2210, Vdd) <+ cpphdl_channel(V(EVALUATE, Vdd), V(cpphdl_n2210, Vdd), 0.002, 0.69999999999999996, -1.0);
        // device 1754, IC IC305, analog/basic/strongarm_comparator.hpp:39
        I(cpphdl_n2211, Vdd) <+ cpphdl_channel(V(EVALUATE, Vdd), V(cpphdl_n2211, Vdd), 0.002, 0.69999999999999996, -1.0);
        // device 1755, IC IC305, analog/basic/strongarm_comparator.hpp:40
        I(cpphdl_n2229, Vdd) <+ cpphdl_channel(V(EVALUATE, Vdd), V(cpphdl_n2229, Vdd), 0.002, 0.69999999999999996, -1.0);
        // device 1756, IC IC305, analog/basic/strongarm_comparator.hpp:41
        I(cpphdl_n2225, Vdd) <+ cpphdl_channel(V(EVALUATE, Vdd), V(cpphdl_n2225, Vdd), 0.002, 0.69999999999999996, -1.0);
        // device 1757, IC IC305, analog/basic/strongarm_comparator.hpp:42
        I(cpphdl_n2210, Vss) <+ 2.9999999999999998e-14 * ddt(V(cpphdl_n2210, Vss)); // Bench initial voltage = 0.0 V.
        // device 1758, IC IC305, analog/basic/strongarm_comparator.hpp:43
        I(cpphdl_n2211, Vss) <+ 2.9999999999999998e-14 * ddt(V(cpphdl_n2211, Vss)); // Bench initial voltage = 0.0 V.
        // device 1759, IC IC305, analog/basic/strongarm_comparator.hpp:44
        I(cpphdl_n2212, Vss) <+ 2.9999999999999998e-14 * ddt(V(cpphdl_n2212, Vss)); // Bench initial voltage = 0.0 V.
        // device 1760, IC IC305, analog/basic/strongarm_comparator.hpp:45
        I(cpphdl_n2229, Vss) <+ 5.0000000000000002e-14 * ddt(V(cpphdl_n2229, Vss)); // Bench initial voltage = 0.0 V.
        // device 1761, IC IC305, analog/basic/strongarm_comparator.hpp:46
        I(cpphdl_n2225, Vss) <+ 5.0000000000000002e-14 * ddt(V(cpphdl_n2225, Vss)); // Bench initial voltage = 0.0 V.
        // device 1762, IC IC305, analog/basic/strongarm_comparator.hpp:47
        I(cpphdl_n2205, cpphdl_n2212) <+ 2e-14 * ddt(V(cpphdl_n2205, cpphdl_n2212)); // Bench initial voltage = 0.0 V.
        // device 1763, IC IC305, analog/basic/strongarm_comparator.hpp:48
        I(cpphdl_n2206, cpphdl_n2212) <+ 2e-14 * ddt(V(cpphdl_n2206, cpphdl_n2212)); // Bench initial voltage = 0.0 V.
        // device 1764, IC IC305, analog/basic/strongarm_comparator.hpp:49
        I(cpphdl_n2205, cpphdl_n2210) <+ 2.9999999999999998e-15 * ddt(V(cpphdl_n2205, cpphdl_n2210)); // Bench initial voltage = 0.0 V.
        // device 1765, IC IC305, analog/basic/strongarm_comparator.hpp:50
        I(cpphdl_n2206, cpphdl_n2211) <+ 2.9999999999999998e-15 * ddt(V(cpphdl_n2206, cpphdl_n2211)); // Bench initial voltage = 0.0 V.
        // device 1766, IC IC307, analog/basic/inverter.hpp:11
        I(cpphdl_n2233, Vdd) <+ cpphdl_channel(V(cpphdl_n2225, Vdd), V(cpphdl_n2233, Vdd), 0.001, 0.69999999999999996, -1.0);
        // device 1767, IC IC307, analog/basic/inverter.hpp:12
        I(cpphdl_n2233, Vss) <+ cpphdl_channel(V(cpphdl_n2225, Vss), V(cpphdl_n2233, Vss), 0.001, 0.69999999999999996, 1.0);
        // device 1768, IC IC309, analog/basic/inverter.hpp:11
        I(cpphdl_n2247, Vdd) <+ cpphdl_channel(V(cpphdl_n2233, Vdd), V(cpphdl_n2247, Vdd), 0.0040000000000000001, 0.69999999999999996, -1.0);
        // device 1769, IC IC309, analog/basic/inverter.hpp:12
        I(cpphdl_n2247, Vss) <+ cpphdl_channel(V(cpphdl_n2233, Vss), V(cpphdl_n2247, Vss), 0.0040000000000000001, 0.69999999999999996, 1.0);
        // device 1770, IC IC306, analog/basic/buffered_nand_latch.hpp:34
        I(cpphdl_n2225, Vss) <+ 2.0000000000000002e-15 * ddt(V(cpphdl_n2225, Vss)); // Bench initial voltage = 0.0 V.
        // device 1771, IC IC306, analog/basic/buffered_nand_latch.hpp:35
        I(cpphdl_n2225, cpphdl_n2233) <+ 1.0000000000000001e-15 * ddt(V(cpphdl_n2225, cpphdl_n2233)); // Bench initial voltage = 0.0 V.
        // device 1772, IC IC306, analog/basic/buffered_nand_latch.hpp:36
        I(cpphdl_n2233, Vss) <+ 5e-15 * ddt(V(cpphdl_n2233, Vss)); // Bench initial voltage = 0.0 V.
        // device 1773, IC IC306, analog/basic/buffered_nand_latch.hpp:37
        I(cpphdl_n2233, Vss) <+ 8.0000000000000006e-15 * ddt(V(cpphdl_n2233, Vss)); // Bench initial voltage = 0.0 V.
        // device 1774, IC IC306, analog/basic/buffered_nand_latch.hpp:38
        I(cpphdl_n2247, Vss) <+ 1e-14 * ddt(V(cpphdl_n2247, Vss)); // Bench initial voltage = 0.0 V.
        // device 1775, IC IC308, analog/basic/inverter.hpp:11
        I(cpphdl_n2237, Vdd) <+ cpphdl_channel(V(cpphdl_n2229, Vdd), V(cpphdl_n2237, Vdd), 0.001, 0.69999999999999996, -1.0);
        // device 1776, IC IC308, analog/basic/inverter.hpp:12
        I(cpphdl_n2237, Vss) <+ cpphdl_channel(V(cpphdl_n2229, Vss), V(cpphdl_n2237, Vss), 0.001, 0.69999999999999996, 1.0);
        // device 1777, IC IC310, analog/basic/inverter.hpp:11
        I(cpphdl_n2253, Vdd) <+ cpphdl_channel(V(cpphdl_n2237, Vdd), V(cpphdl_n2253, Vdd), 0.0040000000000000001, 0.69999999999999996, -1.0);
        // device 1778, IC IC310, analog/basic/inverter.hpp:12
        I(cpphdl_n2253, Vss) <+ cpphdl_channel(V(cpphdl_n2237, Vss), V(cpphdl_n2253, Vss), 0.0040000000000000001, 0.69999999999999996, 1.0);
        // device 1779, IC IC306, analog/basic/buffered_nand_latch.hpp:34
        I(cpphdl_n2229, Vss) <+ 2.0000000000000002e-15 * ddt(V(cpphdl_n2229, Vss)); // Bench initial voltage = 0.0 V.
        // device 1780, IC IC306, analog/basic/buffered_nand_latch.hpp:35
        I(cpphdl_n2229, cpphdl_n2237) <+ 1.0000000000000001e-15 * ddt(V(cpphdl_n2229, cpphdl_n2237)); // Bench initial voltage = 0.0 V.
        // device 1781, IC IC306, analog/basic/buffered_nand_latch.hpp:36
        I(cpphdl_n2237, Vss) <+ 5e-15 * ddt(V(cpphdl_n2237, Vss)); // Bench initial voltage = 0.0 V.
        // device 1782, IC IC306, analog/basic/buffered_nand_latch.hpp:37
        I(cpphdl_n2237, Vss) <+ 8.0000000000000006e-15 * ddt(V(cpphdl_n2237, Vss)); // Bench initial voltage = 0.0 V.
        // device 1783, IC IC306, analog/basic/buffered_nand_latch.hpp:38
        I(cpphdl_n2253, Vss) <+ 1e-14 * ddt(V(cpphdl_n2253, Vss)); // Bench initial voltage = 0.0 V.
        // device 1784, IC IC312, analog/basic/cmos_logic.hpp:17
        I(cpphdl_n2338, Vss) <+ 5.0000000000000002e-14 * ddt(V(cpphdl_n2338, Vss)); // Bench initial voltage = 0.0 V.
        // device 1785, IC IC312, analog/basic/cmos_logic.hpp:18
        I(cpphdl_n2338, Vdd) <+ cpphdl_channel(V(cpphdl_n2247, Vdd), V(cpphdl_n2338, Vdd), 0.01, 0.69999999999999996, -1.0);
        // device 1786, IC IC312, analog/basic/cmos_logic.hpp:19
        I(cpphdl_n2338, Vdd) <+ cpphdl_channel(V(cpphdl_n2255, Vdd), V(cpphdl_n2338, Vdd), 0.01, 0.69999999999999996, -1.0);
        // device 1787, IC IC312, analog/basic/cmos_logic.hpp:20
        I(cpphdl_n2338, cpphdl_n2250) <+ cpphdl_channel(V(cpphdl_n2247, cpphdl_n2250), V(cpphdl_n2338, cpphdl_n2250), 0.01, 0.69999999999999996, 1.0);
        // device 1788, IC IC312, analog/basic/cmos_logic.hpp:21
        I(cpphdl_n2250, Vss) <+ cpphdl_channel(V(cpphdl_n2255, Vss), V(cpphdl_n2250, Vss), 0.01, 0.69999999999999996, 1.0);
        // device 1789, IC IC312, analog/basic/cmos_logic.hpp:27
        I(cpphdl_n2250, Vss) <+ 1e-14 * ddt(V(cpphdl_n2250, Vss)); // Bench initial voltage = 0.0 V.
        // device 1790, IC IC313, analog/basic/cmos_logic.hpp:17
        I(cpphdl_n2255, Vss) <+ 5.0000000000000002e-14 * ddt(V(cpphdl_n2255, Vss)); // Bench initial voltage = 0.0 V.
        // device 1791, IC IC313, analog/basic/cmos_logic.hpp:18
        I(cpphdl_n2255, Vdd) <+ cpphdl_channel(V(cpphdl_n2253, Vdd), V(cpphdl_n2255, Vdd), 0.01, 0.69999999999999996, -1.0);
        // device 1792, IC IC313, analog/basic/cmos_logic.hpp:19
        I(cpphdl_n2255, Vdd) <+ cpphdl_channel(V(cpphdl_n2338, Vdd), V(cpphdl_n2255, Vdd), 0.01, 0.69999999999999996, -1.0);
        // device 1793, IC IC313, analog/basic/cmos_logic.hpp:20
        I(cpphdl_n2255, cpphdl_n2256) <+ cpphdl_channel(V(cpphdl_n2253, cpphdl_n2256), V(cpphdl_n2255, cpphdl_n2256), 0.01, 0.69999999999999996, 1.0);
        // device 1794, IC IC313, analog/basic/cmos_logic.hpp:21
        I(cpphdl_n2256, Vss) <+ cpphdl_channel(V(cpphdl_n2338, Vss), V(cpphdl_n2256, Vss), 0.01, 0.69999999999999996, 1.0);
        // device 1795, IC IC313, analog/basic/cmos_logic.hpp:27
        I(cpphdl_n2256, Vss) <+ 1e-14 * ddt(V(cpphdl_n2256, Vss)); // Bench initial voltage = 0.0 V.
        // device 1796, IC IC311, analog/basic/nand_latch.hpp:36
        I(cpphdl_n2247, Vss) <+ 2.9999999999999998e-15 * ddt(V(cpphdl_n2247, Vss)); // Bench initial voltage = 0.0 V.
        // device 1797, IC IC311, analog/basic/nand_latch.hpp:37
        I(cpphdl_n2253, Vss) <+ 2.9999999999999998e-15 * ddt(V(cpphdl_n2253, Vss)); // Bench initial voltage = 0.0 V.
        // device 1798, IC IC314, analog/basic/inverter.hpp:11
        I(cpphdl_n2261, Vdd) <+ cpphdl_channel(V(CLEAR, Vdd), V(cpphdl_n2261, Vdd), 0.01, 0.69999999999999996, -1.0);
        // device 1799, IC IC314, analog/basic/inverter.hpp:12
        I(cpphdl_n2261, Vss) <+ cpphdl_channel(V(CLEAR, Vss), V(cpphdl_n2261, Vss), 0.01, 0.69999999999999996, 1.0);
        // device 1800, IC IC311, analog/basic/nand_latch.hpp:58
        I(cpphdl_n2261, Vss) <+ 2.9999999999999998e-15 * ddt(V(cpphdl_n2261, Vss)); // Bench initial voltage = 0.0 V.
        // device 1801, IC IC311, analog/basic/nand_latch.hpp:59
        I(cpphdl_n2338, Vss) <+ cpphdl_channel(V(CLEAR, Vss), V(cpphdl_n2338, Vss), 0.050000000000000003, 0.69999999999999996, 1.0);
        // device 1802, IC IC311, analog/basic/nand_latch.hpp:60
        I(cpphdl_n2255, Vdd) <+ cpphdl_channel(V(cpphdl_n2261, Vdd), V(cpphdl_n2255, Vdd), 0.050000000000000003, 0.69999999999999996, -1.0);
        // device 1803, IC IC315, analog/basic/level_down.hpp:23
        I(cpphdl_n2280, Vlogic) <+ cpphdl_channel(V(Vss, Vlogic), V(cpphdl_n2280, Vlogic), 0.00050000000000000001, 0.34999999999999998, -1.0);
        // device 1804, IC IC315, analog/basic/level_down.hpp:24
        I(cpphdl_n2280, Vss) <+ cpphdl_channel(V(cpphdl_n2278, Vss), V(cpphdl_n2280, Vss), 0.0040000000000000001, 0.69999999999999996, 1.0);
        // device 1805, IC IC315, analog/basic/level_down.hpp:25
        I(CORE_DECISION0, Vlogic) <+ cpphdl_channel(V(cpphdl_n2280, Vlogic), V(CORE_DECISION0, Vlogic), 0.0050000000000000001, 0.34999999999999998, -1.0);
        // device 1806, IC IC315, analog/basic/level_down.hpp:26
        I(CORE_DECISION0, Vss) <+ cpphdl_channel(V(cpphdl_n2280, Vss), V(CORE_DECISION0, Vss), 0.01, 0.34999999999999998, 1.0);
        // device 1807, IC IC315, analog/basic/level_down.hpp:27
        I(cpphdl_n2278, Vss) <+ 5e-15 * ddt(V(cpphdl_n2278, Vss)); // Bench initial voltage = 0.0 V.
        // device 1808, IC IC315, analog/basic/level_down.hpp:28
        I(cpphdl_n2278, Vlogic) <+ 5e-15 * ddt(V(cpphdl_n2278, Vlogic)); // Bench initial voltage = 0.0 V.
        // device 1809, IC IC315, analog/basic/level_down.hpp:29
        I(cpphdl_n2278, cpphdl_n2280) <+ 2.0000000000000002e-15 * ddt(V(cpphdl_n2278, cpphdl_n2280)); // Bench initial voltage = 0.0 V.
        // device 1810, IC IC315, analog/basic/level_down.hpp:30
        I(cpphdl_n2280, Vss) <+ 8e-14 * ddt(V(cpphdl_n2280, Vss)); // Bench initial voltage = 0.0 V.
        // device 1811, IC IC315, analog/basic/level_down.hpp:31
        I(cpphdl_n2280, Vlogic) <+ 5e-15 * ddt(V(cpphdl_n2280, Vlogic)); // Bench initial voltage = 0.0 V.
        // device 1812, IC IC315, analog/basic/level_down.hpp:32
        I(cpphdl_n2280, CORE_DECISION0) <+ 2.0000000000000002e-15 * ddt(V(cpphdl_n2280, CORE_DECISION0)); // Bench initial voltage = 0.0 V.
        // device 1813, IC IC315, analog/basic/level_down.hpp:33
        I(CORE_DECISION0, Vss) <+ 1e-14 * ddt(V(CORE_DECISION0, Vss)); // Bench initial voltage = 0.0 V.
        // device 1814, IC IC316, analog/basic/level_down.hpp:23
        I(cpphdl_n2285, Vlogic) <+ cpphdl_channel(V(Vss, Vlogic), V(cpphdl_n2285, Vlogic), 0.00050000000000000001, 0.34999999999999998, -1.0);
        // device 1815, IC IC316, analog/basic/level_down.hpp:24
        I(cpphdl_n2285, Vss) <+ cpphdl_channel(V(cpphdl_n2283, Vss), V(cpphdl_n2285, Vss), 0.0040000000000000001, 0.69999999999999996, 1.0);
        // device 1816, IC IC316, analog/basic/level_down.hpp:25
        I(CORE_DECISION1, Vlogic) <+ cpphdl_channel(V(cpphdl_n2285, Vlogic), V(CORE_DECISION1, Vlogic), 0.0050000000000000001, 0.34999999999999998, -1.0);
        // device 1817, IC IC316, analog/basic/level_down.hpp:26
        I(CORE_DECISION1, Vss) <+ cpphdl_channel(V(cpphdl_n2285, Vss), V(CORE_DECISION1, Vss), 0.01, 0.34999999999999998, 1.0);
        // device 1818, IC IC316, analog/basic/level_down.hpp:27
        I(cpphdl_n2283, Vss) <+ 5e-15 * ddt(V(cpphdl_n2283, Vss)); // Bench initial voltage = 0.0 V.
        // device 1819, IC IC316, analog/basic/level_down.hpp:28
        I(cpphdl_n2283, Vlogic) <+ 5e-15 * ddt(V(cpphdl_n2283, Vlogic)); // Bench initial voltage = 0.0 V.
        // device 1820, IC IC316, analog/basic/level_down.hpp:29
        I(cpphdl_n2283, cpphdl_n2285) <+ 2.0000000000000002e-15 * ddt(V(cpphdl_n2283, cpphdl_n2285)); // Bench initial voltage = 0.0 V.
        // device 1821, IC IC316, analog/basic/level_down.hpp:30
        I(cpphdl_n2285, Vss) <+ 8e-14 * ddt(V(cpphdl_n2285, Vss)); // Bench initial voltage = 0.0 V.
        // device 1822, IC IC316, analog/basic/level_down.hpp:31
        I(cpphdl_n2285, Vlogic) <+ 5e-15 * ddt(V(cpphdl_n2285, Vlogic)); // Bench initial voltage = 0.0 V.
        // device 1823, IC IC316, analog/basic/level_down.hpp:32
        I(cpphdl_n2285, CORE_DECISION1) <+ 2.0000000000000002e-15 * ddt(V(cpphdl_n2285, CORE_DECISION1)); // Bench initial voltage = 0.0 V.
        // device 1824, IC IC316, analog/basic/level_down.hpp:33
        I(CORE_DECISION1, Vss) <+ 1e-14 * ddt(V(CORE_DECISION1, Vss)); // Bench initial voltage = 0.0 V.
        // device 1825, IC IC317, analog/basic/level_down.hpp:23
        I(cpphdl_n2290, Vlogic) <+ cpphdl_channel(V(Vss, Vlogic), V(cpphdl_n2290, Vlogic), 0.00050000000000000001, 0.34999999999999998, -1.0);
        // device 1826, IC IC317, analog/basic/level_down.hpp:24
        I(cpphdl_n2290, Vss) <+ cpphdl_channel(V(cpphdl_n2288, Vss), V(cpphdl_n2290, Vss), 0.0040000000000000001, 0.69999999999999996, 1.0);
        // device 1827, IC IC317, analog/basic/level_down.hpp:25
        I(CORE_DECISION2, Vlogic) <+ cpphdl_channel(V(cpphdl_n2290, Vlogic), V(CORE_DECISION2, Vlogic), 0.0050000000000000001, 0.34999999999999998, -1.0);
        // device 1828, IC IC317, analog/basic/level_down.hpp:26
        I(CORE_DECISION2, Vss) <+ cpphdl_channel(V(cpphdl_n2290, Vss), V(CORE_DECISION2, Vss), 0.01, 0.34999999999999998, 1.0);
        // device 1829, IC IC317, analog/basic/level_down.hpp:27
        I(cpphdl_n2288, Vss) <+ 5e-15 * ddt(V(cpphdl_n2288, Vss)); // Bench initial voltage = 0.0 V.
        // device 1830, IC IC317, analog/basic/level_down.hpp:28
        I(cpphdl_n2288, Vlogic) <+ 5e-15 * ddt(V(cpphdl_n2288, Vlogic)); // Bench initial voltage = 0.0 V.
        // device 1831, IC IC317, analog/basic/level_down.hpp:29
        I(cpphdl_n2288, cpphdl_n2290) <+ 2.0000000000000002e-15 * ddt(V(cpphdl_n2288, cpphdl_n2290)); // Bench initial voltage = 0.0 V.
        // device 1832, IC IC317, analog/basic/level_down.hpp:30
        I(cpphdl_n2290, Vss) <+ 8e-14 * ddt(V(cpphdl_n2290, Vss)); // Bench initial voltage = 0.0 V.
        // device 1833, IC IC317, analog/basic/level_down.hpp:31
        I(cpphdl_n2290, Vlogic) <+ 5e-15 * ddt(V(cpphdl_n2290, Vlogic)); // Bench initial voltage = 0.0 V.
        // device 1834, IC IC317, analog/basic/level_down.hpp:32
        I(cpphdl_n2290, CORE_DECISION2) <+ 2.0000000000000002e-15 * ddt(V(cpphdl_n2290, CORE_DECISION2)); // Bench initial voltage = 0.0 V.
        // device 1835, IC IC317, analog/basic/level_down.hpp:33
        I(CORE_DECISION2, Vss) <+ 1e-14 * ddt(V(CORE_DECISION2, Vss)); // Bench initial voltage = 0.0 V.
        // device 1836, IC IC318, analog/basic/level_down.hpp:23
        I(cpphdl_n2295, Vlogic) <+ cpphdl_channel(V(Vss, Vlogic), V(cpphdl_n2295, Vlogic), 0.00050000000000000001, 0.34999999999999998, -1.0);
        // device 1837, IC IC318, analog/basic/level_down.hpp:24
        I(cpphdl_n2295, Vss) <+ cpphdl_channel(V(cpphdl_n2293, Vss), V(cpphdl_n2295, Vss), 0.0040000000000000001, 0.69999999999999996, 1.0);
        // device 1838, IC IC318, analog/basic/level_down.hpp:25
        I(CORE_DECISION3, Vlogic) <+ cpphdl_channel(V(cpphdl_n2295, Vlogic), V(CORE_DECISION3, Vlogic), 0.0050000000000000001, 0.34999999999999998, -1.0);
        // device 1839, IC IC318, analog/basic/level_down.hpp:26
        I(CORE_DECISION3, Vss) <+ cpphdl_channel(V(cpphdl_n2295, Vss), V(CORE_DECISION3, Vss), 0.01, 0.34999999999999998, 1.0);
        // device 1840, IC IC318, analog/basic/level_down.hpp:27
        I(cpphdl_n2293, Vss) <+ 5e-15 * ddt(V(cpphdl_n2293, Vss)); // Bench initial voltage = 0.0 V.
        // device 1841, IC IC318, analog/basic/level_down.hpp:28
        I(cpphdl_n2293, Vlogic) <+ 5e-15 * ddt(V(cpphdl_n2293, Vlogic)); // Bench initial voltage = 0.0 V.
        // device 1842, IC IC318, analog/basic/level_down.hpp:29
        I(cpphdl_n2293, cpphdl_n2295) <+ 2.0000000000000002e-15 * ddt(V(cpphdl_n2293, cpphdl_n2295)); // Bench initial voltage = 0.0 V.
        // device 1843, IC IC318, analog/basic/level_down.hpp:30
        I(cpphdl_n2295, Vss) <+ 8e-14 * ddt(V(cpphdl_n2295, Vss)); // Bench initial voltage = 0.0 V.
        // device 1844, IC IC318, analog/basic/level_down.hpp:31
        I(cpphdl_n2295, Vlogic) <+ 5e-15 * ddt(V(cpphdl_n2295, Vlogic)); // Bench initial voltage = 0.0 V.
        // device 1845, IC IC318, analog/basic/level_down.hpp:32
        I(cpphdl_n2295, CORE_DECISION3) <+ 2.0000000000000002e-15 * ddt(V(cpphdl_n2295, CORE_DECISION3)); // Bench initial voltage = 0.0 V.
        // device 1846, IC IC318, analog/basic/level_down.hpp:33
        I(CORE_DECISION3, Vss) <+ 1e-14 * ddt(V(CORE_DECISION3, Vss)); // Bench initial voltage = 0.0 V.
        // device 1847, IC IC319, analog/basic/level_down.hpp:23
        I(cpphdl_n2300, Vlogic) <+ cpphdl_channel(V(Vss, Vlogic), V(cpphdl_n2300, Vlogic), 0.00050000000000000001, 0.34999999999999998, -1.0);
        // device 1848, IC IC319, analog/basic/level_down.hpp:24
        I(cpphdl_n2300, Vss) <+ cpphdl_channel(V(cpphdl_n2298, Vss), V(cpphdl_n2300, Vss), 0.0040000000000000001, 0.69999999999999996, 1.0);
        // device 1849, IC IC319, analog/basic/level_down.hpp:25
        I(CORE_DECISION4, Vlogic) <+ cpphdl_channel(V(cpphdl_n2300, Vlogic), V(CORE_DECISION4, Vlogic), 0.0050000000000000001, 0.34999999999999998, -1.0);
        // device 1850, IC IC319, analog/basic/level_down.hpp:26
        I(CORE_DECISION4, Vss) <+ cpphdl_channel(V(cpphdl_n2300, Vss), V(CORE_DECISION4, Vss), 0.01, 0.34999999999999998, 1.0);
        // device 1851, IC IC319, analog/basic/level_down.hpp:27
        I(cpphdl_n2298, Vss) <+ 5e-15 * ddt(V(cpphdl_n2298, Vss)); // Bench initial voltage = 0.0 V.
        // device 1852, IC IC319, analog/basic/level_down.hpp:28
        I(cpphdl_n2298, Vlogic) <+ 5e-15 * ddt(V(cpphdl_n2298, Vlogic)); // Bench initial voltage = 0.0 V.
        // device 1853, IC IC319, analog/basic/level_down.hpp:29
        I(cpphdl_n2298, cpphdl_n2300) <+ 2.0000000000000002e-15 * ddt(V(cpphdl_n2298, cpphdl_n2300)); // Bench initial voltage = 0.0 V.
        // device 1854, IC IC319, analog/basic/level_down.hpp:30
        I(cpphdl_n2300, Vss) <+ 8e-14 * ddt(V(cpphdl_n2300, Vss)); // Bench initial voltage = 0.0 V.
        // device 1855, IC IC319, analog/basic/level_down.hpp:31
        I(cpphdl_n2300, Vlogic) <+ 5e-15 * ddt(V(cpphdl_n2300, Vlogic)); // Bench initial voltage = 0.0 V.
        // device 1856, IC IC319, analog/basic/level_down.hpp:32
        I(cpphdl_n2300, CORE_DECISION4) <+ 2.0000000000000002e-15 * ddt(V(cpphdl_n2300, CORE_DECISION4)); // Bench initial voltage = 0.0 V.
        // device 1857, IC IC319, analog/basic/level_down.hpp:33
        I(CORE_DECISION4, Vss) <+ 1e-14 * ddt(V(CORE_DECISION4, Vss)); // Bench initial voltage = 0.0 V.
        // device 1858, IC IC320, analog/basic/level_down.hpp:23
        I(cpphdl_n2305, Vlogic) <+ cpphdl_channel(V(Vss, Vlogic), V(cpphdl_n2305, Vlogic), 0.00050000000000000001, 0.34999999999999998, -1.0);
        // device 1859, IC IC320, analog/basic/level_down.hpp:24
        I(cpphdl_n2305, Vss) <+ cpphdl_channel(V(cpphdl_n2303, Vss), V(cpphdl_n2305, Vss), 0.0040000000000000001, 0.69999999999999996, 1.0);
        // device 1860, IC IC320, analog/basic/level_down.hpp:25
        I(CORE_DECISION5, Vlogic) <+ cpphdl_channel(V(cpphdl_n2305, Vlogic), V(CORE_DECISION5, Vlogic), 0.0050000000000000001, 0.34999999999999998, -1.0);
        // device 1861, IC IC320, analog/basic/level_down.hpp:26
        I(CORE_DECISION5, Vss) <+ cpphdl_channel(V(cpphdl_n2305, Vss), V(CORE_DECISION5, Vss), 0.01, 0.34999999999999998, 1.0);
        // device 1862, IC IC320, analog/basic/level_down.hpp:27
        I(cpphdl_n2303, Vss) <+ 5e-15 * ddt(V(cpphdl_n2303, Vss)); // Bench initial voltage = 0.0 V.
        // device 1863, IC IC320, analog/basic/level_down.hpp:28
        I(cpphdl_n2303, Vlogic) <+ 5e-15 * ddt(V(cpphdl_n2303, Vlogic)); // Bench initial voltage = 0.0 V.
        // device 1864, IC IC320, analog/basic/level_down.hpp:29
        I(cpphdl_n2303, cpphdl_n2305) <+ 2.0000000000000002e-15 * ddt(V(cpphdl_n2303, cpphdl_n2305)); // Bench initial voltage = 0.0 V.
        // device 1865, IC IC320, analog/basic/level_down.hpp:30
        I(cpphdl_n2305, Vss) <+ 8e-14 * ddt(V(cpphdl_n2305, Vss)); // Bench initial voltage = 0.0 V.
        // device 1866, IC IC320, analog/basic/level_down.hpp:31
        I(cpphdl_n2305, Vlogic) <+ 5e-15 * ddt(V(cpphdl_n2305, Vlogic)); // Bench initial voltage = 0.0 V.
        // device 1867, IC IC320, analog/basic/level_down.hpp:32
        I(cpphdl_n2305, CORE_DECISION5) <+ 2.0000000000000002e-15 * ddt(V(cpphdl_n2305, CORE_DECISION5)); // Bench initial voltage = 0.0 V.
        // device 1868, IC IC320, analog/basic/level_down.hpp:33
        I(CORE_DECISION5, Vss) <+ 1e-14 * ddt(V(CORE_DECISION5, Vss)); // Bench initial voltage = 0.0 V.
        // device 1869, IC IC321, analog/basic/level_down.hpp:23
        I(cpphdl_n2310, Vlogic) <+ cpphdl_channel(V(Vss, Vlogic), V(cpphdl_n2310, Vlogic), 0.00050000000000000001, 0.34999999999999998, -1.0);
        // device 1870, IC IC321, analog/basic/level_down.hpp:24
        I(cpphdl_n2310, Vss) <+ cpphdl_channel(V(cpphdl_n2308, Vss), V(cpphdl_n2310, Vss), 0.0040000000000000001, 0.69999999999999996, 1.0);
        // device 1871, IC IC321, analog/basic/level_down.hpp:25
        I(CORE_DECISION6, Vlogic) <+ cpphdl_channel(V(cpphdl_n2310, Vlogic), V(CORE_DECISION6, Vlogic), 0.0050000000000000001, 0.34999999999999998, -1.0);
        // device 1872, IC IC321, analog/basic/level_down.hpp:26
        I(CORE_DECISION6, Vss) <+ cpphdl_channel(V(cpphdl_n2310, Vss), V(CORE_DECISION6, Vss), 0.01, 0.34999999999999998, 1.0);
        // device 1873, IC IC321, analog/basic/level_down.hpp:27
        I(cpphdl_n2308, Vss) <+ 5e-15 * ddt(V(cpphdl_n2308, Vss)); // Bench initial voltage = 0.0 V.
        // device 1874, IC IC321, analog/basic/level_down.hpp:28
        I(cpphdl_n2308, Vlogic) <+ 5e-15 * ddt(V(cpphdl_n2308, Vlogic)); // Bench initial voltage = 0.0 V.
        // device 1875, IC IC321, analog/basic/level_down.hpp:29
        I(cpphdl_n2308, cpphdl_n2310) <+ 2.0000000000000002e-15 * ddt(V(cpphdl_n2308, cpphdl_n2310)); // Bench initial voltage = 0.0 V.
        // device 1876, IC IC321, analog/basic/level_down.hpp:30
        I(cpphdl_n2310, Vss) <+ 8e-14 * ddt(V(cpphdl_n2310, Vss)); // Bench initial voltage = 0.0 V.
        // device 1877, IC IC321, analog/basic/level_down.hpp:31
        I(cpphdl_n2310, Vlogic) <+ 5e-15 * ddt(V(cpphdl_n2310, Vlogic)); // Bench initial voltage = 0.0 V.
        // device 1878, IC IC321, analog/basic/level_down.hpp:32
        I(cpphdl_n2310, CORE_DECISION6) <+ 2.0000000000000002e-15 * ddt(V(cpphdl_n2310, CORE_DECISION6)); // Bench initial voltage = 0.0 V.
        // device 1879, IC IC321, analog/basic/level_down.hpp:33
        I(CORE_DECISION6, Vss) <+ 1e-14 * ddt(V(CORE_DECISION6, Vss)); // Bench initial voltage = 0.0 V.
        // device 1880, IC IC322, analog/basic/level_down.hpp:23
        I(cpphdl_n2315, Vlogic) <+ cpphdl_channel(V(Vss, Vlogic), V(cpphdl_n2315, Vlogic), 0.00050000000000000001, 0.34999999999999998, -1.0);
        // device 1881, IC IC322, analog/basic/level_down.hpp:24
        I(cpphdl_n2315, Vss) <+ cpphdl_channel(V(cpphdl_n2313, Vss), V(cpphdl_n2315, Vss), 0.0040000000000000001, 0.69999999999999996, 1.0);
        // device 1882, IC IC322, analog/basic/level_down.hpp:25
        I(CORE_DECISION7, Vlogic) <+ cpphdl_channel(V(cpphdl_n2315, Vlogic), V(CORE_DECISION7, Vlogic), 0.0050000000000000001, 0.34999999999999998, -1.0);
        // device 1883, IC IC322, analog/basic/level_down.hpp:26
        I(CORE_DECISION7, Vss) <+ cpphdl_channel(V(cpphdl_n2315, Vss), V(CORE_DECISION7, Vss), 0.01, 0.34999999999999998, 1.0);
        // device 1884, IC IC322, analog/basic/level_down.hpp:27
        I(cpphdl_n2313, Vss) <+ 5e-15 * ddt(V(cpphdl_n2313, Vss)); // Bench initial voltage = 0.0 V.
        // device 1885, IC IC322, analog/basic/level_down.hpp:28
        I(cpphdl_n2313, Vlogic) <+ 5e-15 * ddt(V(cpphdl_n2313, Vlogic)); // Bench initial voltage = 0.0 V.
        // device 1886, IC IC322, analog/basic/level_down.hpp:29
        I(cpphdl_n2313, cpphdl_n2315) <+ 2.0000000000000002e-15 * ddt(V(cpphdl_n2313, cpphdl_n2315)); // Bench initial voltage = 0.0 V.
        // device 1887, IC IC322, analog/basic/level_down.hpp:30
        I(cpphdl_n2315, Vss) <+ 8e-14 * ddt(V(cpphdl_n2315, Vss)); // Bench initial voltage = 0.0 V.
        // device 1888, IC IC322, analog/basic/level_down.hpp:31
        I(cpphdl_n2315, Vlogic) <+ 5e-15 * ddt(V(cpphdl_n2315, Vlogic)); // Bench initial voltage = 0.0 V.
        // device 1889, IC IC322, analog/basic/level_down.hpp:32
        I(cpphdl_n2315, CORE_DECISION7) <+ 2.0000000000000002e-15 * ddt(V(cpphdl_n2315, CORE_DECISION7)); // Bench initial voltage = 0.0 V.
        // device 1890, IC IC322, analog/basic/level_down.hpp:33
        I(CORE_DECISION7, Vss) <+ 1e-14 * ddt(V(CORE_DECISION7, Vss)); // Bench initial voltage = 0.0 V.
        // device 1891, IC IC323, analog/basic/level_down.hpp:23
        I(cpphdl_n2320, Vlogic) <+ cpphdl_channel(V(Vss, Vlogic), V(cpphdl_n2320, Vlogic), 0.00050000000000000001, 0.34999999999999998, -1.0);
        // device 1892, IC IC323, analog/basic/level_down.hpp:24
        I(cpphdl_n2320, Vss) <+ cpphdl_channel(V(cpphdl_n2318, Vss), V(cpphdl_n2320, Vss), 0.0040000000000000001, 0.69999999999999996, 1.0);
        // device 1893, IC IC323, analog/basic/level_down.hpp:25
        I(CORE_DECISION8, Vlogic) <+ cpphdl_channel(V(cpphdl_n2320, Vlogic), V(CORE_DECISION8, Vlogic), 0.0050000000000000001, 0.34999999999999998, -1.0);
        // device 1894, IC IC323, analog/basic/level_down.hpp:26
        I(CORE_DECISION8, Vss) <+ cpphdl_channel(V(cpphdl_n2320, Vss), V(CORE_DECISION8, Vss), 0.01, 0.34999999999999998, 1.0);
        // device 1895, IC IC323, analog/basic/level_down.hpp:27
        I(cpphdl_n2318, Vss) <+ 5e-15 * ddt(V(cpphdl_n2318, Vss)); // Bench initial voltage = 0.0 V.
        // device 1896, IC IC323, analog/basic/level_down.hpp:28
        I(cpphdl_n2318, Vlogic) <+ 5e-15 * ddt(V(cpphdl_n2318, Vlogic)); // Bench initial voltage = 0.0 V.
        // device 1897, IC IC323, analog/basic/level_down.hpp:29
        I(cpphdl_n2318, cpphdl_n2320) <+ 2.0000000000000002e-15 * ddt(V(cpphdl_n2318, cpphdl_n2320)); // Bench initial voltage = 0.0 V.
        // device 1898, IC IC323, analog/basic/level_down.hpp:30
        I(cpphdl_n2320, Vss) <+ 8e-14 * ddt(V(cpphdl_n2320, Vss)); // Bench initial voltage = 0.0 V.
        // device 1899, IC IC323, analog/basic/level_down.hpp:31
        I(cpphdl_n2320, Vlogic) <+ 5e-15 * ddt(V(cpphdl_n2320, Vlogic)); // Bench initial voltage = 0.0 V.
        // device 1900, IC IC323, analog/basic/level_down.hpp:32
        I(cpphdl_n2320, CORE_DECISION8) <+ 2.0000000000000002e-15 * ddt(V(cpphdl_n2320, CORE_DECISION8)); // Bench initial voltage = 0.0 V.
        // device 1901, IC IC323, analog/basic/level_down.hpp:33
        I(CORE_DECISION8, Vss) <+ 1e-14 * ddt(V(CORE_DECISION8, Vss)); // Bench initial voltage = 0.0 V.
        // device 1902, IC IC324, analog/basic/level_down.hpp:23
        I(cpphdl_n2325, Vlogic) <+ cpphdl_channel(V(Vss, Vlogic), V(cpphdl_n2325, Vlogic), 0.00050000000000000001, 0.34999999999999998, -1.0);
        // device 1903, IC IC324, analog/basic/level_down.hpp:24
        I(cpphdl_n2325, Vss) <+ cpphdl_channel(V(cpphdl_n2323, Vss), V(cpphdl_n2325, Vss), 0.0040000000000000001, 0.69999999999999996, 1.0);
        // device 1904, IC IC324, analog/basic/level_down.hpp:25
        I(CORE_DECISION9, Vlogic) <+ cpphdl_channel(V(cpphdl_n2325, Vlogic), V(CORE_DECISION9, Vlogic), 0.0050000000000000001, 0.34999999999999998, -1.0);
        // device 1905, IC IC324, analog/basic/level_down.hpp:26
        I(CORE_DECISION9, Vss) <+ cpphdl_channel(V(cpphdl_n2325, Vss), V(CORE_DECISION9, Vss), 0.01, 0.34999999999999998, 1.0);
        // device 1906, IC IC324, analog/basic/level_down.hpp:27
        I(cpphdl_n2323, Vss) <+ 5e-15 * ddt(V(cpphdl_n2323, Vss)); // Bench initial voltage = 0.0 V.
        // device 1907, IC IC324, analog/basic/level_down.hpp:28
        I(cpphdl_n2323, Vlogic) <+ 5e-15 * ddt(V(cpphdl_n2323, Vlogic)); // Bench initial voltage = 0.0 V.
        // device 1908, IC IC324, analog/basic/level_down.hpp:29
        I(cpphdl_n2323, cpphdl_n2325) <+ 2.0000000000000002e-15 * ddt(V(cpphdl_n2323, cpphdl_n2325)); // Bench initial voltage = 0.0 V.
        // device 1909, IC IC324, analog/basic/level_down.hpp:30
        I(cpphdl_n2325, Vss) <+ 8e-14 * ddt(V(cpphdl_n2325, Vss)); // Bench initial voltage = 0.0 V.
        // device 1910, IC IC324, analog/basic/level_down.hpp:31
        I(cpphdl_n2325, Vlogic) <+ 5e-15 * ddt(V(cpphdl_n2325, Vlogic)); // Bench initial voltage = 0.0 V.
        // device 1911, IC IC324, analog/basic/level_down.hpp:32
        I(cpphdl_n2325, CORE_DECISION9) <+ 2.0000000000000002e-15 * ddt(V(cpphdl_n2325, CORE_DECISION9)); // Bench initial voltage = 0.0 V.
        // device 1912, IC IC324, analog/basic/level_down.hpp:33
        I(CORE_DECISION9, Vss) <+ 1e-14 * ddt(V(CORE_DECISION9, Vss)); // Bench initial voltage = 0.0 V.
        // device 1913, IC IC325, analog/basic/level_down.hpp:23
        I(cpphdl_n2330, Vlogic) <+ cpphdl_channel(V(Vss, Vlogic), V(cpphdl_n2330, Vlogic), 0.00050000000000000001, 0.34999999999999998, -1.0);
        // device 1914, IC IC325, analog/basic/level_down.hpp:24
        I(cpphdl_n2330, Vss) <+ cpphdl_channel(V(cpphdl_n2328, Vss), V(cpphdl_n2330, Vss), 0.0040000000000000001, 0.69999999999999996, 1.0);
        // device 1915, IC IC325, analog/basic/level_down.hpp:25
        I(CORE_DECISION10, Vlogic) <+ cpphdl_channel(V(cpphdl_n2330, Vlogic), V(CORE_DECISION10, Vlogic), 0.0050000000000000001, 0.34999999999999998, -1.0);
        // device 1916, IC IC325, analog/basic/level_down.hpp:26
        I(CORE_DECISION10, Vss) <+ cpphdl_channel(V(cpphdl_n2330, Vss), V(CORE_DECISION10, Vss), 0.01, 0.34999999999999998, 1.0);
        // device 1917, IC IC325, analog/basic/level_down.hpp:27
        I(cpphdl_n2328, Vss) <+ 5e-15 * ddt(V(cpphdl_n2328, Vss)); // Bench initial voltage = 0.0 V.
        // device 1918, IC IC325, analog/basic/level_down.hpp:28
        I(cpphdl_n2328, Vlogic) <+ 5e-15 * ddt(V(cpphdl_n2328, Vlogic)); // Bench initial voltage = 0.0 V.
        // device 1919, IC IC325, analog/basic/level_down.hpp:29
        I(cpphdl_n2328, cpphdl_n2330) <+ 2.0000000000000002e-15 * ddt(V(cpphdl_n2328, cpphdl_n2330)); // Bench initial voltage = 0.0 V.
        // device 1920, IC IC325, analog/basic/level_down.hpp:30
        I(cpphdl_n2330, Vss) <+ 8e-14 * ddt(V(cpphdl_n2330, Vss)); // Bench initial voltage = 0.0 V.
        // device 1921, IC IC325, analog/basic/level_down.hpp:31
        I(cpphdl_n2330, Vlogic) <+ 5e-15 * ddt(V(cpphdl_n2330, Vlogic)); // Bench initial voltage = 0.0 V.
        // device 1922, IC IC325, analog/basic/level_down.hpp:32
        I(cpphdl_n2330, CORE_DECISION10) <+ 2.0000000000000002e-15 * ddt(V(cpphdl_n2330, CORE_DECISION10)); // Bench initial voltage = 0.0 V.
        // device 1923, IC IC325, analog/basic/level_down.hpp:33
        I(CORE_DECISION10, Vss) <+ 1e-14 * ddt(V(CORE_DECISION10, Vss)); // Bench initial voltage = 0.0 V.
        // device 1924, IC IC326, analog/basic/level_down.hpp:23
        I(cpphdl_n2335, Vlogic) <+ cpphdl_channel(V(Vss, Vlogic), V(cpphdl_n2335, Vlogic), 0.00050000000000000001, 0.34999999999999998, -1.0);
        // device 1925, IC IC326, analog/basic/level_down.hpp:24
        I(cpphdl_n2335, Vss) <+ cpphdl_channel(V(cpphdl_n2333, Vss), V(cpphdl_n2335, Vss), 0.0040000000000000001, 0.69999999999999996, 1.0);
        // device 1926, IC IC326, analog/basic/level_down.hpp:25
        I(CORE_DECISION11, Vlogic) <+ cpphdl_channel(V(cpphdl_n2335, Vlogic), V(CORE_DECISION11, Vlogic), 0.0050000000000000001, 0.34999999999999998, -1.0);
        // device 1927, IC IC326, analog/basic/level_down.hpp:26
        I(CORE_DECISION11, Vss) <+ cpphdl_channel(V(cpphdl_n2335, Vss), V(CORE_DECISION11, Vss), 0.01, 0.34999999999999998, 1.0);
        // device 1928, IC IC326, analog/basic/level_down.hpp:27
        I(cpphdl_n2333, Vss) <+ 5e-15 * ddt(V(cpphdl_n2333, Vss)); // Bench initial voltage = 0.0 V.
        // device 1929, IC IC326, analog/basic/level_down.hpp:28
        I(cpphdl_n2333, Vlogic) <+ 5e-15 * ddt(V(cpphdl_n2333, Vlogic)); // Bench initial voltage = 0.0 V.
        // device 1930, IC IC326, analog/basic/level_down.hpp:29
        I(cpphdl_n2333, cpphdl_n2335) <+ 2.0000000000000002e-15 * ddt(V(cpphdl_n2333, cpphdl_n2335)); // Bench initial voltage = 0.0 V.
        // device 1931, IC IC326, analog/basic/level_down.hpp:30
        I(cpphdl_n2335, Vss) <+ 8e-14 * ddt(V(cpphdl_n2335, Vss)); // Bench initial voltage = 0.0 V.
        // device 1932, IC IC326, analog/basic/level_down.hpp:31
        I(cpphdl_n2335, Vlogic) <+ 5e-15 * ddt(V(cpphdl_n2335, Vlogic)); // Bench initial voltage = 0.0 V.
        // device 1933, IC IC326, analog/basic/level_down.hpp:32
        I(cpphdl_n2335, CORE_DECISION11) <+ 2.0000000000000002e-15 * ddt(V(cpphdl_n2335, CORE_DECISION11)); // Bench initial voltage = 0.0 V.
        // device 1934, IC IC326, analog/basic/level_down.hpp:33
        I(CORE_DECISION11, Vss) <+ 1e-14 * ddt(V(CORE_DECISION11, Vss)); // Bench initial voltage = 0.0 V.
        // device 1935, IC IC327, analog/basic/level_down.hpp:23
        I(cpphdl_n2340, Vlogic) <+ cpphdl_channel(V(Vss, Vlogic), V(cpphdl_n2340, Vlogic), 0.00050000000000000001, 0.34999999999999998, -1.0);
        // device 1936, IC IC327, analog/basic/level_down.hpp:24
        I(cpphdl_n2340, Vss) <+ cpphdl_channel(V(cpphdl_n2338, Vss), V(cpphdl_n2340, Vss), 0.0040000000000000001, 0.69999999999999996, 1.0);
        // device 1937, IC IC327, analog/basic/level_down.hpp:25
        I(CORE_DECISION12, Vlogic) <+ cpphdl_channel(V(cpphdl_n2340, Vlogic), V(CORE_DECISION12, Vlogic), 0.0050000000000000001, 0.34999999999999998, -1.0);
        // device 1938, IC IC327, analog/basic/level_down.hpp:26
        I(CORE_DECISION12, Vss) <+ cpphdl_channel(V(cpphdl_n2340, Vss), V(CORE_DECISION12, Vss), 0.01, 0.34999999999999998, 1.0);
        // device 1939, IC IC327, analog/basic/level_down.hpp:27
        I(cpphdl_n2338, Vss) <+ 5e-15 * ddt(V(cpphdl_n2338, Vss)); // Bench initial voltage = 0.0 V.
        // device 1940, IC IC327, analog/basic/level_down.hpp:28
        I(cpphdl_n2338, Vlogic) <+ 5e-15 * ddt(V(cpphdl_n2338, Vlogic)); // Bench initial voltage = 0.0 V.
        // device 1941, IC IC327, analog/basic/level_down.hpp:29
        I(cpphdl_n2338, cpphdl_n2340) <+ 2.0000000000000002e-15 * ddt(V(cpphdl_n2338, cpphdl_n2340)); // Bench initial voltage = 0.0 V.
        // device 1942, IC IC327, analog/basic/level_down.hpp:30
        I(cpphdl_n2340, Vss) <+ 8e-14 * ddt(V(cpphdl_n2340, Vss)); // Bench initial voltage = 0.0 V.
        // device 1943, IC IC327, analog/basic/level_down.hpp:31
        I(cpphdl_n2340, Vlogic) <+ 5e-15 * ddt(V(cpphdl_n2340, Vlogic)); // Bench initial voltage = 0.0 V.
        // device 1944, IC IC327, analog/basic/level_down.hpp:32
        I(cpphdl_n2340, CORE_DECISION12) <+ 2.0000000000000002e-15 * ddt(V(cpphdl_n2340, CORE_DECISION12)); // Bench initial voltage = 0.0 V.
        // device 1945, IC IC327, analog/basic/level_down.hpp:33
        I(CORE_DECISION12, Vss) <+ 1e-14 * ddt(V(CORE_DECISION12, Vss)); // Bench initial voltage = 0.0 V.
    end
endmodule
