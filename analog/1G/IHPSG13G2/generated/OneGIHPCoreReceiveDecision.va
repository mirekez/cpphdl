// SIMULATION APPROXIMATION: controlled conductances are not physical MOS devices.
// Generated from elaborated C++HDL IC purposes; all contributions coexist.
// Capacitor initialization belongs to the host analysis; declared initial voltages appear below.
`include "disciplines.vams"

module OneGIHPCoreReceiveDecision(Vdd, Vss, Vlogic, IN, EVALUATE, CLEAR, CORE_DECISION, TRIAL0, TRIAL1, TRIAL2, TRIAL3, TRIAL4, TRIAL5, TRIAL6, TRIAL7);
    inout Vdd, Vss, Vlogic, IN, EVALUATE, CLEAR, CORE_DECISION, TRIAL0, TRIAL1, TRIAL2, TRIAL3, TRIAL4, TRIAL5, TRIAL6, TRIAL7;
    electrical Vdd, Vss, Vlogic, IN, EVALUATE, CLEAR, CORE_DECISION, TRIAL0, TRIAL1, TRIAL2, TRIAL3, TRIAL4, TRIAL5, TRIAL6, TRIAL7;
    electrical cpphdl_n32;
    electrical cpphdl_n43;
    electrical cpphdl_n44;
    electrical cpphdl_n48;
    electrical cpphdl_n51;
    electrical cpphdl_n52;
    electrical cpphdl_n55;
    electrical cpphdl_n67;
    electrical cpphdl_n68;
    electrical cpphdl_n72;
    electrical cpphdl_n75;
    electrical cpphdl_n76;
    electrical cpphdl_n79;
    electrical cpphdl_n91;
    electrical cpphdl_n92;
    electrical cpphdl_n96;
    electrical cpphdl_n99;
    electrical cpphdl_n100;
    electrical cpphdl_n103;
    electrical cpphdl_n115;
    electrical cpphdl_n116;
    electrical cpphdl_n120;
    electrical cpphdl_n123;
    electrical cpphdl_n124;
    electrical cpphdl_n127;
    electrical cpphdl_n139;
    electrical cpphdl_n140;
    electrical cpphdl_n144;
    electrical cpphdl_n147;
    electrical cpphdl_n148;
    electrical cpphdl_n151;
    electrical cpphdl_n163;
    electrical cpphdl_n164;
    electrical cpphdl_n168;
    electrical cpphdl_n171;
    electrical cpphdl_n172;
    electrical cpphdl_n175;
    electrical cpphdl_n187;
    electrical cpphdl_n188;
    electrical cpphdl_n192;
    electrical cpphdl_n195;
    electrical cpphdl_n196;
    electrical cpphdl_n199;
    electrical cpphdl_n211;
    electrical cpphdl_n212;
    electrical cpphdl_n216;
    electrical cpphdl_n219;
    electrical cpphdl_n220;
    electrical cpphdl_n223;
    electrical cpphdl_n238;
    electrical cpphdl_n239;
    electrical cpphdl_n242;
    electrical cpphdl_n243;
    electrical cpphdl_n246;
    electrical cpphdl_n247;
    electrical cpphdl_n250;
    electrical cpphdl_n251;
    electrical cpphdl_n254;
    electrical cpphdl_n255;
    electrical cpphdl_n258;
    electrical cpphdl_n259;
    electrical cpphdl_n262;
    electrical cpphdl_n263;
    electrical cpphdl_n266;
    electrical cpphdl_n267;
    electrical cpphdl_n268;
    electrical cpphdl_n269;
    electrical cpphdl_n270;
    electrical cpphdl_n271;
    electrical cpphdl_n272;
    electrical cpphdl_n273;
    electrical cpphdl_n274;
    electrical cpphdl_n287;
    electrical cpphdl_n288;
    electrical cpphdl_n292;
    electrical cpphdl_n295;
    electrical cpphdl_n299;
    electrical cpphdl_n300;
    electrical cpphdl_n304;
    electrical cpphdl_n311;
    electrical cpphdl_n312;
    electrical cpphdl_n316;
    electrical cpphdl_n319;
    electrical cpphdl_n323;
    electrical cpphdl_n324;
    electrical cpphdl_n328;
    electrical cpphdl_n331;
    electrical cpphdl_n332;
    electrical cpphdl_n333;
    electrical cpphdl_n336;
    electrical cpphdl_n337;
    electrical cpphdl_n338;
    electrical cpphdl_n341;
    electrical cpphdl_n342;
    electrical cpphdl_n343;
    electrical cpphdl_n353;
    electrical cpphdl_n357;
    electrical cpphdl_n361;
    electrical cpphdl_n365;
    electrical cpphdl_n375;
    electrical cpphdl_n378;
    electrical cpphdl_n381;
    electrical cpphdl_n383;
    electrical cpphdl_n384;
    electrical cpphdl_n388;
    electrical cpphdl_n389;
    electrical cpphdl_n392;
    electrical cpphdl_n394;

    // Square-law channel, including reverse conduction. This is not a BSIM model.
    analog function real cpphdl_channel;
        input vgs, vds, beta, threshold, polarity;
        real vgs, vds, beta, threshold, polarity;
        real gate, drain, direction, overdrive, current;
        begin
            gate = polarity * vgs;
            drain = polarity * vds;
            direction = 1.0;
            if (drain < 0.0) begin
                gate = gate - drain;
                drain = -drain;
                direction = -1.0;
            end
            overdrive = gate - threshold;
            current = 0.0;
            if (overdrive > 0.0) begin
                if (drain < overdrive)
                    current = beta * (overdrive * drain - drain * drain / 2.0);
                else
                    current = beta * overdrive * overdrive / 2.0;
            end
            cpphdl_channel = polarity * direction * current;
        end
    endfunction

    analog begin
        // device 0, IC IC2, analog/basic/cascoded_level_shifter.hpp:18
        I(Vlogic, cpphdl_n32) <+ V(Vlogic, cpphdl_n32) / 200.0;
        // device 1, IC IC2, analog/basic/cascoded_level_shifter.hpp:19
        I(Vss, cpphdl_n32) <+ V(Vss, cpphdl_n32) / 800.0;
        // device 2, IC IC2, analog/basic/cascoded_level_shifter.hpp:20
        I(Vdd, cpphdl_n304) <+ V(Vdd, cpphdl_n304) / 10000.0;
        // device 3, IC IC2, analog/basic/cascoded_level_shifter.hpp:21
        I(cpphdl_n304, cpphdl_n32) <+ cpphdl_channel(V(cpphdl_n304, cpphdl_n32), V(cpphdl_n304, cpphdl_n32), 0.018749999999999999, 0.69999999999999996, 1.0);
        // device 4, IC IC2, analog/basic/cascoded_level_shifter.hpp:22
        I(cpphdl_n304, Vss) <+ 2.5000000000000001e-11 * ddt(V(cpphdl_n304, Vss)); // Bench initial voltage = 0.0 V.
        // device 5, IC IC4, analog/basic/inverter.hpp:11
        I(cpphdl_n48, Vlogic) <+ cpphdl_channel(V(TRIAL0, Vlogic), V(cpphdl_n48, Vlogic), 0.02, 0.5, -1.0);
        // device 6, IC IC4, analog/basic/inverter.hpp:12
        I(cpphdl_n48, Vss) <+ cpphdl_channel(V(TRIAL0, Vss), V(cpphdl_n48, Vss), 0.02, 0.5, 1.0);
        // device 7, IC IC3, analog/basic/cascoded_level_shifter.hpp:58
        I(cpphdl_n48, Vss) <+ 1e-14 * ddt(V(cpphdl_n48, Vss)); // Bench initial voltage = 0.0 V.
        // device 8, IC IC3, analog/basic/cascoded_level_shifter.hpp:59
        I(cpphdl_n55, Vdd) <+ cpphdl_channel(V(cpphdl_n51, Vdd), V(cpphdl_n55, Vdd), 0.0028, 0.69999999999999996, -1.0);
        // device 9, IC IC3, analog/basic/cascoded_level_shifter.hpp:60
        I(cpphdl_n51, Vdd) <+ cpphdl_channel(V(cpphdl_n55, Vdd), V(cpphdl_n51, Vdd), 0.0028, 0.69999999999999996, -1.0);
        // device 10, IC IC3, analog/basic/cascoded_level_shifter.hpp:61
        I(cpphdl_n55, cpphdl_n43) <+ cpphdl_channel(V(cpphdl_n304, cpphdl_n43), V(cpphdl_n55, cpphdl_n43), 0.014999999999999999, 0.69999999999999996, 1.0);
        // device 11, IC IC3, analog/basic/cascoded_level_shifter.hpp:62
        I(cpphdl_n51, cpphdl_n44) <+ cpphdl_channel(V(cpphdl_n304, cpphdl_n44), V(cpphdl_n51, cpphdl_n44), 0.014999999999999999, 0.69999999999999996, 1.0);
        // device 12, IC IC3, analog/basic/cascoded_level_shifter.hpp:63
        I(cpphdl_n43, Vss) <+ cpphdl_channel(V(cpphdl_n48, Vss), V(cpphdl_n43, Vss), 0.059999999999999998, 0.5, 1.0);
        // device 13, IC IC3, analog/basic/cascoded_level_shifter.hpp:64
        I(cpphdl_n44, Vss) <+ cpphdl_channel(V(TRIAL0, Vss), V(cpphdl_n44, Vss), 0.059999999999999998, 0.5, 1.0);
        // device 14, IC IC3, analog/basic/cascoded_level_shifter.hpp:65
        I(cpphdl_n55, Vss) <+ 1e-14 * ddt(V(cpphdl_n55, Vss)); // Bench initial voltage = 0.0 V.
        // device 15, IC IC3, analog/basic/cascoded_level_shifter.hpp:66
        I(cpphdl_n51, Vss) <+ 1e-14 * ddt(V(cpphdl_n51, Vss)); // Bench initial voltage = 0.0 V.
        // device 16, IC IC3, analog/basic/cascoded_level_shifter.hpp:67
        I(cpphdl_n43, Vss) <+ 1e-14 * ddt(V(cpphdl_n43, Vss)); // Bench initial voltage = 0.0 V.
        // device 17, IC IC3, analog/basic/cascoded_level_shifter.hpp:68
        I(cpphdl_n44, Vss) <+ 1e-14 * ddt(V(cpphdl_n44, Vss)); // Bench initial voltage = 0.0 V.
        // device 18, IC IC3, analog/basic/cascoded_level_shifter.hpp:72
        I(cpphdl_n304, cpphdl_n43) <+ 5.9999999999999997e-14 * ddt(V(cpphdl_n304, cpphdl_n43)); // Bench initial voltage = 0.0 V.
        // device 19, IC IC3, analog/basic/cascoded_level_shifter.hpp:73
        I(cpphdl_n304, cpphdl_n44) <+ 5.9999999999999997e-14 * ddt(V(cpphdl_n304, cpphdl_n44)); // Bench initial voltage = 0.0 V.
        // device 20, IC IC3, analog/basic/cascoded_level_shifter.hpp:74
        I(cpphdl_n304, cpphdl_n55) <+ 3.5999999999999998e-14 * ddt(V(cpphdl_n304, cpphdl_n55)); // Bench initial voltage = 0.0 V.
        // device 21, IC IC3, analog/basic/cascoded_level_shifter.hpp:75
        I(cpphdl_n304, cpphdl_n51) <+ 3.5999999999999998e-14 * ddt(V(cpphdl_n304, cpphdl_n51)); // Bench initial voltage = 0.0 V.
        // device 22, IC IC3, analog/basic/cascoded_level_shifter.hpp:76
        I(TRIAL0, Vss) <+ 4e-14 * ddt(V(TRIAL0, Vss)); // Bench initial voltage = 0.0 V.
        // device 23, IC IC3, analog/basic/cascoded_level_shifter.hpp:77
        I(cpphdl_n48, Vss) <+ 4e-14 * ddt(V(cpphdl_n48, Vss)); // Bench initial voltage = 0.0 V.
        // device 24, IC IC3, analog/basic/cascoded_level_shifter.hpp:78
        I(cpphdl_n55, Vdd) <+ 4e-14 * ddt(V(cpphdl_n55, Vdd)); // Bench initial voltage = 0.0 V.
        // device 25, IC IC3, analog/basic/cascoded_level_shifter.hpp:79
        I(cpphdl_n51, Vdd) <+ 4e-14 * ddt(V(cpphdl_n51, Vdd)); // Bench initial voltage = 0.0 V.
        // device 26, IC IC3, analog/basic/cascoded_level_shifter.hpp:80
        I(cpphdl_n55, cpphdl_n51) <+ 1.4e-14 * ddt(V(cpphdl_n55, cpphdl_n51)); // Bench initial voltage = 0.0 V.
        // device 27, IC IC3, analog/basic/cascoded_level_shifter.hpp:81
        I(cpphdl_n55, Vss) <+ 7.0000000000000005e-14 * ddt(V(cpphdl_n55, Vss)); // Bench initial voltage = 0.0 V.
        // device 28, IC IC3, analog/basic/cascoded_level_shifter.hpp:82
        I(cpphdl_n51, Vss) <+ 7.0000000000000005e-14 * ddt(V(cpphdl_n51, Vss)); // Bench initial voltage = 0.0 V.
        // device 29, IC IC3, analog/basic/cascoded_level_shifter.hpp:83
        I(cpphdl_n55, cpphdl_n238) <+ 2.3e-14 * ddt(V(cpphdl_n55, cpphdl_n238)); // Bench initial voltage = 0.0 V.
        // device 30, IC IC3, analog/basic/cascoded_level_shifter.hpp:84
        I(cpphdl_n51, cpphdl_n52) <+ 2.3e-14 * ddt(V(cpphdl_n51, cpphdl_n52)); // Bench initial voltage = 0.0 V.
        // device 31, IC IC5, analog/basic/inverter.hpp:11
        I(cpphdl_n52, Vdd) <+ cpphdl_channel(V(cpphdl_n51, Vdd), V(cpphdl_n52, Vdd), 0.0060000000000000001, 0.69999999999999996, -1.0);
        // device 32, IC IC5, analog/basic/inverter.hpp:12
        I(cpphdl_n52, Vss) <+ cpphdl_channel(V(cpphdl_n51, Vss), V(cpphdl_n52, Vss), 0.0060000000000000001, 0.69999999999999996, 1.0);
        // device 33, IC IC6, analog/basic/inverter.hpp:11
        I(cpphdl_n238, Vdd) <+ cpphdl_channel(V(cpphdl_n55, Vdd), V(cpphdl_n238, Vdd), 0.0060000000000000001, 0.69999999999999996, -1.0);
        // device 34, IC IC6, analog/basic/inverter.hpp:12
        I(cpphdl_n238, Vss) <+ cpphdl_channel(V(cpphdl_n55, Vss), V(cpphdl_n238, Vss), 0.0060000000000000001, 0.69999999999999996, 1.0);
        // device 35, IC IC3, analog/basic/cascoded_level_shifter.hpp:95
        I(cpphdl_n52, Vss) <+ 5.0000000000000002e-14 * ddt(V(cpphdl_n52, Vss)); // Bench initial voltage = 0.0 V.
        // device 36, IC IC3, analog/basic/cascoded_level_shifter.hpp:96
        I(cpphdl_n238, Vss) <+ 5.0000000000000002e-14 * ddt(V(cpphdl_n238, Vss)); // Bench initial voltage = 0.0 V.
        // device 37, IC IC3, analog/basic/cascoded_level_shifter.hpp:97
        I(TRIAL0, cpphdl_n44) <+ 1.6000000000000001e-14 * ddt(V(TRIAL0, cpphdl_n44)); // Bench initial voltage = 0.0 V.
        // device 38, IC IC3, analog/basic/cascoded_level_shifter.hpp:98
        I(cpphdl_n48, cpphdl_n43) <+ 1.6000000000000001e-14 * ddt(V(cpphdl_n48, cpphdl_n43)); // Bench initial voltage = 0.0 V.
        // device 39, IC IC3, analog/1G/clock_level_shifter.hpp:14
        I(cpphdl_n52, Vss) <+ 2.0000000000000001e-13 * ddt(V(cpphdl_n52, Vss)); // Bench initial voltage = 0.0 V.
        // device 40, IC IC3, analog/1G/clock_level_shifter.hpp:15
        I(cpphdl_n238, Vss) <+ 2.0000000000000001e-13 * ddt(V(cpphdl_n238, Vss)); // Bench initial voltage = 0.0 V.
        // device 41, IC IC8, analog/basic/inverter.hpp:11
        I(cpphdl_n72, Vlogic) <+ cpphdl_channel(V(TRIAL1, Vlogic), V(cpphdl_n72, Vlogic), 0.02, 0.5, -1.0);
        // device 42, IC IC8, analog/basic/inverter.hpp:12
        I(cpphdl_n72, Vss) <+ cpphdl_channel(V(TRIAL1, Vss), V(cpphdl_n72, Vss), 0.02, 0.5, 1.0);
        // device 43, IC IC7, analog/basic/cascoded_level_shifter.hpp:58
        I(cpphdl_n72, Vss) <+ 1e-14 * ddt(V(cpphdl_n72, Vss)); // Bench initial voltage = 0.0 V.
        // device 44, IC IC7, analog/basic/cascoded_level_shifter.hpp:59
        I(cpphdl_n79, Vdd) <+ cpphdl_channel(V(cpphdl_n75, Vdd), V(cpphdl_n79, Vdd), 0.0028, 0.69999999999999996, -1.0);
        // device 45, IC IC7, analog/basic/cascoded_level_shifter.hpp:60
        I(cpphdl_n75, Vdd) <+ cpphdl_channel(V(cpphdl_n79, Vdd), V(cpphdl_n75, Vdd), 0.0028, 0.69999999999999996, -1.0);
        // device 46, IC IC7, analog/basic/cascoded_level_shifter.hpp:61
        I(cpphdl_n79, cpphdl_n67) <+ cpphdl_channel(V(cpphdl_n304, cpphdl_n67), V(cpphdl_n79, cpphdl_n67), 0.014999999999999999, 0.69999999999999996, 1.0);
        // device 47, IC IC7, analog/basic/cascoded_level_shifter.hpp:62
        I(cpphdl_n75, cpphdl_n68) <+ cpphdl_channel(V(cpphdl_n304, cpphdl_n68), V(cpphdl_n75, cpphdl_n68), 0.014999999999999999, 0.69999999999999996, 1.0);
        // device 48, IC IC7, analog/basic/cascoded_level_shifter.hpp:63
        I(cpphdl_n67, Vss) <+ cpphdl_channel(V(cpphdl_n72, Vss), V(cpphdl_n67, Vss), 0.059999999999999998, 0.5, 1.0);
        // device 49, IC IC7, analog/basic/cascoded_level_shifter.hpp:64
        I(cpphdl_n68, Vss) <+ cpphdl_channel(V(TRIAL1, Vss), V(cpphdl_n68, Vss), 0.059999999999999998, 0.5, 1.0);
        // device 50, IC IC7, analog/basic/cascoded_level_shifter.hpp:65
        I(cpphdl_n79, Vss) <+ 1e-14 * ddt(V(cpphdl_n79, Vss)); // Bench initial voltage = 0.0 V.
        // device 51, IC IC7, analog/basic/cascoded_level_shifter.hpp:66
        I(cpphdl_n75, Vss) <+ 1e-14 * ddt(V(cpphdl_n75, Vss)); // Bench initial voltage = 0.0 V.
        // device 52, IC IC7, analog/basic/cascoded_level_shifter.hpp:67
        I(cpphdl_n67, Vss) <+ 1e-14 * ddt(V(cpphdl_n67, Vss)); // Bench initial voltage = 0.0 V.
        // device 53, IC IC7, analog/basic/cascoded_level_shifter.hpp:68
        I(cpphdl_n68, Vss) <+ 1e-14 * ddt(V(cpphdl_n68, Vss)); // Bench initial voltage = 0.0 V.
        // device 54, IC IC7, analog/basic/cascoded_level_shifter.hpp:72
        I(cpphdl_n304, cpphdl_n67) <+ 5.9999999999999997e-14 * ddt(V(cpphdl_n304, cpphdl_n67)); // Bench initial voltage = 0.0 V.
        // device 55, IC IC7, analog/basic/cascoded_level_shifter.hpp:73
        I(cpphdl_n304, cpphdl_n68) <+ 5.9999999999999997e-14 * ddt(V(cpphdl_n304, cpphdl_n68)); // Bench initial voltage = 0.0 V.
        // device 56, IC IC7, analog/basic/cascoded_level_shifter.hpp:74
        I(cpphdl_n304, cpphdl_n79) <+ 3.5999999999999998e-14 * ddt(V(cpphdl_n304, cpphdl_n79)); // Bench initial voltage = 0.0 V.
        // device 57, IC IC7, analog/basic/cascoded_level_shifter.hpp:75
        I(cpphdl_n304, cpphdl_n75) <+ 3.5999999999999998e-14 * ddt(V(cpphdl_n304, cpphdl_n75)); // Bench initial voltage = 0.0 V.
        // device 58, IC IC7, analog/basic/cascoded_level_shifter.hpp:76
        I(TRIAL1, Vss) <+ 4e-14 * ddt(V(TRIAL1, Vss)); // Bench initial voltage = 0.0 V.
        // device 59, IC IC7, analog/basic/cascoded_level_shifter.hpp:77
        I(cpphdl_n72, Vss) <+ 4e-14 * ddt(V(cpphdl_n72, Vss)); // Bench initial voltage = 0.0 V.
        // device 60, IC IC7, analog/basic/cascoded_level_shifter.hpp:78
        I(cpphdl_n79, Vdd) <+ 4e-14 * ddt(V(cpphdl_n79, Vdd)); // Bench initial voltage = 0.0 V.
        // device 61, IC IC7, analog/basic/cascoded_level_shifter.hpp:79
        I(cpphdl_n75, Vdd) <+ 4e-14 * ddt(V(cpphdl_n75, Vdd)); // Bench initial voltage = 0.0 V.
        // device 62, IC IC7, analog/basic/cascoded_level_shifter.hpp:80
        I(cpphdl_n79, cpphdl_n75) <+ 1.4e-14 * ddt(V(cpphdl_n79, cpphdl_n75)); // Bench initial voltage = 0.0 V.
        // device 63, IC IC7, analog/basic/cascoded_level_shifter.hpp:81
        I(cpphdl_n79, Vss) <+ 7.0000000000000005e-14 * ddt(V(cpphdl_n79, Vss)); // Bench initial voltage = 0.0 V.
        // device 64, IC IC7, analog/basic/cascoded_level_shifter.hpp:82
        I(cpphdl_n75, Vss) <+ 7.0000000000000005e-14 * ddt(V(cpphdl_n75, Vss)); // Bench initial voltage = 0.0 V.
        // device 65, IC IC7, analog/basic/cascoded_level_shifter.hpp:83
        I(cpphdl_n79, cpphdl_n242) <+ 2.3e-14 * ddt(V(cpphdl_n79, cpphdl_n242)); // Bench initial voltage = 0.0 V.
        // device 66, IC IC7, analog/basic/cascoded_level_shifter.hpp:84
        I(cpphdl_n75, cpphdl_n76) <+ 2.3e-14 * ddt(V(cpphdl_n75, cpphdl_n76)); // Bench initial voltage = 0.0 V.
        // device 67, IC IC9, analog/basic/inverter.hpp:11
        I(cpphdl_n76, Vdd) <+ cpphdl_channel(V(cpphdl_n75, Vdd), V(cpphdl_n76, Vdd), 0.0060000000000000001, 0.69999999999999996, -1.0);
        // device 68, IC IC9, analog/basic/inverter.hpp:12
        I(cpphdl_n76, Vss) <+ cpphdl_channel(V(cpphdl_n75, Vss), V(cpphdl_n76, Vss), 0.0060000000000000001, 0.69999999999999996, 1.0);
        // device 69, IC IC10, analog/basic/inverter.hpp:11
        I(cpphdl_n242, Vdd) <+ cpphdl_channel(V(cpphdl_n79, Vdd), V(cpphdl_n242, Vdd), 0.0060000000000000001, 0.69999999999999996, -1.0);
        // device 70, IC IC10, analog/basic/inverter.hpp:12
        I(cpphdl_n242, Vss) <+ cpphdl_channel(V(cpphdl_n79, Vss), V(cpphdl_n242, Vss), 0.0060000000000000001, 0.69999999999999996, 1.0);
        // device 71, IC IC7, analog/basic/cascoded_level_shifter.hpp:95
        I(cpphdl_n76, Vss) <+ 5.0000000000000002e-14 * ddt(V(cpphdl_n76, Vss)); // Bench initial voltage = 0.0 V.
        // device 72, IC IC7, analog/basic/cascoded_level_shifter.hpp:96
        I(cpphdl_n242, Vss) <+ 5.0000000000000002e-14 * ddt(V(cpphdl_n242, Vss)); // Bench initial voltage = 0.0 V.
        // device 73, IC IC7, analog/basic/cascoded_level_shifter.hpp:97
        I(TRIAL1, cpphdl_n68) <+ 1.6000000000000001e-14 * ddt(V(TRIAL1, cpphdl_n68)); // Bench initial voltage = 0.0 V.
        // device 74, IC IC7, analog/basic/cascoded_level_shifter.hpp:98
        I(cpphdl_n72, cpphdl_n67) <+ 1.6000000000000001e-14 * ddt(V(cpphdl_n72, cpphdl_n67)); // Bench initial voltage = 0.0 V.
        // device 75, IC IC7, analog/1G/clock_level_shifter.hpp:14
        I(cpphdl_n76, Vss) <+ 2.0000000000000001e-13 * ddt(V(cpphdl_n76, Vss)); // Bench initial voltage = 0.0 V.
        // device 76, IC IC7, analog/1G/clock_level_shifter.hpp:15
        I(cpphdl_n242, Vss) <+ 2.0000000000000001e-13 * ddt(V(cpphdl_n242, Vss)); // Bench initial voltage = 0.0 V.
        // device 77, IC IC12, analog/basic/inverter.hpp:11
        I(cpphdl_n96, Vlogic) <+ cpphdl_channel(V(TRIAL2, Vlogic), V(cpphdl_n96, Vlogic), 0.02, 0.5, -1.0);
        // device 78, IC IC12, analog/basic/inverter.hpp:12
        I(cpphdl_n96, Vss) <+ cpphdl_channel(V(TRIAL2, Vss), V(cpphdl_n96, Vss), 0.02, 0.5, 1.0);
        // device 79, IC IC11, analog/basic/cascoded_level_shifter.hpp:58
        I(cpphdl_n96, Vss) <+ 1e-14 * ddt(V(cpphdl_n96, Vss)); // Bench initial voltage = 0.0 V.
        // device 80, IC IC11, analog/basic/cascoded_level_shifter.hpp:59
        I(cpphdl_n103, Vdd) <+ cpphdl_channel(V(cpphdl_n99, Vdd), V(cpphdl_n103, Vdd), 0.0028, 0.69999999999999996, -1.0);
        // device 81, IC IC11, analog/basic/cascoded_level_shifter.hpp:60
        I(cpphdl_n99, Vdd) <+ cpphdl_channel(V(cpphdl_n103, Vdd), V(cpphdl_n99, Vdd), 0.0028, 0.69999999999999996, -1.0);
        // device 82, IC IC11, analog/basic/cascoded_level_shifter.hpp:61
        I(cpphdl_n103, cpphdl_n91) <+ cpphdl_channel(V(cpphdl_n304, cpphdl_n91), V(cpphdl_n103, cpphdl_n91), 0.014999999999999999, 0.69999999999999996, 1.0);
        // device 83, IC IC11, analog/basic/cascoded_level_shifter.hpp:62
        I(cpphdl_n99, cpphdl_n92) <+ cpphdl_channel(V(cpphdl_n304, cpphdl_n92), V(cpphdl_n99, cpphdl_n92), 0.014999999999999999, 0.69999999999999996, 1.0);
        // device 84, IC IC11, analog/basic/cascoded_level_shifter.hpp:63
        I(cpphdl_n91, Vss) <+ cpphdl_channel(V(cpphdl_n96, Vss), V(cpphdl_n91, Vss), 0.059999999999999998, 0.5, 1.0);
        // device 85, IC IC11, analog/basic/cascoded_level_shifter.hpp:64
        I(cpphdl_n92, Vss) <+ cpphdl_channel(V(TRIAL2, Vss), V(cpphdl_n92, Vss), 0.059999999999999998, 0.5, 1.0);
        // device 86, IC IC11, analog/basic/cascoded_level_shifter.hpp:65
        I(cpphdl_n103, Vss) <+ 1e-14 * ddt(V(cpphdl_n103, Vss)); // Bench initial voltage = 0.0 V.
        // device 87, IC IC11, analog/basic/cascoded_level_shifter.hpp:66
        I(cpphdl_n99, Vss) <+ 1e-14 * ddt(V(cpphdl_n99, Vss)); // Bench initial voltage = 0.0 V.
        // device 88, IC IC11, analog/basic/cascoded_level_shifter.hpp:67
        I(cpphdl_n91, Vss) <+ 1e-14 * ddt(V(cpphdl_n91, Vss)); // Bench initial voltage = 0.0 V.
        // device 89, IC IC11, analog/basic/cascoded_level_shifter.hpp:68
        I(cpphdl_n92, Vss) <+ 1e-14 * ddt(V(cpphdl_n92, Vss)); // Bench initial voltage = 0.0 V.
        // device 90, IC IC11, analog/basic/cascoded_level_shifter.hpp:72
        I(cpphdl_n304, cpphdl_n91) <+ 5.9999999999999997e-14 * ddt(V(cpphdl_n304, cpphdl_n91)); // Bench initial voltage = 0.0 V.
        // device 91, IC IC11, analog/basic/cascoded_level_shifter.hpp:73
        I(cpphdl_n304, cpphdl_n92) <+ 5.9999999999999997e-14 * ddt(V(cpphdl_n304, cpphdl_n92)); // Bench initial voltage = 0.0 V.
        // device 92, IC IC11, analog/basic/cascoded_level_shifter.hpp:74
        I(cpphdl_n304, cpphdl_n103) <+ 3.5999999999999998e-14 * ddt(V(cpphdl_n304, cpphdl_n103)); // Bench initial voltage = 0.0 V.
        // device 93, IC IC11, analog/basic/cascoded_level_shifter.hpp:75
        I(cpphdl_n304, cpphdl_n99) <+ 3.5999999999999998e-14 * ddt(V(cpphdl_n304, cpphdl_n99)); // Bench initial voltage = 0.0 V.
        // device 94, IC IC11, analog/basic/cascoded_level_shifter.hpp:76
        I(TRIAL2, Vss) <+ 4e-14 * ddt(V(TRIAL2, Vss)); // Bench initial voltage = 0.0 V.
        // device 95, IC IC11, analog/basic/cascoded_level_shifter.hpp:77
        I(cpphdl_n96, Vss) <+ 4e-14 * ddt(V(cpphdl_n96, Vss)); // Bench initial voltage = 0.0 V.
        // device 96, IC IC11, analog/basic/cascoded_level_shifter.hpp:78
        I(cpphdl_n103, Vdd) <+ 4e-14 * ddt(V(cpphdl_n103, Vdd)); // Bench initial voltage = 0.0 V.
        // device 97, IC IC11, analog/basic/cascoded_level_shifter.hpp:79
        I(cpphdl_n99, Vdd) <+ 4e-14 * ddt(V(cpphdl_n99, Vdd)); // Bench initial voltage = 0.0 V.
        // device 98, IC IC11, analog/basic/cascoded_level_shifter.hpp:80
        I(cpphdl_n103, cpphdl_n99) <+ 1.4e-14 * ddt(V(cpphdl_n103, cpphdl_n99)); // Bench initial voltage = 0.0 V.
        // device 99, IC IC11, analog/basic/cascoded_level_shifter.hpp:81
        I(cpphdl_n103, Vss) <+ 7.0000000000000005e-14 * ddt(V(cpphdl_n103, Vss)); // Bench initial voltage = 0.0 V.
        // device 100, IC IC11, analog/basic/cascoded_level_shifter.hpp:82
        I(cpphdl_n99, Vss) <+ 7.0000000000000005e-14 * ddt(V(cpphdl_n99, Vss)); // Bench initial voltage = 0.0 V.
        // device 101, IC IC11, analog/basic/cascoded_level_shifter.hpp:83
        I(cpphdl_n103, cpphdl_n246) <+ 2.3e-14 * ddt(V(cpphdl_n103, cpphdl_n246)); // Bench initial voltage = 0.0 V.
        // device 102, IC IC11, analog/basic/cascoded_level_shifter.hpp:84
        I(cpphdl_n99, cpphdl_n100) <+ 2.3e-14 * ddt(V(cpphdl_n99, cpphdl_n100)); // Bench initial voltage = 0.0 V.
        // device 103, IC IC13, analog/basic/inverter.hpp:11
        I(cpphdl_n100, Vdd) <+ cpphdl_channel(V(cpphdl_n99, Vdd), V(cpphdl_n100, Vdd), 0.0060000000000000001, 0.69999999999999996, -1.0);
        // device 104, IC IC13, analog/basic/inverter.hpp:12
        I(cpphdl_n100, Vss) <+ cpphdl_channel(V(cpphdl_n99, Vss), V(cpphdl_n100, Vss), 0.0060000000000000001, 0.69999999999999996, 1.0);
        // device 105, IC IC14, analog/basic/inverter.hpp:11
        I(cpphdl_n246, Vdd) <+ cpphdl_channel(V(cpphdl_n103, Vdd), V(cpphdl_n246, Vdd), 0.0060000000000000001, 0.69999999999999996, -1.0);
        // device 106, IC IC14, analog/basic/inverter.hpp:12
        I(cpphdl_n246, Vss) <+ cpphdl_channel(V(cpphdl_n103, Vss), V(cpphdl_n246, Vss), 0.0060000000000000001, 0.69999999999999996, 1.0);
        // device 107, IC IC11, analog/basic/cascoded_level_shifter.hpp:95
        I(cpphdl_n100, Vss) <+ 5.0000000000000002e-14 * ddt(V(cpphdl_n100, Vss)); // Bench initial voltage = 0.0 V.
        // device 108, IC IC11, analog/basic/cascoded_level_shifter.hpp:96
        I(cpphdl_n246, Vss) <+ 5.0000000000000002e-14 * ddt(V(cpphdl_n246, Vss)); // Bench initial voltage = 0.0 V.
        // device 109, IC IC11, analog/basic/cascoded_level_shifter.hpp:97
        I(TRIAL2, cpphdl_n92) <+ 1.6000000000000001e-14 * ddt(V(TRIAL2, cpphdl_n92)); // Bench initial voltage = 0.0 V.
        // device 110, IC IC11, analog/basic/cascoded_level_shifter.hpp:98
        I(cpphdl_n96, cpphdl_n91) <+ 1.6000000000000001e-14 * ddt(V(cpphdl_n96, cpphdl_n91)); // Bench initial voltage = 0.0 V.
        // device 111, IC IC11, analog/1G/clock_level_shifter.hpp:14
        I(cpphdl_n100, Vss) <+ 2.0000000000000001e-13 * ddt(V(cpphdl_n100, Vss)); // Bench initial voltage = 0.0 V.
        // device 112, IC IC11, analog/1G/clock_level_shifter.hpp:15
        I(cpphdl_n246, Vss) <+ 2.0000000000000001e-13 * ddt(V(cpphdl_n246, Vss)); // Bench initial voltage = 0.0 V.
        // device 113, IC IC16, analog/basic/inverter.hpp:11
        I(cpphdl_n120, Vlogic) <+ cpphdl_channel(V(TRIAL3, Vlogic), V(cpphdl_n120, Vlogic), 0.02, 0.5, -1.0);
        // device 114, IC IC16, analog/basic/inverter.hpp:12
        I(cpphdl_n120, Vss) <+ cpphdl_channel(V(TRIAL3, Vss), V(cpphdl_n120, Vss), 0.02, 0.5, 1.0);
        // device 115, IC IC15, analog/basic/cascoded_level_shifter.hpp:58
        I(cpphdl_n120, Vss) <+ 1e-14 * ddt(V(cpphdl_n120, Vss)); // Bench initial voltage = 0.0 V.
        // device 116, IC IC15, analog/basic/cascoded_level_shifter.hpp:59
        I(cpphdl_n127, Vdd) <+ cpphdl_channel(V(cpphdl_n123, Vdd), V(cpphdl_n127, Vdd), 0.0028, 0.69999999999999996, -1.0);
        // device 117, IC IC15, analog/basic/cascoded_level_shifter.hpp:60
        I(cpphdl_n123, Vdd) <+ cpphdl_channel(V(cpphdl_n127, Vdd), V(cpphdl_n123, Vdd), 0.0028, 0.69999999999999996, -1.0);
        // device 118, IC IC15, analog/basic/cascoded_level_shifter.hpp:61
        I(cpphdl_n127, cpphdl_n115) <+ cpphdl_channel(V(cpphdl_n304, cpphdl_n115), V(cpphdl_n127, cpphdl_n115), 0.014999999999999999, 0.69999999999999996, 1.0);
        // device 119, IC IC15, analog/basic/cascoded_level_shifter.hpp:62
        I(cpphdl_n123, cpphdl_n116) <+ cpphdl_channel(V(cpphdl_n304, cpphdl_n116), V(cpphdl_n123, cpphdl_n116), 0.014999999999999999, 0.69999999999999996, 1.0);
        // device 120, IC IC15, analog/basic/cascoded_level_shifter.hpp:63
        I(cpphdl_n115, Vss) <+ cpphdl_channel(V(cpphdl_n120, Vss), V(cpphdl_n115, Vss), 0.059999999999999998, 0.5, 1.0);
        // device 121, IC IC15, analog/basic/cascoded_level_shifter.hpp:64
        I(cpphdl_n116, Vss) <+ cpphdl_channel(V(TRIAL3, Vss), V(cpphdl_n116, Vss), 0.059999999999999998, 0.5, 1.0);
        // device 122, IC IC15, analog/basic/cascoded_level_shifter.hpp:65
        I(cpphdl_n127, Vss) <+ 1e-14 * ddt(V(cpphdl_n127, Vss)); // Bench initial voltage = 0.0 V.
        // device 123, IC IC15, analog/basic/cascoded_level_shifter.hpp:66
        I(cpphdl_n123, Vss) <+ 1e-14 * ddt(V(cpphdl_n123, Vss)); // Bench initial voltage = 0.0 V.
        // device 124, IC IC15, analog/basic/cascoded_level_shifter.hpp:67
        I(cpphdl_n115, Vss) <+ 1e-14 * ddt(V(cpphdl_n115, Vss)); // Bench initial voltage = 0.0 V.
        // device 125, IC IC15, analog/basic/cascoded_level_shifter.hpp:68
        I(cpphdl_n116, Vss) <+ 1e-14 * ddt(V(cpphdl_n116, Vss)); // Bench initial voltage = 0.0 V.
        // device 126, IC IC15, analog/basic/cascoded_level_shifter.hpp:72
        I(cpphdl_n304, cpphdl_n115) <+ 5.9999999999999997e-14 * ddt(V(cpphdl_n304, cpphdl_n115)); // Bench initial voltage = 0.0 V.
        // device 127, IC IC15, analog/basic/cascoded_level_shifter.hpp:73
        I(cpphdl_n304, cpphdl_n116) <+ 5.9999999999999997e-14 * ddt(V(cpphdl_n304, cpphdl_n116)); // Bench initial voltage = 0.0 V.
        // device 128, IC IC15, analog/basic/cascoded_level_shifter.hpp:74
        I(cpphdl_n304, cpphdl_n127) <+ 3.5999999999999998e-14 * ddt(V(cpphdl_n304, cpphdl_n127)); // Bench initial voltage = 0.0 V.
        // device 129, IC IC15, analog/basic/cascoded_level_shifter.hpp:75
        I(cpphdl_n304, cpphdl_n123) <+ 3.5999999999999998e-14 * ddt(V(cpphdl_n304, cpphdl_n123)); // Bench initial voltage = 0.0 V.
        // device 130, IC IC15, analog/basic/cascoded_level_shifter.hpp:76
        I(TRIAL3, Vss) <+ 4e-14 * ddt(V(TRIAL3, Vss)); // Bench initial voltage = 0.0 V.
        // device 131, IC IC15, analog/basic/cascoded_level_shifter.hpp:77
        I(cpphdl_n120, Vss) <+ 4e-14 * ddt(V(cpphdl_n120, Vss)); // Bench initial voltage = 0.0 V.
        // device 132, IC IC15, analog/basic/cascoded_level_shifter.hpp:78
        I(cpphdl_n127, Vdd) <+ 4e-14 * ddt(V(cpphdl_n127, Vdd)); // Bench initial voltage = 0.0 V.
        // device 133, IC IC15, analog/basic/cascoded_level_shifter.hpp:79
        I(cpphdl_n123, Vdd) <+ 4e-14 * ddt(V(cpphdl_n123, Vdd)); // Bench initial voltage = 0.0 V.
        // device 134, IC IC15, analog/basic/cascoded_level_shifter.hpp:80
        I(cpphdl_n127, cpphdl_n123) <+ 1.4e-14 * ddt(V(cpphdl_n127, cpphdl_n123)); // Bench initial voltage = 0.0 V.
        // device 135, IC IC15, analog/basic/cascoded_level_shifter.hpp:81
        I(cpphdl_n127, Vss) <+ 7.0000000000000005e-14 * ddt(V(cpphdl_n127, Vss)); // Bench initial voltage = 0.0 V.
        // device 136, IC IC15, analog/basic/cascoded_level_shifter.hpp:82
        I(cpphdl_n123, Vss) <+ 7.0000000000000005e-14 * ddt(V(cpphdl_n123, Vss)); // Bench initial voltage = 0.0 V.
        // device 137, IC IC15, analog/basic/cascoded_level_shifter.hpp:83
        I(cpphdl_n127, cpphdl_n250) <+ 2.3e-14 * ddt(V(cpphdl_n127, cpphdl_n250)); // Bench initial voltage = 0.0 V.
        // device 138, IC IC15, analog/basic/cascoded_level_shifter.hpp:84
        I(cpphdl_n123, cpphdl_n124) <+ 2.3e-14 * ddt(V(cpphdl_n123, cpphdl_n124)); // Bench initial voltage = 0.0 V.
        // device 139, IC IC17, analog/basic/inverter.hpp:11
        I(cpphdl_n124, Vdd) <+ cpphdl_channel(V(cpphdl_n123, Vdd), V(cpphdl_n124, Vdd), 0.0060000000000000001, 0.69999999999999996, -1.0);
        // device 140, IC IC17, analog/basic/inverter.hpp:12
        I(cpphdl_n124, Vss) <+ cpphdl_channel(V(cpphdl_n123, Vss), V(cpphdl_n124, Vss), 0.0060000000000000001, 0.69999999999999996, 1.0);
        // device 141, IC IC18, analog/basic/inverter.hpp:11
        I(cpphdl_n250, Vdd) <+ cpphdl_channel(V(cpphdl_n127, Vdd), V(cpphdl_n250, Vdd), 0.0060000000000000001, 0.69999999999999996, -1.0);
        // device 142, IC IC18, analog/basic/inverter.hpp:12
        I(cpphdl_n250, Vss) <+ cpphdl_channel(V(cpphdl_n127, Vss), V(cpphdl_n250, Vss), 0.0060000000000000001, 0.69999999999999996, 1.0);
        // device 143, IC IC15, analog/basic/cascoded_level_shifter.hpp:95
        I(cpphdl_n124, Vss) <+ 5.0000000000000002e-14 * ddt(V(cpphdl_n124, Vss)); // Bench initial voltage = 0.0 V.
        // device 144, IC IC15, analog/basic/cascoded_level_shifter.hpp:96
        I(cpphdl_n250, Vss) <+ 5.0000000000000002e-14 * ddt(V(cpphdl_n250, Vss)); // Bench initial voltage = 0.0 V.
        // device 145, IC IC15, analog/basic/cascoded_level_shifter.hpp:97
        I(TRIAL3, cpphdl_n116) <+ 1.6000000000000001e-14 * ddt(V(TRIAL3, cpphdl_n116)); // Bench initial voltage = 0.0 V.
        // device 146, IC IC15, analog/basic/cascoded_level_shifter.hpp:98
        I(cpphdl_n120, cpphdl_n115) <+ 1.6000000000000001e-14 * ddt(V(cpphdl_n120, cpphdl_n115)); // Bench initial voltage = 0.0 V.
        // device 147, IC IC15, analog/1G/clock_level_shifter.hpp:14
        I(cpphdl_n124, Vss) <+ 2.0000000000000001e-13 * ddt(V(cpphdl_n124, Vss)); // Bench initial voltage = 0.0 V.
        // device 148, IC IC15, analog/1G/clock_level_shifter.hpp:15
        I(cpphdl_n250, Vss) <+ 2.0000000000000001e-13 * ddt(V(cpphdl_n250, Vss)); // Bench initial voltage = 0.0 V.
        // device 149, IC IC20, analog/basic/inverter.hpp:11
        I(cpphdl_n144, Vlogic) <+ cpphdl_channel(V(TRIAL4, Vlogic), V(cpphdl_n144, Vlogic), 0.02, 0.5, -1.0);
        // device 150, IC IC20, analog/basic/inverter.hpp:12
        I(cpphdl_n144, Vss) <+ cpphdl_channel(V(TRIAL4, Vss), V(cpphdl_n144, Vss), 0.02, 0.5, 1.0);
        // device 151, IC IC19, analog/basic/cascoded_level_shifter.hpp:58
        I(cpphdl_n144, Vss) <+ 1e-14 * ddt(V(cpphdl_n144, Vss)); // Bench initial voltage = 0.0 V.
        // device 152, IC IC19, analog/basic/cascoded_level_shifter.hpp:59
        I(cpphdl_n151, Vdd) <+ cpphdl_channel(V(cpphdl_n147, Vdd), V(cpphdl_n151, Vdd), 0.0028, 0.69999999999999996, -1.0);
        // device 153, IC IC19, analog/basic/cascoded_level_shifter.hpp:60
        I(cpphdl_n147, Vdd) <+ cpphdl_channel(V(cpphdl_n151, Vdd), V(cpphdl_n147, Vdd), 0.0028, 0.69999999999999996, -1.0);
        // device 154, IC IC19, analog/basic/cascoded_level_shifter.hpp:61
        I(cpphdl_n151, cpphdl_n139) <+ cpphdl_channel(V(cpphdl_n304, cpphdl_n139), V(cpphdl_n151, cpphdl_n139), 0.014999999999999999, 0.69999999999999996, 1.0);
        // device 155, IC IC19, analog/basic/cascoded_level_shifter.hpp:62
        I(cpphdl_n147, cpphdl_n140) <+ cpphdl_channel(V(cpphdl_n304, cpphdl_n140), V(cpphdl_n147, cpphdl_n140), 0.014999999999999999, 0.69999999999999996, 1.0);
        // device 156, IC IC19, analog/basic/cascoded_level_shifter.hpp:63
        I(cpphdl_n139, Vss) <+ cpphdl_channel(V(cpphdl_n144, Vss), V(cpphdl_n139, Vss), 0.059999999999999998, 0.5, 1.0);
        // device 157, IC IC19, analog/basic/cascoded_level_shifter.hpp:64
        I(cpphdl_n140, Vss) <+ cpphdl_channel(V(TRIAL4, Vss), V(cpphdl_n140, Vss), 0.059999999999999998, 0.5, 1.0);
        // device 158, IC IC19, analog/basic/cascoded_level_shifter.hpp:65
        I(cpphdl_n151, Vss) <+ 1e-14 * ddt(V(cpphdl_n151, Vss)); // Bench initial voltage = 0.0 V.
        // device 159, IC IC19, analog/basic/cascoded_level_shifter.hpp:66
        I(cpphdl_n147, Vss) <+ 1e-14 * ddt(V(cpphdl_n147, Vss)); // Bench initial voltage = 0.0 V.
        // device 160, IC IC19, analog/basic/cascoded_level_shifter.hpp:67
        I(cpphdl_n139, Vss) <+ 1e-14 * ddt(V(cpphdl_n139, Vss)); // Bench initial voltage = 0.0 V.
        // device 161, IC IC19, analog/basic/cascoded_level_shifter.hpp:68
        I(cpphdl_n140, Vss) <+ 1e-14 * ddt(V(cpphdl_n140, Vss)); // Bench initial voltage = 0.0 V.
        // device 162, IC IC19, analog/basic/cascoded_level_shifter.hpp:72
        I(cpphdl_n304, cpphdl_n139) <+ 5.9999999999999997e-14 * ddt(V(cpphdl_n304, cpphdl_n139)); // Bench initial voltage = 0.0 V.
        // device 163, IC IC19, analog/basic/cascoded_level_shifter.hpp:73
        I(cpphdl_n304, cpphdl_n140) <+ 5.9999999999999997e-14 * ddt(V(cpphdl_n304, cpphdl_n140)); // Bench initial voltage = 0.0 V.
        // device 164, IC IC19, analog/basic/cascoded_level_shifter.hpp:74
        I(cpphdl_n304, cpphdl_n151) <+ 3.5999999999999998e-14 * ddt(V(cpphdl_n304, cpphdl_n151)); // Bench initial voltage = 0.0 V.
        // device 165, IC IC19, analog/basic/cascoded_level_shifter.hpp:75
        I(cpphdl_n304, cpphdl_n147) <+ 3.5999999999999998e-14 * ddt(V(cpphdl_n304, cpphdl_n147)); // Bench initial voltage = 0.0 V.
        // device 166, IC IC19, analog/basic/cascoded_level_shifter.hpp:76
        I(TRIAL4, Vss) <+ 4e-14 * ddt(V(TRIAL4, Vss)); // Bench initial voltage = 0.0 V.
        // device 167, IC IC19, analog/basic/cascoded_level_shifter.hpp:77
        I(cpphdl_n144, Vss) <+ 4e-14 * ddt(V(cpphdl_n144, Vss)); // Bench initial voltage = 0.0 V.
        // device 168, IC IC19, analog/basic/cascoded_level_shifter.hpp:78
        I(cpphdl_n151, Vdd) <+ 4e-14 * ddt(V(cpphdl_n151, Vdd)); // Bench initial voltage = 0.0 V.
        // device 169, IC IC19, analog/basic/cascoded_level_shifter.hpp:79
        I(cpphdl_n147, Vdd) <+ 4e-14 * ddt(V(cpphdl_n147, Vdd)); // Bench initial voltage = 0.0 V.
        // device 170, IC IC19, analog/basic/cascoded_level_shifter.hpp:80
        I(cpphdl_n151, cpphdl_n147) <+ 1.4e-14 * ddt(V(cpphdl_n151, cpphdl_n147)); // Bench initial voltage = 0.0 V.
        // device 171, IC IC19, analog/basic/cascoded_level_shifter.hpp:81
        I(cpphdl_n151, Vss) <+ 7.0000000000000005e-14 * ddt(V(cpphdl_n151, Vss)); // Bench initial voltage = 0.0 V.
        // device 172, IC IC19, analog/basic/cascoded_level_shifter.hpp:82
        I(cpphdl_n147, Vss) <+ 7.0000000000000005e-14 * ddt(V(cpphdl_n147, Vss)); // Bench initial voltage = 0.0 V.
        // device 173, IC IC19, analog/basic/cascoded_level_shifter.hpp:83
        I(cpphdl_n151, cpphdl_n254) <+ 2.3e-14 * ddt(V(cpphdl_n151, cpphdl_n254)); // Bench initial voltage = 0.0 V.
        // device 174, IC IC19, analog/basic/cascoded_level_shifter.hpp:84
        I(cpphdl_n147, cpphdl_n148) <+ 2.3e-14 * ddt(V(cpphdl_n147, cpphdl_n148)); // Bench initial voltage = 0.0 V.
        // device 175, IC IC21, analog/basic/inverter.hpp:11
        I(cpphdl_n148, Vdd) <+ cpphdl_channel(V(cpphdl_n147, Vdd), V(cpphdl_n148, Vdd), 0.0060000000000000001, 0.69999999999999996, -1.0);
        // device 176, IC IC21, analog/basic/inverter.hpp:12
        I(cpphdl_n148, Vss) <+ cpphdl_channel(V(cpphdl_n147, Vss), V(cpphdl_n148, Vss), 0.0060000000000000001, 0.69999999999999996, 1.0);
        // device 177, IC IC22, analog/basic/inverter.hpp:11
        I(cpphdl_n254, Vdd) <+ cpphdl_channel(V(cpphdl_n151, Vdd), V(cpphdl_n254, Vdd), 0.0060000000000000001, 0.69999999999999996, -1.0);
        // device 178, IC IC22, analog/basic/inverter.hpp:12
        I(cpphdl_n254, Vss) <+ cpphdl_channel(V(cpphdl_n151, Vss), V(cpphdl_n254, Vss), 0.0060000000000000001, 0.69999999999999996, 1.0);
        // device 179, IC IC19, analog/basic/cascoded_level_shifter.hpp:95
        I(cpphdl_n148, Vss) <+ 5.0000000000000002e-14 * ddt(V(cpphdl_n148, Vss)); // Bench initial voltage = 0.0 V.
        // device 180, IC IC19, analog/basic/cascoded_level_shifter.hpp:96
        I(cpphdl_n254, Vss) <+ 5.0000000000000002e-14 * ddt(V(cpphdl_n254, Vss)); // Bench initial voltage = 0.0 V.
        // device 181, IC IC19, analog/basic/cascoded_level_shifter.hpp:97
        I(TRIAL4, cpphdl_n140) <+ 1.6000000000000001e-14 * ddt(V(TRIAL4, cpphdl_n140)); // Bench initial voltage = 0.0 V.
        // device 182, IC IC19, analog/basic/cascoded_level_shifter.hpp:98
        I(cpphdl_n144, cpphdl_n139) <+ 1.6000000000000001e-14 * ddt(V(cpphdl_n144, cpphdl_n139)); // Bench initial voltage = 0.0 V.
        // device 183, IC IC19, analog/1G/clock_level_shifter.hpp:14
        I(cpphdl_n148, Vss) <+ 2.0000000000000001e-13 * ddt(V(cpphdl_n148, Vss)); // Bench initial voltage = 0.0 V.
        // device 184, IC IC19, analog/1G/clock_level_shifter.hpp:15
        I(cpphdl_n254, Vss) <+ 2.0000000000000001e-13 * ddt(V(cpphdl_n254, Vss)); // Bench initial voltage = 0.0 V.
        // device 185, IC IC24, analog/basic/inverter.hpp:11
        I(cpphdl_n168, Vlogic) <+ cpphdl_channel(V(TRIAL5, Vlogic), V(cpphdl_n168, Vlogic), 0.02, 0.5, -1.0);
        // device 186, IC IC24, analog/basic/inverter.hpp:12
        I(cpphdl_n168, Vss) <+ cpphdl_channel(V(TRIAL5, Vss), V(cpphdl_n168, Vss), 0.02, 0.5, 1.0);
        // device 187, IC IC23, analog/basic/cascoded_level_shifter.hpp:58
        I(cpphdl_n168, Vss) <+ 1e-14 * ddt(V(cpphdl_n168, Vss)); // Bench initial voltage = 0.0 V.
        // device 188, IC IC23, analog/basic/cascoded_level_shifter.hpp:59
        I(cpphdl_n175, Vdd) <+ cpphdl_channel(V(cpphdl_n171, Vdd), V(cpphdl_n175, Vdd), 0.0028, 0.69999999999999996, -1.0);
        // device 189, IC IC23, analog/basic/cascoded_level_shifter.hpp:60
        I(cpphdl_n171, Vdd) <+ cpphdl_channel(V(cpphdl_n175, Vdd), V(cpphdl_n171, Vdd), 0.0028, 0.69999999999999996, -1.0);
        // device 190, IC IC23, analog/basic/cascoded_level_shifter.hpp:61
        I(cpphdl_n175, cpphdl_n163) <+ cpphdl_channel(V(cpphdl_n304, cpphdl_n163), V(cpphdl_n175, cpphdl_n163), 0.014999999999999999, 0.69999999999999996, 1.0);
        // device 191, IC IC23, analog/basic/cascoded_level_shifter.hpp:62
        I(cpphdl_n171, cpphdl_n164) <+ cpphdl_channel(V(cpphdl_n304, cpphdl_n164), V(cpphdl_n171, cpphdl_n164), 0.014999999999999999, 0.69999999999999996, 1.0);
        // device 192, IC IC23, analog/basic/cascoded_level_shifter.hpp:63
        I(cpphdl_n163, Vss) <+ cpphdl_channel(V(cpphdl_n168, Vss), V(cpphdl_n163, Vss), 0.059999999999999998, 0.5, 1.0);
        // device 193, IC IC23, analog/basic/cascoded_level_shifter.hpp:64
        I(cpphdl_n164, Vss) <+ cpphdl_channel(V(TRIAL5, Vss), V(cpphdl_n164, Vss), 0.059999999999999998, 0.5, 1.0);
        // device 194, IC IC23, analog/basic/cascoded_level_shifter.hpp:65
        I(cpphdl_n175, Vss) <+ 1e-14 * ddt(V(cpphdl_n175, Vss)); // Bench initial voltage = 0.0 V.
        // device 195, IC IC23, analog/basic/cascoded_level_shifter.hpp:66
        I(cpphdl_n171, Vss) <+ 1e-14 * ddt(V(cpphdl_n171, Vss)); // Bench initial voltage = 0.0 V.
        // device 196, IC IC23, analog/basic/cascoded_level_shifter.hpp:67
        I(cpphdl_n163, Vss) <+ 1e-14 * ddt(V(cpphdl_n163, Vss)); // Bench initial voltage = 0.0 V.
        // device 197, IC IC23, analog/basic/cascoded_level_shifter.hpp:68
        I(cpphdl_n164, Vss) <+ 1e-14 * ddt(V(cpphdl_n164, Vss)); // Bench initial voltage = 0.0 V.
        // device 198, IC IC23, analog/basic/cascoded_level_shifter.hpp:72
        I(cpphdl_n304, cpphdl_n163) <+ 5.9999999999999997e-14 * ddt(V(cpphdl_n304, cpphdl_n163)); // Bench initial voltage = 0.0 V.
        // device 199, IC IC23, analog/basic/cascoded_level_shifter.hpp:73
        I(cpphdl_n304, cpphdl_n164) <+ 5.9999999999999997e-14 * ddt(V(cpphdl_n304, cpphdl_n164)); // Bench initial voltage = 0.0 V.
        // device 200, IC IC23, analog/basic/cascoded_level_shifter.hpp:74
        I(cpphdl_n304, cpphdl_n175) <+ 3.5999999999999998e-14 * ddt(V(cpphdl_n304, cpphdl_n175)); // Bench initial voltage = 0.0 V.
        // device 201, IC IC23, analog/basic/cascoded_level_shifter.hpp:75
        I(cpphdl_n304, cpphdl_n171) <+ 3.5999999999999998e-14 * ddt(V(cpphdl_n304, cpphdl_n171)); // Bench initial voltage = 0.0 V.
        // device 202, IC IC23, analog/basic/cascoded_level_shifter.hpp:76
        I(TRIAL5, Vss) <+ 4e-14 * ddt(V(TRIAL5, Vss)); // Bench initial voltage = 0.0 V.
        // device 203, IC IC23, analog/basic/cascoded_level_shifter.hpp:77
        I(cpphdl_n168, Vss) <+ 4e-14 * ddt(V(cpphdl_n168, Vss)); // Bench initial voltage = 0.0 V.
        // device 204, IC IC23, analog/basic/cascoded_level_shifter.hpp:78
        I(cpphdl_n175, Vdd) <+ 4e-14 * ddt(V(cpphdl_n175, Vdd)); // Bench initial voltage = 0.0 V.
        // device 205, IC IC23, analog/basic/cascoded_level_shifter.hpp:79
        I(cpphdl_n171, Vdd) <+ 4e-14 * ddt(V(cpphdl_n171, Vdd)); // Bench initial voltage = 0.0 V.
        // device 206, IC IC23, analog/basic/cascoded_level_shifter.hpp:80
        I(cpphdl_n175, cpphdl_n171) <+ 1.4e-14 * ddt(V(cpphdl_n175, cpphdl_n171)); // Bench initial voltage = 0.0 V.
        // device 207, IC IC23, analog/basic/cascoded_level_shifter.hpp:81
        I(cpphdl_n175, Vss) <+ 7.0000000000000005e-14 * ddt(V(cpphdl_n175, Vss)); // Bench initial voltage = 0.0 V.
        // device 208, IC IC23, analog/basic/cascoded_level_shifter.hpp:82
        I(cpphdl_n171, Vss) <+ 7.0000000000000005e-14 * ddt(V(cpphdl_n171, Vss)); // Bench initial voltage = 0.0 V.
        // device 209, IC IC23, analog/basic/cascoded_level_shifter.hpp:83
        I(cpphdl_n175, cpphdl_n258) <+ 2.3e-14 * ddt(V(cpphdl_n175, cpphdl_n258)); // Bench initial voltage = 0.0 V.
        // device 210, IC IC23, analog/basic/cascoded_level_shifter.hpp:84
        I(cpphdl_n171, cpphdl_n172) <+ 2.3e-14 * ddt(V(cpphdl_n171, cpphdl_n172)); // Bench initial voltage = 0.0 V.
        // device 211, IC IC25, analog/basic/inverter.hpp:11
        I(cpphdl_n172, Vdd) <+ cpphdl_channel(V(cpphdl_n171, Vdd), V(cpphdl_n172, Vdd), 0.0060000000000000001, 0.69999999999999996, -1.0);
        // device 212, IC IC25, analog/basic/inverter.hpp:12
        I(cpphdl_n172, Vss) <+ cpphdl_channel(V(cpphdl_n171, Vss), V(cpphdl_n172, Vss), 0.0060000000000000001, 0.69999999999999996, 1.0);
        // device 213, IC IC26, analog/basic/inverter.hpp:11
        I(cpphdl_n258, Vdd) <+ cpphdl_channel(V(cpphdl_n175, Vdd), V(cpphdl_n258, Vdd), 0.0060000000000000001, 0.69999999999999996, -1.0);
        // device 214, IC IC26, analog/basic/inverter.hpp:12
        I(cpphdl_n258, Vss) <+ cpphdl_channel(V(cpphdl_n175, Vss), V(cpphdl_n258, Vss), 0.0060000000000000001, 0.69999999999999996, 1.0);
        // device 215, IC IC23, analog/basic/cascoded_level_shifter.hpp:95
        I(cpphdl_n172, Vss) <+ 5.0000000000000002e-14 * ddt(V(cpphdl_n172, Vss)); // Bench initial voltage = 0.0 V.
        // device 216, IC IC23, analog/basic/cascoded_level_shifter.hpp:96
        I(cpphdl_n258, Vss) <+ 5.0000000000000002e-14 * ddt(V(cpphdl_n258, Vss)); // Bench initial voltage = 0.0 V.
        // device 217, IC IC23, analog/basic/cascoded_level_shifter.hpp:97
        I(TRIAL5, cpphdl_n164) <+ 1.6000000000000001e-14 * ddt(V(TRIAL5, cpphdl_n164)); // Bench initial voltage = 0.0 V.
        // device 218, IC IC23, analog/basic/cascoded_level_shifter.hpp:98
        I(cpphdl_n168, cpphdl_n163) <+ 1.6000000000000001e-14 * ddt(V(cpphdl_n168, cpphdl_n163)); // Bench initial voltage = 0.0 V.
        // device 219, IC IC23, analog/1G/clock_level_shifter.hpp:14
        I(cpphdl_n172, Vss) <+ 2.0000000000000001e-13 * ddt(V(cpphdl_n172, Vss)); // Bench initial voltage = 0.0 V.
        // device 220, IC IC23, analog/1G/clock_level_shifter.hpp:15
        I(cpphdl_n258, Vss) <+ 2.0000000000000001e-13 * ddt(V(cpphdl_n258, Vss)); // Bench initial voltage = 0.0 V.
        // device 221, IC IC28, analog/basic/inverter.hpp:11
        I(cpphdl_n192, Vlogic) <+ cpphdl_channel(V(TRIAL6, Vlogic), V(cpphdl_n192, Vlogic), 0.02, 0.5, -1.0);
        // device 222, IC IC28, analog/basic/inverter.hpp:12
        I(cpphdl_n192, Vss) <+ cpphdl_channel(V(TRIAL6, Vss), V(cpphdl_n192, Vss), 0.02, 0.5, 1.0);
        // device 223, IC IC27, analog/basic/cascoded_level_shifter.hpp:58
        I(cpphdl_n192, Vss) <+ 1e-14 * ddt(V(cpphdl_n192, Vss)); // Bench initial voltage = 0.0 V.
        // device 224, IC IC27, analog/basic/cascoded_level_shifter.hpp:59
        I(cpphdl_n199, Vdd) <+ cpphdl_channel(V(cpphdl_n195, Vdd), V(cpphdl_n199, Vdd), 0.0028, 0.69999999999999996, -1.0);
        // device 225, IC IC27, analog/basic/cascoded_level_shifter.hpp:60
        I(cpphdl_n195, Vdd) <+ cpphdl_channel(V(cpphdl_n199, Vdd), V(cpphdl_n195, Vdd), 0.0028, 0.69999999999999996, -1.0);
        // device 226, IC IC27, analog/basic/cascoded_level_shifter.hpp:61
        I(cpphdl_n199, cpphdl_n187) <+ cpphdl_channel(V(cpphdl_n304, cpphdl_n187), V(cpphdl_n199, cpphdl_n187), 0.014999999999999999, 0.69999999999999996, 1.0);
        // device 227, IC IC27, analog/basic/cascoded_level_shifter.hpp:62
        I(cpphdl_n195, cpphdl_n188) <+ cpphdl_channel(V(cpphdl_n304, cpphdl_n188), V(cpphdl_n195, cpphdl_n188), 0.014999999999999999, 0.69999999999999996, 1.0);
        // device 228, IC IC27, analog/basic/cascoded_level_shifter.hpp:63
        I(cpphdl_n187, Vss) <+ cpphdl_channel(V(cpphdl_n192, Vss), V(cpphdl_n187, Vss), 0.059999999999999998, 0.5, 1.0);
        // device 229, IC IC27, analog/basic/cascoded_level_shifter.hpp:64
        I(cpphdl_n188, Vss) <+ cpphdl_channel(V(TRIAL6, Vss), V(cpphdl_n188, Vss), 0.059999999999999998, 0.5, 1.0);
        // device 230, IC IC27, analog/basic/cascoded_level_shifter.hpp:65
        I(cpphdl_n199, Vss) <+ 1e-14 * ddt(V(cpphdl_n199, Vss)); // Bench initial voltage = 0.0 V.
        // device 231, IC IC27, analog/basic/cascoded_level_shifter.hpp:66
        I(cpphdl_n195, Vss) <+ 1e-14 * ddt(V(cpphdl_n195, Vss)); // Bench initial voltage = 0.0 V.
        // device 232, IC IC27, analog/basic/cascoded_level_shifter.hpp:67
        I(cpphdl_n187, Vss) <+ 1e-14 * ddt(V(cpphdl_n187, Vss)); // Bench initial voltage = 0.0 V.
        // device 233, IC IC27, analog/basic/cascoded_level_shifter.hpp:68
        I(cpphdl_n188, Vss) <+ 1e-14 * ddt(V(cpphdl_n188, Vss)); // Bench initial voltage = 0.0 V.
        // device 234, IC IC27, analog/basic/cascoded_level_shifter.hpp:72
        I(cpphdl_n304, cpphdl_n187) <+ 5.9999999999999997e-14 * ddt(V(cpphdl_n304, cpphdl_n187)); // Bench initial voltage = 0.0 V.
        // device 235, IC IC27, analog/basic/cascoded_level_shifter.hpp:73
        I(cpphdl_n304, cpphdl_n188) <+ 5.9999999999999997e-14 * ddt(V(cpphdl_n304, cpphdl_n188)); // Bench initial voltage = 0.0 V.
        // device 236, IC IC27, analog/basic/cascoded_level_shifter.hpp:74
        I(cpphdl_n304, cpphdl_n199) <+ 3.5999999999999998e-14 * ddt(V(cpphdl_n304, cpphdl_n199)); // Bench initial voltage = 0.0 V.
        // device 237, IC IC27, analog/basic/cascoded_level_shifter.hpp:75
        I(cpphdl_n304, cpphdl_n195) <+ 3.5999999999999998e-14 * ddt(V(cpphdl_n304, cpphdl_n195)); // Bench initial voltage = 0.0 V.
        // device 238, IC IC27, analog/basic/cascoded_level_shifter.hpp:76
        I(TRIAL6, Vss) <+ 4e-14 * ddt(V(TRIAL6, Vss)); // Bench initial voltage = 0.0 V.
        // device 239, IC IC27, analog/basic/cascoded_level_shifter.hpp:77
        I(cpphdl_n192, Vss) <+ 4e-14 * ddt(V(cpphdl_n192, Vss)); // Bench initial voltage = 0.0 V.
        // device 240, IC IC27, analog/basic/cascoded_level_shifter.hpp:78
        I(cpphdl_n199, Vdd) <+ 4e-14 * ddt(V(cpphdl_n199, Vdd)); // Bench initial voltage = 0.0 V.
        // device 241, IC IC27, analog/basic/cascoded_level_shifter.hpp:79
        I(cpphdl_n195, Vdd) <+ 4e-14 * ddt(V(cpphdl_n195, Vdd)); // Bench initial voltage = 0.0 V.
        // device 242, IC IC27, analog/basic/cascoded_level_shifter.hpp:80
        I(cpphdl_n199, cpphdl_n195) <+ 1.4e-14 * ddt(V(cpphdl_n199, cpphdl_n195)); // Bench initial voltage = 0.0 V.
        // device 243, IC IC27, analog/basic/cascoded_level_shifter.hpp:81
        I(cpphdl_n199, Vss) <+ 7.0000000000000005e-14 * ddt(V(cpphdl_n199, Vss)); // Bench initial voltage = 0.0 V.
        // device 244, IC IC27, analog/basic/cascoded_level_shifter.hpp:82
        I(cpphdl_n195, Vss) <+ 7.0000000000000005e-14 * ddt(V(cpphdl_n195, Vss)); // Bench initial voltage = 0.0 V.
        // device 245, IC IC27, analog/basic/cascoded_level_shifter.hpp:83
        I(cpphdl_n199, cpphdl_n262) <+ 2.3e-14 * ddt(V(cpphdl_n199, cpphdl_n262)); // Bench initial voltage = 0.0 V.
        // device 246, IC IC27, analog/basic/cascoded_level_shifter.hpp:84
        I(cpphdl_n195, cpphdl_n196) <+ 2.3e-14 * ddt(V(cpphdl_n195, cpphdl_n196)); // Bench initial voltage = 0.0 V.
        // device 247, IC IC29, analog/basic/inverter.hpp:11
        I(cpphdl_n196, Vdd) <+ cpphdl_channel(V(cpphdl_n195, Vdd), V(cpphdl_n196, Vdd), 0.0060000000000000001, 0.69999999999999996, -1.0);
        // device 248, IC IC29, analog/basic/inverter.hpp:12
        I(cpphdl_n196, Vss) <+ cpphdl_channel(V(cpphdl_n195, Vss), V(cpphdl_n196, Vss), 0.0060000000000000001, 0.69999999999999996, 1.0);
        // device 249, IC IC30, analog/basic/inverter.hpp:11
        I(cpphdl_n262, Vdd) <+ cpphdl_channel(V(cpphdl_n199, Vdd), V(cpphdl_n262, Vdd), 0.0060000000000000001, 0.69999999999999996, -1.0);
        // device 250, IC IC30, analog/basic/inverter.hpp:12
        I(cpphdl_n262, Vss) <+ cpphdl_channel(V(cpphdl_n199, Vss), V(cpphdl_n262, Vss), 0.0060000000000000001, 0.69999999999999996, 1.0);
        // device 251, IC IC27, analog/basic/cascoded_level_shifter.hpp:95
        I(cpphdl_n196, Vss) <+ 5.0000000000000002e-14 * ddt(V(cpphdl_n196, Vss)); // Bench initial voltage = 0.0 V.
        // device 252, IC IC27, analog/basic/cascoded_level_shifter.hpp:96
        I(cpphdl_n262, Vss) <+ 5.0000000000000002e-14 * ddt(V(cpphdl_n262, Vss)); // Bench initial voltage = 0.0 V.
        // device 253, IC IC27, analog/basic/cascoded_level_shifter.hpp:97
        I(TRIAL6, cpphdl_n188) <+ 1.6000000000000001e-14 * ddt(V(TRIAL6, cpphdl_n188)); // Bench initial voltage = 0.0 V.
        // device 254, IC IC27, analog/basic/cascoded_level_shifter.hpp:98
        I(cpphdl_n192, cpphdl_n187) <+ 1.6000000000000001e-14 * ddt(V(cpphdl_n192, cpphdl_n187)); // Bench initial voltage = 0.0 V.
        // device 255, IC IC27, analog/1G/clock_level_shifter.hpp:14
        I(cpphdl_n196, Vss) <+ 2.0000000000000001e-13 * ddt(V(cpphdl_n196, Vss)); // Bench initial voltage = 0.0 V.
        // device 256, IC IC27, analog/1G/clock_level_shifter.hpp:15
        I(cpphdl_n262, Vss) <+ 2.0000000000000001e-13 * ddt(V(cpphdl_n262, Vss)); // Bench initial voltage = 0.0 V.
        // device 257, IC IC32, analog/basic/inverter.hpp:11
        I(cpphdl_n216, Vlogic) <+ cpphdl_channel(V(TRIAL7, Vlogic), V(cpphdl_n216, Vlogic), 0.02, 0.5, -1.0);
        // device 258, IC IC32, analog/basic/inverter.hpp:12
        I(cpphdl_n216, Vss) <+ cpphdl_channel(V(TRIAL7, Vss), V(cpphdl_n216, Vss), 0.02, 0.5, 1.0);
        // device 259, IC IC31, analog/basic/cascoded_level_shifter.hpp:58
        I(cpphdl_n216, Vss) <+ 1e-14 * ddt(V(cpphdl_n216, Vss)); // Bench initial voltage = 0.0 V.
        // device 260, IC IC31, analog/basic/cascoded_level_shifter.hpp:59
        I(cpphdl_n223, Vdd) <+ cpphdl_channel(V(cpphdl_n219, Vdd), V(cpphdl_n223, Vdd), 0.0028, 0.69999999999999996, -1.0);
        // device 261, IC IC31, analog/basic/cascoded_level_shifter.hpp:60
        I(cpphdl_n219, Vdd) <+ cpphdl_channel(V(cpphdl_n223, Vdd), V(cpphdl_n219, Vdd), 0.0028, 0.69999999999999996, -1.0);
        // device 262, IC IC31, analog/basic/cascoded_level_shifter.hpp:61
        I(cpphdl_n223, cpphdl_n211) <+ cpphdl_channel(V(cpphdl_n304, cpphdl_n211), V(cpphdl_n223, cpphdl_n211), 0.014999999999999999, 0.69999999999999996, 1.0);
        // device 263, IC IC31, analog/basic/cascoded_level_shifter.hpp:62
        I(cpphdl_n219, cpphdl_n212) <+ cpphdl_channel(V(cpphdl_n304, cpphdl_n212), V(cpphdl_n219, cpphdl_n212), 0.014999999999999999, 0.69999999999999996, 1.0);
        // device 264, IC IC31, analog/basic/cascoded_level_shifter.hpp:63
        I(cpphdl_n211, Vss) <+ cpphdl_channel(V(cpphdl_n216, Vss), V(cpphdl_n211, Vss), 0.059999999999999998, 0.5, 1.0);
        // device 265, IC IC31, analog/basic/cascoded_level_shifter.hpp:64
        I(cpphdl_n212, Vss) <+ cpphdl_channel(V(TRIAL7, Vss), V(cpphdl_n212, Vss), 0.059999999999999998, 0.5, 1.0);
        // device 266, IC IC31, analog/basic/cascoded_level_shifter.hpp:65
        I(cpphdl_n223, Vss) <+ 1e-14 * ddt(V(cpphdl_n223, Vss)); // Bench initial voltage = 0.0 V.
        // device 267, IC IC31, analog/basic/cascoded_level_shifter.hpp:66
        I(cpphdl_n219, Vss) <+ 1e-14 * ddt(V(cpphdl_n219, Vss)); // Bench initial voltage = 0.0 V.
        // device 268, IC IC31, analog/basic/cascoded_level_shifter.hpp:67
        I(cpphdl_n211, Vss) <+ 1e-14 * ddt(V(cpphdl_n211, Vss)); // Bench initial voltage = 0.0 V.
        // device 269, IC IC31, analog/basic/cascoded_level_shifter.hpp:68
        I(cpphdl_n212, Vss) <+ 1e-14 * ddt(V(cpphdl_n212, Vss)); // Bench initial voltage = 0.0 V.
        // device 270, IC IC31, analog/basic/cascoded_level_shifter.hpp:72
        I(cpphdl_n304, cpphdl_n211) <+ 5.9999999999999997e-14 * ddt(V(cpphdl_n304, cpphdl_n211)); // Bench initial voltage = 0.0 V.
        // device 271, IC IC31, analog/basic/cascoded_level_shifter.hpp:73
        I(cpphdl_n304, cpphdl_n212) <+ 5.9999999999999997e-14 * ddt(V(cpphdl_n304, cpphdl_n212)); // Bench initial voltage = 0.0 V.
        // device 272, IC IC31, analog/basic/cascoded_level_shifter.hpp:74
        I(cpphdl_n304, cpphdl_n223) <+ 3.5999999999999998e-14 * ddt(V(cpphdl_n304, cpphdl_n223)); // Bench initial voltage = 0.0 V.
        // device 273, IC IC31, analog/basic/cascoded_level_shifter.hpp:75
        I(cpphdl_n304, cpphdl_n219) <+ 3.5999999999999998e-14 * ddt(V(cpphdl_n304, cpphdl_n219)); // Bench initial voltage = 0.0 V.
        // device 274, IC IC31, analog/basic/cascoded_level_shifter.hpp:76
        I(TRIAL7, Vss) <+ 4e-14 * ddt(V(TRIAL7, Vss)); // Bench initial voltage = 0.0 V.
        // device 275, IC IC31, analog/basic/cascoded_level_shifter.hpp:77
        I(cpphdl_n216, Vss) <+ 4e-14 * ddt(V(cpphdl_n216, Vss)); // Bench initial voltage = 0.0 V.
        // device 276, IC IC31, analog/basic/cascoded_level_shifter.hpp:78
        I(cpphdl_n223, Vdd) <+ 4e-14 * ddt(V(cpphdl_n223, Vdd)); // Bench initial voltage = 0.0 V.
        // device 277, IC IC31, analog/basic/cascoded_level_shifter.hpp:79
        I(cpphdl_n219, Vdd) <+ 4e-14 * ddt(V(cpphdl_n219, Vdd)); // Bench initial voltage = 0.0 V.
        // device 278, IC IC31, analog/basic/cascoded_level_shifter.hpp:80
        I(cpphdl_n223, cpphdl_n219) <+ 1.4e-14 * ddt(V(cpphdl_n223, cpphdl_n219)); // Bench initial voltage = 0.0 V.
        // device 279, IC IC31, analog/basic/cascoded_level_shifter.hpp:81
        I(cpphdl_n223, Vss) <+ 7.0000000000000005e-14 * ddt(V(cpphdl_n223, Vss)); // Bench initial voltage = 0.0 V.
        // device 280, IC IC31, analog/basic/cascoded_level_shifter.hpp:82
        I(cpphdl_n219, Vss) <+ 7.0000000000000005e-14 * ddt(V(cpphdl_n219, Vss)); // Bench initial voltage = 0.0 V.
        // device 281, IC IC31, analog/basic/cascoded_level_shifter.hpp:83
        I(cpphdl_n223, cpphdl_n266) <+ 2.3e-14 * ddt(V(cpphdl_n223, cpphdl_n266)); // Bench initial voltage = 0.0 V.
        // device 282, IC IC31, analog/basic/cascoded_level_shifter.hpp:84
        I(cpphdl_n219, cpphdl_n220) <+ 2.3e-14 * ddt(V(cpphdl_n219, cpphdl_n220)); // Bench initial voltage = 0.0 V.
        // device 283, IC IC33, analog/basic/inverter.hpp:11
        I(cpphdl_n220, Vdd) <+ cpphdl_channel(V(cpphdl_n219, Vdd), V(cpphdl_n220, Vdd), 0.0060000000000000001, 0.69999999999999996, -1.0);
        // device 284, IC IC33, analog/basic/inverter.hpp:12
        I(cpphdl_n220, Vss) <+ cpphdl_channel(V(cpphdl_n219, Vss), V(cpphdl_n220, Vss), 0.0060000000000000001, 0.69999999999999996, 1.0);
        // device 285, IC IC34, analog/basic/inverter.hpp:11
        I(cpphdl_n266, Vdd) <+ cpphdl_channel(V(cpphdl_n223, Vdd), V(cpphdl_n266, Vdd), 0.0060000000000000001, 0.69999999999999996, -1.0);
        // device 286, IC IC34, analog/basic/inverter.hpp:12
        I(cpphdl_n266, Vss) <+ cpphdl_channel(V(cpphdl_n223, Vss), V(cpphdl_n266, Vss), 0.0060000000000000001, 0.69999999999999996, 1.0);
        // device 287, IC IC31, analog/basic/cascoded_level_shifter.hpp:95
        I(cpphdl_n220, Vss) <+ 5.0000000000000002e-14 * ddt(V(cpphdl_n220, Vss)); // Bench initial voltage = 0.0 V.
        // device 288, IC IC31, analog/basic/cascoded_level_shifter.hpp:96
        I(cpphdl_n266, Vss) <+ 5.0000000000000002e-14 * ddt(V(cpphdl_n266, Vss)); // Bench initial voltage = 0.0 V.
        // device 289, IC IC31, analog/basic/cascoded_level_shifter.hpp:97
        I(TRIAL7, cpphdl_n212) <+ 1.6000000000000001e-14 * ddt(V(TRIAL7, cpphdl_n212)); // Bench initial voltage = 0.0 V.
        // device 290, IC IC31, analog/basic/cascoded_level_shifter.hpp:98
        I(cpphdl_n216, cpphdl_n211) <+ 1.6000000000000001e-14 * ddt(V(cpphdl_n216, cpphdl_n211)); // Bench initial voltage = 0.0 V.
        // device 291, IC IC31, analog/1G/clock_level_shifter.hpp:14
        I(cpphdl_n220, Vss) <+ 2.0000000000000001e-13 * ddt(V(cpphdl_n220, Vss)); // Bench initial voltage = 0.0 V.
        // device 292, IC IC31, analog/1G/clock_level_shifter.hpp:15
        I(cpphdl_n266, Vss) <+ 2.0000000000000001e-13 * ddt(V(cpphdl_n266, Vss)); // Bench initial voltage = 0.0 V.
        // device 293, IC IC36, analog/basic/inverter.hpp:11
        I(cpphdl_n239, Vdd) <+ cpphdl_channel(V(cpphdl_n238, Vdd), V(cpphdl_n239, Vdd), 0.040000000000000001, 0.69999999999999996, -1.0);
        // device 294, IC IC36, analog/basic/inverter.hpp:12
        I(cpphdl_n239, Vss) <+ cpphdl_channel(V(cpphdl_n238, Vss), V(cpphdl_n239, Vss), 0.040000000000000001, 0.69999999999999996, 1.0);
        // device 295, IC IC35, analog/basic/mos_r2r_dac.hpp:27
        I(cpphdl_n239, Vss) <+ 2.9999999999999998e-15 * ddt(V(cpphdl_n239, Vss)); // Bench initial voltage = 0.0 V.
        // device 296, IC IC35, analog/basic/mos_r2r_dac.hpp:28
        I(cpphdl_n239, cpphdl_n268) <+ V(cpphdl_n239, cpphdl_n268) / 1500.0;
        // device 297, IC IC35, analog/basic/mos_r2r_dac.hpp:29
        I(cpphdl_n268, Vss) <+ 2.9999999999999998e-15 * ddt(V(cpphdl_n268, Vss)); // Bench initial voltage = 0.0 V.
        // device 298, IC IC37, analog/basic/inverter.hpp:11
        I(cpphdl_n243, Vdd) <+ cpphdl_channel(V(cpphdl_n242, Vdd), V(cpphdl_n243, Vdd), 0.040000000000000001, 0.69999999999999996, -1.0);
        // device 299, IC IC37, analog/basic/inverter.hpp:12
        I(cpphdl_n243, Vss) <+ cpphdl_channel(V(cpphdl_n242, Vss), V(cpphdl_n243, Vss), 0.040000000000000001, 0.69999999999999996, 1.0);
        // device 300, IC IC35, analog/basic/mos_r2r_dac.hpp:27
        I(cpphdl_n243, Vss) <+ 2.9999999999999998e-15 * ddt(V(cpphdl_n243, Vss)); // Bench initial voltage = 0.0 V.
        // device 301, IC IC35, analog/basic/mos_r2r_dac.hpp:28
        I(cpphdl_n243, cpphdl_n269) <+ V(cpphdl_n243, cpphdl_n269) / 1500.0;
        // device 302, IC IC35, analog/basic/mos_r2r_dac.hpp:29
        I(cpphdl_n269, Vss) <+ 2.9999999999999998e-15 * ddt(V(cpphdl_n269, Vss)); // Bench initial voltage = 0.0 V.
        // device 303, IC IC35, analog/basic/mos_r2r_dac.hpp:31
        I(cpphdl_n268, cpphdl_n269) <+ V(cpphdl_n268, cpphdl_n269) / 750.0;
        // device 304, IC IC38, analog/basic/inverter.hpp:11
        I(cpphdl_n247, Vdd) <+ cpphdl_channel(V(cpphdl_n246, Vdd), V(cpphdl_n247, Vdd), 0.040000000000000001, 0.69999999999999996, -1.0);
        // device 305, IC IC38, analog/basic/inverter.hpp:12
        I(cpphdl_n247, Vss) <+ cpphdl_channel(V(cpphdl_n246, Vss), V(cpphdl_n247, Vss), 0.040000000000000001, 0.69999999999999996, 1.0);
        // device 306, IC IC35, analog/basic/mos_r2r_dac.hpp:27
        I(cpphdl_n247, Vss) <+ 2.9999999999999998e-15 * ddt(V(cpphdl_n247, Vss)); // Bench initial voltage = 0.0 V.
        // device 307, IC IC35, analog/basic/mos_r2r_dac.hpp:28
        I(cpphdl_n247, cpphdl_n270) <+ V(cpphdl_n247, cpphdl_n270) / 1500.0;
        // device 308, IC IC35, analog/basic/mos_r2r_dac.hpp:29
        I(cpphdl_n270, Vss) <+ 2.9999999999999998e-15 * ddt(V(cpphdl_n270, Vss)); // Bench initial voltage = 0.0 V.
        // device 309, IC IC35, analog/basic/mos_r2r_dac.hpp:31
        I(cpphdl_n269, cpphdl_n270) <+ V(cpphdl_n269, cpphdl_n270) / 750.0;
        // device 310, IC IC39, analog/basic/inverter.hpp:11
        I(cpphdl_n251, Vdd) <+ cpphdl_channel(V(cpphdl_n250, Vdd), V(cpphdl_n251, Vdd), 0.040000000000000001, 0.69999999999999996, -1.0);
        // device 311, IC IC39, analog/basic/inverter.hpp:12
        I(cpphdl_n251, Vss) <+ cpphdl_channel(V(cpphdl_n250, Vss), V(cpphdl_n251, Vss), 0.040000000000000001, 0.69999999999999996, 1.0);
        // device 312, IC IC35, analog/basic/mos_r2r_dac.hpp:27
        I(cpphdl_n251, Vss) <+ 2.9999999999999998e-15 * ddt(V(cpphdl_n251, Vss)); // Bench initial voltage = 0.0 V.
        // device 313, IC IC35, analog/basic/mos_r2r_dac.hpp:28
        I(cpphdl_n251, cpphdl_n271) <+ V(cpphdl_n251, cpphdl_n271) / 1500.0;
        // device 314, IC IC35, analog/basic/mos_r2r_dac.hpp:29
        I(cpphdl_n271, Vss) <+ 2.9999999999999998e-15 * ddt(V(cpphdl_n271, Vss)); // Bench initial voltage = 0.0 V.
        // device 315, IC IC35, analog/basic/mos_r2r_dac.hpp:31
        I(cpphdl_n270, cpphdl_n271) <+ V(cpphdl_n270, cpphdl_n271) / 750.0;
        // device 316, IC IC40, analog/basic/inverter.hpp:11
        I(cpphdl_n255, Vdd) <+ cpphdl_channel(V(cpphdl_n254, Vdd), V(cpphdl_n255, Vdd), 0.040000000000000001, 0.69999999999999996, -1.0);
        // device 317, IC IC40, analog/basic/inverter.hpp:12
        I(cpphdl_n255, Vss) <+ cpphdl_channel(V(cpphdl_n254, Vss), V(cpphdl_n255, Vss), 0.040000000000000001, 0.69999999999999996, 1.0);
        // device 318, IC IC35, analog/basic/mos_r2r_dac.hpp:27
        I(cpphdl_n255, Vss) <+ 2.9999999999999998e-15 * ddt(V(cpphdl_n255, Vss)); // Bench initial voltage = 0.0 V.
        // device 319, IC IC35, analog/basic/mos_r2r_dac.hpp:28
        I(cpphdl_n255, cpphdl_n272) <+ V(cpphdl_n255, cpphdl_n272) / 1500.0;
        // device 320, IC IC35, analog/basic/mos_r2r_dac.hpp:29
        I(cpphdl_n272, Vss) <+ 2.9999999999999998e-15 * ddt(V(cpphdl_n272, Vss)); // Bench initial voltage = 0.0 V.
        // device 321, IC IC35, analog/basic/mos_r2r_dac.hpp:31
        I(cpphdl_n271, cpphdl_n272) <+ V(cpphdl_n271, cpphdl_n272) / 750.0;
        // device 322, IC IC41, analog/basic/inverter.hpp:11
        I(cpphdl_n259, Vdd) <+ cpphdl_channel(V(cpphdl_n258, Vdd), V(cpphdl_n259, Vdd), 0.040000000000000001, 0.69999999999999996, -1.0);
        // device 323, IC IC41, analog/basic/inverter.hpp:12
        I(cpphdl_n259, Vss) <+ cpphdl_channel(V(cpphdl_n258, Vss), V(cpphdl_n259, Vss), 0.040000000000000001, 0.69999999999999996, 1.0);
        // device 324, IC IC35, analog/basic/mos_r2r_dac.hpp:27
        I(cpphdl_n259, Vss) <+ 2.9999999999999998e-15 * ddt(V(cpphdl_n259, Vss)); // Bench initial voltage = 0.0 V.
        // device 325, IC IC35, analog/basic/mos_r2r_dac.hpp:28
        I(cpphdl_n259, cpphdl_n273) <+ V(cpphdl_n259, cpphdl_n273) / 1500.0;
        // device 326, IC IC35, analog/basic/mos_r2r_dac.hpp:29
        I(cpphdl_n273, Vss) <+ 2.9999999999999998e-15 * ddt(V(cpphdl_n273, Vss)); // Bench initial voltage = 0.0 V.
        // device 327, IC IC35, analog/basic/mos_r2r_dac.hpp:31
        I(cpphdl_n272, cpphdl_n273) <+ V(cpphdl_n272, cpphdl_n273) / 750.0;
        // device 328, IC IC42, analog/basic/inverter.hpp:11
        I(cpphdl_n263, Vdd) <+ cpphdl_channel(V(cpphdl_n262, Vdd), V(cpphdl_n263, Vdd), 0.040000000000000001, 0.69999999999999996, -1.0);
        // device 329, IC IC42, analog/basic/inverter.hpp:12
        I(cpphdl_n263, Vss) <+ cpphdl_channel(V(cpphdl_n262, Vss), V(cpphdl_n263, Vss), 0.040000000000000001, 0.69999999999999996, 1.0);
        // device 330, IC IC35, analog/basic/mos_r2r_dac.hpp:27
        I(cpphdl_n263, Vss) <+ 2.9999999999999998e-15 * ddt(V(cpphdl_n263, Vss)); // Bench initial voltage = 0.0 V.
        // device 331, IC IC35, analog/basic/mos_r2r_dac.hpp:28
        I(cpphdl_n263, cpphdl_n274) <+ V(cpphdl_n263, cpphdl_n274) / 1500.0;
        // device 332, IC IC35, analog/basic/mos_r2r_dac.hpp:29
        I(cpphdl_n274, Vss) <+ 2.9999999999999998e-15 * ddt(V(cpphdl_n274, Vss)); // Bench initial voltage = 0.0 V.
        // device 333, IC IC35, analog/basic/mos_r2r_dac.hpp:31
        I(cpphdl_n273, cpphdl_n274) <+ V(cpphdl_n273, cpphdl_n274) / 750.0;
        // device 334, IC IC43, analog/basic/inverter.hpp:11
        I(cpphdl_n267, Vdd) <+ cpphdl_channel(V(cpphdl_n266, Vdd), V(cpphdl_n267, Vdd), 0.040000000000000001, 0.69999999999999996, -1.0);
        // device 335, IC IC43, analog/basic/inverter.hpp:12
        I(cpphdl_n267, Vss) <+ cpphdl_channel(V(cpphdl_n266, Vss), V(cpphdl_n267, Vss), 0.040000000000000001, 0.69999999999999996, 1.0);
        // device 336, IC IC35, analog/basic/mos_r2r_dac.hpp:27
        I(cpphdl_n267, Vss) <+ 2.9999999999999998e-15 * ddt(V(cpphdl_n267, Vss)); // Bench initial voltage = 0.0 V.
        // device 337, IC IC35, analog/basic/mos_r2r_dac.hpp:28
        I(cpphdl_n267, cpphdl_n328) <+ V(cpphdl_n267, cpphdl_n328) / 1500.0;
        // device 338, IC IC35, analog/basic/mos_r2r_dac.hpp:29
        I(cpphdl_n328, Vss) <+ 2.9999999999999998e-15 * ddt(V(cpphdl_n328, Vss)); // Bench initial voltage = 0.0 V.
        // device 339, IC IC35, analog/basic/mos_r2r_dac.hpp:31
        I(cpphdl_n274, cpphdl_n328) <+ V(cpphdl_n274, cpphdl_n328) / 750.0;
        // device 340, IC IC35, analog/basic/mos_r2r_dac.hpp:33
        I(Vss, cpphdl_n268) <+ V(Vss, cpphdl_n268) / 1500.0;
        // device 341, IC IC45, analog/basic/inverter.hpp:11
        I(cpphdl_n292, Vlogic) <+ cpphdl_channel(V(EVALUATE, Vlogic), V(cpphdl_n292, Vlogic), 0.02, 0.5, -1.0);
        // device 342, IC IC45, analog/basic/inverter.hpp:12
        I(cpphdl_n292, Vss) <+ cpphdl_channel(V(EVALUATE, Vss), V(cpphdl_n292, Vss), 0.02, 0.5, 1.0);
        // device 343, IC IC44, analog/basic/cascoded_level_shifter.hpp:58
        I(cpphdl_n292, Vss) <+ 1e-14 * ddt(V(cpphdl_n292, Vss)); // Bench initial voltage = 0.0 V.
        // device 344, IC IC44, analog/basic/cascoded_level_shifter.hpp:59
        I(cpphdl_n299, Vdd) <+ cpphdl_channel(V(cpphdl_n295, Vdd), V(cpphdl_n299, Vdd), 0.0028, 0.69999999999999996, -1.0);
        // device 345, IC IC44, analog/basic/cascoded_level_shifter.hpp:60
        I(cpphdl_n295, Vdd) <+ cpphdl_channel(V(cpphdl_n299, Vdd), V(cpphdl_n295, Vdd), 0.0028, 0.69999999999999996, -1.0);
        // device 346, IC IC44, analog/basic/cascoded_level_shifter.hpp:61
        I(cpphdl_n299, cpphdl_n287) <+ cpphdl_channel(V(cpphdl_n304, cpphdl_n287), V(cpphdl_n299, cpphdl_n287), 0.014999999999999999, 0.69999999999999996, 1.0);
        // device 347, IC IC44, analog/basic/cascoded_level_shifter.hpp:62
        I(cpphdl_n295, cpphdl_n288) <+ cpphdl_channel(V(cpphdl_n304, cpphdl_n288), V(cpphdl_n295, cpphdl_n288), 0.014999999999999999, 0.69999999999999996, 1.0);
        // device 348, IC IC44, analog/basic/cascoded_level_shifter.hpp:63
        I(cpphdl_n287, Vss) <+ cpphdl_channel(V(cpphdl_n292, Vss), V(cpphdl_n287, Vss), 0.059999999999999998, 0.5, 1.0);
        // device 349, IC IC44, analog/basic/cascoded_level_shifter.hpp:64
        I(cpphdl_n288, Vss) <+ cpphdl_channel(V(EVALUATE, Vss), V(cpphdl_n288, Vss), 0.059999999999999998, 0.5, 1.0);
        // device 350, IC IC44, analog/basic/cascoded_level_shifter.hpp:65
        I(cpphdl_n299, Vss) <+ 1e-14 * ddt(V(cpphdl_n299, Vss)); // Bench initial voltage = 0.0 V.
        // device 351, IC IC44, analog/basic/cascoded_level_shifter.hpp:66
        I(cpphdl_n295, Vss) <+ 1e-14 * ddt(V(cpphdl_n295, Vss)); // Bench initial voltage = 0.0 V.
        // device 352, IC IC44, analog/basic/cascoded_level_shifter.hpp:67
        I(cpphdl_n287, Vss) <+ 1e-14 * ddt(V(cpphdl_n287, Vss)); // Bench initial voltage = 0.0 V.
        // device 353, IC IC44, analog/basic/cascoded_level_shifter.hpp:68
        I(cpphdl_n288, Vss) <+ 1e-14 * ddt(V(cpphdl_n288, Vss)); // Bench initial voltage = 0.0 V.
        // device 354, IC IC44, analog/basic/cascoded_level_shifter.hpp:72
        I(cpphdl_n304, cpphdl_n287) <+ 5.9999999999999997e-14 * ddt(V(cpphdl_n304, cpphdl_n287)); // Bench initial voltage = 0.0 V.
        // device 355, IC IC44, analog/basic/cascoded_level_shifter.hpp:73
        I(cpphdl_n304, cpphdl_n288) <+ 5.9999999999999997e-14 * ddt(V(cpphdl_n304, cpphdl_n288)); // Bench initial voltage = 0.0 V.
        // device 356, IC IC44, analog/basic/cascoded_level_shifter.hpp:74
        I(cpphdl_n304, cpphdl_n299) <+ 3.5999999999999998e-14 * ddt(V(cpphdl_n304, cpphdl_n299)); // Bench initial voltage = 0.0 V.
        // device 357, IC IC44, analog/basic/cascoded_level_shifter.hpp:75
        I(cpphdl_n304, cpphdl_n295) <+ 3.5999999999999998e-14 * ddt(V(cpphdl_n304, cpphdl_n295)); // Bench initial voltage = 0.0 V.
        // device 358, IC IC44, analog/basic/cascoded_level_shifter.hpp:76
        I(EVALUATE, Vss) <+ 4e-14 * ddt(V(EVALUATE, Vss)); // Bench initial voltage = 0.0 V.
        // device 359, IC IC44, analog/basic/cascoded_level_shifter.hpp:77
        I(cpphdl_n292, Vss) <+ 4e-14 * ddt(V(cpphdl_n292, Vss)); // Bench initial voltage = 0.0 V.
        // device 360, IC IC44, analog/basic/cascoded_level_shifter.hpp:78
        I(cpphdl_n299, Vdd) <+ 4e-14 * ddt(V(cpphdl_n299, Vdd)); // Bench initial voltage = 0.0 V.
        // device 361, IC IC44, analog/basic/cascoded_level_shifter.hpp:79
        I(cpphdl_n295, Vdd) <+ 4e-14 * ddt(V(cpphdl_n295, Vdd)); // Bench initial voltage = 0.0 V.
        // device 362, IC IC44, analog/basic/cascoded_level_shifter.hpp:80
        I(cpphdl_n299, cpphdl_n295) <+ 1.4e-14 * ddt(V(cpphdl_n299, cpphdl_n295)); // Bench initial voltage = 0.0 V.
        // device 363, IC IC44, analog/basic/cascoded_level_shifter.hpp:81
        I(cpphdl_n299, Vss) <+ 7.0000000000000005e-14 * ddt(V(cpphdl_n299, Vss)); // Bench initial voltage = 0.0 V.
        // device 364, IC IC44, analog/basic/cascoded_level_shifter.hpp:82
        I(cpphdl_n295, Vss) <+ 7.0000000000000005e-14 * ddt(V(cpphdl_n295, Vss)); // Bench initial voltage = 0.0 V.
        // device 365, IC IC44, analog/basic/cascoded_level_shifter.hpp:83
        I(cpphdl_n299, cpphdl_n300) <+ 2.3e-14 * ddt(V(cpphdl_n299, cpphdl_n300)); // Bench initial voltage = 0.0 V.
        // device 366, IC IC44, analog/basic/cascoded_level_shifter.hpp:84
        I(cpphdl_n295, cpphdl_n338) <+ 2.3e-14 * ddt(V(cpphdl_n295, cpphdl_n338)); // Bench initial voltage = 0.0 V.
        // device 367, IC IC46, analog/basic/inverter.hpp:11
        I(cpphdl_n338, Vdd) <+ cpphdl_channel(V(cpphdl_n295, Vdd), V(cpphdl_n338, Vdd), 0.0060000000000000001, 0.69999999999999996, -1.0);
        // device 368, IC IC46, analog/basic/inverter.hpp:12
        I(cpphdl_n338, Vss) <+ cpphdl_channel(V(cpphdl_n295, Vss), V(cpphdl_n338, Vss), 0.0060000000000000001, 0.69999999999999996, 1.0);
        // device 369, IC IC47, analog/basic/inverter.hpp:11
        I(cpphdl_n300, Vdd) <+ cpphdl_channel(V(cpphdl_n299, Vdd), V(cpphdl_n300, Vdd), 0.0060000000000000001, 0.69999999999999996, -1.0);
        // device 370, IC IC47, analog/basic/inverter.hpp:12
        I(cpphdl_n300, Vss) <+ cpphdl_channel(V(cpphdl_n299, Vss), V(cpphdl_n300, Vss), 0.0060000000000000001, 0.69999999999999996, 1.0);
        // device 371, IC IC44, analog/basic/cascoded_level_shifter.hpp:95
        I(cpphdl_n338, Vss) <+ 5.0000000000000002e-14 * ddt(V(cpphdl_n338, Vss)); // Bench initial voltage = 0.0 V.
        // device 372, IC IC44, analog/basic/cascoded_level_shifter.hpp:96
        I(cpphdl_n300, Vss) <+ 5.0000000000000002e-14 * ddt(V(cpphdl_n300, Vss)); // Bench initial voltage = 0.0 V.
        // device 373, IC IC44, analog/basic/cascoded_level_shifter.hpp:97
        I(EVALUATE, cpphdl_n288) <+ 1.6000000000000001e-14 * ddt(V(EVALUATE, cpphdl_n288)); // Bench initial voltage = 0.0 V.
        // device 374, IC IC44, analog/basic/cascoded_level_shifter.hpp:98
        I(cpphdl_n292, cpphdl_n287) <+ 1.6000000000000001e-14 * ddt(V(cpphdl_n292, cpphdl_n287)); // Bench initial voltage = 0.0 V.
        // device 375, IC IC44, analog/1G/clock_level_shifter.hpp:14
        I(cpphdl_n338, Vss) <+ 2.0000000000000001e-13 * ddt(V(cpphdl_n338, Vss)); // Bench initial voltage = 0.0 V.
        // device 376, IC IC44, analog/1G/clock_level_shifter.hpp:15
        I(cpphdl_n300, Vss) <+ 2.0000000000000001e-13 * ddt(V(cpphdl_n300, Vss)); // Bench initial voltage = 0.0 V.
        // device 377, IC IC49, analog/basic/inverter.hpp:11
        I(cpphdl_n316, Vlogic) <+ cpphdl_channel(V(CLEAR, Vlogic), V(cpphdl_n316, Vlogic), 0.02, 0.5, -1.0);
        // device 378, IC IC49, analog/basic/inverter.hpp:12
        I(cpphdl_n316, Vss) <+ cpphdl_channel(V(CLEAR, Vss), V(cpphdl_n316, Vss), 0.02, 0.5, 1.0);
        // device 379, IC IC48, analog/basic/cascoded_level_shifter.hpp:58
        I(cpphdl_n316, Vss) <+ 1e-14 * ddt(V(cpphdl_n316, Vss)); // Bench initial voltage = 0.0 V.
        // device 380, IC IC48, analog/basic/cascoded_level_shifter.hpp:59
        I(cpphdl_n323, Vdd) <+ cpphdl_channel(V(cpphdl_n319, Vdd), V(cpphdl_n323, Vdd), 0.0028, 0.69999999999999996, -1.0);
        // device 381, IC IC48, analog/basic/cascoded_level_shifter.hpp:60
        I(cpphdl_n319, Vdd) <+ cpphdl_channel(V(cpphdl_n323, Vdd), V(cpphdl_n319, Vdd), 0.0028, 0.69999999999999996, -1.0);
        // device 382, IC IC48, analog/basic/cascoded_level_shifter.hpp:61
        I(cpphdl_n323, cpphdl_n311) <+ cpphdl_channel(V(cpphdl_n304, cpphdl_n311), V(cpphdl_n323, cpphdl_n311), 0.014999999999999999, 0.69999999999999996, 1.0);
        // device 383, IC IC48, analog/basic/cascoded_level_shifter.hpp:62
        I(cpphdl_n319, cpphdl_n312) <+ cpphdl_channel(V(cpphdl_n304, cpphdl_n312), V(cpphdl_n319, cpphdl_n312), 0.014999999999999999, 0.69999999999999996, 1.0);
        // device 384, IC IC48, analog/basic/cascoded_level_shifter.hpp:63
        I(cpphdl_n311, Vss) <+ cpphdl_channel(V(cpphdl_n316, Vss), V(cpphdl_n311, Vss), 0.059999999999999998, 0.5, 1.0);
        // device 385, IC IC48, analog/basic/cascoded_level_shifter.hpp:64
        I(cpphdl_n312, Vss) <+ cpphdl_channel(V(CLEAR, Vss), V(cpphdl_n312, Vss), 0.059999999999999998, 0.5, 1.0);
        // device 386, IC IC48, analog/basic/cascoded_level_shifter.hpp:65
        I(cpphdl_n323, Vss) <+ 1e-14 * ddt(V(cpphdl_n323, Vss)); // Bench initial voltage = 0.0 V.
        // device 387, IC IC48, analog/basic/cascoded_level_shifter.hpp:66
        I(cpphdl_n319, Vss) <+ 1e-14 * ddt(V(cpphdl_n319, Vss)); // Bench initial voltage = 0.0 V.
        // device 388, IC IC48, analog/basic/cascoded_level_shifter.hpp:67
        I(cpphdl_n311, Vss) <+ 1e-14 * ddt(V(cpphdl_n311, Vss)); // Bench initial voltage = 0.0 V.
        // device 389, IC IC48, analog/basic/cascoded_level_shifter.hpp:68
        I(cpphdl_n312, Vss) <+ 1e-14 * ddt(V(cpphdl_n312, Vss)); // Bench initial voltage = 0.0 V.
        // device 390, IC IC48, analog/basic/cascoded_level_shifter.hpp:72
        I(cpphdl_n304, cpphdl_n311) <+ 5.9999999999999997e-14 * ddt(V(cpphdl_n304, cpphdl_n311)); // Bench initial voltage = 0.0 V.
        // device 391, IC IC48, analog/basic/cascoded_level_shifter.hpp:73
        I(cpphdl_n304, cpphdl_n312) <+ 5.9999999999999997e-14 * ddt(V(cpphdl_n304, cpphdl_n312)); // Bench initial voltage = 0.0 V.
        // device 392, IC IC48, analog/basic/cascoded_level_shifter.hpp:74
        I(cpphdl_n304, cpphdl_n323) <+ 3.5999999999999998e-14 * ddt(V(cpphdl_n304, cpphdl_n323)); // Bench initial voltage = 0.0 V.
        // device 393, IC IC48, analog/basic/cascoded_level_shifter.hpp:75
        I(cpphdl_n304, cpphdl_n319) <+ 3.5999999999999998e-14 * ddt(V(cpphdl_n304, cpphdl_n319)); // Bench initial voltage = 0.0 V.
        // device 394, IC IC48, analog/basic/cascoded_level_shifter.hpp:76
        I(CLEAR, Vss) <+ 4e-14 * ddt(V(CLEAR, Vss)); // Bench initial voltage = 0.0 V.
        // device 395, IC IC48, analog/basic/cascoded_level_shifter.hpp:77
        I(cpphdl_n316, Vss) <+ 4e-14 * ddt(V(cpphdl_n316, Vss)); // Bench initial voltage = 0.0 V.
        // device 396, IC IC48, analog/basic/cascoded_level_shifter.hpp:78
        I(cpphdl_n323, Vdd) <+ 4e-14 * ddt(V(cpphdl_n323, Vdd)); // Bench initial voltage = 0.0 V.
        // device 397, IC IC48, analog/basic/cascoded_level_shifter.hpp:79
        I(cpphdl_n319, Vdd) <+ 4e-14 * ddt(V(cpphdl_n319, Vdd)); // Bench initial voltage = 0.0 V.
        // device 398, IC IC48, analog/basic/cascoded_level_shifter.hpp:80
        I(cpphdl_n323, cpphdl_n319) <+ 1.4e-14 * ddt(V(cpphdl_n323, cpphdl_n319)); // Bench initial voltage = 0.0 V.
        // device 399, IC IC48, analog/basic/cascoded_level_shifter.hpp:81
        I(cpphdl_n323, Vss) <+ 7.0000000000000005e-14 * ddt(V(cpphdl_n323, Vss)); // Bench initial voltage = 0.0 V.
        // device 400, IC IC48, analog/basic/cascoded_level_shifter.hpp:82
        I(cpphdl_n319, Vss) <+ 7.0000000000000005e-14 * ddt(V(cpphdl_n319, Vss)); // Bench initial voltage = 0.0 V.
        // device 401, IC IC48, analog/basic/cascoded_level_shifter.hpp:83
        I(cpphdl_n323, cpphdl_n324) <+ 2.3e-14 * ddt(V(cpphdl_n323, cpphdl_n324)); // Bench initial voltage = 0.0 V.
        // device 402, IC IC48, analog/basic/cascoded_level_shifter.hpp:84
        I(cpphdl_n319, cpphdl_n388) <+ 2.3e-14 * ddt(V(cpphdl_n319, cpphdl_n388)); // Bench initial voltage = 0.0 V.
        // device 403, IC IC50, analog/basic/inverter.hpp:11
        I(cpphdl_n388, Vdd) <+ cpphdl_channel(V(cpphdl_n319, Vdd), V(cpphdl_n388, Vdd), 0.0060000000000000001, 0.69999999999999996, -1.0);
        // device 404, IC IC50, analog/basic/inverter.hpp:12
        I(cpphdl_n388, Vss) <+ cpphdl_channel(V(cpphdl_n319, Vss), V(cpphdl_n388, Vss), 0.0060000000000000001, 0.69999999999999996, 1.0);
        // device 405, IC IC51, analog/basic/inverter.hpp:11
        I(cpphdl_n324, Vdd) <+ cpphdl_channel(V(cpphdl_n323, Vdd), V(cpphdl_n324, Vdd), 0.0060000000000000001, 0.69999999999999996, -1.0);
        // device 406, IC IC51, analog/basic/inverter.hpp:12
        I(cpphdl_n324, Vss) <+ cpphdl_channel(V(cpphdl_n323, Vss), V(cpphdl_n324, Vss), 0.0060000000000000001, 0.69999999999999996, 1.0);
        // device 407, IC IC48, analog/basic/cascoded_level_shifter.hpp:95
        I(cpphdl_n388, Vss) <+ 5.0000000000000002e-14 * ddt(V(cpphdl_n388, Vss)); // Bench initial voltage = 0.0 V.
        // device 408, IC IC48, analog/basic/cascoded_level_shifter.hpp:96
        I(cpphdl_n324, Vss) <+ 5.0000000000000002e-14 * ddt(V(cpphdl_n324, Vss)); // Bench initial voltage = 0.0 V.
        // device 409, IC IC48, analog/basic/cascoded_level_shifter.hpp:97
        I(CLEAR, cpphdl_n312) <+ 1.6000000000000001e-14 * ddt(V(CLEAR, cpphdl_n312)); // Bench initial voltage = 0.0 V.
        // device 410, IC IC48, analog/basic/cascoded_level_shifter.hpp:98
        I(cpphdl_n316, cpphdl_n311) <+ 1.6000000000000001e-14 * ddt(V(cpphdl_n316, cpphdl_n311)); // Bench initial voltage = 0.0 V.
        // device 411, IC IC48, analog/1G/clock_level_shifter.hpp:14
        I(cpphdl_n388, Vss) <+ 2.0000000000000001e-13 * ddt(V(cpphdl_n388, Vss)); // Bench initial voltage = 0.0 V.
        // device 412, IC IC48, analog/1G/clock_level_shifter.hpp:15
        I(cpphdl_n324, Vss) <+ 2.0000000000000001e-13 * ddt(V(cpphdl_n324, Vss)); // Bench initial voltage = 0.0 V.
        // device 413, IC OneGIHPCoreReceiveDecision, analog/1G/IHPSG13G2/core_receive_decision.hpp:57
        I(cpphdl_n338, Vss) <+ 1e-13 * ddt(V(cpphdl_n338, Vss)); // Bench initial voltage = 0.0 V.
        // device 414, IC OneGIHPCoreReceiveDecision, analog/1G/IHPSG13G2/core_receive_decision.hpp:58
        I(cpphdl_n388, Vss) <+ 2e-14 * ddt(V(cpphdl_n388, Vss)); // Bench initial voltage = 0.0 V.
        // device 415, IC IC52, analog/basic/nmos_resistor_amplifier.hpp:23
        I(Vdd, cpphdl_n337) <+ V(Vdd, cpphdl_n337) / 1000.0;
        // device 416, IC IC52, analog/basic/nmos_resistor_amplifier.hpp:24
        I(Vdd, cpphdl_n336) <+ V(Vdd, cpphdl_n336) / 1000.0;
        // device 417, IC IC52, analog/basic/nmos_resistor_amplifier.hpp:25
        I(cpphdl_n337, cpphdl_n331) <+ cpphdl_channel(V(IN, cpphdl_n331), V(cpphdl_n337, cpphdl_n331), 0.0074999999999999997, 0.69999999999999996, 1.0);
        // device 418, IC IC52, analog/basic/nmos_resistor_amplifier.hpp:26
        I(cpphdl_n336, cpphdl_n332) <+ cpphdl_channel(V(cpphdl_n328, cpphdl_n332), V(cpphdl_n336, cpphdl_n332), 0.0074999999999999997, 0.69999999999999996, 1.0);
        // device 419, IC IC52, analog/basic/nmos_resistor_amplifier.hpp:27
        I(cpphdl_n333, cpphdl_n331) <+ V(cpphdl_n333, cpphdl_n331) / 100.0;
        // device 420, IC IC52, analog/basic/nmos_resistor_amplifier.hpp:28
        I(cpphdl_n333, cpphdl_n332) <+ V(cpphdl_n333, cpphdl_n332) / 100.0;
        // device 421, IC IC52, analog/basic/nmos_resistor_amplifier.hpp:29
        I(Vss, cpphdl_n333) <+ V(Vss, cpphdl_n333) / 300.0;
        // device 422, IC IC52, analog/basic/nmos_resistor_amplifier.hpp:30
        I(cpphdl_n337, Vdd) <+ 2.9999999999999998e-13 * ddt(V(cpphdl_n337, Vdd)); // Bench initial voltage = 0.0 V.
        // device 423, IC IC52, analog/basic/nmos_resistor_amplifier.hpp:31
        I(cpphdl_n336, Vdd) <+ 2.9999999999999998e-13 * ddt(V(cpphdl_n336, Vdd)); // Bench initial voltage = 0.0 V.
        // device 424, IC IC52, analog/basic/nmos_resistor_amplifier.hpp:32
        I(cpphdl_n333, Vss) <+ 4e-14 * ddt(V(cpphdl_n333, Vss)); // Bench initial voltage = 0.0 V.
        // device 425, IC IC52, analog/basic/nmos_resistor_amplifier.hpp:34
        I(IN, cpphdl_n331) <+ 2e-14 * ddt(V(IN, cpphdl_n331)); // Bench initial voltage = 0.0 V.
        // device 426, IC IC52, analog/basic/nmos_resistor_amplifier.hpp:35
        I(cpphdl_n328, cpphdl_n332) <+ 2e-14 * ddt(V(cpphdl_n328, cpphdl_n332)); // Bench initial voltage = 0.0 V.
        // device 427, IC IC52, analog/basic/nmos_resistor_amplifier.hpp:36
        I(IN, cpphdl_n337) <+ 2.9999999999999998e-15 * ddt(V(IN, cpphdl_n337)); // Bench initial voltage = 0.0 V.
        // device 428, IC IC52, analog/basic/nmos_resistor_amplifier.hpp:37
        I(cpphdl_n328, cpphdl_n336) <+ 2.9999999999999998e-15 * ddt(V(cpphdl_n328, cpphdl_n336)); // Bench initial voltage = 0.0 V.
        // device 429, IC IC53, analog/basic/strongarm_comparator.hpp:28
        I(cpphdl_n341, cpphdl_n343) <+ cpphdl_channel(V(cpphdl_n336, cpphdl_n343), V(cpphdl_n341, cpphdl_n343), 0.0080000000000000002, 0.69999999999999996, 1.0);
        // device 430, IC IC53, analog/basic/strongarm_comparator.hpp:29
        I(cpphdl_n342, cpphdl_n343) <+ cpphdl_channel(V(cpphdl_n337, cpphdl_n343), V(cpphdl_n342, cpphdl_n343), 0.0080000000000000002, 0.69999999999999996, 1.0);
        // device 431, IC IC53, analog/basic/strongarm_comparator.hpp:30
        I(cpphdl_n343, Vss) <+ cpphdl_channel(V(cpphdl_n338, Vss), V(cpphdl_n343, Vss), 0.0080000000000000002, 0.69999999999999996, 1.0);
        // device 432, IC IC53, analog/basic/strongarm_comparator.hpp:33
        I(cpphdl_n353, cpphdl_n341) <+ cpphdl_channel(V(cpphdl_n357, cpphdl_n341), V(cpphdl_n353, cpphdl_n341), 0.0040000000000000001, 0.69999999999999996, 1.0);
        // device 433, IC IC53, analog/basic/strongarm_comparator.hpp:34
        I(cpphdl_n357, cpphdl_n342) <+ cpphdl_channel(V(cpphdl_n353, cpphdl_n342), V(cpphdl_n357, cpphdl_n342), 0.0040000000000000001, 0.69999999999999996, 1.0);
        // device 434, IC IC53, analog/basic/strongarm_comparator.hpp:35
        I(cpphdl_n357, Vdd) <+ cpphdl_channel(V(cpphdl_n353, Vdd), V(cpphdl_n357, Vdd), 0.002, 0.69999999999999996, -1.0);
        // device 435, IC IC53, analog/basic/strongarm_comparator.hpp:36
        I(cpphdl_n353, Vdd) <+ cpphdl_channel(V(cpphdl_n357, Vdd), V(cpphdl_n353, Vdd), 0.002, 0.69999999999999996, -1.0);
        // device 436, IC IC53, analog/basic/strongarm_comparator.hpp:38
        I(cpphdl_n341, Vdd) <+ cpphdl_channel(V(cpphdl_n338, Vdd), V(cpphdl_n341, Vdd), 0.002, 0.69999999999999996, -1.0);
        // device 437, IC IC53, analog/basic/strongarm_comparator.hpp:39
        I(cpphdl_n342, Vdd) <+ cpphdl_channel(V(cpphdl_n338, Vdd), V(cpphdl_n342, Vdd), 0.002, 0.69999999999999996, -1.0);
        // device 438, IC IC53, analog/basic/strongarm_comparator.hpp:40
        I(cpphdl_n357, Vdd) <+ cpphdl_channel(V(cpphdl_n338, Vdd), V(cpphdl_n357, Vdd), 0.002, 0.69999999999999996, -1.0);
        // device 439, IC IC53, analog/basic/strongarm_comparator.hpp:41
        I(cpphdl_n353, Vdd) <+ cpphdl_channel(V(cpphdl_n338, Vdd), V(cpphdl_n353, Vdd), 0.002, 0.69999999999999996, -1.0);
        // device 440, IC IC53, analog/basic/strongarm_comparator.hpp:42
        I(cpphdl_n341, Vss) <+ 2.9999999999999998e-14 * ddt(V(cpphdl_n341, Vss)); // Bench initial voltage = 0.0 V.
        // device 441, IC IC53, analog/basic/strongarm_comparator.hpp:43
        I(cpphdl_n342, Vss) <+ 2.9999999999999998e-14 * ddt(V(cpphdl_n342, Vss)); // Bench initial voltage = 0.0 V.
        // device 442, IC IC53, analog/basic/strongarm_comparator.hpp:44
        I(cpphdl_n343, Vss) <+ 2.9999999999999998e-14 * ddt(V(cpphdl_n343, Vss)); // Bench initial voltage = 0.0 V.
        // device 443, IC IC53, analog/basic/strongarm_comparator.hpp:45
        I(cpphdl_n357, Vss) <+ 5.0000000000000002e-14 * ddt(V(cpphdl_n357, Vss)); // Bench initial voltage = 0.0 V.
        // device 444, IC IC53, analog/basic/strongarm_comparator.hpp:46
        I(cpphdl_n353, Vss) <+ 5.0000000000000002e-14 * ddt(V(cpphdl_n353, Vss)); // Bench initial voltage = 0.0 V.
        // device 445, IC IC53, analog/basic/strongarm_comparator.hpp:47
        I(cpphdl_n336, cpphdl_n343) <+ 2e-14 * ddt(V(cpphdl_n336, cpphdl_n343)); // Bench initial voltage = 0.0 V.
        // device 446, IC IC53, analog/basic/strongarm_comparator.hpp:48
        I(cpphdl_n337, cpphdl_n343) <+ 2e-14 * ddt(V(cpphdl_n337, cpphdl_n343)); // Bench initial voltage = 0.0 V.
        // device 447, IC IC53, analog/basic/strongarm_comparator.hpp:49
        I(cpphdl_n336, cpphdl_n341) <+ 2.9999999999999998e-15 * ddt(V(cpphdl_n336, cpphdl_n341)); // Bench initial voltage = 0.0 V.
        // device 448, IC IC53, analog/basic/strongarm_comparator.hpp:50
        I(cpphdl_n337, cpphdl_n342) <+ 2.9999999999999998e-15 * ddt(V(cpphdl_n337, cpphdl_n342)); // Bench initial voltage = 0.0 V.
        // device 449, IC IC55, analog/basic/inverter.hpp:11
        I(cpphdl_n361, Vdd) <+ cpphdl_channel(V(cpphdl_n353, Vdd), V(cpphdl_n361, Vdd), 0.001, 0.69999999999999996, -1.0);
        // device 450, IC IC55, analog/basic/inverter.hpp:12
        I(cpphdl_n361, Vss) <+ cpphdl_channel(V(cpphdl_n353, Vss), V(cpphdl_n361, Vss), 0.001, 0.69999999999999996, 1.0);
        // device 451, IC IC57, analog/basic/inverter.hpp:11
        I(cpphdl_n375, Vdd) <+ cpphdl_channel(V(cpphdl_n361, Vdd), V(cpphdl_n375, Vdd), 0.0040000000000000001, 0.69999999999999996, -1.0);
        // device 452, IC IC57, analog/basic/inverter.hpp:12
        I(cpphdl_n375, Vss) <+ cpphdl_channel(V(cpphdl_n361, Vss), V(cpphdl_n375, Vss), 0.0040000000000000001, 0.69999999999999996, 1.0);
        // device 453, IC IC54, analog/basic/buffered_nand_latch.hpp:34
        I(cpphdl_n353, Vss) <+ 2.0000000000000002e-15 * ddt(V(cpphdl_n353, Vss)); // Bench initial voltage = 0.0 V.
        // device 454, IC IC54, analog/basic/buffered_nand_latch.hpp:35
        I(cpphdl_n353, cpphdl_n361) <+ 1.0000000000000001e-15 * ddt(V(cpphdl_n353, cpphdl_n361)); // Bench initial voltage = 0.0 V.
        // device 455, IC IC54, analog/basic/buffered_nand_latch.hpp:36
        I(cpphdl_n361, Vss) <+ 5e-15 * ddt(V(cpphdl_n361, Vss)); // Bench initial voltage = 0.0 V.
        // device 456, IC IC54, analog/basic/buffered_nand_latch.hpp:37
        I(cpphdl_n361, Vss) <+ 8.0000000000000006e-15 * ddt(V(cpphdl_n361, Vss)); // Bench initial voltage = 0.0 V.
        // device 457, IC IC54, analog/basic/buffered_nand_latch.hpp:38
        I(cpphdl_n375, Vss) <+ 1e-14 * ddt(V(cpphdl_n375, Vss)); // Bench initial voltage = 0.0 V.
        // device 458, IC IC56, analog/basic/inverter.hpp:11
        I(cpphdl_n365, Vdd) <+ cpphdl_channel(V(cpphdl_n357, Vdd), V(cpphdl_n365, Vdd), 0.001, 0.69999999999999996, -1.0);
        // device 459, IC IC56, analog/basic/inverter.hpp:12
        I(cpphdl_n365, Vss) <+ cpphdl_channel(V(cpphdl_n357, Vss), V(cpphdl_n365, Vss), 0.001, 0.69999999999999996, 1.0);
        // device 460, IC IC58, analog/basic/inverter.hpp:11
        I(cpphdl_n381, Vdd) <+ cpphdl_channel(V(cpphdl_n365, Vdd), V(cpphdl_n381, Vdd), 0.0040000000000000001, 0.69999999999999996, -1.0);
        // device 461, IC IC58, analog/basic/inverter.hpp:12
        I(cpphdl_n381, Vss) <+ cpphdl_channel(V(cpphdl_n365, Vss), V(cpphdl_n381, Vss), 0.0040000000000000001, 0.69999999999999996, 1.0);
        // device 462, IC IC54, analog/basic/buffered_nand_latch.hpp:34
        I(cpphdl_n357, Vss) <+ 2.0000000000000002e-15 * ddt(V(cpphdl_n357, Vss)); // Bench initial voltage = 0.0 V.
        // device 463, IC IC54, analog/basic/buffered_nand_latch.hpp:35
        I(cpphdl_n357, cpphdl_n365) <+ 1.0000000000000001e-15 * ddt(V(cpphdl_n357, cpphdl_n365)); // Bench initial voltage = 0.0 V.
        // device 464, IC IC54, analog/basic/buffered_nand_latch.hpp:36
        I(cpphdl_n365, Vss) <+ 5e-15 * ddt(V(cpphdl_n365, Vss)); // Bench initial voltage = 0.0 V.
        // device 465, IC IC54, analog/basic/buffered_nand_latch.hpp:37
        I(cpphdl_n365, Vss) <+ 8.0000000000000006e-15 * ddt(V(cpphdl_n365, Vss)); // Bench initial voltage = 0.0 V.
        // device 466, IC IC54, analog/basic/buffered_nand_latch.hpp:38
        I(cpphdl_n381, Vss) <+ 1e-14 * ddt(V(cpphdl_n381, Vss)); // Bench initial voltage = 0.0 V.
        // device 467, IC IC60, analog/basic/cmos_logic.hpp:17
        I(cpphdl_n392, Vss) <+ 5.0000000000000002e-14 * ddt(V(cpphdl_n392, Vss)); // Bench initial voltage = 0.0 V.
        // device 468, IC IC60, analog/basic/cmos_logic.hpp:18
        I(cpphdl_n392, Vdd) <+ cpphdl_channel(V(cpphdl_n375, Vdd), V(cpphdl_n392, Vdd), 0.01, 0.69999999999999996, -1.0);
        // device 469, IC IC60, analog/basic/cmos_logic.hpp:19
        I(cpphdl_n392, Vdd) <+ cpphdl_channel(V(cpphdl_n383, Vdd), V(cpphdl_n392, Vdd), 0.01, 0.69999999999999996, -1.0);
        // device 470, IC IC60, analog/basic/cmos_logic.hpp:20
        I(cpphdl_n392, cpphdl_n378) <+ cpphdl_channel(V(cpphdl_n375, cpphdl_n378), V(cpphdl_n392, cpphdl_n378), 0.01, 0.69999999999999996, 1.0);
        // device 471, IC IC60, analog/basic/cmos_logic.hpp:21
        I(cpphdl_n378, Vss) <+ cpphdl_channel(V(cpphdl_n383, Vss), V(cpphdl_n378, Vss), 0.01, 0.69999999999999996, 1.0);
        // device 472, IC IC60, analog/basic/cmos_logic.hpp:27
        I(cpphdl_n378, Vss) <+ 1e-14 * ddt(V(cpphdl_n378, Vss)); // Bench initial voltage = 0.0 V.
        // device 473, IC IC61, analog/basic/cmos_logic.hpp:17
        I(cpphdl_n383, Vss) <+ 5.0000000000000002e-14 * ddt(V(cpphdl_n383, Vss)); // Bench initial voltage = 0.0 V.
        // device 474, IC IC61, analog/basic/cmos_logic.hpp:18
        I(cpphdl_n383, Vdd) <+ cpphdl_channel(V(cpphdl_n381, Vdd), V(cpphdl_n383, Vdd), 0.01, 0.69999999999999996, -1.0);
        // device 475, IC IC61, analog/basic/cmos_logic.hpp:19
        I(cpphdl_n383, Vdd) <+ cpphdl_channel(V(cpphdl_n392, Vdd), V(cpphdl_n383, Vdd), 0.01, 0.69999999999999996, -1.0);
        // device 476, IC IC61, analog/basic/cmos_logic.hpp:20
        I(cpphdl_n383, cpphdl_n384) <+ cpphdl_channel(V(cpphdl_n381, cpphdl_n384), V(cpphdl_n383, cpphdl_n384), 0.01, 0.69999999999999996, 1.0);
        // device 477, IC IC61, analog/basic/cmos_logic.hpp:21
        I(cpphdl_n384, Vss) <+ cpphdl_channel(V(cpphdl_n392, Vss), V(cpphdl_n384, Vss), 0.01, 0.69999999999999996, 1.0);
        // device 478, IC IC61, analog/basic/cmos_logic.hpp:27
        I(cpphdl_n384, Vss) <+ 1e-14 * ddt(V(cpphdl_n384, Vss)); // Bench initial voltage = 0.0 V.
        // device 479, IC IC59, analog/basic/nand_latch.hpp:36
        I(cpphdl_n375, Vss) <+ 2.9999999999999998e-15 * ddt(V(cpphdl_n375, Vss)); // Bench initial voltage = 0.0 V.
        // device 480, IC IC59, analog/basic/nand_latch.hpp:37
        I(cpphdl_n381, Vss) <+ 2.9999999999999998e-15 * ddt(V(cpphdl_n381, Vss)); // Bench initial voltage = 0.0 V.
        // device 481, IC IC62, analog/basic/inverter.hpp:11
        I(cpphdl_n389, Vdd) <+ cpphdl_channel(V(cpphdl_n388, Vdd), V(cpphdl_n389, Vdd), 0.01, 0.69999999999999996, -1.0);
        // device 482, IC IC62, analog/basic/inverter.hpp:12
        I(cpphdl_n389, Vss) <+ cpphdl_channel(V(cpphdl_n388, Vss), V(cpphdl_n389, Vss), 0.01, 0.69999999999999996, 1.0);
        // device 483, IC IC59, analog/basic/nand_latch.hpp:58
        I(cpphdl_n389, Vss) <+ 2.9999999999999998e-15 * ddt(V(cpphdl_n389, Vss)); // Bench initial voltage = 0.0 V.
        // device 484, IC IC59, analog/basic/nand_latch.hpp:59
        I(cpphdl_n392, Vss) <+ cpphdl_channel(V(cpphdl_n388, Vss), V(cpphdl_n392, Vss), 0.050000000000000003, 0.69999999999999996, 1.0);
        // device 485, IC IC59, analog/basic/nand_latch.hpp:60
        I(cpphdl_n383, Vdd) <+ cpphdl_channel(V(cpphdl_n389, Vdd), V(cpphdl_n383, Vdd), 0.050000000000000003, 0.69999999999999996, -1.0);
        // device 486, IC IC63, analog/basic/level_down.hpp:23
        I(cpphdl_n394, Vlogic) <+ cpphdl_channel(V(Vss, Vlogic), V(cpphdl_n394, Vlogic), 0.00050000000000000001, 0.34999999999999998, -1.0);
        // device 487, IC IC63, analog/basic/level_down.hpp:24
        I(cpphdl_n394, Vss) <+ cpphdl_channel(V(cpphdl_n392, Vss), V(cpphdl_n394, Vss), 0.0040000000000000001, 0.69999999999999996, 1.0);
        // device 488, IC IC63, analog/basic/level_down.hpp:25
        I(CORE_DECISION, Vlogic) <+ cpphdl_channel(V(cpphdl_n394, Vlogic), V(CORE_DECISION, Vlogic), 0.0050000000000000001, 0.34999999999999998, -1.0);
        // device 489, IC IC63, analog/basic/level_down.hpp:26
        I(CORE_DECISION, Vss) <+ cpphdl_channel(V(cpphdl_n394, Vss), V(CORE_DECISION, Vss), 0.01, 0.34999999999999998, 1.0);
        // device 490, IC IC63, analog/basic/level_down.hpp:27
        I(cpphdl_n392, Vss) <+ 5e-15 * ddt(V(cpphdl_n392, Vss)); // Bench initial voltage = 0.0 V.
        // device 491, IC IC63, analog/basic/level_down.hpp:28
        I(cpphdl_n392, Vlogic) <+ 5e-15 * ddt(V(cpphdl_n392, Vlogic)); // Bench initial voltage = 0.0 V.
        // device 492, IC IC63, analog/basic/level_down.hpp:29
        I(cpphdl_n392, cpphdl_n394) <+ 2.0000000000000002e-15 * ddt(V(cpphdl_n392, cpphdl_n394)); // Bench initial voltage = 0.0 V.
        // device 493, IC IC63, analog/basic/level_down.hpp:30
        I(cpphdl_n394, Vss) <+ 8e-14 * ddt(V(cpphdl_n394, Vss)); // Bench initial voltage = 0.0 V.
        // device 494, IC IC63, analog/basic/level_down.hpp:31
        I(cpphdl_n394, Vlogic) <+ 5e-15 * ddt(V(cpphdl_n394, Vlogic)); // Bench initial voltage = 0.0 V.
        // device 495, IC IC63, analog/basic/level_down.hpp:32
        I(cpphdl_n394, CORE_DECISION) <+ 2.0000000000000002e-15 * ddt(V(cpphdl_n394, CORE_DECISION)); // Bench initial voltage = 0.0 V.
        // device 496, IC IC63, analog/basic/level_down.hpp:33
        I(CORE_DECISION, Vss) <+ 1e-14 * ddt(V(CORE_DECISION, Vss)); // Bench initial voltage = 0.0 V.
    end
endmodule
