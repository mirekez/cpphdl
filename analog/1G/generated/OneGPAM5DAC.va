// SIMULATION APPROXIMATION: controlled conductances are not physical MOS devices.
// Generated from elaborated C++HDL IC purposes; all contributions coexist.
// Capacitor initialization belongs to the host analysis; declared initial voltages appear below.
`include "disciplines.vams"

module OneGPAM5DAC(Vdd, Vss, VREF, VCM, OUT, C0, C1, C2, C3);
    inout Vdd, Vss, VREF, VCM, OUT, C0, C1, C2, C3;
    electrical Vdd, Vss, VREF, VCM, OUT, C0, C1, C2, C3;

    analog begin
        // device 0, IC OneGPAM5DAC, analog/1G/pam5.hpp:18
        I(VCM, OUT) <+ V(VCM, OUT) / 1000.0;
        // device 1, IC OneGPAM5DAC, analog/1G/pam5.hpp:19
        I(OUT, VCM) <+ 2e-14 * ddt(V(OUT, VCM)); // Bench initial voltage = 0.0 V.
        // device 2, IC OneGPAM5DAC, analog/1G/pam5.hpp:21
        I(OUT, VCM) <+ (-0.00041666666666666669) * V(C0, VREF);
        // device 3, IC OneGPAM5DAC, analog/1G/pam5.hpp:21
        I(OUT, VCM) <+ (-0.00041666666666666669) * V(C1, VREF);
        // device 4, IC OneGPAM5DAC, analog/1G/pam5.hpp:21
        I(OUT, VCM) <+ (-0.00041666666666666669) * V(C2, VREF);
        // device 5, IC OneGPAM5DAC, analog/1G/pam5.hpp:21
        I(OUT, VCM) <+ (-0.00041666666666666669) * V(C3, VREF);
    end
endmodule
