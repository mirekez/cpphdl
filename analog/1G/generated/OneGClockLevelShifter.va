// SIMULATION APPROXIMATION: controlled conductances are not physical MOS devices.
// Generated from elaborated C++HDL IC purposes; all contributions coexist.
// Capacitor initialization belongs to the host analysis; declared initial voltages appear below.
`include "disciplines.vams"

module OneGClockLevelShifter(Vdd, Vss, Vlogic, BIAS, A, Y, Y_N);
    inout Vdd, Vss, Vlogic, BIAS, A, Y, Y_N;
    electrical Vdd, Vss, Vlogic, BIAS, A, Y, Y_N;
    electrical cpphdl_n11;
    electrical cpphdl_n12;
    electrical cpphdl_n16;
    electrical cpphdl_n19;
    electrical cpphdl_n23;

    // Square-law channel, including reverse conduction. This is not a BSIM model.
    analog function real cpphdl_channel;
        input vgs, vds, beta, threshold, polarity;
        real vgs, vds, beta, threshold, polarity;
        real gate, drain, direction, overdrive, current;
        begin
            gate = polarity * vgs;
            drain = polarity * vds;
            direction = 1.0;
            if (drain < 0.0) begin
                gate = gate - drain;
                drain = -drain;
                direction = -1.0;
            end
            overdrive = gate - threshold;
            current = 0.0;
            if (overdrive > 0.0) begin
                if (drain < overdrive)
                    current = beta * (overdrive * drain - drain * drain / 2.0);
                else
                    current = beta * overdrive * overdrive / 2.0;
            end
            cpphdl_channel = polarity * direction * current;
        end
    endfunction

    analog begin
        // device 0, IC IC1, analog/basic/inverter.hpp:11
        I(cpphdl_n16, Vlogic) <+ cpphdl_channel(V(A, Vlogic), V(cpphdl_n16, Vlogic), 0.02, 0.5, -1.0);
        // device 1, IC IC1, analog/basic/inverter.hpp:12
        I(cpphdl_n16, Vss) <+ cpphdl_channel(V(A, Vss), V(cpphdl_n16, Vss), 0.02, 0.5, 1.0);
        // device 2, IC OneGClockLevelShifter, analog/basic/cascoded_level_shifter.hpp:58
        I(cpphdl_n16, Vss) <+ 1e-14 * ddt(V(cpphdl_n16, Vss)); // Bench initial voltage = 0.0 V.
        // device 3, IC OneGClockLevelShifter, analog/basic/cascoded_level_shifter.hpp:59
        I(cpphdl_n23, Vdd) <+ cpphdl_channel(V(cpphdl_n19, Vdd), V(cpphdl_n23, Vdd), 0.0014, 0.69999999999999996, -1.0);
        // device 4, IC OneGClockLevelShifter, analog/basic/cascoded_level_shifter.hpp:60
        I(cpphdl_n19, Vdd) <+ cpphdl_channel(V(cpphdl_n23, Vdd), V(cpphdl_n19, Vdd), 0.0014, 0.69999999999999996, -1.0);
        // device 5, IC OneGClockLevelShifter, analog/basic/cascoded_level_shifter.hpp:61
        I(cpphdl_n23, cpphdl_n11) <+ cpphdl_channel(V(BIAS, cpphdl_n11), V(cpphdl_n23, cpphdl_n11), 0.014999999999999999, 0.69999999999999996, 1.0);
        // device 6, IC OneGClockLevelShifter, analog/basic/cascoded_level_shifter.hpp:62
        I(cpphdl_n19, cpphdl_n12) <+ cpphdl_channel(V(BIAS, cpphdl_n12), V(cpphdl_n19, cpphdl_n12), 0.014999999999999999, 0.69999999999999996, 1.0);
        // device 7, IC OneGClockLevelShifter, analog/basic/cascoded_level_shifter.hpp:63
        I(cpphdl_n11, Vss) <+ cpphdl_channel(V(cpphdl_n16, Vss), V(cpphdl_n11, Vss), 0.059999999999999998, 0.5, 1.0);
        // device 8, IC OneGClockLevelShifter, analog/basic/cascoded_level_shifter.hpp:64
        I(cpphdl_n12, Vss) <+ cpphdl_channel(V(A, Vss), V(cpphdl_n12, Vss), 0.059999999999999998, 0.5, 1.0);
        // device 9, IC OneGClockLevelShifter, analog/basic/cascoded_level_shifter.hpp:65
        I(cpphdl_n23, Vss) <+ 1e-14 * ddt(V(cpphdl_n23, Vss)); // Bench initial voltage = 0.0 V.
        // device 10, IC OneGClockLevelShifter, analog/basic/cascoded_level_shifter.hpp:66
        I(cpphdl_n19, Vss) <+ 1e-14 * ddt(V(cpphdl_n19, Vss)); // Bench initial voltage = 0.0 V.
        // device 11, IC OneGClockLevelShifter, analog/basic/cascoded_level_shifter.hpp:67
        I(cpphdl_n11, Vss) <+ 1e-14 * ddt(V(cpphdl_n11, Vss)); // Bench initial voltage = 0.0 V.
        // device 12, IC OneGClockLevelShifter, analog/basic/cascoded_level_shifter.hpp:68
        I(cpphdl_n12, Vss) <+ 1e-14 * ddt(V(cpphdl_n12, Vss)); // Bench initial voltage = 0.0 V.
        // device 13, IC OneGClockLevelShifter, analog/basic/cascoded_level_shifter.hpp:72
        I(BIAS, cpphdl_n11) <+ 5.9999999999999997e-14 * ddt(V(BIAS, cpphdl_n11)); // Bench initial voltage = 0.0 V.
        // device 14, IC OneGClockLevelShifter, analog/basic/cascoded_level_shifter.hpp:73
        I(BIAS, cpphdl_n12) <+ 5.9999999999999997e-14 * ddt(V(BIAS, cpphdl_n12)); // Bench initial voltage = 0.0 V.
        // device 15, IC OneGClockLevelShifter, analog/basic/cascoded_level_shifter.hpp:74
        I(BIAS, cpphdl_n23) <+ 3.5999999999999998e-14 * ddt(V(BIAS, cpphdl_n23)); // Bench initial voltage = 0.0 V.
        // device 16, IC OneGClockLevelShifter, analog/basic/cascoded_level_shifter.hpp:75
        I(BIAS, cpphdl_n19) <+ 3.5999999999999998e-14 * ddt(V(BIAS, cpphdl_n19)); // Bench initial voltage = 0.0 V.
        // device 17, IC OneGClockLevelShifter, analog/basic/cascoded_level_shifter.hpp:76
        I(A, Vss) <+ 4e-14 * ddt(V(A, Vss)); // Bench initial voltage = 0.0 V.
        // device 18, IC OneGClockLevelShifter, analog/basic/cascoded_level_shifter.hpp:77
        I(cpphdl_n16, Vss) <+ 4e-14 * ddt(V(cpphdl_n16, Vss)); // Bench initial voltage = 0.0 V.
        // device 19, IC OneGClockLevelShifter, analog/basic/cascoded_level_shifter.hpp:78
        I(cpphdl_n23, Vdd) <+ 4e-14 * ddt(V(cpphdl_n23, Vdd)); // Bench initial voltage = 0.0 V.
        // device 20, IC OneGClockLevelShifter, analog/basic/cascoded_level_shifter.hpp:79
        I(cpphdl_n19, Vdd) <+ 4e-14 * ddt(V(cpphdl_n19, Vdd)); // Bench initial voltage = 0.0 V.
        // device 21, IC OneGClockLevelShifter, analog/basic/cascoded_level_shifter.hpp:80
        I(cpphdl_n23, cpphdl_n19) <+ 1.4e-14 * ddt(V(cpphdl_n23, cpphdl_n19)); // Bench initial voltage = 0.0 V.
        // device 22, IC OneGClockLevelShifter, analog/basic/cascoded_level_shifter.hpp:81
        I(cpphdl_n23, Vss) <+ 7.0000000000000005e-14 * ddt(V(cpphdl_n23, Vss)); // Bench initial voltage = 0.0 V.
        // device 23, IC OneGClockLevelShifter, analog/basic/cascoded_level_shifter.hpp:82
        I(cpphdl_n19, Vss) <+ 7.0000000000000005e-14 * ddt(V(cpphdl_n19, Vss)); // Bench initial voltage = 0.0 V.
        // device 24, IC OneGClockLevelShifter, analog/basic/cascoded_level_shifter.hpp:83
        I(cpphdl_n23, Y_N) <+ 2.3e-14 * ddt(V(cpphdl_n23, Y_N)); // Bench initial voltage = 0.0 V.
        // device 25, IC OneGClockLevelShifter, analog/basic/cascoded_level_shifter.hpp:84
        I(cpphdl_n19, Y) <+ 2.3e-14 * ddt(V(cpphdl_n19, Y)); // Bench initial voltage = 0.0 V.
        // device 26, IC IC2, analog/basic/inverter.hpp:11
        I(Y, Vdd) <+ cpphdl_channel(V(cpphdl_n19, Vdd), V(Y, Vdd), 0.0030000000000000001, 0.69999999999999996, -1.0);
        // device 27, IC IC2, analog/basic/inverter.hpp:12
        I(Y, Vss) <+ cpphdl_channel(V(cpphdl_n19, Vss), V(Y, Vss), 0.0030000000000000001, 0.69999999999999996, 1.0);
        // device 28, IC IC3, analog/basic/inverter.hpp:11
        I(Y_N, Vdd) <+ cpphdl_channel(V(cpphdl_n23, Vdd), V(Y_N, Vdd), 0.0030000000000000001, 0.69999999999999996, -1.0);
        // device 29, IC IC3, analog/basic/inverter.hpp:12
        I(Y_N, Vss) <+ cpphdl_channel(V(cpphdl_n23, Vss), V(Y_N, Vss), 0.0030000000000000001, 0.69999999999999996, 1.0);
        // device 30, IC OneGClockLevelShifter, analog/basic/cascoded_level_shifter.hpp:95
        I(Y, Vss) <+ 5.0000000000000002e-14 * ddt(V(Y, Vss)); // Bench initial voltage = 0.0 V.
        // device 31, IC OneGClockLevelShifter, analog/basic/cascoded_level_shifter.hpp:96
        I(Y_N, Vss) <+ 5.0000000000000002e-14 * ddt(V(Y_N, Vss)); // Bench initial voltage = 0.0 V.
        // device 32, IC OneGClockLevelShifter, analog/basic/cascoded_level_shifter.hpp:97
        I(A, cpphdl_n12) <+ 1.6000000000000001e-14 * ddt(V(A, cpphdl_n12)); // Bench initial voltage = 0.0 V.
        // device 33, IC OneGClockLevelShifter, analog/basic/cascoded_level_shifter.hpp:98
        I(cpphdl_n16, cpphdl_n11) <+ 1.6000000000000001e-14 * ddt(V(cpphdl_n16, cpphdl_n11)); // Bench initial voltage = 0.0 V.
        // device 34, IC OneGClockLevelShifter, analog/1G/clock_level_shifter.hpp:14
        I(Y, Vss) <+ 2.0000000000000001e-13 * ddt(V(Y, Vss)); // Bench initial voltage = 0.0 V.
        // device 35, IC OneGClockLevelShifter, analog/1G/clock_level_shifter.hpp:15
        I(Y_N, Vss) <+ 2.0000000000000001e-13 * ddt(V(Y_N, Vss)); // Bench initial voltage = 0.0 V.
    end
endmodule
