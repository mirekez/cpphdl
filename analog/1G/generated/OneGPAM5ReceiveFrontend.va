// SIMULATION APPROXIMATION: controlled conductances are not physical MOS devices.
// Generated from elaborated C++HDL IC purposes; all contributions coexist.
// Capacitor initialization belongs to the host analysis; declared initial voltages appear below.
`include "disciplines.vams"

module OneGPAM5ReceiveFrontend(Vdd, Vss, Vlogic, PLUS, MINUS, EVALUATE, CLEAR, TRACK0, CORE_DECISION0, BIT_N0_0, BIT_N0_1, BIT_N0_2, BIT_N0_3, BIT_N0_4, BIT_N0_5, BIT_N0_6, BIT_N0_7, TRACK1, CORE_DECISION1, BIT_N1_0, BIT_N1_1, BIT_N1_2, BIT_N1_3, BIT_N1_4, BIT_N1_5, BIT_N1_6, BIT_N1_7, TRACK2, CORE_DECISION2, BIT_N2_0, BIT_N2_1, BIT_N2_2, BIT_N2_3, BIT_N2_4, BIT_N2_5, BIT_N2_6, BIT_N2_7, TRACK3, CORE_DECISION3, BIT_N3_0, BIT_N3_1, BIT_N3_2, BIT_N3_3, BIT_N3_4, BIT_N3_5, BIT_N3_6, BIT_N3_7, TRACK4, CORE_DECISION4, BIT_N4_0, BIT_N4_1, BIT_N4_2, BIT_N4_3, BIT_N4_4, BIT_N4_5, BIT_N4_6, BIT_N4_7, TRACK5, CORE_DECISION5, BIT_N5_0, BIT_N5_1, BIT_N5_2, BIT_N5_3, BIT_N5_4, BIT_N5_5, BIT_N5_6, BIT_N5_7, TRACK6, CORE_DECISION6, BIT_N6_0, BIT_N6_1, BIT_N6_2, BIT_N6_3, BIT_N6_4, BIT_N6_5, BIT_N6_6, BIT_N6_7, TRACK7, CORE_DECISION7, BIT_N7_0, BIT_N7_1, BIT_N7_2, BIT_N7_3, BIT_N7_4, BIT_N7_5, BIT_N7_6, BIT_N7_7, TRACK8, CORE_DECISION8, BIT_N8_0, BIT_N8_1, BIT_N8_2, BIT_N8_3, BIT_N8_4, BIT_N8_5, BIT_N8_6, BIT_N8_7, TRACK9, CORE_DECISION9, BIT_N9_0, BIT_N9_1, BIT_N9_2, BIT_N9_3, BIT_N9_4, BIT_N9_5, BIT_N9_6, BIT_N9_7, TRACK10, CORE_DECISION10, BIT_N10_0, BIT_N10_1, BIT_N10_2, BIT_N10_3, BIT_N10_4, BIT_N10_5, BIT_N10_6, BIT_N10_7, TRACK11, CORE_DECISION11, BIT_N11_0, BIT_N11_1, BIT_N11_2, BIT_N11_3, BIT_N11_4, BIT_N11_5, BIT_N11_6, BIT_N11_7, TRACK12, CORE_DECISION12, BIT_N12_0, BIT_N12_1, BIT_N12_2, BIT_N12_3, BIT_N12_4, BIT_N12_5, BIT_N12_6, BIT_N12_7, TRACK13, CORE_DECISION13, BIT_N13_0, BIT_N13_1, BIT_N13_2, BIT_N13_3, BIT_N13_4, BIT_N13_5, BIT_N13_6, BIT_N13_7, TRACK14, CORE_DECISION14, BIT_N14_0, BIT_N14_1, BIT_N14_2, BIT_N14_3, BIT_N14_4, BIT_N14_5, BIT_N14_6, BIT_N14_7, TRACK15, CORE_DECISION15, BIT_N15_0, BIT_N15_1, BIT_N15_2, BIT_N15_3, BIT_N15_4, BIT_N15_5, BIT_N15_6, BIT_N15_7);
    inout Vdd, Vss, Vlogic, PLUS, MINUS, EVALUATE, CLEAR, TRACK0, CORE_DECISION0, BIT_N0_0, BIT_N0_1, BIT_N0_2, BIT_N0_3, BIT_N0_4, BIT_N0_5, BIT_N0_6, BIT_N0_7, TRACK1, CORE_DECISION1, BIT_N1_0, BIT_N1_1, BIT_N1_2, BIT_N1_3, BIT_N1_4, BIT_N1_5, BIT_N1_6, BIT_N1_7, TRACK2, CORE_DECISION2, BIT_N2_0, BIT_N2_1, BIT_N2_2, BIT_N2_3, BIT_N2_4, BIT_N2_5, BIT_N2_6, BIT_N2_7, TRACK3, CORE_DECISION3, BIT_N3_0, BIT_N3_1, BIT_N3_2, BIT_N3_3, BIT_N3_4, BIT_N3_5, BIT_N3_6, BIT_N3_7, TRACK4, CORE_DECISION4, BIT_N4_0, BIT_N4_1, BIT_N4_2, BIT_N4_3, BIT_N4_4, BIT_N4_5, BIT_N4_6, BIT_N4_7, TRACK5, CORE_DECISION5, BIT_N5_0, BIT_N5_1, BIT_N5_2, BIT_N5_3, BIT_N5_4, BIT_N5_5, BIT_N5_6, BIT_N5_7, TRACK6, CORE_DECISION6, BIT_N6_0, BIT_N6_1, BIT_N6_2, BIT_N6_3, BIT_N6_4, BIT_N6_5, BIT_N6_6, BIT_N6_7, TRACK7, CORE_DECISION7, BIT_N7_0, BIT_N7_1, BIT_N7_2, BIT_N7_3, BIT_N7_4, BIT_N7_5, BIT_N7_6, BIT_N7_7, TRACK8, CORE_DECISION8, BIT_N8_0, BIT_N8_1, BIT_N8_2, BIT_N8_3, BIT_N8_4, BIT_N8_5, BIT_N8_6, BIT_N8_7, TRACK9, CORE_DECISION9, BIT_N9_0, BIT_N9_1, BIT_N9_2, BIT_N9_3, BIT_N9_4, BIT_N9_5, BIT_N9_6, BIT_N9_7, TRACK10, CORE_DECISION10, BIT_N10_0, BIT_N10_1, BIT_N10_2, BIT_N10_3, BIT_N10_4, BIT_N10_5, BIT_N10_6, BIT_N10_7, TRACK11, CORE_DECISION11, BIT_N11_0, BIT_N11_1, BIT_N11_2, BIT_N11_3, BIT_N11_4, BIT_N11_5, BIT_N11_6, BIT_N11_7, TRACK12, CORE_DECISION12, BIT_N12_0, BIT_N12_1, BIT_N12_2, BIT_N12_3, BIT_N12_4, BIT_N12_5, BIT_N12_6, BIT_N12_7, TRACK13, CORE_DECISION13, BIT_N13_0, BIT_N13_1, BIT_N13_2, BIT_N13_3, BIT_N13_4, BIT_N13_5, BIT_N13_6, BIT_N13_7, TRACK14, CORE_DECISION14, BIT_N14_0, BIT_N14_1, BIT_N14_2, BIT_N14_3, BIT_N14_4, BIT_N14_5, BIT_N14_6, BIT_N14_7, TRACK15, CORE_DECISION15, BIT_N15_0, BIT_N15_1, BIT_N15_2, BIT_N15_3, BIT_N15_4, BIT_N15_5, BIT_N15_6, BIT_N15_7;
    electrical Vdd, Vss, Vlogic, PLUS, MINUS, EVALUATE, CLEAR, TRACK0, CORE_DECISION0, BIT_N0_0, BIT_N0_1, BIT_N0_2, BIT_N0_3, BIT_N0_4, BIT_N0_5, BIT_N0_6, BIT_N0_7, TRACK1, CORE_DECISION1, BIT_N1_0, BIT_N1_1, BIT_N1_2, BIT_N1_3, BIT_N1_4, BIT_N1_5, BIT_N1_6, BIT_N1_7, TRACK2, CORE_DECISION2, BIT_N2_0, BIT_N2_1, BIT_N2_2, BIT_N2_3, BIT_N2_4, BIT_N2_5, BIT_N2_6, BIT_N2_7, TRACK3, CORE_DECISION3, BIT_N3_0, BIT_N3_1, BIT_N3_2, BIT_N3_3, BIT_N3_4, BIT_N3_5, BIT_N3_6, BIT_N3_7, TRACK4, CORE_DECISION4, BIT_N4_0, BIT_N4_1, BIT_N4_2, BIT_N4_3, BIT_N4_4, BIT_N4_5, BIT_N4_6, BIT_N4_7, TRACK5, CORE_DECISION5, BIT_N5_0, BIT_N5_1, BIT_N5_2, BIT_N5_3, BIT_N5_4, BIT_N5_5, BIT_N5_6, BIT_N5_7, TRACK6, CORE_DECISION6, BIT_N6_0, BIT_N6_1, BIT_N6_2, BIT_N6_3, BIT_N6_4, BIT_N6_5, BIT_N6_6, BIT_N6_7, TRACK7, CORE_DECISION7, BIT_N7_0, BIT_N7_1, BIT_N7_2, BIT_N7_3, BIT_N7_4, BIT_N7_5, BIT_N7_6, BIT_N7_7, TRACK8, CORE_DECISION8, BIT_N8_0, BIT_N8_1, BIT_N8_2, BIT_N8_3, BIT_N8_4, BIT_N8_5, BIT_N8_6, BIT_N8_7, TRACK9, CORE_DECISION9, BIT_N9_0, BIT_N9_1, BIT_N9_2, BIT_N9_3, BIT_N9_4, BIT_N9_5, BIT_N9_6, BIT_N9_7, TRACK10, CORE_DECISION10, BIT_N10_0, BIT_N10_1, BIT_N10_2, BIT_N10_3, BIT_N10_4, BIT_N10_5, BIT_N10_6, BIT_N10_7, TRACK11, CORE_DECISION11, BIT_N11_0, BIT_N11_1, BIT_N11_2, BIT_N11_3, BIT_N11_4, BIT_N11_5, BIT_N11_6, BIT_N11_7, TRACK12, CORE_DECISION12, BIT_N12_0, BIT_N12_1, BIT_N12_2, BIT_N12_3, BIT_N12_4, BIT_N12_5, BIT_N12_6, BIT_N12_7, TRACK13, CORE_DECISION13, BIT_N13_0, BIT_N13_1, BIT_N13_2, BIT_N13_3, BIT_N13_4, BIT_N13_5, BIT_N13_6, BIT_N13_7, TRACK14, CORE_DECISION14, BIT_N14_0, BIT_N14_1, BIT_N14_2, BIT_N14_3, BIT_N14_4, BIT_N14_5, BIT_N14_6, BIT_N14_7, TRACK15, CORE_DECISION15, BIT_N15_0, BIT_N15_1, BIT_N15_2, BIT_N15_3, BIT_N15_4, BIT_N15_5, BIT_N15_6, BIT_N15_7;
    electrical cpphdl_n173;
    electrical cpphdl_n174;
    electrical cpphdl_n175;
    electrical cpphdl_n176;
    electrical cpphdl_n179;
    electrical cpphdl_n385;
    electrical cpphdl_n400;
    electrical cpphdl_n404;
    electrical cpphdl_n408;
    electrical cpphdl_n412;
    electrical cpphdl_n416;
    electrical cpphdl_n420;
    electrical cpphdl_n424;
    electrical cpphdl_n428;
    electrical cpphdl_n429;
    electrical cpphdl_n430;
    electrical cpphdl_n431;
    electrical cpphdl_n432;
    electrical cpphdl_n433;
    electrical cpphdl_n434;
    electrical cpphdl_n435;
    electrical cpphdl_n439;
    electrical cpphdl_n440;
    electrical cpphdl_n443;
    electrical cpphdl_n444;
    electrical cpphdl_n445;
    electrical cpphdl_n448;
    electrical cpphdl_n449;
    electrical cpphdl_n453;
    electrical cpphdl_n454;
    electrical cpphdl_n455;
    electrical cpphdl_n467;
    electrical cpphdl_n470;
    electrical cpphdl_n473;
    electrical cpphdl_n475;
    electrical cpphdl_n476;
    electrical cpphdl_n481;
    electrical cpphdl_n505;
    electrical cpphdl_n520;
    electrical cpphdl_n524;
    electrical cpphdl_n528;
    electrical cpphdl_n532;
    electrical cpphdl_n536;
    electrical cpphdl_n540;
    electrical cpphdl_n544;
    electrical cpphdl_n548;
    electrical cpphdl_n549;
    electrical cpphdl_n550;
    electrical cpphdl_n551;
    electrical cpphdl_n552;
    electrical cpphdl_n553;
    electrical cpphdl_n554;
    electrical cpphdl_n555;
    electrical cpphdl_n559;
    electrical cpphdl_n560;
    electrical cpphdl_n563;
    electrical cpphdl_n564;
    electrical cpphdl_n565;
    electrical cpphdl_n568;
    electrical cpphdl_n569;
    electrical cpphdl_n573;
    electrical cpphdl_n574;
    electrical cpphdl_n575;
    electrical cpphdl_n587;
    electrical cpphdl_n590;
    electrical cpphdl_n593;
    electrical cpphdl_n595;
    electrical cpphdl_n596;
    electrical cpphdl_n601;
    electrical cpphdl_n625;
    electrical cpphdl_n640;
    electrical cpphdl_n644;
    electrical cpphdl_n648;
    electrical cpphdl_n652;
    electrical cpphdl_n656;
    electrical cpphdl_n660;
    electrical cpphdl_n664;
    electrical cpphdl_n668;
    electrical cpphdl_n669;
    electrical cpphdl_n670;
    electrical cpphdl_n671;
    electrical cpphdl_n672;
    electrical cpphdl_n673;
    electrical cpphdl_n674;
    electrical cpphdl_n675;
    electrical cpphdl_n679;
    electrical cpphdl_n680;
    electrical cpphdl_n683;
    electrical cpphdl_n684;
    electrical cpphdl_n685;
    electrical cpphdl_n688;
    electrical cpphdl_n689;
    electrical cpphdl_n693;
    electrical cpphdl_n694;
    electrical cpphdl_n695;
    electrical cpphdl_n707;
    electrical cpphdl_n710;
    electrical cpphdl_n713;
    electrical cpphdl_n715;
    electrical cpphdl_n716;
    electrical cpphdl_n721;
    electrical cpphdl_n745;
    electrical cpphdl_n760;
    electrical cpphdl_n764;
    electrical cpphdl_n768;
    electrical cpphdl_n772;
    electrical cpphdl_n776;
    electrical cpphdl_n780;
    electrical cpphdl_n784;
    electrical cpphdl_n788;
    electrical cpphdl_n789;
    electrical cpphdl_n790;
    electrical cpphdl_n791;
    electrical cpphdl_n792;
    electrical cpphdl_n793;
    electrical cpphdl_n794;
    electrical cpphdl_n795;
    electrical cpphdl_n799;
    electrical cpphdl_n800;
    electrical cpphdl_n803;
    electrical cpphdl_n804;
    electrical cpphdl_n805;
    electrical cpphdl_n808;
    electrical cpphdl_n809;
    electrical cpphdl_n813;
    electrical cpphdl_n814;
    electrical cpphdl_n815;
    electrical cpphdl_n827;
    electrical cpphdl_n830;
    electrical cpphdl_n833;
    electrical cpphdl_n835;
    electrical cpphdl_n836;
    electrical cpphdl_n841;
    electrical cpphdl_n865;
    electrical cpphdl_n880;
    electrical cpphdl_n884;
    electrical cpphdl_n888;
    electrical cpphdl_n892;
    electrical cpphdl_n896;
    electrical cpphdl_n900;
    electrical cpphdl_n904;
    electrical cpphdl_n908;
    electrical cpphdl_n909;
    electrical cpphdl_n910;
    electrical cpphdl_n911;
    electrical cpphdl_n912;
    electrical cpphdl_n913;
    electrical cpphdl_n914;
    electrical cpphdl_n915;
    electrical cpphdl_n919;
    electrical cpphdl_n920;
    electrical cpphdl_n923;
    electrical cpphdl_n924;
    electrical cpphdl_n925;
    electrical cpphdl_n928;
    electrical cpphdl_n929;
    electrical cpphdl_n933;
    electrical cpphdl_n934;
    electrical cpphdl_n935;
    electrical cpphdl_n947;
    electrical cpphdl_n950;
    electrical cpphdl_n953;
    electrical cpphdl_n955;
    electrical cpphdl_n956;
    electrical cpphdl_n961;
    electrical cpphdl_n985;
    electrical cpphdl_n1000;
    electrical cpphdl_n1004;
    electrical cpphdl_n1008;
    electrical cpphdl_n1012;
    electrical cpphdl_n1016;
    electrical cpphdl_n1020;
    electrical cpphdl_n1024;
    electrical cpphdl_n1028;
    electrical cpphdl_n1029;
    electrical cpphdl_n1030;
    electrical cpphdl_n1031;
    electrical cpphdl_n1032;
    electrical cpphdl_n1033;
    electrical cpphdl_n1034;
    electrical cpphdl_n1035;
    electrical cpphdl_n1039;
    electrical cpphdl_n1040;
    electrical cpphdl_n1043;
    electrical cpphdl_n1044;
    electrical cpphdl_n1045;
    electrical cpphdl_n1048;
    electrical cpphdl_n1049;
    electrical cpphdl_n1053;
    electrical cpphdl_n1054;
    electrical cpphdl_n1055;
    electrical cpphdl_n1067;
    electrical cpphdl_n1070;
    electrical cpphdl_n1073;
    electrical cpphdl_n1075;
    electrical cpphdl_n1076;
    electrical cpphdl_n1081;
    electrical cpphdl_n1105;
    electrical cpphdl_n1120;
    electrical cpphdl_n1124;
    electrical cpphdl_n1128;
    electrical cpphdl_n1132;
    electrical cpphdl_n1136;
    electrical cpphdl_n1140;
    electrical cpphdl_n1144;
    electrical cpphdl_n1148;
    electrical cpphdl_n1149;
    electrical cpphdl_n1150;
    electrical cpphdl_n1151;
    electrical cpphdl_n1152;
    electrical cpphdl_n1153;
    electrical cpphdl_n1154;
    electrical cpphdl_n1155;
    electrical cpphdl_n1159;
    electrical cpphdl_n1160;
    electrical cpphdl_n1163;
    electrical cpphdl_n1164;
    electrical cpphdl_n1165;
    electrical cpphdl_n1168;
    electrical cpphdl_n1169;
    electrical cpphdl_n1173;
    electrical cpphdl_n1174;
    electrical cpphdl_n1175;
    electrical cpphdl_n1187;
    electrical cpphdl_n1190;
    electrical cpphdl_n1193;
    electrical cpphdl_n1195;
    electrical cpphdl_n1196;
    electrical cpphdl_n1201;
    electrical cpphdl_n1225;
    electrical cpphdl_n1240;
    electrical cpphdl_n1244;
    electrical cpphdl_n1248;
    electrical cpphdl_n1252;
    electrical cpphdl_n1256;
    electrical cpphdl_n1260;
    electrical cpphdl_n1264;
    electrical cpphdl_n1268;
    electrical cpphdl_n1269;
    electrical cpphdl_n1270;
    electrical cpphdl_n1271;
    electrical cpphdl_n1272;
    electrical cpphdl_n1273;
    electrical cpphdl_n1274;
    electrical cpphdl_n1275;
    electrical cpphdl_n1279;
    electrical cpphdl_n1280;
    electrical cpphdl_n1283;
    electrical cpphdl_n1284;
    electrical cpphdl_n1285;
    electrical cpphdl_n1288;
    electrical cpphdl_n1289;
    electrical cpphdl_n1293;
    electrical cpphdl_n1294;
    electrical cpphdl_n1295;
    electrical cpphdl_n1307;
    electrical cpphdl_n1310;
    electrical cpphdl_n1313;
    electrical cpphdl_n1315;
    electrical cpphdl_n1316;
    electrical cpphdl_n1321;
    electrical cpphdl_n1345;
    electrical cpphdl_n1360;
    electrical cpphdl_n1364;
    electrical cpphdl_n1368;
    electrical cpphdl_n1372;
    electrical cpphdl_n1376;
    electrical cpphdl_n1380;
    electrical cpphdl_n1384;
    electrical cpphdl_n1388;
    electrical cpphdl_n1389;
    electrical cpphdl_n1390;
    electrical cpphdl_n1391;
    electrical cpphdl_n1392;
    electrical cpphdl_n1393;
    electrical cpphdl_n1394;
    electrical cpphdl_n1395;
    electrical cpphdl_n1399;
    electrical cpphdl_n1400;
    electrical cpphdl_n1403;
    electrical cpphdl_n1404;
    electrical cpphdl_n1405;
    electrical cpphdl_n1408;
    electrical cpphdl_n1409;
    electrical cpphdl_n1413;
    electrical cpphdl_n1414;
    electrical cpphdl_n1415;
    electrical cpphdl_n1427;
    electrical cpphdl_n1430;
    electrical cpphdl_n1433;
    electrical cpphdl_n1435;
    electrical cpphdl_n1436;
    electrical cpphdl_n1441;
    electrical cpphdl_n1465;
    electrical cpphdl_n1480;
    electrical cpphdl_n1484;
    electrical cpphdl_n1488;
    electrical cpphdl_n1492;
    electrical cpphdl_n1496;
    electrical cpphdl_n1500;
    electrical cpphdl_n1504;
    electrical cpphdl_n1508;
    electrical cpphdl_n1509;
    electrical cpphdl_n1510;
    electrical cpphdl_n1511;
    electrical cpphdl_n1512;
    electrical cpphdl_n1513;
    electrical cpphdl_n1514;
    electrical cpphdl_n1515;
    electrical cpphdl_n1519;
    electrical cpphdl_n1520;
    electrical cpphdl_n1523;
    electrical cpphdl_n1524;
    electrical cpphdl_n1525;
    electrical cpphdl_n1528;
    electrical cpphdl_n1529;
    electrical cpphdl_n1533;
    electrical cpphdl_n1534;
    electrical cpphdl_n1535;
    electrical cpphdl_n1547;
    electrical cpphdl_n1550;
    electrical cpphdl_n1553;
    electrical cpphdl_n1555;
    electrical cpphdl_n1556;
    electrical cpphdl_n1561;
    electrical cpphdl_n1585;
    electrical cpphdl_n1600;
    electrical cpphdl_n1604;
    electrical cpphdl_n1608;
    electrical cpphdl_n1612;
    electrical cpphdl_n1616;
    electrical cpphdl_n1620;
    electrical cpphdl_n1624;
    electrical cpphdl_n1628;
    electrical cpphdl_n1629;
    electrical cpphdl_n1630;
    electrical cpphdl_n1631;
    electrical cpphdl_n1632;
    electrical cpphdl_n1633;
    electrical cpphdl_n1634;
    electrical cpphdl_n1635;
    electrical cpphdl_n1639;
    electrical cpphdl_n1640;
    electrical cpphdl_n1643;
    electrical cpphdl_n1644;
    electrical cpphdl_n1645;
    electrical cpphdl_n1648;
    electrical cpphdl_n1649;
    electrical cpphdl_n1653;
    electrical cpphdl_n1654;
    electrical cpphdl_n1655;
    electrical cpphdl_n1667;
    electrical cpphdl_n1670;
    electrical cpphdl_n1673;
    electrical cpphdl_n1675;
    electrical cpphdl_n1676;
    electrical cpphdl_n1681;
    electrical cpphdl_n1705;
    electrical cpphdl_n1720;
    electrical cpphdl_n1724;
    electrical cpphdl_n1728;
    electrical cpphdl_n1732;
    electrical cpphdl_n1736;
    electrical cpphdl_n1740;
    electrical cpphdl_n1744;
    electrical cpphdl_n1748;
    electrical cpphdl_n1749;
    electrical cpphdl_n1750;
    electrical cpphdl_n1751;
    electrical cpphdl_n1752;
    electrical cpphdl_n1753;
    electrical cpphdl_n1754;
    electrical cpphdl_n1755;
    electrical cpphdl_n1759;
    electrical cpphdl_n1760;
    electrical cpphdl_n1763;
    electrical cpphdl_n1764;
    electrical cpphdl_n1765;
    electrical cpphdl_n1768;
    electrical cpphdl_n1769;
    electrical cpphdl_n1773;
    electrical cpphdl_n1774;
    electrical cpphdl_n1775;
    electrical cpphdl_n1787;
    electrical cpphdl_n1790;
    electrical cpphdl_n1793;
    electrical cpphdl_n1795;
    electrical cpphdl_n1796;
    electrical cpphdl_n1801;
    electrical cpphdl_n1825;
    electrical cpphdl_n1840;
    electrical cpphdl_n1844;
    electrical cpphdl_n1848;
    electrical cpphdl_n1852;
    electrical cpphdl_n1856;
    electrical cpphdl_n1860;
    electrical cpphdl_n1864;
    electrical cpphdl_n1868;
    electrical cpphdl_n1869;
    electrical cpphdl_n1870;
    electrical cpphdl_n1871;
    electrical cpphdl_n1872;
    electrical cpphdl_n1873;
    electrical cpphdl_n1874;
    electrical cpphdl_n1875;
    electrical cpphdl_n1879;
    electrical cpphdl_n1880;
    electrical cpphdl_n1883;
    electrical cpphdl_n1884;
    electrical cpphdl_n1885;
    electrical cpphdl_n1888;
    electrical cpphdl_n1889;
    electrical cpphdl_n1893;
    electrical cpphdl_n1894;
    electrical cpphdl_n1895;
    electrical cpphdl_n1907;
    electrical cpphdl_n1910;
    electrical cpphdl_n1913;
    electrical cpphdl_n1915;
    electrical cpphdl_n1916;
    electrical cpphdl_n1921;
    electrical cpphdl_n1945;
    electrical cpphdl_n1960;
    electrical cpphdl_n1964;
    electrical cpphdl_n1968;
    electrical cpphdl_n1972;
    electrical cpphdl_n1976;
    electrical cpphdl_n1980;
    electrical cpphdl_n1984;
    electrical cpphdl_n1988;
    electrical cpphdl_n1989;
    electrical cpphdl_n1990;
    electrical cpphdl_n1991;
    electrical cpphdl_n1992;
    electrical cpphdl_n1993;
    electrical cpphdl_n1994;
    electrical cpphdl_n1995;
    electrical cpphdl_n1999;
    electrical cpphdl_n2000;
    electrical cpphdl_n2003;
    electrical cpphdl_n2004;
    electrical cpphdl_n2005;
    electrical cpphdl_n2008;
    electrical cpphdl_n2009;
    electrical cpphdl_n2013;
    electrical cpphdl_n2014;
    electrical cpphdl_n2015;
    electrical cpphdl_n2027;
    electrical cpphdl_n2030;
    electrical cpphdl_n2033;
    electrical cpphdl_n2035;
    electrical cpphdl_n2036;
    electrical cpphdl_n2041;
    electrical cpphdl_n2065;
    electrical cpphdl_n2080;
    electrical cpphdl_n2084;
    electrical cpphdl_n2088;
    electrical cpphdl_n2092;
    electrical cpphdl_n2096;
    electrical cpphdl_n2100;
    electrical cpphdl_n2104;
    electrical cpphdl_n2108;
    electrical cpphdl_n2109;
    electrical cpphdl_n2110;
    electrical cpphdl_n2111;
    electrical cpphdl_n2112;
    electrical cpphdl_n2113;
    electrical cpphdl_n2114;
    electrical cpphdl_n2115;
    electrical cpphdl_n2119;
    electrical cpphdl_n2120;
    electrical cpphdl_n2123;
    electrical cpphdl_n2124;
    electrical cpphdl_n2125;
    electrical cpphdl_n2128;
    electrical cpphdl_n2129;
    electrical cpphdl_n2133;
    electrical cpphdl_n2134;
    electrical cpphdl_n2135;
    electrical cpphdl_n2147;
    electrical cpphdl_n2150;
    electrical cpphdl_n2153;
    electrical cpphdl_n2155;
    electrical cpphdl_n2156;
    electrical cpphdl_n2161;
    electrical cpphdl_n2179;
    electrical cpphdl_n2185;
    electrical cpphdl_n2200;
    electrical cpphdl_n2204;
    electrical cpphdl_n2208;
    electrical cpphdl_n2212;
    electrical cpphdl_n2216;
    electrical cpphdl_n2220;
    electrical cpphdl_n2224;
    electrical cpphdl_n2228;
    electrical cpphdl_n2229;
    electrical cpphdl_n2230;
    electrical cpphdl_n2231;
    electrical cpphdl_n2232;
    electrical cpphdl_n2233;
    electrical cpphdl_n2234;
    electrical cpphdl_n2235;
    electrical cpphdl_n2239;
    electrical cpphdl_n2240;
    electrical cpphdl_n2243;
    electrical cpphdl_n2244;
    electrical cpphdl_n2245;
    electrical cpphdl_n2248;
    electrical cpphdl_n2249;
    electrical cpphdl_n2253;
    electrical cpphdl_n2254;
    electrical cpphdl_n2255;
    electrical cpphdl_n2267;
    electrical cpphdl_n2270;
    electrical cpphdl_n2273;
    electrical cpphdl_n2275;
    electrical cpphdl_n2276;
    electrical cpphdl_n2281;
    electrical cpphdl_n2301;
    electrical cpphdl_n2303;
    electrical cpphdl_n2306;
    electrical cpphdl_n2308;
    electrical cpphdl_n2311;
    electrical cpphdl_n2313;
    electrical cpphdl_n2316;
    electrical cpphdl_n2318;
    electrical cpphdl_n2321;
    electrical cpphdl_n2323;
    electrical cpphdl_n2326;
    electrical cpphdl_n2328;
    electrical cpphdl_n2331;
    electrical cpphdl_n2333;
    electrical cpphdl_n2336;
    electrical cpphdl_n2338;
    electrical cpphdl_n2341;
    electrical cpphdl_n2343;
    electrical cpphdl_n2346;
    electrical cpphdl_n2348;
    electrical cpphdl_n2351;
    electrical cpphdl_n2353;
    electrical cpphdl_n2356;
    electrical cpphdl_n2358;
    electrical cpphdl_n2361;
    electrical cpphdl_n2363;
    electrical cpphdl_n2366;
    electrical cpphdl_n2368;
    electrical cpphdl_n2371;
    electrical cpphdl_n2373;
    electrical cpphdl_n2376;
    electrical cpphdl_n2378;

    // Square-law channel, including reverse conduction. This is not a BSIM model.
    analog function real cpphdl_channel;
        input vgs, vds, beta, threshold, polarity;
        real vgs, vds, beta, threshold, polarity;
        real gate, drain, direction, overdrive, current;
        begin
            gate = polarity * vgs;
            drain = polarity * vds;
            direction = 1.0;
            if (drain < 0.0) begin
                gate = gate - drain;
                drain = -drain;
                direction = -1.0;
            end
            overdrive = gate - threshold;
            current = 0.0;
            if (overdrive > 0.0) begin
                if (drain < overdrive)
                    current = beta * (overdrive * drain - drain * drain / 2.0);
                else
                    current = beta * overdrive * overdrive / 2.0;
            end
            cpphdl_channel = polarity * direction * current;
        end
    endfunction

    analog begin
        // device 0, IC IC1, analog/basic/nmos_resistor_amplifier.hpp:23
        I(Vdd, cpphdl_n173) <+ V(Vdd, cpphdl_n173) / 500.0;
        // device 1, IC IC1, analog/basic/nmos_resistor_amplifier.hpp:24
        I(Vdd, cpphdl_n179) <+ V(Vdd, cpphdl_n179) / 500.0;
        // device 2, IC IC1, analog/basic/nmos_resistor_amplifier.hpp:25
        I(cpphdl_n173, cpphdl_n174) <+ cpphdl_channel(V(PLUS, cpphdl_n174), V(cpphdl_n173, cpphdl_n174), 0.014999999999999999, 0.69999999999999996, 1.0);
        // device 3, IC IC1, analog/basic/nmos_resistor_amplifier.hpp:26
        I(cpphdl_n179, cpphdl_n175) <+ cpphdl_channel(V(MINUS, cpphdl_n175), V(cpphdl_n179, cpphdl_n175), 0.014999999999999999, 0.69999999999999996, 1.0);
        // device 4, IC IC1, analog/basic/nmos_resistor_amplifier.hpp:27
        I(cpphdl_n176, cpphdl_n174) <+ V(cpphdl_n176, cpphdl_n174) / 50.0;
        // device 5, IC IC1, analog/basic/nmos_resistor_amplifier.hpp:28
        I(cpphdl_n176, cpphdl_n175) <+ V(cpphdl_n176, cpphdl_n175) / 50.0;
        // device 6, IC IC1, analog/basic/nmos_resistor_amplifier.hpp:29
        I(Vss, cpphdl_n176) <+ V(Vss, cpphdl_n176) / 150.0;
        // device 7, IC IC1, analog/basic/nmos_resistor_amplifier.hpp:30
        I(cpphdl_n173, Vdd) <+ 2.9999999999999998e-13 * ddt(V(cpphdl_n173, Vdd)); // Bench initial voltage = 0.0 V.
        // device 8, IC IC1, analog/basic/nmos_resistor_amplifier.hpp:31
        I(cpphdl_n179, Vdd) <+ 2.9999999999999998e-13 * ddt(V(cpphdl_n179, Vdd)); // Bench initial voltage = 0.0 V.
        // device 9, IC IC1, analog/basic/nmos_resistor_amplifier.hpp:32
        I(cpphdl_n176, Vss) <+ 4e-14 * ddt(V(cpphdl_n176, Vss)); // Bench initial voltage = 0.0 V.
        // device 10, IC IC1, analog/basic/nmos_resistor_amplifier.hpp:34
        I(PLUS, cpphdl_n174) <+ 1.4999999999999999e-13 * ddt(V(PLUS, cpphdl_n174)); // Bench initial voltage = 1.6499999999999999 V.
        // device 11, IC IC1, analog/basic/nmos_resistor_amplifier.hpp:35
        I(MINUS, cpphdl_n175) <+ 1.4999999999999999e-13 * ddt(V(MINUS, cpphdl_n175)); // Bench initial voltage = 1.6499999999999999 V.
        // device 12, IC IC1, analog/basic/nmos_resistor_amplifier.hpp:36
        I(PLUS, cpphdl_n173) <+ 2e-14 * ddt(V(PLUS, cpphdl_n173)); // Bench initial voltage = -1.6499999999999999 V.
        // device 13, IC IC1, analog/basic/nmos_resistor_amplifier.hpp:37
        I(MINUS, cpphdl_n179) <+ 2e-14 * ddt(V(MINUS, cpphdl_n179)); // Bench initial voltage = -1.6499999999999999 V.
        // device 14, IC IC2, analog/basic/nmos_source_follower.hpp:19
        I(Vdd, cpphdl_n2179) <+ cpphdl_channel(V(cpphdl_n179, cpphdl_n2179), V(Vdd, cpphdl_n2179), 0.10000000000000001, 0.69999999999999996, 1.0);
        // device 15, IC IC2, analog/basic/nmos_source_follower.hpp:20
        I(Vss, cpphdl_n2179) <+ V(Vss, cpphdl_n2179) / 250.0;
        // device 16, IC IC2, analog/basic/nmos_source_follower.hpp:23
        I(cpphdl_n179, cpphdl_n2179) <+ 4e-14 * ddt(V(cpphdl_n179, cpphdl_n2179)); // Bench initial voltage = 1.6499999999999999 V.
        // device 17, IC IC2, analog/basic/nmos_source_follower.hpp:24
        I(cpphdl_n179, Vdd) <+ 1e-14 * ddt(V(cpphdl_n179, Vdd)); // Bench initial voltage = 0.0 V.
        // device 18, IC IC2, analog/basic/nmos_source_follower.hpp:25
        I(cpphdl_n2179, Vss) <+ 4e-14 * ddt(V(cpphdl_n2179, Vss)); // Bench initial voltage = 1.6499999999999999 V.
        // device 19, IC IC6, analog/basic/inverter.hpp:11
        I(cpphdl_n385, Vdd) <+ cpphdl_channel(V(TRACK0, Vdd), V(cpphdl_n385, Vdd), 0.0040000000000000001, 0.69999999999999996, -1.0);
        // device 20, IC IC6, analog/basic/inverter.hpp:12
        I(cpphdl_n385, Vss) <+ cpphdl_channel(V(TRACK0, Vss), V(cpphdl_n385, Vss), 0.0040000000000000001, 0.69999999999999996, 1.0);
        // device 21, IC IC5, analog/basic/mos_track_hold.hpp:30
        I(cpphdl_n385, Vss) <+ 2e-14 * ddt(V(cpphdl_n385, Vss)); // Bench initial voltage = 3.2999999999999998 V.
        // device 22, IC IC5, analog/basic/mos_track_hold.hpp:31
        I(cpphdl_n2179, cpphdl_n439) <+ cpphdl_channel(V(TRACK0, cpphdl_n439), V(cpphdl_n2179, cpphdl_n439), 0.080000000000000002, 0.69999999999999996, 1.0);
        // device 23, IC IC5, analog/basic/mos_track_hold.hpp:32
        I(cpphdl_n439, cpphdl_n2179) <+ cpphdl_channel(V(cpphdl_n385, cpphdl_n2179), V(cpphdl_n439, cpphdl_n2179), 0.040000000000000001, 0.69999999999999996, -1.0);
        // device 24, IC IC5, analog/basic/mos_track_hold.hpp:36
        I(cpphdl_n439, cpphdl_n439) <+ cpphdl_channel(V(cpphdl_n385, cpphdl_n439), V(cpphdl_n439, cpphdl_n439), 0.040000000000000001, 0.69999999999999996, 1.0);
        // device 25, IC IC5, analog/basic/mos_track_hold.hpp:37
        I(cpphdl_n439, cpphdl_n439) <+ cpphdl_channel(V(TRACK0, cpphdl_n439), V(cpphdl_n439, cpphdl_n439), 0.02, 0.69999999999999996, -1.0);
        // device 26, IC IC5, analog/basic/mos_track_hold.hpp:38
        I(cpphdl_n439, Vss) <+ 2e-12 * ddt(V(cpphdl_n439, Vss)); // Bench initial voltage = 1.6499999999999999 V.
        // device 27, IC IC5, analog/basic/mos_track_hold.hpp:39
        I(Vss, cpphdl_n439) <+ V(Vss, cpphdl_n439) / 1000000000.0;
        // device 28, IC IC5, analog/basic/mos_track_hold.hpp:40
        I(TRACK0, cpphdl_n439) <+ 8.0000000000000006e-15 * ddt(V(TRACK0, cpphdl_n439)); // Bench initial voltage = -1.6499999999999999 V.
        // device 29, IC IC5, analog/basic/mos_track_hold.hpp:41
        I(cpphdl_n385, cpphdl_n439) <+ 8.0000000000000006e-15 * ddt(V(cpphdl_n385, cpphdl_n439)); // Bench initial voltage = 1.6499999999999999 V.
        // device 30, IC IC5, analog/basic/mos_track_hold.hpp:42
        I(cpphdl_n2179, cpphdl_n439) <+ 4.0000000000000003e-15 * ddt(V(cpphdl_n2179, cpphdl_n439)); // Bench initial voltage = 0.0 V.
        // device 31, IC IC8, analog/basic/inverter.hpp:11
        I(cpphdl_n400, Vdd) <+ cpphdl_channel(V(BIT_N0_0, Vdd), V(cpphdl_n400, Vdd), 0.080000000000000002, 0.69999999999999996, -1.0);
        // device 32, IC IC8, analog/basic/inverter.hpp:12
        I(cpphdl_n400, Vss) <+ cpphdl_channel(V(BIT_N0_0, Vss), V(cpphdl_n400, Vss), 0.080000000000000002, 0.69999999999999996, 1.0);
        // device 33, IC IC7, analog/basic/mos_r2r_dac.hpp:27
        I(cpphdl_n400, Vss) <+ 2.9999999999999998e-15 * ddt(V(cpphdl_n400, Vss)); // Bench initial voltage = 0.0 V.
        // device 34, IC IC7, analog/basic/mos_r2r_dac.hpp:28
        I(cpphdl_n400, cpphdl_n429) <+ V(cpphdl_n400, cpphdl_n429) / 20000.0;
        // device 35, IC IC7, analog/basic/mos_r2r_dac.hpp:29
        I(cpphdl_n429, Vss) <+ 2.9999999999999998e-15 * ddt(V(cpphdl_n429, Vss)); // Bench initial voltage = 0.0 V.
        // device 36, IC IC9, analog/basic/inverter.hpp:11
        I(cpphdl_n404, Vdd) <+ cpphdl_channel(V(BIT_N0_1, Vdd), V(cpphdl_n404, Vdd), 0.080000000000000002, 0.69999999999999996, -1.0);
        // device 37, IC IC9, analog/basic/inverter.hpp:12
        I(cpphdl_n404, Vss) <+ cpphdl_channel(V(BIT_N0_1, Vss), V(cpphdl_n404, Vss), 0.080000000000000002, 0.69999999999999996, 1.0);
        // device 38, IC IC7, analog/basic/mos_r2r_dac.hpp:27
        I(cpphdl_n404, Vss) <+ 2.9999999999999998e-15 * ddt(V(cpphdl_n404, Vss)); // Bench initial voltage = 0.0 V.
        // device 39, IC IC7, analog/basic/mos_r2r_dac.hpp:28
        I(cpphdl_n404, cpphdl_n430) <+ V(cpphdl_n404, cpphdl_n430) / 20000.0;
        // device 40, IC IC7, analog/basic/mos_r2r_dac.hpp:29
        I(cpphdl_n430, Vss) <+ 2.9999999999999998e-15 * ddt(V(cpphdl_n430, Vss)); // Bench initial voltage = 0.0 V.
        // device 41, IC IC7, analog/basic/mos_r2r_dac.hpp:31
        I(cpphdl_n429, cpphdl_n430) <+ V(cpphdl_n429, cpphdl_n430) / 10000.0;
        // device 42, IC IC10, analog/basic/inverter.hpp:11
        I(cpphdl_n408, Vdd) <+ cpphdl_channel(V(BIT_N0_2, Vdd), V(cpphdl_n408, Vdd), 0.080000000000000002, 0.69999999999999996, -1.0);
        // device 43, IC IC10, analog/basic/inverter.hpp:12
        I(cpphdl_n408, Vss) <+ cpphdl_channel(V(BIT_N0_2, Vss), V(cpphdl_n408, Vss), 0.080000000000000002, 0.69999999999999996, 1.0);
        // device 44, IC IC7, analog/basic/mos_r2r_dac.hpp:27
        I(cpphdl_n408, Vss) <+ 2.9999999999999998e-15 * ddt(V(cpphdl_n408, Vss)); // Bench initial voltage = 0.0 V.
        // device 45, IC IC7, analog/basic/mos_r2r_dac.hpp:28
        I(cpphdl_n408, cpphdl_n431) <+ V(cpphdl_n408, cpphdl_n431) / 20000.0;
        // device 46, IC IC7, analog/basic/mos_r2r_dac.hpp:29
        I(cpphdl_n431, Vss) <+ 2.9999999999999998e-15 * ddt(V(cpphdl_n431, Vss)); // Bench initial voltage = 0.0 V.
        // device 47, IC IC7, analog/basic/mos_r2r_dac.hpp:31
        I(cpphdl_n430, cpphdl_n431) <+ V(cpphdl_n430, cpphdl_n431) / 10000.0;
        // device 48, IC IC11, analog/basic/inverter.hpp:11
        I(cpphdl_n412, Vdd) <+ cpphdl_channel(V(BIT_N0_3, Vdd), V(cpphdl_n412, Vdd), 0.080000000000000002, 0.69999999999999996, -1.0);
        // device 49, IC IC11, analog/basic/inverter.hpp:12
        I(cpphdl_n412, Vss) <+ cpphdl_channel(V(BIT_N0_3, Vss), V(cpphdl_n412, Vss), 0.080000000000000002, 0.69999999999999996, 1.0);
        // device 50, IC IC7, analog/basic/mos_r2r_dac.hpp:27
        I(cpphdl_n412, Vss) <+ 2.9999999999999998e-15 * ddt(V(cpphdl_n412, Vss)); // Bench initial voltage = 0.0 V.
        // device 51, IC IC7, analog/basic/mos_r2r_dac.hpp:28
        I(cpphdl_n412, cpphdl_n432) <+ V(cpphdl_n412, cpphdl_n432) / 20000.0;
        // device 52, IC IC7, analog/basic/mos_r2r_dac.hpp:29
        I(cpphdl_n432, Vss) <+ 2.9999999999999998e-15 * ddt(V(cpphdl_n432, Vss)); // Bench initial voltage = 0.0 V.
        // device 53, IC IC7, analog/basic/mos_r2r_dac.hpp:31
        I(cpphdl_n431, cpphdl_n432) <+ V(cpphdl_n431, cpphdl_n432) / 10000.0;
        // device 54, IC IC12, analog/basic/inverter.hpp:11
        I(cpphdl_n416, Vdd) <+ cpphdl_channel(V(BIT_N0_4, Vdd), V(cpphdl_n416, Vdd), 0.080000000000000002, 0.69999999999999996, -1.0);
        // device 55, IC IC12, analog/basic/inverter.hpp:12
        I(cpphdl_n416, Vss) <+ cpphdl_channel(V(BIT_N0_4, Vss), V(cpphdl_n416, Vss), 0.080000000000000002, 0.69999999999999996, 1.0);
        // device 56, IC IC7, analog/basic/mos_r2r_dac.hpp:27
        I(cpphdl_n416, Vss) <+ 2.9999999999999998e-15 * ddt(V(cpphdl_n416, Vss)); // Bench initial voltage = 0.0 V.
        // device 57, IC IC7, analog/basic/mos_r2r_dac.hpp:28
        I(cpphdl_n416, cpphdl_n433) <+ V(cpphdl_n416, cpphdl_n433) / 20000.0;
        // device 58, IC IC7, analog/basic/mos_r2r_dac.hpp:29
        I(cpphdl_n433, Vss) <+ 2.9999999999999998e-15 * ddt(V(cpphdl_n433, Vss)); // Bench initial voltage = 0.0 V.
        // device 59, IC IC7, analog/basic/mos_r2r_dac.hpp:31
        I(cpphdl_n432, cpphdl_n433) <+ V(cpphdl_n432, cpphdl_n433) / 10000.0;
        // device 60, IC IC13, analog/basic/inverter.hpp:11
        I(cpphdl_n420, Vdd) <+ cpphdl_channel(V(BIT_N0_5, Vdd), V(cpphdl_n420, Vdd), 0.080000000000000002, 0.69999999999999996, -1.0);
        // device 61, IC IC13, analog/basic/inverter.hpp:12
        I(cpphdl_n420, Vss) <+ cpphdl_channel(V(BIT_N0_5, Vss), V(cpphdl_n420, Vss), 0.080000000000000002, 0.69999999999999996, 1.0);
        // device 62, IC IC7, analog/basic/mos_r2r_dac.hpp:27
        I(cpphdl_n420, Vss) <+ 2.9999999999999998e-15 * ddt(V(cpphdl_n420, Vss)); // Bench initial voltage = 0.0 V.
        // device 63, IC IC7, analog/basic/mos_r2r_dac.hpp:28
        I(cpphdl_n420, cpphdl_n434) <+ V(cpphdl_n420, cpphdl_n434) / 20000.0;
        // device 64, IC IC7, analog/basic/mos_r2r_dac.hpp:29
        I(cpphdl_n434, Vss) <+ 2.9999999999999998e-15 * ddt(V(cpphdl_n434, Vss)); // Bench initial voltage = 0.0 V.
        // device 65, IC IC7, analog/basic/mos_r2r_dac.hpp:31
        I(cpphdl_n433, cpphdl_n434) <+ V(cpphdl_n433, cpphdl_n434) / 10000.0;
        // device 66, IC IC14, analog/basic/inverter.hpp:11
        I(cpphdl_n424, Vdd) <+ cpphdl_channel(V(BIT_N0_6, Vdd), V(cpphdl_n424, Vdd), 0.080000000000000002, 0.69999999999999996, -1.0);
        // device 67, IC IC14, analog/basic/inverter.hpp:12
        I(cpphdl_n424, Vss) <+ cpphdl_channel(V(BIT_N0_6, Vss), V(cpphdl_n424, Vss), 0.080000000000000002, 0.69999999999999996, 1.0);
        // device 68, IC IC7, analog/basic/mos_r2r_dac.hpp:27
        I(cpphdl_n424, Vss) <+ 2.9999999999999998e-15 * ddt(V(cpphdl_n424, Vss)); // Bench initial voltage = 0.0 V.
        // device 69, IC IC7, analog/basic/mos_r2r_dac.hpp:28
        I(cpphdl_n424, cpphdl_n435) <+ V(cpphdl_n424, cpphdl_n435) / 20000.0;
        // device 70, IC IC7, analog/basic/mos_r2r_dac.hpp:29
        I(cpphdl_n435, Vss) <+ 2.9999999999999998e-15 * ddt(V(cpphdl_n435, Vss)); // Bench initial voltage = 0.0 V.
        // device 71, IC IC7, analog/basic/mos_r2r_dac.hpp:31
        I(cpphdl_n434, cpphdl_n435) <+ V(cpphdl_n434, cpphdl_n435) / 10000.0;
        // device 72, IC IC15, analog/basic/inverter.hpp:11
        I(cpphdl_n428, Vdd) <+ cpphdl_channel(V(BIT_N0_7, Vdd), V(cpphdl_n428, Vdd), 0.080000000000000002, 0.69999999999999996, -1.0);
        // device 73, IC IC15, analog/basic/inverter.hpp:12
        I(cpphdl_n428, Vss) <+ cpphdl_channel(V(BIT_N0_7, Vss), V(cpphdl_n428, Vss), 0.080000000000000002, 0.69999999999999996, 1.0);
        // device 74, IC IC7, analog/basic/mos_r2r_dac.hpp:27
        I(cpphdl_n428, Vss) <+ 2.9999999999999998e-15 * ddt(V(cpphdl_n428, Vss)); // Bench initial voltage = 0.0 V.
        // device 75, IC IC7, analog/basic/mos_r2r_dac.hpp:28
        I(cpphdl_n428, cpphdl_n440) <+ V(cpphdl_n428, cpphdl_n440) / 20000.0;
        // device 76, IC IC7, analog/basic/mos_r2r_dac.hpp:29
        I(cpphdl_n440, Vss) <+ 2.9999999999999998e-15 * ddt(V(cpphdl_n440, Vss)); // Bench initial voltage = 0.0 V.
        // device 77, IC IC7, analog/basic/mos_r2r_dac.hpp:31
        I(cpphdl_n435, cpphdl_n440) <+ V(cpphdl_n435, cpphdl_n440) / 10000.0;
        // device 78, IC IC7, analog/basic/mos_r2r_dac.hpp:33
        I(Vss, cpphdl_n429) <+ V(Vss, cpphdl_n429) / 20000.0;
        // device 79, IC IC16, analog/basic/nmos_resistor_amplifier.hpp:23
        I(Vdd, cpphdl_n449) <+ V(Vdd, cpphdl_n449) / 1000.0;
        // device 80, IC IC16, analog/basic/nmos_resistor_amplifier.hpp:24
        I(Vdd, cpphdl_n448) <+ V(Vdd, cpphdl_n448) / 1000.0;
        // device 81, IC IC16, analog/basic/nmos_resistor_amplifier.hpp:25
        I(cpphdl_n449, cpphdl_n443) <+ cpphdl_channel(V(cpphdl_n439, cpphdl_n443), V(cpphdl_n449, cpphdl_n443), 0.014999999999999999, 0.69999999999999996, 1.0);
        // device 82, IC IC16, analog/basic/nmos_resistor_amplifier.hpp:26
        I(cpphdl_n448, cpphdl_n444) <+ cpphdl_channel(V(cpphdl_n440, cpphdl_n444), V(cpphdl_n448, cpphdl_n444), 0.014999999999999999, 0.69999999999999996, 1.0);
        // device 83, IC IC16, analog/basic/nmos_resistor_amplifier.hpp:27
        I(cpphdl_n445, cpphdl_n443) <+ V(cpphdl_n445, cpphdl_n443) / 50.0;
        // device 84, IC IC16, analog/basic/nmos_resistor_amplifier.hpp:28
        I(cpphdl_n445, cpphdl_n444) <+ V(cpphdl_n445, cpphdl_n444) / 50.0;
        // device 85, IC IC16, analog/basic/nmos_resistor_amplifier.hpp:29
        I(Vss, cpphdl_n445) <+ V(Vss, cpphdl_n445) / 150.0;
        // device 86, IC IC16, analog/basic/nmos_resistor_amplifier.hpp:30
        I(cpphdl_n449, Vdd) <+ 2.9999999999999998e-13 * ddt(V(cpphdl_n449, Vdd)); // Bench initial voltage = 0.0 V.
        // device 87, IC IC16, analog/basic/nmos_resistor_amplifier.hpp:31
        I(cpphdl_n448, Vdd) <+ 2.9999999999999998e-13 * ddt(V(cpphdl_n448, Vdd)); // Bench initial voltage = 0.0 V.
        // device 88, IC IC16, analog/basic/nmos_resistor_amplifier.hpp:32
        I(cpphdl_n445, Vss) <+ 4e-14 * ddt(V(cpphdl_n445, Vss)); // Bench initial voltage = 0.0 V.
        // device 89, IC IC16, analog/basic/nmos_resistor_amplifier.hpp:34
        I(cpphdl_n439, cpphdl_n443) <+ 2e-14 * ddt(V(cpphdl_n439, cpphdl_n443)); // Bench initial voltage = 1.6499999999999999 V.
        // device 90, IC IC16, analog/basic/nmos_resistor_amplifier.hpp:35
        I(cpphdl_n440, cpphdl_n444) <+ 2e-14 * ddt(V(cpphdl_n440, cpphdl_n444)); // Bench initial voltage = 0.0 V.
        // device 91, IC IC16, analog/basic/nmos_resistor_amplifier.hpp:36
        I(cpphdl_n439, cpphdl_n449) <+ 2.9999999999999998e-15 * ddt(V(cpphdl_n439, cpphdl_n449)); // Bench initial voltage = -1.6499999999999999 V.
        // device 92, IC IC16, analog/basic/nmos_resistor_amplifier.hpp:37
        I(cpphdl_n440, cpphdl_n448) <+ 2.9999999999999998e-15 * ddt(V(cpphdl_n440, cpphdl_n448)); // Bench initial voltage = -3.2999999999999998 V.
        // device 93, IC IC17, analog/basic/strongarm_comparator.hpp:28
        I(cpphdl_n453, cpphdl_n455) <+ cpphdl_channel(V(cpphdl_n448, cpphdl_n455), V(cpphdl_n453, cpphdl_n455), 0.0080000000000000002, 0.69999999999999996, 1.0);
        // device 94, IC IC17, analog/basic/strongarm_comparator.hpp:29
        I(cpphdl_n454, cpphdl_n455) <+ cpphdl_channel(V(cpphdl_n449, cpphdl_n455), V(cpphdl_n454, cpphdl_n455), 0.0080000000000000002, 0.69999999999999996, 1.0);
        // device 95, IC IC17, analog/basic/strongarm_comparator.hpp:30
        I(cpphdl_n455, Vss) <+ cpphdl_channel(V(EVALUATE, Vss), V(cpphdl_n455, Vss), 0.0080000000000000002, 0.69999999999999996, 1.0);
        // device 96, IC IC17, analog/basic/strongarm_comparator.hpp:33
        I(cpphdl_n467, cpphdl_n453) <+ cpphdl_channel(V(cpphdl_n473, cpphdl_n453), V(cpphdl_n467, cpphdl_n453), 0.0040000000000000001, 0.69999999999999996, 1.0);
        // device 97, IC IC17, analog/basic/strongarm_comparator.hpp:34
        I(cpphdl_n473, cpphdl_n454) <+ cpphdl_channel(V(cpphdl_n467, cpphdl_n454), V(cpphdl_n473, cpphdl_n454), 0.0040000000000000001, 0.69999999999999996, 1.0);
        // device 98, IC IC17, analog/basic/strongarm_comparator.hpp:35
        I(cpphdl_n473, Vdd) <+ cpphdl_channel(V(cpphdl_n467, Vdd), V(cpphdl_n473, Vdd), 0.002, 0.69999999999999996, -1.0);
        // device 99, IC IC17, analog/basic/strongarm_comparator.hpp:36
        I(cpphdl_n467, Vdd) <+ cpphdl_channel(V(cpphdl_n473, Vdd), V(cpphdl_n467, Vdd), 0.002, 0.69999999999999996, -1.0);
        // device 100, IC IC17, analog/basic/strongarm_comparator.hpp:38
        I(cpphdl_n453, Vdd) <+ cpphdl_channel(V(EVALUATE, Vdd), V(cpphdl_n453, Vdd), 0.002, 0.69999999999999996, -1.0);
        // device 101, IC IC17, analog/basic/strongarm_comparator.hpp:39
        I(cpphdl_n454, Vdd) <+ cpphdl_channel(V(EVALUATE, Vdd), V(cpphdl_n454, Vdd), 0.002, 0.69999999999999996, -1.0);
        // device 102, IC IC17, analog/basic/strongarm_comparator.hpp:40
        I(cpphdl_n473, Vdd) <+ cpphdl_channel(V(EVALUATE, Vdd), V(cpphdl_n473, Vdd), 0.002, 0.69999999999999996, -1.0);
        // device 103, IC IC17, analog/basic/strongarm_comparator.hpp:41
        I(cpphdl_n467, Vdd) <+ cpphdl_channel(V(EVALUATE, Vdd), V(cpphdl_n467, Vdd), 0.002, 0.69999999999999996, -1.0);
        // device 104, IC IC17, analog/basic/strongarm_comparator.hpp:42
        I(cpphdl_n453, Vss) <+ 2.9999999999999998e-14 * ddt(V(cpphdl_n453, Vss)); // Bench initial voltage = 0.0 V.
        // device 105, IC IC17, analog/basic/strongarm_comparator.hpp:43
        I(cpphdl_n454, Vss) <+ 2.9999999999999998e-14 * ddt(V(cpphdl_n454, Vss)); // Bench initial voltage = 0.0 V.
        // device 106, IC IC17, analog/basic/strongarm_comparator.hpp:44
        I(cpphdl_n455, Vss) <+ 2.9999999999999998e-14 * ddt(V(cpphdl_n455, Vss)); // Bench initial voltage = 0.0 V.
        // device 107, IC IC17, analog/basic/strongarm_comparator.hpp:45
        I(cpphdl_n473, Vss) <+ 5.0000000000000002e-14 * ddt(V(cpphdl_n473, Vss)); // Bench initial voltage = 0.0 V.
        // device 108, IC IC17, analog/basic/strongarm_comparator.hpp:46
        I(cpphdl_n467, Vss) <+ 5.0000000000000002e-14 * ddt(V(cpphdl_n467, Vss)); // Bench initial voltage = 0.0 V.
        // device 109, IC IC17, analog/basic/strongarm_comparator.hpp:47
        I(cpphdl_n448, cpphdl_n455) <+ 2e-14 * ddt(V(cpphdl_n448, cpphdl_n455)); // Bench initial voltage = 3.2999999999999998 V.
        // device 110, IC IC17, analog/basic/strongarm_comparator.hpp:48
        I(cpphdl_n449, cpphdl_n455) <+ 2e-14 * ddt(V(cpphdl_n449, cpphdl_n455)); // Bench initial voltage = 3.2999999999999998 V.
        // device 111, IC IC17, analog/basic/strongarm_comparator.hpp:49
        I(cpphdl_n448, cpphdl_n453) <+ 2.9999999999999998e-15 * ddt(V(cpphdl_n448, cpphdl_n453)); // Bench initial voltage = 3.2999999999999998 V.
        // device 112, IC IC17, analog/basic/strongarm_comparator.hpp:50
        I(cpphdl_n449, cpphdl_n454) <+ 2.9999999999999998e-15 * ddt(V(cpphdl_n449, cpphdl_n454)); // Bench initial voltage = 3.2999999999999998 V.
        // device 113, IC IC19, analog/basic/cmos_logic.hpp:15
        I(cpphdl_n2301, Vss) <+ 5.0000000000000002e-14 * ddt(V(cpphdl_n2301, Vss)); // Bench initial voltage = 0.0 V.
        // device 114, IC IC19, analog/basic/cmos_logic.hpp:16
        I(cpphdl_n2301, Vdd) <+ cpphdl_channel(V(cpphdl_n467, Vdd), V(cpphdl_n2301, Vdd), 0.01, 0.69999999999999996, -1.0);
        // device 115, IC IC19, analog/basic/cmos_logic.hpp:17
        I(cpphdl_n2301, Vdd) <+ cpphdl_channel(V(cpphdl_n475, Vdd), V(cpphdl_n2301, Vdd), 0.01, 0.69999999999999996, -1.0);
        // device 116, IC IC19, analog/basic/cmos_logic.hpp:18
        I(cpphdl_n2301, cpphdl_n470) <+ cpphdl_channel(V(cpphdl_n467, cpphdl_n470), V(cpphdl_n2301, cpphdl_n470), 0.01, 0.69999999999999996, 1.0);
        // device 117, IC IC19, analog/basic/cmos_logic.hpp:19
        I(cpphdl_n470, Vss) <+ cpphdl_channel(V(cpphdl_n475, Vss), V(cpphdl_n470, Vss), 0.01, 0.69999999999999996, 1.0);
        // device 118, IC IC19, analog/basic/cmos_logic.hpp:20
        I(cpphdl_n2301, Vss) <+ V(cpphdl_n2301, Vss) / 1000000000.0;
        // device 119, IC IC19, analog/basic/cmos_logic.hpp:21
        I(cpphdl_n470, Vss) <+ V(cpphdl_n470, Vss) / 1000000000.0;
        // device 120, IC IC20, analog/basic/cmos_logic.hpp:15
        I(cpphdl_n475, Vss) <+ 5.0000000000000002e-14 * ddt(V(cpphdl_n475, Vss)); // Bench initial voltage = 0.0 V.
        // device 121, IC IC20, analog/basic/cmos_logic.hpp:16
        I(cpphdl_n475, Vdd) <+ cpphdl_channel(V(cpphdl_n473, Vdd), V(cpphdl_n475, Vdd), 0.01, 0.69999999999999996, -1.0);
        // device 122, IC IC20, analog/basic/cmos_logic.hpp:17
        I(cpphdl_n475, Vdd) <+ cpphdl_channel(V(cpphdl_n2301, Vdd), V(cpphdl_n475, Vdd), 0.01, 0.69999999999999996, -1.0);
        // device 123, IC IC20, analog/basic/cmos_logic.hpp:18
        I(cpphdl_n475, cpphdl_n476) <+ cpphdl_channel(V(cpphdl_n473, cpphdl_n476), V(cpphdl_n475, cpphdl_n476), 0.01, 0.69999999999999996, 1.0);
        // device 124, IC IC20, analog/basic/cmos_logic.hpp:19
        I(cpphdl_n476, Vss) <+ cpphdl_channel(V(cpphdl_n2301, Vss), V(cpphdl_n476, Vss), 0.01, 0.69999999999999996, 1.0);
        // device 125, IC IC20, analog/basic/cmos_logic.hpp:20
        I(cpphdl_n475, Vss) <+ V(cpphdl_n475, Vss) / 1000000000.0;
        // device 126, IC IC20, analog/basic/cmos_logic.hpp:21
        I(cpphdl_n476, Vss) <+ V(cpphdl_n476, Vss) / 1000000000.0;
        // device 127, IC IC18, analog/basic/nand_latch.hpp:34
        I(cpphdl_n467, Vss) <+ 2.9999999999999998e-15 * ddt(V(cpphdl_n467, Vss)); // Bench initial voltage = 0.0 V.
        // device 128, IC IC18, analog/basic/nand_latch.hpp:35
        I(cpphdl_n473, Vss) <+ 2.9999999999999998e-15 * ddt(V(cpphdl_n473, Vss)); // Bench initial voltage = 0.0 V.
        // device 129, IC IC21, analog/basic/inverter.hpp:11
        I(cpphdl_n481, Vdd) <+ cpphdl_channel(V(CLEAR, Vdd), V(cpphdl_n481, Vdd), 0.01, 0.69999999999999996, -1.0);
        // device 130, IC IC21, analog/basic/inverter.hpp:12
        I(cpphdl_n481, Vss) <+ cpphdl_channel(V(CLEAR, Vss), V(cpphdl_n481, Vss), 0.01, 0.69999999999999996, 1.0);
        // device 131, IC IC18, analog/basic/nand_latch.hpp:56
        I(cpphdl_n481, Vss) <+ 2.9999999999999998e-15 * ddt(V(cpphdl_n481, Vss)); // Bench initial voltage = 0.0 V.
        // device 132, IC IC18, analog/basic/nand_latch.hpp:57
        I(cpphdl_n2301, Vss) <+ cpphdl_channel(V(CLEAR, Vss), V(cpphdl_n2301, Vss), 0.050000000000000003, 0.69999999999999996, 1.0);
        // device 133, IC IC18, analog/basic/nand_latch.hpp:58
        I(cpphdl_n475, Vdd) <+ cpphdl_channel(V(cpphdl_n481, Vdd), V(cpphdl_n475, Vdd), 0.050000000000000003, 0.69999999999999996, -1.0);
        // device 134, IC IC24, analog/basic/inverter.hpp:11
        I(cpphdl_n505, Vdd) <+ cpphdl_channel(V(TRACK1, Vdd), V(cpphdl_n505, Vdd), 0.0040000000000000001, 0.69999999999999996, -1.0);
        // device 135, IC IC24, analog/basic/inverter.hpp:12
        I(cpphdl_n505, Vss) <+ cpphdl_channel(V(TRACK1, Vss), V(cpphdl_n505, Vss), 0.0040000000000000001, 0.69999999999999996, 1.0);
        // device 136, IC IC23, analog/basic/mos_track_hold.hpp:30
        I(cpphdl_n505, Vss) <+ 2e-14 * ddt(V(cpphdl_n505, Vss)); // Bench initial voltage = 3.2999999999999998 V.
        // device 137, IC IC23, analog/basic/mos_track_hold.hpp:31
        I(cpphdl_n2179, cpphdl_n559) <+ cpphdl_channel(V(TRACK1, cpphdl_n559), V(cpphdl_n2179, cpphdl_n559), 0.080000000000000002, 0.69999999999999996, 1.0);
        // device 138, IC IC23, analog/basic/mos_track_hold.hpp:32
        I(cpphdl_n559, cpphdl_n2179) <+ cpphdl_channel(V(cpphdl_n505, cpphdl_n2179), V(cpphdl_n559, cpphdl_n2179), 0.040000000000000001, 0.69999999999999996, -1.0);
        // device 139, IC IC23, analog/basic/mos_track_hold.hpp:36
        I(cpphdl_n559, cpphdl_n559) <+ cpphdl_channel(V(cpphdl_n505, cpphdl_n559), V(cpphdl_n559, cpphdl_n559), 0.040000000000000001, 0.69999999999999996, 1.0);
        // device 140, IC IC23, analog/basic/mos_track_hold.hpp:37
        I(cpphdl_n559, cpphdl_n559) <+ cpphdl_channel(V(TRACK1, cpphdl_n559), V(cpphdl_n559, cpphdl_n559), 0.02, 0.69999999999999996, -1.0);
        // device 141, IC IC23, analog/basic/mos_track_hold.hpp:38
        I(cpphdl_n559, Vss) <+ 2e-12 * ddt(V(cpphdl_n559, Vss)); // Bench initial voltage = 1.6499999999999999 V.
        // device 142, IC IC23, analog/basic/mos_track_hold.hpp:39
        I(Vss, cpphdl_n559) <+ V(Vss, cpphdl_n559) / 1000000000.0;
        // device 143, IC IC23, analog/basic/mos_track_hold.hpp:40
        I(TRACK1, cpphdl_n559) <+ 8.0000000000000006e-15 * ddt(V(TRACK1, cpphdl_n559)); // Bench initial voltage = -1.6499999999999999 V.
        // device 144, IC IC23, analog/basic/mos_track_hold.hpp:41
        I(cpphdl_n505, cpphdl_n559) <+ 8.0000000000000006e-15 * ddt(V(cpphdl_n505, cpphdl_n559)); // Bench initial voltage = 1.6499999999999999 V.
        // device 145, IC IC23, analog/basic/mos_track_hold.hpp:42
        I(cpphdl_n2179, cpphdl_n559) <+ 4.0000000000000003e-15 * ddt(V(cpphdl_n2179, cpphdl_n559)); // Bench initial voltage = 0.0 V.
        // device 146, IC IC26, analog/basic/inverter.hpp:11
        I(cpphdl_n520, Vdd) <+ cpphdl_channel(V(BIT_N1_0, Vdd), V(cpphdl_n520, Vdd), 0.080000000000000002, 0.69999999999999996, -1.0);
        // device 147, IC IC26, analog/basic/inverter.hpp:12
        I(cpphdl_n520, Vss) <+ cpphdl_channel(V(BIT_N1_0, Vss), V(cpphdl_n520, Vss), 0.080000000000000002, 0.69999999999999996, 1.0);
        // device 148, IC IC25, analog/basic/mos_r2r_dac.hpp:27
        I(cpphdl_n520, Vss) <+ 2.9999999999999998e-15 * ddt(V(cpphdl_n520, Vss)); // Bench initial voltage = 0.0 V.
        // device 149, IC IC25, analog/basic/mos_r2r_dac.hpp:28
        I(cpphdl_n520, cpphdl_n549) <+ V(cpphdl_n520, cpphdl_n549) / 20000.0;
        // device 150, IC IC25, analog/basic/mos_r2r_dac.hpp:29
        I(cpphdl_n549, Vss) <+ 2.9999999999999998e-15 * ddt(V(cpphdl_n549, Vss)); // Bench initial voltage = 0.0 V.
        // device 151, IC IC27, analog/basic/inverter.hpp:11
        I(cpphdl_n524, Vdd) <+ cpphdl_channel(V(BIT_N1_1, Vdd), V(cpphdl_n524, Vdd), 0.080000000000000002, 0.69999999999999996, -1.0);
        // device 152, IC IC27, analog/basic/inverter.hpp:12
        I(cpphdl_n524, Vss) <+ cpphdl_channel(V(BIT_N1_1, Vss), V(cpphdl_n524, Vss), 0.080000000000000002, 0.69999999999999996, 1.0);
        // device 153, IC IC25, analog/basic/mos_r2r_dac.hpp:27
        I(cpphdl_n524, Vss) <+ 2.9999999999999998e-15 * ddt(V(cpphdl_n524, Vss)); // Bench initial voltage = 0.0 V.
        // device 154, IC IC25, analog/basic/mos_r2r_dac.hpp:28
        I(cpphdl_n524, cpphdl_n550) <+ V(cpphdl_n524, cpphdl_n550) / 20000.0;
        // device 155, IC IC25, analog/basic/mos_r2r_dac.hpp:29
        I(cpphdl_n550, Vss) <+ 2.9999999999999998e-15 * ddt(V(cpphdl_n550, Vss)); // Bench initial voltage = 0.0 V.
        // device 156, IC IC25, analog/basic/mos_r2r_dac.hpp:31
        I(cpphdl_n549, cpphdl_n550) <+ V(cpphdl_n549, cpphdl_n550) / 10000.0;
        // device 157, IC IC28, analog/basic/inverter.hpp:11
        I(cpphdl_n528, Vdd) <+ cpphdl_channel(V(BIT_N1_2, Vdd), V(cpphdl_n528, Vdd), 0.080000000000000002, 0.69999999999999996, -1.0);
        // device 158, IC IC28, analog/basic/inverter.hpp:12
        I(cpphdl_n528, Vss) <+ cpphdl_channel(V(BIT_N1_2, Vss), V(cpphdl_n528, Vss), 0.080000000000000002, 0.69999999999999996, 1.0);
        // device 159, IC IC25, analog/basic/mos_r2r_dac.hpp:27
        I(cpphdl_n528, Vss) <+ 2.9999999999999998e-15 * ddt(V(cpphdl_n528, Vss)); // Bench initial voltage = 0.0 V.
        // device 160, IC IC25, analog/basic/mos_r2r_dac.hpp:28
        I(cpphdl_n528, cpphdl_n551) <+ V(cpphdl_n528, cpphdl_n551) / 20000.0;
        // device 161, IC IC25, analog/basic/mos_r2r_dac.hpp:29
        I(cpphdl_n551, Vss) <+ 2.9999999999999998e-15 * ddt(V(cpphdl_n551, Vss)); // Bench initial voltage = 0.0 V.
        // device 162, IC IC25, analog/basic/mos_r2r_dac.hpp:31
        I(cpphdl_n550, cpphdl_n551) <+ V(cpphdl_n550, cpphdl_n551) / 10000.0;
        // device 163, IC IC29, analog/basic/inverter.hpp:11
        I(cpphdl_n532, Vdd) <+ cpphdl_channel(V(BIT_N1_3, Vdd), V(cpphdl_n532, Vdd), 0.080000000000000002, 0.69999999999999996, -1.0);
        // device 164, IC IC29, analog/basic/inverter.hpp:12
        I(cpphdl_n532, Vss) <+ cpphdl_channel(V(BIT_N1_3, Vss), V(cpphdl_n532, Vss), 0.080000000000000002, 0.69999999999999996, 1.0);
        // device 165, IC IC25, analog/basic/mos_r2r_dac.hpp:27
        I(cpphdl_n532, Vss) <+ 2.9999999999999998e-15 * ddt(V(cpphdl_n532, Vss)); // Bench initial voltage = 0.0 V.
        // device 166, IC IC25, analog/basic/mos_r2r_dac.hpp:28
        I(cpphdl_n532, cpphdl_n552) <+ V(cpphdl_n532, cpphdl_n552) / 20000.0;
        // device 167, IC IC25, analog/basic/mos_r2r_dac.hpp:29
        I(cpphdl_n552, Vss) <+ 2.9999999999999998e-15 * ddt(V(cpphdl_n552, Vss)); // Bench initial voltage = 0.0 V.
        // device 168, IC IC25, analog/basic/mos_r2r_dac.hpp:31
        I(cpphdl_n551, cpphdl_n552) <+ V(cpphdl_n551, cpphdl_n552) / 10000.0;
        // device 169, IC IC30, analog/basic/inverter.hpp:11
        I(cpphdl_n536, Vdd) <+ cpphdl_channel(V(BIT_N1_4, Vdd), V(cpphdl_n536, Vdd), 0.080000000000000002, 0.69999999999999996, -1.0);
        // device 170, IC IC30, analog/basic/inverter.hpp:12
        I(cpphdl_n536, Vss) <+ cpphdl_channel(V(BIT_N1_4, Vss), V(cpphdl_n536, Vss), 0.080000000000000002, 0.69999999999999996, 1.0);
        // device 171, IC IC25, analog/basic/mos_r2r_dac.hpp:27
        I(cpphdl_n536, Vss) <+ 2.9999999999999998e-15 * ddt(V(cpphdl_n536, Vss)); // Bench initial voltage = 0.0 V.
        // device 172, IC IC25, analog/basic/mos_r2r_dac.hpp:28
        I(cpphdl_n536, cpphdl_n553) <+ V(cpphdl_n536, cpphdl_n553) / 20000.0;
        // device 173, IC IC25, analog/basic/mos_r2r_dac.hpp:29
        I(cpphdl_n553, Vss) <+ 2.9999999999999998e-15 * ddt(V(cpphdl_n553, Vss)); // Bench initial voltage = 0.0 V.
        // device 174, IC IC25, analog/basic/mos_r2r_dac.hpp:31
        I(cpphdl_n552, cpphdl_n553) <+ V(cpphdl_n552, cpphdl_n553) / 10000.0;
        // device 175, IC IC31, analog/basic/inverter.hpp:11
        I(cpphdl_n540, Vdd) <+ cpphdl_channel(V(BIT_N1_5, Vdd), V(cpphdl_n540, Vdd), 0.080000000000000002, 0.69999999999999996, -1.0);
        // device 176, IC IC31, analog/basic/inverter.hpp:12
        I(cpphdl_n540, Vss) <+ cpphdl_channel(V(BIT_N1_5, Vss), V(cpphdl_n540, Vss), 0.080000000000000002, 0.69999999999999996, 1.0);
        // device 177, IC IC25, analog/basic/mos_r2r_dac.hpp:27
        I(cpphdl_n540, Vss) <+ 2.9999999999999998e-15 * ddt(V(cpphdl_n540, Vss)); // Bench initial voltage = 0.0 V.
        // device 178, IC IC25, analog/basic/mos_r2r_dac.hpp:28
        I(cpphdl_n540, cpphdl_n554) <+ V(cpphdl_n540, cpphdl_n554) / 20000.0;
        // device 179, IC IC25, analog/basic/mos_r2r_dac.hpp:29
        I(cpphdl_n554, Vss) <+ 2.9999999999999998e-15 * ddt(V(cpphdl_n554, Vss)); // Bench initial voltage = 0.0 V.
        // device 180, IC IC25, analog/basic/mos_r2r_dac.hpp:31
        I(cpphdl_n553, cpphdl_n554) <+ V(cpphdl_n553, cpphdl_n554) / 10000.0;
        // device 181, IC IC32, analog/basic/inverter.hpp:11
        I(cpphdl_n544, Vdd) <+ cpphdl_channel(V(BIT_N1_6, Vdd), V(cpphdl_n544, Vdd), 0.080000000000000002, 0.69999999999999996, -1.0);
        // device 182, IC IC32, analog/basic/inverter.hpp:12
        I(cpphdl_n544, Vss) <+ cpphdl_channel(V(BIT_N1_6, Vss), V(cpphdl_n544, Vss), 0.080000000000000002, 0.69999999999999996, 1.0);
        // device 183, IC IC25, analog/basic/mos_r2r_dac.hpp:27
        I(cpphdl_n544, Vss) <+ 2.9999999999999998e-15 * ddt(V(cpphdl_n544, Vss)); // Bench initial voltage = 0.0 V.
        // device 184, IC IC25, analog/basic/mos_r2r_dac.hpp:28
        I(cpphdl_n544, cpphdl_n555) <+ V(cpphdl_n544, cpphdl_n555) / 20000.0;
        // device 185, IC IC25, analog/basic/mos_r2r_dac.hpp:29
        I(cpphdl_n555, Vss) <+ 2.9999999999999998e-15 * ddt(V(cpphdl_n555, Vss)); // Bench initial voltage = 0.0 V.
        // device 186, IC IC25, analog/basic/mos_r2r_dac.hpp:31
        I(cpphdl_n554, cpphdl_n555) <+ V(cpphdl_n554, cpphdl_n555) / 10000.0;
        // device 187, IC IC33, analog/basic/inverter.hpp:11
        I(cpphdl_n548, Vdd) <+ cpphdl_channel(V(BIT_N1_7, Vdd), V(cpphdl_n548, Vdd), 0.080000000000000002, 0.69999999999999996, -1.0);
        // device 188, IC IC33, analog/basic/inverter.hpp:12
        I(cpphdl_n548, Vss) <+ cpphdl_channel(V(BIT_N1_7, Vss), V(cpphdl_n548, Vss), 0.080000000000000002, 0.69999999999999996, 1.0);
        // device 189, IC IC25, analog/basic/mos_r2r_dac.hpp:27
        I(cpphdl_n548, Vss) <+ 2.9999999999999998e-15 * ddt(V(cpphdl_n548, Vss)); // Bench initial voltage = 0.0 V.
        // device 190, IC IC25, analog/basic/mos_r2r_dac.hpp:28
        I(cpphdl_n548, cpphdl_n560) <+ V(cpphdl_n548, cpphdl_n560) / 20000.0;
        // device 191, IC IC25, analog/basic/mos_r2r_dac.hpp:29
        I(cpphdl_n560, Vss) <+ 2.9999999999999998e-15 * ddt(V(cpphdl_n560, Vss)); // Bench initial voltage = 0.0 V.
        // device 192, IC IC25, analog/basic/mos_r2r_dac.hpp:31
        I(cpphdl_n555, cpphdl_n560) <+ V(cpphdl_n555, cpphdl_n560) / 10000.0;
        // device 193, IC IC25, analog/basic/mos_r2r_dac.hpp:33
        I(Vss, cpphdl_n549) <+ V(Vss, cpphdl_n549) / 20000.0;
        // device 194, IC IC34, analog/basic/nmos_resistor_amplifier.hpp:23
        I(Vdd, cpphdl_n569) <+ V(Vdd, cpphdl_n569) / 1000.0;
        // device 195, IC IC34, analog/basic/nmos_resistor_amplifier.hpp:24
        I(Vdd, cpphdl_n568) <+ V(Vdd, cpphdl_n568) / 1000.0;
        // device 196, IC IC34, analog/basic/nmos_resistor_amplifier.hpp:25
        I(cpphdl_n569, cpphdl_n563) <+ cpphdl_channel(V(cpphdl_n559, cpphdl_n563), V(cpphdl_n569, cpphdl_n563), 0.014999999999999999, 0.69999999999999996, 1.0);
        // device 197, IC IC34, analog/basic/nmos_resistor_amplifier.hpp:26
        I(cpphdl_n568, cpphdl_n564) <+ cpphdl_channel(V(cpphdl_n560, cpphdl_n564), V(cpphdl_n568, cpphdl_n564), 0.014999999999999999, 0.69999999999999996, 1.0);
        // device 198, IC IC34, analog/basic/nmos_resistor_amplifier.hpp:27
        I(cpphdl_n565, cpphdl_n563) <+ V(cpphdl_n565, cpphdl_n563) / 50.0;
        // device 199, IC IC34, analog/basic/nmos_resistor_amplifier.hpp:28
        I(cpphdl_n565, cpphdl_n564) <+ V(cpphdl_n565, cpphdl_n564) / 50.0;
        // device 200, IC IC34, analog/basic/nmos_resistor_amplifier.hpp:29
        I(Vss, cpphdl_n565) <+ V(Vss, cpphdl_n565) / 150.0;
        // device 201, IC IC34, analog/basic/nmos_resistor_amplifier.hpp:30
        I(cpphdl_n569, Vdd) <+ 2.9999999999999998e-13 * ddt(V(cpphdl_n569, Vdd)); // Bench initial voltage = 0.0 V.
        // device 202, IC IC34, analog/basic/nmos_resistor_amplifier.hpp:31
        I(cpphdl_n568, Vdd) <+ 2.9999999999999998e-13 * ddt(V(cpphdl_n568, Vdd)); // Bench initial voltage = 0.0 V.
        // device 203, IC IC34, analog/basic/nmos_resistor_amplifier.hpp:32
        I(cpphdl_n565, Vss) <+ 4e-14 * ddt(V(cpphdl_n565, Vss)); // Bench initial voltage = 0.0 V.
        // device 204, IC IC34, analog/basic/nmos_resistor_amplifier.hpp:34
        I(cpphdl_n559, cpphdl_n563) <+ 2e-14 * ddt(V(cpphdl_n559, cpphdl_n563)); // Bench initial voltage = 1.6499999999999999 V.
        // device 205, IC IC34, analog/basic/nmos_resistor_amplifier.hpp:35
        I(cpphdl_n560, cpphdl_n564) <+ 2e-14 * ddt(V(cpphdl_n560, cpphdl_n564)); // Bench initial voltage = 0.0 V.
        // device 206, IC IC34, analog/basic/nmos_resistor_amplifier.hpp:36
        I(cpphdl_n559, cpphdl_n569) <+ 2.9999999999999998e-15 * ddt(V(cpphdl_n559, cpphdl_n569)); // Bench initial voltage = -1.6499999999999999 V.
        // device 207, IC IC34, analog/basic/nmos_resistor_amplifier.hpp:37
        I(cpphdl_n560, cpphdl_n568) <+ 2.9999999999999998e-15 * ddt(V(cpphdl_n560, cpphdl_n568)); // Bench initial voltage = -3.2999999999999998 V.
        // device 208, IC IC35, analog/basic/strongarm_comparator.hpp:28
        I(cpphdl_n573, cpphdl_n575) <+ cpphdl_channel(V(cpphdl_n568, cpphdl_n575), V(cpphdl_n573, cpphdl_n575), 0.0080000000000000002, 0.69999999999999996, 1.0);
        // device 209, IC IC35, analog/basic/strongarm_comparator.hpp:29
        I(cpphdl_n574, cpphdl_n575) <+ cpphdl_channel(V(cpphdl_n569, cpphdl_n575), V(cpphdl_n574, cpphdl_n575), 0.0080000000000000002, 0.69999999999999996, 1.0);
        // device 210, IC IC35, analog/basic/strongarm_comparator.hpp:30
        I(cpphdl_n575, Vss) <+ cpphdl_channel(V(EVALUATE, Vss), V(cpphdl_n575, Vss), 0.0080000000000000002, 0.69999999999999996, 1.0);
        // device 211, IC IC35, analog/basic/strongarm_comparator.hpp:33
        I(cpphdl_n587, cpphdl_n573) <+ cpphdl_channel(V(cpphdl_n593, cpphdl_n573), V(cpphdl_n587, cpphdl_n573), 0.0040000000000000001, 0.69999999999999996, 1.0);
        // device 212, IC IC35, analog/basic/strongarm_comparator.hpp:34
        I(cpphdl_n593, cpphdl_n574) <+ cpphdl_channel(V(cpphdl_n587, cpphdl_n574), V(cpphdl_n593, cpphdl_n574), 0.0040000000000000001, 0.69999999999999996, 1.0);
        // device 213, IC IC35, analog/basic/strongarm_comparator.hpp:35
        I(cpphdl_n593, Vdd) <+ cpphdl_channel(V(cpphdl_n587, Vdd), V(cpphdl_n593, Vdd), 0.002, 0.69999999999999996, -1.0);
        // device 214, IC IC35, analog/basic/strongarm_comparator.hpp:36
        I(cpphdl_n587, Vdd) <+ cpphdl_channel(V(cpphdl_n593, Vdd), V(cpphdl_n587, Vdd), 0.002, 0.69999999999999996, -1.0);
        // device 215, IC IC35, analog/basic/strongarm_comparator.hpp:38
        I(cpphdl_n573, Vdd) <+ cpphdl_channel(V(EVALUATE, Vdd), V(cpphdl_n573, Vdd), 0.002, 0.69999999999999996, -1.0);
        // device 216, IC IC35, analog/basic/strongarm_comparator.hpp:39
        I(cpphdl_n574, Vdd) <+ cpphdl_channel(V(EVALUATE, Vdd), V(cpphdl_n574, Vdd), 0.002, 0.69999999999999996, -1.0);
        // device 217, IC IC35, analog/basic/strongarm_comparator.hpp:40
        I(cpphdl_n593, Vdd) <+ cpphdl_channel(V(EVALUATE, Vdd), V(cpphdl_n593, Vdd), 0.002, 0.69999999999999996, -1.0);
        // device 218, IC IC35, analog/basic/strongarm_comparator.hpp:41
        I(cpphdl_n587, Vdd) <+ cpphdl_channel(V(EVALUATE, Vdd), V(cpphdl_n587, Vdd), 0.002, 0.69999999999999996, -1.0);
        // device 219, IC IC35, analog/basic/strongarm_comparator.hpp:42
        I(cpphdl_n573, Vss) <+ 2.9999999999999998e-14 * ddt(V(cpphdl_n573, Vss)); // Bench initial voltage = 0.0 V.
        // device 220, IC IC35, analog/basic/strongarm_comparator.hpp:43
        I(cpphdl_n574, Vss) <+ 2.9999999999999998e-14 * ddt(V(cpphdl_n574, Vss)); // Bench initial voltage = 0.0 V.
        // device 221, IC IC35, analog/basic/strongarm_comparator.hpp:44
        I(cpphdl_n575, Vss) <+ 2.9999999999999998e-14 * ddt(V(cpphdl_n575, Vss)); // Bench initial voltage = 0.0 V.
        // device 222, IC IC35, analog/basic/strongarm_comparator.hpp:45
        I(cpphdl_n593, Vss) <+ 5.0000000000000002e-14 * ddt(V(cpphdl_n593, Vss)); // Bench initial voltage = 0.0 V.
        // device 223, IC IC35, analog/basic/strongarm_comparator.hpp:46
        I(cpphdl_n587, Vss) <+ 5.0000000000000002e-14 * ddt(V(cpphdl_n587, Vss)); // Bench initial voltage = 0.0 V.
        // device 224, IC IC35, analog/basic/strongarm_comparator.hpp:47
        I(cpphdl_n568, cpphdl_n575) <+ 2e-14 * ddt(V(cpphdl_n568, cpphdl_n575)); // Bench initial voltage = 3.2999999999999998 V.
        // device 225, IC IC35, analog/basic/strongarm_comparator.hpp:48
        I(cpphdl_n569, cpphdl_n575) <+ 2e-14 * ddt(V(cpphdl_n569, cpphdl_n575)); // Bench initial voltage = 3.2999999999999998 V.
        // device 226, IC IC35, analog/basic/strongarm_comparator.hpp:49
        I(cpphdl_n568, cpphdl_n573) <+ 2.9999999999999998e-15 * ddt(V(cpphdl_n568, cpphdl_n573)); // Bench initial voltage = 3.2999999999999998 V.
        // device 227, IC IC35, analog/basic/strongarm_comparator.hpp:50
        I(cpphdl_n569, cpphdl_n574) <+ 2.9999999999999998e-15 * ddt(V(cpphdl_n569, cpphdl_n574)); // Bench initial voltage = 3.2999999999999998 V.
        // device 228, IC IC37, analog/basic/cmos_logic.hpp:15
        I(cpphdl_n2306, Vss) <+ 5.0000000000000002e-14 * ddt(V(cpphdl_n2306, Vss)); // Bench initial voltage = 0.0 V.
        // device 229, IC IC37, analog/basic/cmos_logic.hpp:16
        I(cpphdl_n2306, Vdd) <+ cpphdl_channel(V(cpphdl_n587, Vdd), V(cpphdl_n2306, Vdd), 0.01, 0.69999999999999996, -1.0);
        // device 230, IC IC37, analog/basic/cmos_logic.hpp:17
        I(cpphdl_n2306, Vdd) <+ cpphdl_channel(V(cpphdl_n595, Vdd), V(cpphdl_n2306, Vdd), 0.01, 0.69999999999999996, -1.0);
        // device 231, IC IC37, analog/basic/cmos_logic.hpp:18
        I(cpphdl_n2306, cpphdl_n590) <+ cpphdl_channel(V(cpphdl_n587, cpphdl_n590), V(cpphdl_n2306, cpphdl_n590), 0.01, 0.69999999999999996, 1.0);
        // device 232, IC IC37, analog/basic/cmos_logic.hpp:19
        I(cpphdl_n590, Vss) <+ cpphdl_channel(V(cpphdl_n595, Vss), V(cpphdl_n590, Vss), 0.01, 0.69999999999999996, 1.0);
        // device 233, IC IC37, analog/basic/cmos_logic.hpp:20
        I(cpphdl_n2306, Vss) <+ V(cpphdl_n2306, Vss) / 1000000000.0;
        // device 234, IC IC37, analog/basic/cmos_logic.hpp:21
        I(cpphdl_n590, Vss) <+ V(cpphdl_n590, Vss) / 1000000000.0;
        // device 235, IC IC38, analog/basic/cmos_logic.hpp:15
        I(cpphdl_n595, Vss) <+ 5.0000000000000002e-14 * ddt(V(cpphdl_n595, Vss)); // Bench initial voltage = 0.0 V.
        // device 236, IC IC38, analog/basic/cmos_logic.hpp:16
        I(cpphdl_n595, Vdd) <+ cpphdl_channel(V(cpphdl_n593, Vdd), V(cpphdl_n595, Vdd), 0.01, 0.69999999999999996, -1.0);
        // device 237, IC IC38, analog/basic/cmos_logic.hpp:17
        I(cpphdl_n595, Vdd) <+ cpphdl_channel(V(cpphdl_n2306, Vdd), V(cpphdl_n595, Vdd), 0.01, 0.69999999999999996, -1.0);
        // device 238, IC IC38, analog/basic/cmos_logic.hpp:18
        I(cpphdl_n595, cpphdl_n596) <+ cpphdl_channel(V(cpphdl_n593, cpphdl_n596), V(cpphdl_n595, cpphdl_n596), 0.01, 0.69999999999999996, 1.0);
        // device 239, IC IC38, analog/basic/cmos_logic.hpp:19
        I(cpphdl_n596, Vss) <+ cpphdl_channel(V(cpphdl_n2306, Vss), V(cpphdl_n596, Vss), 0.01, 0.69999999999999996, 1.0);
        // device 240, IC IC38, analog/basic/cmos_logic.hpp:20
        I(cpphdl_n595, Vss) <+ V(cpphdl_n595, Vss) / 1000000000.0;
        // device 241, IC IC38, analog/basic/cmos_logic.hpp:21
        I(cpphdl_n596, Vss) <+ V(cpphdl_n596, Vss) / 1000000000.0;
        // device 242, IC IC36, analog/basic/nand_latch.hpp:34
        I(cpphdl_n587, Vss) <+ 2.9999999999999998e-15 * ddt(V(cpphdl_n587, Vss)); // Bench initial voltage = 0.0 V.
        // device 243, IC IC36, analog/basic/nand_latch.hpp:35
        I(cpphdl_n593, Vss) <+ 2.9999999999999998e-15 * ddt(V(cpphdl_n593, Vss)); // Bench initial voltage = 0.0 V.
        // device 244, IC IC39, analog/basic/inverter.hpp:11
        I(cpphdl_n601, Vdd) <+ cpphdl_channel(V(CLEAR, Vdd), V(cpphdl_n601, Vdd), 0.01, 0.69999999999999996, -1.0);
        // device 245, IC IC39, analog/basic/inverter.hpp:12
        I(cpphdl_n601, Vss) <+ cpphdl_channel(V(CLEAR, Vss), V(cpphdl_n601, Vss), 0.01, 0.69999999999999996, 1.0);
        // device 246, IC IC36, analog/basic/nand_latch.hpp:56
        I(cpphdl_n601, Vss) <+ 2.9999999999999998e-15 * ddt(V(cpphdl_n601, Vss)); // Bench initial voltage = 0.0 V.
        // device 247, IC IC36, analog/basic/nand_latch.hpp:57
        I(cpphdl_n2306, Vss) <+ cpphdl_channel(V(CLEAR, Vss), V(cpphdl_n2306, Vss), 0.050000000000000003, 0.69999999999999996, 1.0);
        // device 248, IC IC36, analog/basic/nand_latch.hpp:58
        I(cpphdl_n595, Vdd) <+ cpphdl_channel(V(cpphdl_n601, Vdd), V(cpphdl_n595, Vdd), 0.050000000000000003, 0.69999999999999996, -1.0);
        // device 249, IC IC42, analog/basic/inverter.hpp:11
        I(cpphdl_n625, Vdd) <+ cpphdl_channel(V(TRACK2, Vdd), V(cpphdl_n625, Vdd), 0.0040000000000000001, 0.69999999999999996, -1.0);
        // device 250, IC IC42, analog/basic/inverter.hpp:12
        I(cpphdl_n625, Vss) <+ cpphdl_channel(V(TRACK2, Vss), V(cpphdl_n625, Vss), 0.0040000000000000001, 0.69999999999999996, 1.0);
        // device 251, IC IC41, analog/basic/mos_track_hold.hpp:30
        I(cpphdl_n625, Vss) <+ 2e-14 * ddt(V(cpphdl_n625, Vss)); // Bench initial voltage = 3.2999999999999998 V.
        // device 252, IC IC41, analog/basic/mos_track_hold.hpp:31
        I(cpphdl_n2179, cpphdl_n679) <+ cpphdl_channel(V(TRACK2, cpphdl_n679), V(cpphdl_n2179, cpphdl_n679), 0.080000000000000002, 0.69999999999999996, 1.0);
        // device 253, IC IC41, analog/basic/mos_track_hold.hpp:32
        I(cpphdl_n679, cpphdl_n2179) <+ cpphdl_channel(V(cpphdl_n625, cpphdl_n2179), V(cpphdl_n679, cpphdl_n2179), 0.040000000000000001, 0.69999999999999996, -1.0);
        // device 254, IC IC41, analog/basic/mos_track_hold.hpp:36
        I(cpphdl_n679, cpphdl_n679) <+ cpphdl_channel(V(cpphdl_n625, cpphdl_n679), V(cpphdl_n679, cpphdl_n679), 0.040000000000000001, 0.69999999999999996, 1.0);
        // device 255, IC IC41, analog/basic/mos_track_hold.hpp:37
        I(cpphdl_n679, cpphdl_n679) <+ cpphdl_channel(V(TRACK2, cpphdl_n679), V(cpphdl_n679, cpphdl_n679), 0.02, 0.69999999999999996, -1.0);
        // device 256, IC IC41, analog/basic/mos_track_hold.hpp:38
        I(cpphdl_n679, Vss) <+ 2e-12 * ddt(V(cpphdl_n679, Vss)); // Bench initial voltage = 1.6499999999999999 V.
        // device 257, IC IC41, analog/basic/mos_track_hold.hpp:39
        I(Vss, cpphdl_n679) <+ V(Vss, cpphdl_n679) / 1000000000.0;
        // device 258, IC IC41, analog/basic/mos_track_hold.hpp:40
        I(TRACK2, cpphdl_n679) <+ 8.0000000000000006e-15 * ddt(V(TRACK2, cpphdl_n679)); // Bench initial voltage = -1.6499999999999999 V.
        // device 259, IC IC41, analog/basic/mos_track_hold.hpp:41
        I(cpphdl_n625, cpphdl_n679) <+ 8.0000000000000006e-15 * ddt(V(cpphdl_n625, cpphdl_n679)); // Bench initial voltage = 1.6499999999999999 V.
        // device 260, IC IC41, analog/basic/mos_track_hold.hpp:42
        I(cpphdl_n2179, cpphdl_n679) <+ 4.0000000000000003e-15 * ddt(V(cpphdl_n2179, cpphdl_n679)); // Bench initial voltage = 0.0 V.
        // device 261, IC IC44, analog/basic/inverter.hpp:11
        I(cpphdl_n640, Vdd) <+ cpphdl_channel(V(BIT_N2_0, Vdd), V(cpphdl_n640, Vdd), 0.080000000000000002, 0.69999999999999996, -1.0);
        // device 262, IC IC44, analog/basic/inverter.hpp:12
        I(cpphdl_n640, Vss) <+ cpphdl_channel(V(BIT_N2_0, Vss), V(cpphdl_n640, Vss), 0.080000000000000002, 0.69999999999999996, 1.0);
        // device 263, IC IC43, analog/basic/mos_r2r_dac.hpp:27
        I(cpphdl_n640, Vss) <+ 2.9999999999999998e-15 * ddt(V(cpphdl_n640, Vss)); // Bench initial voltage = 0.0 V.
        // device 264, IC IC43, analog/basic/mos_r2r_dac.hpp:28
        I(cpphdl_n640, cpphdl_n669) <+ V(cpphdl_n640, cpphdl_n669) / 20000.0;
        // device 265, IC IC43, analog/basic/mos_r2r_dac.hpp:29
        I(cpphdl_n669, Vss) <+ 2.9999999999999998e-15 * ddt(V(cpphdl_n669, Vss)); // Bench initial voltage = 0.0 V.
        // device 266, IC IC45, analog/basic/inverter.hpp:11
        I(cpphdl_n644, Vdd) <+ cpphdl_channel(V(BIT_N2_1, Vdd), V(cpphdl_n644, Vdd), 0.080000000000000002, 0.69999999999999996, -1.0);
        // device 267, IC IC45, analog/basic/inverter.hpp:12
        I(cpphdl_n644, Vss) <+ cpphdl_channel(V(BIT_N2_1, Vss), V(cpphdl_n644, Vss), 0.080000000000000002, 0.69999999999999996, 1.0);
        // device 268, IC IC43, analog/basic/mos_r2r_dac.hpp:27
        I(cpphdl_n644, Vss) <+ 2.9999999999999998e-15 * ddt(V(cpphdl_n644, Vss)); // Bench initial voltage = 0.0 V.
        // device 269, IC IC43, analog/basic/mos_r2r_dac.hpp:28
        I(cpphdl_n644, cpphdl_n670) <+ V(cpphdl_n644, cpphdl_n670) / 20000.0;
        // device 270, IC IC43, analog/basic/mos_r2r_dac.hpp:29
        I(cpphdl_n670, Vss) <+ 2.9999999999999998e-15 * ddt(V(cpphdl_n670, Vss)); // Bench initial voltage = 0.0 V.
        // device 271, IC IC43, analog/basic/mos_r2r_dac.hpp:31
        I(cpphdl_n669, cpphdl_n670) <+ V(cpphdl_n669, cpphdl_n670) / 10000.0;
        // device 272, IC IC46, analog/basic/inverter.hpp:11
        I(cpphdl_n648, Vdd) <+ cpphdl_channel(V(BIT_N2_2, Vdd), V(cpphdl_n648, Vdd), 0.080000000000000002, 0.69999999999999996, -1.0);
        // device 273, IC IC46, analog/basic/inverter.hpp:12
        I(cpphdl_n648, Vss) <+ cpphdl_channel(V(BIT_N2_2, Vss), V(cpphdl_n648, Vss), 0.080000000000000002, 0.69999999999999996, 1.0);
        // device 274, IC IC43, analog/basic/mos_r2r_dac.hpp:27
        I(cpphdl_n648, Vss) <+ 2.9999999999999998e-15 * ddt(V(cpphdl_n648, Vss)); // Bench initial voltage = 0.0 V.
        // device 275, IC IC43, analog/basic/mos_r2r_dac.hpp:28
        I(cpphdl_n648, cpphdl_n671) <+ V(cpphdl_n648, cpphdl_n671) / 20000.0;
        // device 276, IC IC43, analog/basic/mos_r2r_dac.hpp:29
        I(cpphdl_n671, Vss) <+ 2.9999999999999998e-15 * ddt(V(cpphdl_n671, Vss)); // Bench initial voltage = 0.0 V.
        // device 277, IC IC43, analog/basic/mos_r2r_dac.hpp:31
        I(cpphdl_n670, cpphdl_n671) <+ V(cpphdl_n670, cpphdl_n671) / 10000.0;
        // device 278, IC IC47, analog/basic/inverter.hpp:11
        I(cpphdl_n652, Vdd) <+ cpphdl_channel(V(BIT_N2_3, Vdd), V(cpphdl_n652, Vdd), 0.080000000000000002, 0.69999999999999996, -1.0);
        // device 279, IC IC47, analog/basic/inverter.hpp:12
        I(cpphdl_n652, Vss) <+ cpphdl_channel(V(BIT_N2_3, Vss), V(cpphdl_n652, Vss), 0.080000000000000002, 0.69999999999999996, 1.0);
        // device 280, IC IC43, analog/basic/mos_r2r_dac.hpp:27
        I(cpphdl_n652, Vss) <+ 2.9999999999999998e-15 * ddt(V(cpphdl_n652, Vss)); // Bench initial voltage = 0.0 V.
        // device 281, IC IC43, analog/basic/mos_r2r_dac.hpp:28
        I(cpphdl_n652, cpphdl_n672) <+ V(cpphdl_n652, cpphdl_n672) / 20000.0;
        // device 282, IC IC43, analog/basic/mos_r2r_dac.hpp:29
        I(cpphdl_n672, Vss) <+ 2.9999999999999998e-15 * ddt(V(cpphdl_n672, Vss)); // Bench initial voltage = 0.0 V.
        // device 283, IC IC43, analog/basic/mos_r2r_dac.hpp:31
        I(cpphdl_n671, cpphdl_n672) <+ V(cpphdl_n671, cpphdl_n672) / 10000.0;
        // device 284, IC IC48, analog/basic/inverter.hpp:11
        I(cpphdl_n656, Vdd) <+ cpphdl_channel(V(BIT_N2_4, Vdd), V(cpphdl_n656, Vdd), 0.080000000000000002, 0.69999999999999996, -1.0);
        // device 285, IC IC48, analog/basic/inverter.hpp:12
        I(cpphdl_n656, Vss) <+ cpphdl_channel(V(BIT_N2_4, Vss), V(cpphdl_n656, Vss), 0.080000000000000002, 0.69999999999999996, 1.0);
        // device 286, IC IC43, analog/basic/mos_r2r_dac.hpp:27
        I(cpphdl_n656, Vss) <+ 2.9999999999999998e-15 * ddt(V(cpphdl_n656, Vss)); // Bench initial voltage = 0.0 V.
        // device 287, IC IC43, analog/basic/mos_r2r_dac.hpp:28
        I(cpphdl_n656, cpphdl_n673) <+ V(cpphdl_n656, cpphdl_n673) / 20000.0;
        // device 288, IC IC43, analog/basic/mos_r2r_dac.hpp:29
        I(cpphdl_n673, Vss) <+ 2.9999999999999998e-15 * ddt(V(cpphdl_n673, Vss)); // Bench initial voltage = 0.0 V.
        // device 289, IC IC43, analog/basic/mos_r2r_dac.hpp:31
        I(cpphdl_n672, cpphdl_n673) <+ V(cpphdl_n672, cpphdl_n673) / 10000.0;
        // device 290, IC IC49, analog/basic/inverter.hpp:11
        I(cpphdl_n660, Vdd) <+ cpphdl_channel(V(BIT_N2_5, Vdd), V(cpphdl_n660, Vdd), 0.080000000000000002, 0.69999999999999996, -1.0);
        // device 291, IC IC49, analog/basic/inverter.hpp:12
        I(cpphdl_n660, Vss) <+ cpphdl_channel(V(BIT_N2_5, Vss), V(cpphdl_n660, Vss), 0.080000000000000002, 0.69999999999999996, 1.0);
        // device 292, IC IC43, analog/basic/mos_r2r_dac.hpp:27
        I(cpphdl_n660, Vss) <+ 2.9999999999999998e-15 * ddt(V(cpphdl_n660, Vss)); // Bench initial voltage = 0.0 V.
        // device 293, IC IC43, analog/basic/mos_r2r_dac.hpp:28
        I(cpphdl_n660, cpphdl_n674) <+ V(cpphdl_n660, cpphdl_n674) / 20000.0;
        // device 294, IC IC43, analog/basic/mos_r2r_dac.hpp:29
        I(cpphdl_n674, Vss) <+ 2.9999999999999998e-15 * ddt(V(cpphdl_n674, Vss)); // Bench initial voltage = 0.0 V.
        // device 295, IC IC43, analog/basic/mos_r2r_dac.hpp:31
        I(cpphdl_n673, cpphdl_n674) <+ V(cpphdl_n673, cpphdl_n674) / 10000.0;
        // device 296, IC IC50, analog/basic/inverter.hpp:11
        I(cpphdl_n664, Vdd) <+ cpphdl_channel(V(BIT_N2_6, Vdd), V(cpphdl_n664, Vdd), 0.080000000000000002, 0.69999999999999996, -1.0);
        // device 297, IC IC50, analog/basic/inverter.hpp:12
        I(cpphdl_n664, Vss) <+ cpphdl_channel(V(BIT_N2_6, Vss), V(cpphdl_n664, Vss), 0.080000000000000002, 0.69999999999999996, 1.0);
        // device 298, IC IC43, analog/basic/mos_r2r_dac.hpp:27
        I(cpphdl_n664, Vss) <+ 2.9999999999999998e-15 * ddt(V(cpphdl_n664, Vss)); // Bench initial voltage = 0.0 V.
        // device 299, IC IC43, analog/basic/mos_r2r_dac.hpp:28
        I(cpphdl_n664, cpphdl_n675) <+ V(cpphdl_n664, cpphdl_n675) / 20000.0;
        // device 300, IC IC43, analog/basic/mos_r2r_dac.hpp:29
        I(cpphdl_n675, Vss) <+ 2.9999999999999998e-15 * ddt(V(cpphdl_n675, Vss)); // Bench initial voltage = 0.0 V.
        // device 301, IC IC43, analog/basic/mos_r2r_dac.hpp:31
        I(cpphdl_n674, cpphdl_n675) <+ V(cpphdl_n674, cpphdl_n675) / 10000.0;
        // device 302, IC IC51, analog/basic/inverter.hpp:11
        I(cpphdl_n668, Vdd) <+ cpphdl_channel(V(BIT_N2_7, Vdd), V(cpphdl_n668, Vdd), 0.080000000000000002, 0.69999999999999996, -1.0);
        // device 303, IC IC51, analog/basic/inverter.hpp:12
        I(cpphdl_n668, Vss) <+ cpphdl_channel(V(BIT_N2_7, Vss), V(cpphdl_n668, Vss), 0.080000000000000002, 0.69999999999999996, 1.0);
        // device 304, IC IC43, analog/basic/mos_r2r_dac.hpp:27
        I(cpphdl_n668, Vss) <+ 2.9999999999999998e-15 * ddt(V(cpphdl_n668, Vss)); // Bench initial voltage = 0.0 V.
        // device 305, IC IC43, analog/basic/mos_r2r_dac.hpp:28
        I(cpphdl_n668, cpphdl_n680) <+ V(cpphdl_n668, cpphdl_n680) / 20000.0;
        // device 306, IC IC43, analog/basic/mos_r2r_dac.hpp:29
        I(cpphdl_n680, Vss) <+ 2.9999999999999998e-15 * ddt(V(cpphdl_n680, Vss)); // Bench initial voltage = 0.0 V.
        // device 307, IC IC43, analog/basic/mos_r2r_dac.hpp:31
        I(cpphdl_n675, cpphdl_n680) <+ V(cpphdl_n675, cpphdl_n680) / 10000.0;
        // device 308, IC IC43, analog/basic/mos_r2r_dac.hpp:33
        I(Vss, cpphdl_n669) <+ V(Vss, cpphdl_n669) / 20000.0;
        // device 309, IC IC52, analog/basic/nmos_resistor_amplifier.hpp:23
        I(Vdd, cpphdl_n689) <+ V(Vdd, cpphdl_n689) / 1000.0;
        // device 310, IC IC52, analog/basic/nmos_resistor_amplifier.hpp:24
        I(Vdd, cpphdl_n688) <+ V(Vdd, cpphdl_n688) / 1000.0;
        // device 311, IC IC52, analog/basic/nmos_resistor_amplifier.hpp:25
        I(cpphdl_n689, cpphdl_n683) <+ cpphdl_channel(V(cpphdl_n679, cpphdl_n683), V(cpphdl_n689, cpphdl_n683), 0.014999999999999999, 0.69999999999999996, 1.0);
        // device 312, IC IC52, analog/basic/nmos_resistor_amplifier.hpp:26
        I(cpphdl_n688, cpphdl_n684) <+ cpphdl_channel(V(cpphdl_n680, cpphdl_n684), V(cpphdl_n688, cpphdl_n684), 0.014999999999999999, 0.69999999999999996, 1.0);
        // device 313, IC IC52, analog/basic/nmos_resistor_amplifier.hpp:27
        I(cpphdl_n685, cpphdl_n683) <+ V(cpphdl_n685, cpphdl_n683) / 50.0;
        // device 314, IC IC52, analog/basic/nmos_resistor_amplifier.hpp:28
        I(cpphdl_n685, cpphdl_n684) <+ V(cpphdl_n685, cpphdl_n684) / 50.0;
        // device 315, IC IC52, analog/basic/nmos_resistor_amplifier.hpp:29
        I(Vss, cpphdl_n685) <+ V(Vss, cpphdl_n685) / 150.0;
        // device 316, IC IC52, analog/basic/nmos_resistor_amplifier.hpp:30
        I(cpphdl_n689, Vdd) <+ 2.9999999999999998e-13 * ddt(V(cpphdl_n689, Vdd)); // Bench initial voltage = 0.0 V.
        // device 317, IC IC52, analog/basic/nmos_resistor_amplifier.hpp:31
        I(cpphdl_n688, Vdd) <+ 2.9999999999999998e-13 * ddt(V(cpphdl_n688, Vdd)); // Bench initial voltage = 0.0 V.
        // device 318, IC IC52, analog/basic/nmos_resistor_amplifier.hpp:32
        I(cpphdl_n685, Vss) <+ 4e-14 * ddt(V(cpphdl_n685, Vss)); // Bench initial voltage = 0.0 V.
        // device 319, IC IC52, analog/basic/nmos_resistor_amplifier.hpp:34
        I(cpphdl_n679, cpphdl_n683) <+ 2e-14 * ddt(V(cpphdl_n679, cpphdl_n683)); // Bench initial voltage = 1.6499999999999999 V.
        // device 320, IC IC52, analog/basic/nmos_resistor_amplifier.hpp:35
        I(cpphdl_n680, cpphdl_n684) <+ 2e-14 * ddt(V(cpphdl_n680, cpphdl_n684)); // Bench initial voltage = 0.0 V.
        // device 321, IC IC52, analog/basic/nmos_resistor_amplifier.hpp:36
        I(cpphdl_n679, cpphdl_n689) <+ 2.9999999999999998e-15 * ddt(V(cpphdl_n679, cpphdl_n689)); // Bench initial voltage = -1.6499999999999999 V.
        // device 322, IC IC52, analog/basic/nmos_resistor_amplifier.hpp:37
        I(cpphdl_n680, cpphdl_n688) <+ 2.9999999999999998e-15 * ddt(V(cpphdl_n680, cpphdl_n688)); // Bench initial voltage = -3.2999999999999998 V.
        // device 323, IC IC53, analog/basic/strongarm_comparator.hpp:28
        I(cpphdl_n693, cpphdl_n695) <+ cpphdl_channel(V(cpphdl_n688, cpphdl_n695), V(cpphdl_n693, cpphdl_n695), 0.0080000000000000002, 0.69999999999999996, 1.0);
        // device 324, IC IC53, analog/basic/strongarm_comparator.hpp:29
        I(cpphdl_n694, cpphdl_n695) <+ cpphdl_channel(V(cpphdl_n689, cpphdl_n695), V(cpphdl_n694, cpphdl_n695), 0.0080000000000000002, 0.69999999999999996, 1.0);
        // device 325, IC IC53, analog/basic/strongarm_comparator.hpp:30
        I(cpphdl_n695, Vss) <+ cpphdl_channel(V(EVALUATE, Vss), V(cpphdl_n695, Vss), 0.0080000000000000002, 0.69999999999999996, 1.0);
        // device 326, IC IC53, analog/basic/strongarm_comparator.hpp:33
        I(cpphdl_n707, cpphdl_n693) <+ cpphdl_channel(V(cpphdl_n713, cpphdl_n693), V(cpphdl_n707, cpphdl_n693), 0.0040000000000000001, 0.69999999999999996, 1.0);
        // device 327, IC IC53, analog/basic/strongarm_comparator.hpp:34
        I(cpphdl_n713, cpphdl_n694) <+ cpphdl_channel(V(cpphdl_n707, cpphdl_n694), V(cpphdl_n713, cpphdl_n694), 0.0040000000000000001, 0.69999999999999996, 1.0);
        // device 328, IC IC53, analog/basic/strongarm_comparator.hpp:35
        I(cpphdl_n713, Vdd) <+ cpphdl_channel(V(cpphdl_n707, Vdd), V(cpphdl_n713, Vdd), 0.002, 0.69999999999999996, -1.0);
        // device 329, IC IC53, analog/basic/strongarm_comparator.hpp:36
        I(cpphdl_n707, Vdd) <+ cpphdl_channel(V(cpphdl_n713, Vdd), V(cpphdl_n707, Vdd), 0.002, 0.69999999999999996, -1.0);
        // device 330, IC IC53, analog/basic/strongarm_comparator.hpp:38
        I(cpphdl_n693, Vdd) <+ cpphdl_channel(V(EVALUATE, Vdd), V(cpphdl_n693, Vdd), 0.002, 0.69999999999999996, -1.0);
        // device 331, IC IC53, analog/basic/strongarm_comparator.hpp:39
        I(cpphdl_n694, Vdd) <+ cpphdl_channel(V(EVALUATE, Vdd), V(cpphdl_n694, Vdd), 0.002, 0.69999999999999996, -1.0);
        // device 332, IC IC53, analog/basic/strongarm_comparator.hpp:40
        I(cpphdl_n713, Vdd) <+ cpphdl_channel(V(EVALUATE, Vdd), V(cpphdl_n713, Vdd), 0.002, 0.69999999999999996, -1.0);
        // device 333, IC IC53, analog/basic/strongarm_comparator.hpp:41
        I(cpphdl_n707, Vdd) <+ cpphdl_channel(V(EVALUATE, Vdd), V(cpphdl_n707, Vdd), 0.002, 0.69999999999999996, -1.0);
        // device 334, IC IC53, analog/basic/strongarm_comparator.hpp:42
        I(cpphdl_n693, Vss) <+ 2.9999999999999998e-14 * ddt(V(cpphdl_n693, Vss)); // Bench initial voltage = 0.0 V.
        // device 335, IC IC53, analog/basic/strongarm_comparator.hpp:43
        I(cpphdl_n694, Vss) <+ 2.9999999999999998e-14 * ddt(V(cpphdl_n694, Vss)); // Bench initial voltage = 0.0 V.
        // device 336, IC IC53, analog/basic/strongarm_comparator.hpp:44
        I(cpphdl_n695, Vss) <+ 2.9999999999999998e-14 * ddt(V(cpphdl_n695, Vss)); // Bench initial voltage = 0.0 V.
        // device 337, IC IC53, analog/basic/strongarm_comparator.hpp:45
        I(cpphdl_n713, Vss) <+ 5.0000000000000002e-14 * ddt(V(cpphdl_n713, Vss)); // Bench initial voltage = 0.0 V.
        // device 338, IC IC53, analog/basic/strongarm_comparator.hpp:46
        I(cpphdl_n707, Vss) <+ 5.0000000000000002e-14 * ddt(V(cpphdl_n707, Vss)); // Bench initial voltage = 0.0 V.
        // device 339, IC IC53, analog/basic/strongarm_comparator.hpp:47
        I(cpphdl_n688, cpphdl_n695) <+ 2e-14 * ddt(V(cpphdl_n688, cpphdl_n695)); // Bench initial voltage = 3.2999999999999998 V.
        // device 340, IC IC53, analog/basic/strongarm_comparator.hpp:48
        I(cpphdl_n689, cpphdl_n695) <+ 2e-14 * ddt(V(cpphdl_n689, cpphdl_n695)); // Bench initial voltage = 3.2999999999999998 V.
        // device 341, IC IC53, analog/basic/strongarm_comparator.hpp:49
        I(cpphdl_n688, cpphdl_n693) <+ 2.9999999999999998e-15 * ddt(V(cpphdl_n688, cpphdl_n693)); // Bench initial voltage = 3.2999999999999998 V.
        // device 342, IC IC53, analog/basic/strongarm_comparator.hpp:50
        I(cpphdl_n689, cpphdl_n694) <+ 2.9999999999999998e-15 * ddt(V(cpphdl_n689, cpphdl_n694)); // Bench initial voltage = 3.2999999999999998 V.
        // device 343, IC IC55, analog/basic/cmos_logic.hpp:15
        I(cpphdl_n2311, Vss) <+ 5.0000000000000002e-14 * ddt(V(cpphdl_n2311, Vss)); // Bench initial voltage = 0.0 V.
        // device 344, IC IC55, analog/basic/cmos_logic.hpp:16
        I(cpphdl_n2311, Vdd) <+ cpphdl_channel(V(cpphdl_n707, Vdd), V(cpphdl_n2311, Vdd), 0.01, 0.69999999999999996, -1.0);
        // device 345, IC IC55, analog/basic/cmos_logic.hpp:17
        I(cpphdl_n2311, Vdd) <+ cpphdl_channel(V(cpphdl_n715, Vdd), V(cpphdl_n2311, Vdd), 0.01, 0.69999999999999996, -1.0);
        // device 346, IC IC55, analog/basic/cmos_logic.hpp:18
        I(cpphdl_n2311, cpphdl_n710) <+ cpphdl_channel(V(cpphdl_n707, cpphdl_n710), V(cpphdl_n2311, cpphdl_n710), 0.01, 0.69999999999999996, 1.0);
        // device 347, IC IC55, analog/basic/cmos_logic.hpp:19
        I(cpphdl_n710, Vss) <+ cpphdl_channel(V(cpphdl_n715, Vss), V(cpphdl_n710, Vss), 0.01, 0.69999999999999996, 1.0);
        // device 348, IC IC55, analog/basic/cmos_logic.hpp:20
        I(cpphdl_n2311, Vss) <+ V(cpphdl_n2311, Vss) / 1000000000.0;
        // device 349, IC IC55, analog/basic/cmos_logic.hpp:21
        I(cpphdl_n710, Vss) <+ V(cpphdl_n710, Vss) / 1000000000.0;
        // device 350, IC IC56, analog/basic/cmos_logic.hpp:15
        I(cpphdl_n715, Vss) <+ 5.0000000000000002e-14 * ddt(V(cpphdl_n715, Vss)); // Bench initial voltage = 0.0 V.
        // device 351, IC IC56, analog/basic/cmos_logic.hpp:16
        I(cpphdl_n715, Vdd) <+ cpphdl_channel(V(cpphdl_n713, Vdd), V(cpphdl_n715, Vdd), 0.01, 0.69999999999999996, -1.0);
        // device 352, IC IC56, analog/basic/cmos_logic.hpp:17
        I(cpphdl_n715, Vdd) <+ cpphdl_channel(V(cpphdl_n2311, Vdd), V(cpphdl_n715, Vdd), 0.01, 0.69999999999999996, -1.0);
        // device 353, IC IC56, analog/basic/cmos_logic.hpp:18
        I(cpphdl_n715, cpphdl_n716) <+ cpphdl_channel(V(cpphdl_n713, cpphdl_n716), V(cpphdl_n715, cpphdl_n716), 0.01, 0.69999999999999996, 1.0);
        // device 354, IC IC56, analog/basic/cmos_logic.hpp:19
        I(cpphdl_n716, Vss) <+ cpphdl_channel(V(cpphdl_n2311, Vss), V(cpphdl_n716, Vss), 0.01, 0.69999999999999996, 1.0);
        // device 355, IC IC56, analog/basic/cmos_logic.hpp:20
        I(cpphdl_n715, Vss) <+ V(cpphdl_n715, Vss) / 1000000000.0;
        // device 356, IC IC56, analog/basic/cmos_logic.hpp:21
        I(cpphdl_n716, Vss) <+ V(cpphdl_n716, Vss) / 1000000000.0;
        // device 357, IC IC54, analog/basic/nand_latch.hpp:34
        I(cpphdl_n707, Vss) <+ 2.9999999999999998e-15 * ddt(V(cpphdl_n707, Vss)); // Bench initial voltage = 0.0 V.
        // device 358, IC IC54, analog/basic/nand_latch.hpp:35
        I(cpphdl_n713, Vss) <+ 2.9999999999999998e-15 * ddt(V(cpphdl_n713, Vss)); // Bench initial voltage = 0.0 V.
        // device 359, IC IC57, analog/basic/inverter.hpp:11
        I(cpphdl_n721, Vdd) <+ cpphdl_channel(V(CLEAR, Vdd), V(cpphdl_n721, Vdd), 0.01, 0.69999999999999996, -1.0);
        // device 360, IC IC57, analog/basic/inverter.hpp:12
        I(cpphdl_n721, Vss) <+ cpphdl_channel(V(CLEAR, Vss), V(cpphdl_n721, Vss), 0.01, 0.69999999999999996, 1.0);
        // device 361, IC IC54, analog/basic/nand_latch.hpp:56
        I(cpphdl_n721, Vss) <+ 2.9999999999999998e-15 * ddt(V(cpphdl_n721, Vss)); // Bench initial voltage = 0.0 V.
        // device 362, IC IC54, analog/basic/nand_latch.hpp:57
        I(cpphdl_n2311, Vss) <+ cpphdl_channel(V(CLEAR, Vss), V(cpphdl_n2311, Vss), 0.050000000000000003, 0.69999999999999996, 1.0);
        // device 363, IC IC54, analog/basic/nand_latch.hpp:58
        I(cpphdl_n715, Vdd) <+ cpphdl_channel(V(cpphdl_n721, Vdd), V(cpphdl_n715, Vdd), 0.050000000000000003, 0.69999999999999996, -1.0);
        // device 364, IC IC60, analog/basic/inverter.hpp:11
        I(cpphdl_n745, Vdd) <+ cpphdl_channel(V(TRACK3, Vdd), V(cpphdl_n745, Vdd), 0.0040000000000000001, 0.69999999999999996, -1.0);
        // device 365, IC IC60, analog/basic/inverter.hpp:12
        I(cpphdl_n745, Vss) <+ cpphdl_channel(V(TRACK3, Vss), V(cpphdl_n745, Vss), 0.0040000000000000001, 0.69999999999999996, 1.0);
        // device 366, IC IC59, analog/basic/mos_track_hold.hpp:30
        I(cpphdl_n745, Vss) <+ 2e-14 * ddt(V(cpphdl_n745, Vss)); // Bench initial voltage = 3.2999999999999998 V.
        // device 367, IC IC59, analog/basic/mos_track_hold.hpp:31
        I(cpphdl_n2179, cpphdl_n799) <+ cpphdl_channel(V(TRACK3, cpphdl_n799), V(cpphdl_n2179, cpphdl_n799), 0.080000000000000002, 0.69999999999999996, 1.0);
        // device 368, IC IC59, analog/basic/mos_track_hold.hpp:32
        I(cpphdl_n799, cpphdl_n2179) <+ cpphdl_channel(V(cpphdl_n745, cpphdl_n2179), V(cpphdl_n799, cpphdl_n2179), 0.040000000000000001, 0.69999999999999996, -1.0);
        // device 369, IC IC59, analog/basic/mos_track_hold.hpp:36
        I(cpphdl_n799, cpphdl_n799) <+ cpphdl_channel(V(cpphdl_n745, cpphdl_n799), V(cpphdl_n799, cpphdl_n799), 0.040000000000000001, 0.69999999999999996, 1.0);
        // device 370, IC IC59, analog/basic/mos_track_hold.hpp:37
        I(cpphdl_n799, cpphdl_n799) <+ cpphdl_channel(V(TRACK3, cpphdl_n799), V(cpphdl_n799, cpphdl_n799), 0.02, 0.69999999999999996, -1.0);
        // device 371, IC IC59, analog/basic/mos_track_hold.hpp:38
        I(cpphdl_n799, Vss) <+ 2e-12 * ddt(V(cpphdl_n799, Vss)); // Bench initial voltage = 1.6499999999999999 V.
        // device 372, IC IC59, analog/basic/mos_track_hold.hpp:39
        I(Vss, cpphdl_n799) <+ V(Vss, cpphdl_n799) / 1000000000.0;
        // device 373, IC IC59, analog/basic/mos_track_hold.hpp:40
        I(TRACK3, cpphdl_n799) <+ 8.0000000000000006e-15 * ddt(V(TRACK3, cpphdl_n799)); // Bench initial voltage = -1.6499999999999999 V.
        // device 374, IC IC59, analog/basic/mos_track_hold.hpp:41
        I(cpphdl_n745, cpphdl_n799) <+ 8.0000000000000006e-15 * ddt(V(cpphdl_n745, cpphdl_n799)); // Bench initial voltage = 1.6499999999999999 V.
        // device 375, IC IC59, analog/basic/mos_track_hold.hpp:42
        I(cpphdl_n2179, cpphdl_n799) <+ 4.0000000000000003e-15 * ddt(V(cpphdl_n2179, cpphdl_n799)); // Bench initial voltage = 0.0 V.
        // device 376, IC IC62, analog/basic/inverter.hpp:11
        I(cpphdl_n760, Vdd) <+ cpphdl_channel(V(BIT_N3_0, Vdd), V(cpphdl_n760, Vdd), 0.080000000000000002, 0.69999999999999996, -1.0);
        // device 377, IC IC62, analog/basic/inverter.hpp:12
        I(cpphdl_n760, Vss) <+ cpphdl_channel(V(BIT_N3_0, Vss), V(cpphdl_n760, Vss), 0.080000000000000002, 0.69999999999999996, 1.0);
        // device 378, IC IC61, analog/basic/mos_r2r_dac.hpp:27
        I(cpphdl_n760, Vss) <+ 2.9999999999999998e-15 * ddt(V(cpphdl_n760, Vss)); // Bench initial voltage = 0.0 V.
        // device 379, IC IC61, analog/basic/mos_r2r_dac.hpp:28
        I(cpphdl_n760, cpphdl_n789) <+ V(cpphdl_n760, cpphdl_n789) / 20000.0;
        // device 380, IC IC61, analog/basic/mos_r2r_dac.hpp:29
        I(cpphdl_n789, Vss) <+ 2.9999999999999998e-15 * ddt(V(cpphdl_n789, Vss)); // Bench initial voltage = 0.0 V.
        // device 381, IC IC63, analog/basic/inverter.hpp:11
        I(cpphdl_n764, Vdd) <+ cpphdl_channel(V(BIT_N3_1, Vdd), V(cpphdl_n764, Vdd), 0.080000000000000002, 0.69999999999999996, -1.0);
        // device 382, IC IC63, analog/basic/inverter.hpp:12
        I(cpphdl_n764, Vss) <+ cpphdl_channel(V(BIT_N3_1, Vss), V(cpphdl_n764, Vss), 0.080000000000000002, 0.69999999999999996, 1.0);
        // device 383, IC IC61, analog/basic/mos_r2r_dac.hpp:27
        I(cpphdl_n764, Vss) <+ 2.9999999999999998e-15 * ddt(V(cpphdl_n764, Vss)); // Bench initial voltage = 0.0 V.
        // device 384, IC IC61, analog/basic/mos_r2r_dac.hpp:28
        I(cpphdl_n764, cpphdl_n790) <+ V(cpphdl_n764, cpphdl_n790) / 20000.0;
        // device 385, IC IC61, analog/basic/mos_r2r_dac.hpp:29
        I(cpphdl_n790, Vss) <+ 2.9999999999999998e-15 * ddt(V(cpphdl_n790, Vss)); // Bench initial voltage = 0.0 V.
        // device 386, IC IC61, analog/basic/mos_r2r_dac.hpp:31
        I(cpphdl_n789, cpphdl_n790) <+ V(cpphdl_n789, cpphdl_n790) / 10000.0;
        // device 387, IC IC64, analog/basic/inverter.hpp:11
        I(cpphdl_n768, Vdd) <+ cpphdl_channel(V(BIT_N3_2, Vdd), V(cpphdl_n768, Vdd), 0.080000000000000002, 0.69999999999999996, -1.0);
        // device 388, IC IC64, analog/basic/inverter.hpp:12
        I(cpphdl_n768, Vss) <+ cpphdl_channel(V(BIT_N3_2, Vss), V(cpphdl_n768, Vss), 0.080000000000000002, 0.69999999999999996, 1.0);
        // device 389, IC IC61, analog/basic/mos_r2r_dac.hpp:27
        I(cpphdl_n768, Vss) <+ 2.9999999999999998e-15 * ddt(V(cpphdl_n768, Vss)); // Bench initial voltage = 0.0 V.
        // device 390, IC IC61, analog/basic/mos_r2r_dac.hpp:28
        I(cpphdl_n768, cpphdl_n791) <+ V(cpphdl_n768, cpphdl_n791) / 20000.0;
        // device 391, IC IC61, analog/basic/mos_r2r_dac.hpp:29
        I(cpphdl_n791, Vss) <+ 2.9999999999999998e-15 * ddt(V(cpphdl_n791, Vss)); // Bench initial voltage = 0.0 V.
        // device 392, IC IC61, analog/basic/mos_r2r_dac.hpp:31
        I(cpphdl_n790, cpphdl_n791) <+ V(cpphdl_n790, cpphdl_n791) / 10000.0;
        // device 393, IC IC65, analog/basic/inverter.hpp:11
        I(cpphdl_n772, Vdd) <+ cpphdl_channel(V(BIT_N3_3, Vdd), V(cpphdl_n772, Vdd), 0.080000000000000002, 0.69999999999999996, -1.0);
        // device 394, IC IC65, analog/basic/inverter.hpp:12
        I(cpphdl_n772, Vss) <+ cpphdl_channel(V(BIT_N3_3, Vss), V(cpphdl_n772, Vss), 0.080000000000000002, 0.69999999999999996, 1.0);
        // device 395, IC IC61, analog/basic/mos_r2r_dac.hpp:27
        I(cpphdl_n772, Vss) <+ 2.9999999999999998e-15 * ddt(V(cpphdl_n772, Vss)); // Bench initial voltage = 0.0 V.
        // device 396, IC IC61, analog/basic/mos_r2r_dac.hpp:28
        I(cpphdl_n772, cpphdl_n792) <+ V(cpphdl_n772, cpphdl_n792) / 20000.0;
        // device 397, IC IC61, analog/basic/mos_r2r_dac.hpp:29
        I(cpphdl_n792, Vss) <+ 2.9999999999999998e-15 * ddt(V(cpphdl_n792, Vss)); // Bench initial voltage = 0.0 V.
        // device 398, IC IC61, analog/basic/mos_r2r_dac.hpp:31
        I(cpphdl_n791, cpphdl_n792) <+ V(cpphdl_n791, cpphdl_n792) / 10000.0;
        // device 399, IC IC66, analog/basic/inverter.hpp:11
        I(cpphdl_n776, Vdd) <+ cpphdl_channel(V(BIT_N3_4, Vdd), V(cpphdl_n776, Vdd), 0.080000000000000002, 0.69999999999999996, -1.0);
        // device 400, IC IC66, analog/basic/inverter.hpp:12
        I(cpphdl_n776, Vss) <+ cpphdl_channel(V(BIT_N3_4, Vss), V(cpphdl_n776, Vss), 0.080000000000000002, 0.69999999999999996, 1.0);
        // device 401, IC IC61, analog/basic/mos_r2r_dac.hpp:27
        I(cpphdl_n776, Vss) <+ 2.9999999999999998e-15 * ddt(V(cpphdl_n776, Vss)); // Bench initial voltage = 0.0 V.
        // device 402, IC IC61, analog/basic/mos_r2r_dac.hpp:28
        I(cpphdl_n776, cpphdl_n793) <+ V(cpphdl_n776, cpphdl_n793) / 20000.0;
        // device 403, IC IC61, analog/basic/mos_r2r_dac.hpp:29
        I(cpphdl_n793, Vss) <+ 2.9999999999999998e-15 * ddt(V(cpphdl_n793, Vss)); // Bench initial voltage = 0.0 V.
        // device 404, IC IC61, analog/basic/mos_r2r_dac.hpp:31
        I(cpphdl_n792, cpphdl_n793) <+ V(cpphdl_n792, cpphdl_n793) / 10000.0;
        // device 405, IC IC67, analog/basic/inverter.hpp:11
        I(cpphdl_n780, Vdd) <+ cpphdl_channel(V(BIT_N3_5, Vdd), V(cpphdl_n780, Vdd), 0.080000000000000002, 0.69999999999999996, -1.0);
        // device 406, IC IC67, analog/basic/inverter.hpp:12
        I(cpphdl_n780, Vss) <+ cpphdl_channel(V(BIT_N3_5, Vss), V(cpphdl_n780, Vss), 0.080000000000000002, 0.69999999999999996, 1.0);
        // device 407, IC IC61, analog/basic/mos_r2r_dac.hpp:27
        I(cpphdl_n780, Vss) <+ 2.9999999999999998e-15 * ddt(V(cpphdl_n780, Vss)); // Bench initial voltage = 0.0 V.
        // device 408, IC IC61, analog/basic/mos_r2r_dac.hpp:28
        I(cpphdl_n780, cpphdl_n794) <+ V(cpphdl_n780, cpphdl_n794) / 20000.0;
        // device 409, IC IC61, analog/basic/mos_r2r_dac.hpp:29
        I(cpphdl_n794, Vss) <+ 2.9999999999999998e-15 * ddt(V(cpphdl_n794, Vss)); // Bench initial voltage = 0.0 V.
        // device 410, IC IC61, analog/basic/mos_r2r_dac.hpp:31
        I(cpphdl_n793, cpphdl_n794) <+ V(cpphdl_n793, cpphdl_n794) / 10000.0;
        // device 411, IC IC68, analog/basic/inverter.hpp:11
        I(cpphdl_n784, Vdd) <+ cpphdl_channel(V(BIT_N3_6, Vdd), V(cpphdl_n784, Vdd), 0.080000000000000002, 0.69999999999999996, -1.0);
        // device 412, IC IC68, analog/basic/inverter.hpp:12
        I(cpphdl_n784, Vss) <+ cpphdl_channel(V(BIT_N3_6, Vss), V(cpphdl_n784, Vss), 0.080000000000000002, 0.69999999999999996, 1.0);
        // device 413, IC IC61, analog/basic/mos_r2r_dac.hpp:27
        I(cpphdl_n784, Vss) <+ 2.9999999999999998e-15 * ddt(V(cpphdl_n784, Vss)); // Bench initial voltage = 0.0 V.
        // device 414, IC IC61, analog/basic/mos_r2r_dac.hpp:28
        I(cpphdl_n784, cpphdl_n795) <+ V(cpphdl_n784, cpphdl_n795) / 20000.0;
        // device 415, IC IC61, analog/basic/mos_r2r_dac.hpp:29
        I(cpphdl_n795, Vss) <+ 2.9999999999999998e-15 * ddt(V(cpphdl_n795, Vss)); // Bench initial voltage = 0.0 V.
        // device 416, IC IC61, analog/basic/mos_r2r_dac.hpp:31
        I(cpphdl_n794, cpphdl_n795) <+ V(cpphdl_n794, cpphdl_n795) / 10000.0;
        // device 417, IC IC69, analog/basic/inverter.hpp:11
        I(cpphdl_n788, Vdd) <+ cpphdl_channel(V(BIT_N3_7, Vdd), V(cpphdl_n788, Vdd), 0.080000000000000002, 0.69999999999999996, -1.0);
        // device 418, IC IC69, analog/basic/inverter.hpp:12
        I(cpphdl_n788, Vss) <+ cpphdl_channel(V(BIT_N3_7, Vss), V(cpphdl_n788, Vss), 0.080000000000000002, 0.69999999999999996, 1.0);
        // device 419, IC IC61, analog/basic/mos_r2r_dac.hpp:27
        I(cpphdl_n788, Vss) <+ 2.9999999999999998e-15 * ddt(V(cpphdl_n788, Vss)); // Bench initial voltage = 0.0 V.
        // device 420, IC IC61, analog/basic/mos_r2r_dac.hpp:28
        I(cpphdl_n788, cpphdl_n800) <+ V(cpphdl_n788, cpphdl_n800) / 20000.0;
        // device 421, IC IC61, analog/basic/mos_r2r_dac.hpp:29
        I(cpphdl_n800, Vss) <+ 2.9999999999999998e-15 * ddt(V(cpphdl_n800, Vss)); // Bench initial voltage = 0.0 V.
        // device 422, IC IC61, analog/basic/mos_r2r_dac.hpp:31
        I(cpphdl_n795, cpphdl_n800) <+ V(cpphdl_n795, cpphdl_n800) / 10000.0;
        // device 423, IC IC61, analog/basic/mos_r2r_dac.hpp:33
        I(Vss, cpphdl_n789) <+ V(Vss, cpphdl_n789) / 20000.0;
        // device 424, IC IC70, analog/basic/nmos_resistor_amplifier.hpp:23
        I(Vdd, cpphdl_n809) <+ V(Vdd, cpphdl_n809) / 1000.0;
        // device 425, IC IC70, analog/basic/nmos_resistor_amplifier.hpp:24
        I(Vdd, cpphdl_n808) <+ V(Vdd, cpphdl_n808) / 1000.0;
        // device 426, IC IC70, analog/basic/nmos_resistor_amplifier.hpp:25
        I(cpphdl_n809, cpphdl_n803) <+ cpphdl_channel(V(cpphdl_n799, cpphdl_n803), V(cpphdl_n809, cpphdl_n803), 0.014999999999999999, 0.69999999999999996, 1.0);
        // device 427, IC IC70, analog/basic/nmos_resistor_amplifier.hpp:26
        I(cpphdl_n808, cpphdl_n804) <+ cpphdl_channel(V(cpphdl_n800, cpphdl_n804), V(cpphdl_n808, cpphdl_n804), 0.014999999999999999, 0.69999999999999996, 1.0);
        // device 428, IC IC70, analog/basic/nmos_resistor_amplifier.hpp:27
        I(cpphdl_n805, cpphdl_n803) <+ V(cpphdl_n805, cpphdl_n803) / 50.0;
        // device 429, IC IC70, analog/basic/nmos_resistor_amplifier.hpp:28
        I(cpphdl_n805, cpphdl_n804) <+ V(cpphdl_n805, cpphdl_n804) / 50.0;
        // device 430, IC IC70, analog/basic/nmos_resistor_amplifier.hpp:29
        I(Vss, cpphdl_n805) <+ V(Vss, cpphdl_n805) / 150.0;
        // device 431, IC IC70, analog/basic/nmos_resistor_amplifier.hpp:30
        I(cpphdl_n809, Vdd) <+ 2.9999999999999998e-13 * ddt(V(cpphdl_n809, Vdd)); // Bench initial voltage = 0.0 V.
        // device 432, IC IC70, analog/basic/nmos_resistor_amplifier.hpp:31
        I(cpphdl_n808, Vdd) <+ 2.9999999999999998e-13 * ddt(V(cpphdl_n808, Vdd)); // Bench initial voltage = 0.0 V.
        // device 433, IC IC70, analog/basic/nmos_resistor_amplifier.hpp:32
        I(cpphdl_n805, Vss) <+ 4e-14 * ddt(V(cpphdl_n805, Vss)); // Bench initial voltage = 0.0 V.
        // device 434, IC IC70, analog/basic/nmos_resistor_amplifier.hpp:34
        I(cpphdl_n799, cpphdl_n803) <+ 2e-14 * ddt(V(cpphdl_n799, cpphdl_n803)); // Bench initial voltage = 1.6499999999999999 V.
        // device 435, IC IC70, analog/basic/nmos_resistor_amplifier.hpp:35
        I(cpphdl_n800, cpphdl_n804) <+ 2e-14 * ddt(V(cpphdl_n800, cpphdl_n804)); // Bench initial voltage = 0.0 V.
        // device 436, IC IC70, analog/basic/nmos_resistor_amplifier.hpp:36
        I(cpphdl_n799, cpphdl_n809) <+ 2.9999999999999998e-15 * ddt(V(cpphdl_n799, cpphdl_n809)); // Bench initial voltage = -1.6499999999999999 V.
        // device 437, IC IC70, analog/basic/nmos_resistor_amplifier.hpp:37
        I(cpphdl_n800, cpphdl_n808) <+ 2.9999999999999998e-15 * ddt(V(cpphdl_n800, cpphdl_n808)); // Bench initial voltage = -3.2999999999999998 V.
        // device 438, IC IC71, analog/basic/strongarm_comparator.hpp:28
        I(cpphdl_n813, cpphdl_n815) <+ cpphdl_channel(V(cpphdl_n808, cpphdl_n815), V(cpphdl_n813, cpphdl_n815), 0.0080000000000000002, 0.69999999999999996, 1.0);
        // device 439, IC IC71, analog/basic/strongarm_comparator.hpp:29
        I(cpphdl_n814, cpphdl_n815) <+ cpphdl_channel(V(cpphdl_n809, cpphdl_n815), V(cpphdl_n814, cpphdl_n815), 0.0080000000000000002, 0.69999999999999996, 1.0);
        // device 440, IC IC71, analog/basic/strongarm_comparator.hpp:30
        I(cpphdl_n815, Vss) <+ cpphdl_channel(V(EVALUATE, Vss), V(cpphdl_n815, Vss), 0.0080000000000000002, 0.69999999999999996, 1.0);
        // device 441, IC IC71, analog/basic/strongarm_comparator.hpp:33
        I(cpphdl_n827, cpphdl_n813) <+ cpphdl_channel(V(cpphdl_n833, cpphdl_n813), V(cpphdl_n827, cpphdl_n813), 0.0040000000000000001, 0.69999999999999996, 1.0);
        // device 442, IC IC71, analog/basic/strongarm_comparator.hpp:34
        I(cpphdl_n833, cpphdl_n814) <+ cpphdl_channel(V(cpphdl_n827, cpphdl_n814), V(cpphdl_n833, cpphdl_n814), 0.0040000000000000001, 0.69999999999999996, 1.0);
        // device 443, IC IC71, analog/basic/strongarm_comparator.hpp:35
        I(cpphdl_n833, Vdd) <+ cpphdl_channel(V(cpphdl_n827, Vdd), V(cpphdl_n833, Vdd), 0.002, 0.69999999999999996, -1.0);
        // device 444, IC IC71, analog/basic/strongarm_comparator.hpp:36
        I(cpphdl_n827, Vdd) <+ cpphdl_channel(V(cpphdl_n833, Vdd), V(cpphdl_n827, Vdd), 0.002, 0.69999999999999996, -1.0);
        // device 445, IC IC71, analog/basic/strongarm_comparator.hpp:38
        I(cpphdl_n813, Vdd) <+ cpphdl_channel(V(EVALUATE, Vdd), V(cpphdl_n813, Vdd), 0.002, 0.69999999999999996, -1.0);
        // device 446, IC IC71, analog/basic/strongarm_comparator.hpp:39
        I(cpphdl_n814, Vdd) <+ cpphdl_channel(V(EVALUATE, Vdd), V(cpphdl_n814, Vdd), 0.002, 0.69999999999999996, -1.0);
        // device 447, IC IC71, analog/basic/strongarm_comparator.hpp:40
        I(cpphdl_n833, Vdd) <+ cpphdl_channel(V(EVALUATE, Vdd), V(cpphdl_n833, Vdd), 0.002, 0.69999999999999996, -1.0);
        // device 448, IC IC71, analog/basic/strongarm_comparator.hpp:41
        I(cpphdl_n827, Vdd) <+ cpphdl_channel(V(EVALUATE, Vdd), V(cpphdl_n827, Vdd), 0.002, 0.69999999999999996, -1.0);
        // device 449, IC IC71, analog/basic/strongarm_comparator.hpp:42
        I(cpphdl_n813, Vss) <+ 2.9999999999999998e-14 * ddt(V(cpphdl_n813, Vss)); // Bench initial voltage = 0.0 V.
        // device 450, IC IC71, analog/basic/strongarm_comparator.hpp:43
        I(cpphdl_n814, Vss) <+ 2.9999999999999998e-14 * ddt(V(cpphdl_n814, Vss)); // Bench initial voltage = 0.0 V.
        // device 451, IC IC71, analog/basic/strongarm_comparator.hpp:44
        I(cpphdl_n815, Vss) <+ 2.9999999999999998e-14 * ddt(V(cpphdl_n815, Vss)); // Bench initial voltage = 0.0 V.
        // device 452, IC IC71, analog/basic/strongarm_comparator.hpp:45
        I(cpphdl_n833, Vss) <+ 5.0000000000000002e-14 * ddt(V(cpphdl_n833, Vss)); // Bench initial voltage = 0.0 V.
        // device 453, IC IC71, analog/basic/strongarm_comparator.hpp:46
        I(cpphdl_n827, Vss) <+ 5.0000000000000002e-14 * ddt(V(cpphdl_n827, Vss)); // Bench initial voltage = 0.0 V.
        // device 454, IC IC71, analog/basic/strongarm_comparator.hpp:47
        I(cpphdl_n808, cpphdl_n815) <+ 2e-14 * ddt(V(cpphdl_n808, cpphdl_n815)); // Bench initial voltage = 3.2999999999999998 V.
        // device 455, IC IC71, analog/basic/strongarm_comparator.hpp:48
        I(cpphdl_n809, cpphdl_n815) <+ 2e-14 * ddt(V(cpphdl_n809, cpphdl_n815)); // Bench initial voltage = 3.2999999999999998 V.
        // device 456, IC IC71, analog/basic/strongarm_comparator.hpp:49
        I(cpphdl_n808, cpphdl_n813) <+ 2.9999999999999998e-15 * ddt(V(cpphdl_n808, cpphdl_n813)); // Bench initial voltage = 3.2999999999999998 V.
        // device 457, IC IC71, analog/basic/strongarm_comparator.hpp:50
        I(cpphdl_n809, cpphdl_n814) <+ 2.9999999999999998e-15 * ddt(V(cpphdl_n809, cpphdl_n814)); // Bench initial voltage = 3.2999999999999998 V.
        // device 458, IC IC73, analog/basic/cmos_logic.hpp:15
        I(cpphdl_n2316, Vss) <+ 5.0000000000000002e-14 * ddt(V(cpphdl_n2316, Vss)); // Bench initial voltage = 0.0 V.
        // device 459, IC IC73, analog/basic/cmos_logic.hpp:16
        I(cpphdl_n2316, Vdd) <+ cpphdl_channel(V(cpphdl_n827, Vdd), V(cpphdl_n2316, Vdd), 0.01, 0.69999999999999996, -1.0);
        // device 460, IC IC73, analog/basic/cmos_logic.hpp:17
        I(cpphdl_n2316, Vdd) <+ cpphdl_channel(V(cpphdl_n835, Vdd), V(cpphdl_n2316, Vdd), 0.01, 0.69999999999999996, -1.0);
        // device 461, IC IC73, analog/basic/cmos_logic.hpp:18
        I(cpphdl_n2316, cpphdl_n830) <+ cpphdl_channel(V(cpphdl_n827, cpphdl_n830), V(cpphdl_n2316, cpphdl_n830), 0.01, 0.69999999999999996, 1.0);
        // device 462, IC IC73, analog/basic/cmos_logic.hpp:19
        I(cpphdl_n830, Vss) <+ cpphdl_channel(V(cpphdl_n835, Vss), V(cpphdl_n830, Vss), 0.01, 0.69999999999999996, 1.0);
        // device 463, IC IC73, analog/basic/cmos_logic.hpp:20
        I(cpphdl_n2316, Vss) <+ V(cpphdl_n2316, Vss) / 1000000000.0;
        // device 464, IC IC73, analog/basic/cmos_logic.hpp:21
        I(cpphdl_n830, Vss) <+ V(cpphdl_n830, Vss) / 1000000000.0;
        // device 465, IC IC74, analog/basic/cmos_logic.hpp:15
        I(cpphdl_n835, Vss) <+ 5.0000000000000002e-14 * ddt(V(cpphdl_n835, Vss)); // Bench initial voltage = 0.0 V.
        // device 466, IC IC74, analog/basic/cmos_logic.hpp:16
        I(cpphdl_n835, Vdd) <+ cpphdl_channel(V(cpphdl_n833, Vdd), V(cpphdl_n835, Vdd), 0.01, 0.69999999999999996, -1.0);
        // device 467, IC IC74, analog/basic/cmos_logic.hpp:17
        I(cpphdl_n835, Vdd) <+ cpphdl_channel(V(cpphdl_n2316, Vdd), V(cpphdl_n835, Vdd), 0.01, 0.69999999999999996, -1.0);
        // device 468, IC IC74, analog/basic/cmos_logic.hpp:18
        I(cpphdl_n835, cpphdl_n836) <+ cpphdl_channel(V(cpphdl_n833, cpphdl_n836), V(cpphdl_n835, cpphdl_n836), 0.01, 0.69999999999999996, 1.0);
        // device 469, IC IC74, analog/basic/cmos_logic.hpp:19
        I(cpphdl_n836, Vss) <+ cpphdl_channel(V(cpphdl_n2316, Vss), V(cpphdl_n836, Vss), 0.01, 0.69999999999999996, 1.0);
        // device 470, IC IC74, analog/basic/cmos_logic.hpp:20
        I(cpphdl_n835, Vss) <+ V(cpphdl_n835, Vss) / 1000000000.0;
        // device 471, IC IC74, analog/basic/cmos_logic.hpp:21
        I(cpphdl_n836, Vss) <+ V(cpphdl_n836, Vss) / 1000000000.0;
        // device 472, IC IC72, analog/basic/nand_latch.hpp:34
        I(cpphdl_n827, Vss) <+ 2.9999999999999998e-15 * ddt(V(cpphdl_n827, Vss)); // Bench initial voltage = 0.0 V.
        // device 473, IC IC72, analog/basic/nand_latch.hpp:35
        I(cpphdl_n833, Vss) <+ 2.9999999999999998e-15 * ddt(V(cpphdl_n833, Vss)); // Bench initial voltage = 0.0 V.
        // device 474, IC IC75, analog/basic/inverter.hpp:11
        I(cpphdl_n841, Vdd) <+ cpphdl_channel(V(CLEAR, Vdd), V(cpphdl_n841, Vdd), 0.01, 0.69999999999999996, -1.0);
        // device 475, IC IC75, analog/basic/inverter.hpp:12
        I(cpphdl_n841, Vss) <+ cpphdl_channel(V(CLEAR, Vss), V(cpphdl_n841, Vss), 0.01, 0.69999999999999996, 1.0);
        // device 476, IC IC72, analog/basic/nand_latch.hpp:56
        I(cpphdl_n841, Vss) <+ 2.9999999999999998e-15 * ddt(V(cpphdl_n841, Vss)); // Bench initial voltage = 0.0 V.
        // device 477, IC IC72, analog/basic/nand_latch.hpp:57
        I(cpphdl_n2316, Vss) <+ cpphdl_channel(V(CLEAR, Vss), V(cpphdl_n2316, Vss), 0.050000000000000003, 0.69999999999999996, 1.0);
        // device 478, IC IC72, analog/basic/nand_latch.hpp:58
        I(cpphdl_n835, Vdd) <+ cpphdl_channel(V(cpphdl_n841, Vdd), V(cpphdl_n835, Vdd), 0.050000000000000003, 0.69999999999999996, -1.0);
        // device 479, IC IC78, analog/basic/inverter.hpp:11
        I(cpphdl_n865, Vdd) <+ cpphdl_channel(V(TRACK4, Vdd), V(cpphdl_n865, Vdd), 0.0040000000000000001, 0.69999999999999996, -1.0);
        // device 480, IC IC78, analog/basic/inverter.hpp:12
        I(cpphdl_n865, Vss) <+ cpphdl_channel(V(TRACK4, Vss), V(cpphdl_n865, Vss), 0.0040000000000000001, 0.69999999999999996, 1.0);
        // device 481, IC IC77, analog/basic/mos_track_hold.hpp:30
        I(cpphdl_n865, Vss) <+ 2e-14 * ddt(V(cpphdl_n865, Vss)); // Bench initial voltage = 3.2999999999999998 V.
        // device 482, IC IC77, analog/basic/mos_track_hold.hpp:31
        I(cpphdl_n2179, cpphdl_n919) <+ cpphdl_channel(V(TRACK4, cpphdl_n919), V(cpphdl_n2179, cpphdl_n919), 0.080000000000000002, 0.69999999999999996, 1.0);
        // device 483, IC IC77, analog/basic/mos_track_hold.hpp:32
        I(cpphdl_n919, cpphdl_n2179) <+ cpphdl_channel(V(cpphdl_n865, cpphdl_n2179), V(cpphdl_n919, cpphdl_n2179), 0.040000000000000001, 0.69999999999999996, -1.0);
        // device 484, IC IC77, analog/basic/mos_track_hold.hpp:36
        I(cpphdl_n919, cpphdl_n919) <+ cpphdl_channel(V(cpphdl_n865, cpphdl_n919), V(cpphdl_n919, cpphdl_n919), 0.040000000000000001, 0.69999999999999996, 1.0);
        // device 485, IC IC77, analog/basic/mos_track_hold.hpp:37
        I(cpphdl_n919, cpphdl_n919) <+ cpphdl_channel(V(TRACK4, cpphdl_n919), V(cpphdl_n919, cpphdl_n919), 0.02, 0.69999999999999996, -1.0);
        // device 486, IC IC77, analog/basic/mos_track_hold.hpp:38
        I(cpphdl_n919, Vss) <+ 2e-12 * ddt(V(cpphdl_n919, Vss)); // Bench initial voltage = 1.6499999999999999 V.
        // device 487, IC IC77, analog/basic/mos_track_hold.hpp:39
        I(Vss, cpphdl_n919) <+ V(Vss, cpphdl_n919) / 1000000000.0;
        // device 488, IC IC77, analog/basic/mos_track_hold.hpp:40
        I(TRACK4, cpphdl_n919) <+ 8.0000000000000006e-15 * ddt(V(TRACK4, cpphdl_n919)); // Bench initial voltage = -1.6499999999999999 V.
        // device 489, IC IC77, analog/basic/mos_track_hold.hpp:41
        I(cpphdl_n865, cpphdl_n919) <+ 8.0000000000000006e-15 * ddt(V(cpphdl_n865, cpphdl_n919)); // Bench initial voltage = 1.6499999999999999 V.
        // device 490, IC IC77, analog/basic/mos_track_hold.hpp:42
        I(cpphdl_n2179, cpphdl_n919) <+ 4.0000000000000003e-15 * ddt(V(cpphdl_n2179, cpphdl_n919)); // Bench initial voltage = 0.0 V.
        // device 491, IC IC80, analog/basic/inverter.hpp:11
        I(cpphdl_n880, Vdd) <+ cpphdl_channel(V(BIT_N4_0, Vdd), V(cpphdl_n880, Vdd), 0.080000000000000002, 0.69999999999999996, -1.0);
        // device 492, IC IC80, analog/basic/inverter.hpp:12
        I(cpphdl_n880, Vss) <+ cpphdl_channel(V(BIT_N4_0, Vss), V(cpphdl_n880, Vss), 0.080000000000000002, 0.69999999999999996, 1.0);
        // device 493, IC IC79, analog/basic/mos_r2r_dac.hpp:27
        I(cpphdl_n880, Vss) <+ 2.9999999999999998e-15 * ddt(V(cpphdl_n880, Vss)); // Bench initial voltage = 0.0 V.
        // device 494, IC IC79, analog/basic/mos_r2r_dac.hpp:28
        I(cpphdl_n880, cpphdl_n909) <+ V(cpphdl_n880, cpphdl_n909) / 20000.0;
        // device 495, IC IC79, analog/basic/mos_r2r_dac.hpp:29
        I(cpphdl_n909, Vss) <+ 2.9999999999999998e-15 * ddt(V(cpphdl_n909, Vss)); // Bench initial voltage = 0.0 V.
        // device 496, IC IC81, analog/basic/inverter.hpp:11
        I(cpphdl_n884, Vdd) <+ cpphdl_channel(V(BIT_N4_1, Vdd), V(cpphdl_n884, Vdd), 0.080000000000000002, 0.69999999999999996, -1.0);
        // device 497, IC IC81, analog/basic/inverter.hpp:12
        I(cpphdl_n884, Vss) <+ cpphdl_channel(V(BIT_N4_1, Vss), V(cpphdl_n884, Vss), 0.080000000000000002, 0.69999999999999996, 1.0);
        // device 498, IC IC79, analog/basic/mos_r2r_dac.hpp:27
        I(cpphdl_n884, Vss) <+ 2.9999999999999998e-15 * ddt(V(cpphdl_n884, Vss)); // Bench initial voltage = 0.0 V.
        // device 499, IC IC79, analog/basic/mos_r2r_dac.hpp:28
        I(cpphdl_n884, cpphdl_n910) <+ V(cpphdl_n884, cpphdl_n910) / 20000.0;
        // device 500, IC IC79, analog/basic/mos_r2r_dac.hpp:29
        I(cpphdl_n910, Vss) <+ 2.9999999999999998e-15 * ddt(V(cpphdl_n910, Vss)); // Bench initial voltage = 0.0 V.
        // device 501, IC IC79, analog/basic/mos_r2r_dac.hpp:31
        I(cpphdl_n909, cpphdl_n910) <+ V(cpphdl_n909, cpphdl_n910) / 10000.0;
        // device 502, IC IC82, analog/basic/inverter.hpp:11
        I(cpphdl_n888, Vdd) <+ cpphdl_channel(V(BIT_N4_2, Vdd), V(cpphdl_n888, Vdd), 0.080000000000000002, 0.69999999999999996, -1.0);
        // device 503, IC IC82, analog/basic/inverter.hpp:12
        I(cpphdl_n888, Vss) <+ cpphdl_channel(V(BIT_N4_2, Vss), V(cpphdl_n888, Vss), 0.080000000000000002, 0.69999999999999996, 1.0);
        // device 504, IC IC79, analog/basic/mos_r2r_dac.hpp:27
        I(cpphdl_n888, Vss) <+ 2.9999999999999998e-15 * ddt(V(cpphdl_n888, Vss)); // Bench initial voltage = 0.0 V.
        // device 505, IC IC79, analog/basic/mos_r2r_dac.hpp:28
        I(cpphdl_n888, cpphdl_n911) <+ V(cpphdl_n888, cpphdl_n911) / 20000.0;
        // device 506, IC IC79, analog/basic/mos_r2r_dac.hpp:29
        I(cpphdl_n911, Vss) <+ 2.9999999999999998e-15 * ddt(V(cpphdl_n911, Vss)); // Bench initial voltage = 0.0 V.
        // device 507, IC IC79, analog/basic/mos_r2r_dac.hpp:31
        I(cpphdl_n910, cpphdl_n911) <+ V(cpphdl_n910, cpphdl_n911) / 10000.0;
        // device 508, IC IC83, analog/basic/inverter.hpp:11
        I(cpphdl_n892, Vdd) <+ cpphdl_channel(V(BIT_N4_3, Vdd), V(cpphdl_n892, Vdd), 0.080000000000000002, 0.69999999999999996, -1.0);
        // device 509, IC IC83, analog/basic/inverter.hpp:12
        I(cpphdl_n892, Vss) <+ cpphdl_channel(V(BIT_N4_3, Vss), V(cpphdl_n892, Vss), 0.080000000000000002, 0.69999999999999996, 1.0);
        // device 510, IC IC79, analog/basic/mos_r2r_dac.hpp:27
        I(cpphdl_n892, Vss) <+ 2.9999999999999998e-15 * ddt(V(cpphdl_n892, Vss)); // Bench initial voltage = 0.0 V.
        // device 511, IC IC79, analog/basic/mos_r2r_dac.hpp:28
        I(cpphdl_n892, cpphdl_n912) <+ V(cpphdl_n892, cpphdl_n912) / 20000.0;
        // device 512, IC IC79, analog/basic/mos_r2r_dac.hpp:29
        I(cpphdl_n912, Vss) <+ 2.9999999999999998e-15 * ddt(V(cpphdl_n912, Vss)); // Bench initial voltage = 0.0 V.
        // device 513, IC IC79, analog/basic/mos_r2r_dac.hpp:31
        I(cpphdl_n911, cpphdl_n912) <+ V(cpphdl_n911, cpphdl_n912) / 10000.0;
        // device 514, IC IC84, analog/basic/inverter.hpp:11
        I(cpphdl_n896, Vdd) <+ cpphdl_channel(V(BIT_N4_4, Vdd), V(cpphdl_n896, Vdd), 0.080000000000000002, 0.69999999999999996, -1.0);
        // device 515, IC IC84, analog/basic/inverter.hpp:12
        I(cpphdl_n896, Vss) <+ cpphdl_channel(V(BIT_N4_4, Vss), V(cpphdl_n896, Vss), 0.080000000000000002, 0.69999999999999996, 1.0);
        // device 516, IC IC79, analog/basic/mos_r2r_dac.hpp:27
        I(cpphdl_n896, Vss) <+ 2.9999999999999998e-15 * ddt(V(cpphdl_n896, Vss)); // Bench initial voltage = 0.0 V.
        // device 517, IC IC79, analog/basic/mos_r2r_dac.hpp:28
        I(cpphdl_n896, cpphdl_n913) <+ V(cpphdl_n896, cpphdl_n913) / 20000.0;
        // device 518, IC IC79, analog/basic/mos_r2r_dac.hpp:29
        I(cpphdl_n913, Vss) <+ 2.9999999999999998e-15 * ddt(V(cpphdl_n913, Vss)); // Bench initial voltage = 0.0 V.
        // device 519, IC IC79, analog/basic/mos_r2r_dac.hpp:31
        I(cpphdl_n912, cpphdl_n913) <+ V(cpphdl_n912, cpphdl_n913) / 10000.0;
        // device 520, IC IC85, analog/basic/inverter.hpp:11
        I(cpphdl_n900, Vdd) <+ cpphdl_channel(V(BIT_N4_5, Vdd), V(cpphdl_n900, Vdd), 0.080000000000000002, 0.69999999999999996, -1.0);
        // device 521, IC IC85, analog/basic/inverter.hpp:12
        I(cpphdl_n900, Vss) <+ cpphdl_channel(V(BIT_N4_5, Vss), V(cpphdl_n900, Vss), 0.080000000000000002, 0.69999999999999996, 1.0);
        // device 522, IC IC79, analog/basic/mos_r2r_dac.hpp:27
        I(cpphdl_n900, Vss) <+ 2.9999999999999998e-15 * ddt(V(cpphdl_n900, Vss)); // Bench initial voltage = 0.0 V.
        // device 523, IC IC79, analog/basic/mos_r2r_dac.hpp:28
        I(cpphdl_n900, cpphdl_n914) <+ V(cpphdl_n900, cpphdl_n914) / 20000.0;
        // device 524, IC IC79, analog/basic/mos_r2r_dac.hpp:29
        I(cpphdl_n914, Vss) <+ 2.9999999999999998e-15 * ddt(V(cpphdl_n914, Vss)); // Bench initial voltage = 0.0 V.
        // device 525, IC IC79, analog/basic/mos_r2r_dac.hpp:31
        I(cpphdl_n913, cpphdl_n914) <+ V(cpphdl_n913, cpphdl_n914) / 10000.0;
        // device 526, IC IC86, analog/basic/inverter.hpp:11
        I(cpphdl_n904, Vdd) <+ cpphdl_channel(V(BIT_N4_6, Vdd), V(cpphdl_n904, Vdd), 0.080000000000000002, 0.69999999999999996, -1.0);
        // device 527, IC IC86, analog/basic/inverter.hpp:12
        I(cpphdl_n904, Vss) <+ cpphdl_channel(V(BIT_N4_6, Vss), V(cpphdl_n904, Vss), 0.080000000000000002, 0.69999999999999996, 1.0);
        // device 528, IC IC79, analog/basic/mos_r2r_dac.hpp:27
        I(cpphdl_n904, Vss) <+ 2.9999999999999998e-15 * ddt(V(cpphdl_n904, Vss)); // Bench initial voltage = 0.0 V.
        // device 529, IC IC79, analog/basic/mos_r2r_dac.hpp:28
        I(cpphdl_n904, cpphdl_n915) <+ V(cpphdl_n904, cpphdl_n915) / 20000.0;
        // device 530, IC IC79, analog/basic/mos_r2r_dac.hpp:29
        I(cpphdl_n915, Vss) <+ 2.9999999999999998e-15 * ddt(V(cpphdl_n915, Vss)); // Bench initial voltage = 0.0 V.
        // device 531, IC IC79, analog/basic/mos_r2r_dac.hpp:31
        I(cpphdl_n914, cpphdl_n915) <+ V(cpphdl_n914, cpphdl_n915) / 10000.0;
        // device 532, IC IC87, analog/basic/inverter.hpp:11
        I(cpphdl_n908, Vdd) <+ cpphdl_channel(V(BIT_N4_7, Vdd), V(cpphdl_n908, Vdd), 0.080000000000000002, 0.69999999999999996, -1.0);
        // device 533, IC IC87, analog/basic/inverter.hpp:12
        I(cpphdl_n908, Vss) <+ cpphdl_channel(V(BIT_N4_7, Vss), V(cpphdl_n908, Vss), 0.080000000000000002, 0.69999999999999996, 1.0);
        // device 534, IC IC79, analog/basic/mos_r2r_dac.hpp:27
        I(cpphdl_n908, Vss) <+ 2.9999999999999998e-15 * ddt(V(cpphdl_n908, Vss)); // Bench initial voltage = 0.0 V.
        // device 535, IC IC79, analog/basic/mos_r2r_dac.hpp:28
        I(cpphdl_n908, cpphdl_n920) <+ V(cpphdl_n908, cpphdl_n920) / 20000.0;
        // device 536, IC IC79, analog/basic/mos_r2r_dac.hpp:29
        I(cpphdl_n920, Vss) <+ 2.9999999999999998e-15 * ddt(V(cpphdl_n920, Vss)); // Bench initial voltage = 0.0 V.
        // device 537, IC IC79, analog/basic/mos_r2r_dac.hpp:31
        I(cpphdl_n915, cpphdl_n920) <+ V(cpphdl_n915, cpphdl_n920) / 10000.0;
        // device 538, IC IC79, analog/basic/mos_r2r_dac.hpp:33
        I(Vss, cpphdl_n909) <+ V(Vss, cpphdl_n909) / 20000.0;
        // device 539, IC IC88, analog/basic/nmos_resistor_amplifier.hpp:23
        I(Vdd, cpphdl_n929) <+ V(Vdd, cpphdl_n929) / 1000.0;
        // device 540, IC IC88, analog/basic/nmos_resistor_amplifier.hpp:24
        I(Vdd, cpphdl_n928) <+ V(Vdd, cpphdl_n928) / 1000.0;
        // device 541, IC IC88, analog/basic/nmos_resistor_amplifier.hpp:25
        I(cpphdl_n929, cpphdl_n923) <+ cpphdl_channel(V(cpphdl_n919, cpphdl_n923), V(cpphdl_n929, cpphdl_n923), 0.014999999999999999, 0.69999999999999996, 1.0);
        // device 542, IC IC88, analog/basic/nmos_resistor_amplifier.hpp:26
        I(cpphdl_n928, cpphdl_n924) <+ cpphdl_channel(V(cpphdl_n920, cpphdl_n924), V(cpphdl_n928, cpphdl_n924), 0.014999999999999999, 0.69999999999999996, 1.0);
        // device 543, IC IC88, analog/basic/nmos_resistor_amplifier.hpp:27
        I(cpphdl_n925, cpphdl_n923) <+ V(cpphdl_n925, cpphdl_n923) / 50.0;
        // device 544, IC IC88, analog/basic/nmos_resistor_amplifier.hpp:28
        I(cpphdl_n925, cpphdl_n924) <+ V(cpphdl_n925, cpphdl_n924) / 50.0;
        // device 545, IC IC88, analog/basic/nmos_resistor_amplifier.hpp:29
        I(Vss, cpphdl_n925) <+ V(Vss, cpphdl_n925) / 150.0;
        // device 546, IC IC88, analog/basic/nmos_resistor_amplifier.hpp:30
        I(cpphdl_n929, Vdd) <+ 2.9999999999999998e-13 * ddt(V(cpphdl_n929, Vdd)); // Bench initial voltage = 0.0 V.
        // device 547, IC IC88, analog/basic/nmos_resistor_amplifier.hpp:31
        I(cpphdl_n928, Vdd) <+ 2.9999999999999998e-13 * ddt(V(cpphdl_n928, Vdd)); // Bench initial voltage = 0.0 V.
        // device 548, IC IC88, analog/basic/nmos_resistor_amplifier.hpp:32
        I(cpphdl_n925, Vss) <+ 4e-14 * ddt(V(cpphdl_n925, Vss)); // Bench initial voltage = 0.0 V.
        // device 549, IC IC88, analog/basic/nmos_resistor_amplifier.hpp:34
        I(cpphdl_n919, cpphdl_n923) <+ 2e-14 * ddt(V(cpphdl_n919, cpphdl_n923)); // Bench initial voltage = 1.6499999999999999 V.
        // device 550, IC IC88, analog/basic/nmos_resistor_amplifier.hpp:35
        I(cpphdl_n920, cpphdl_n924) <+ 2e-14 * ddt(V(cpphdl_n920, cpphdl_n924)); // Bench initial voltage = 0.0 V.
        // device 551, IC IC88, analog/basic/nmos_resistor_amplifier.hpp:36
        I(cpphdl_n919, cpphdl_n929) <+ 2.9999999999999998e-15 * ddt(V(cpphdl_n919, cpphdl_n929)); // Bench initial voltage = -1.6499999999999999 V.
        // device 552, IC IC88, analog/basic/nmos_resistor_amplifier.hpp:37
        I(cpphdl_n920, cpphdl_n928) <+ 2.9999999999999998e-15 * ddt(V(cpphdl_n920, cpphdl_n928)); // Bench initial voltage = -3.2999999999999998 V.
        // device 553, IC IC89, analog/basic/strongarm_comparator.hpp:28
        I(cpphdl_n933, cpphdl_n935) <+ cpphdl_channel(V(cpphdl_n928, cpphdl_n935), V(cpphdl_n933, cpphdl_n935), 0.0080000000000000002, 0.69999999999999996, 1.0);
        // device 554, IC IC89, analog/basic/strongarm_comparator.hpp:29
        I(cpphdl_n934, cpphdl_n935) <+ cpphdl_channel(V(cpphdl_n929, cpphdl_n935), V(cpphdl_n934, cpphdl_n935), 0.0080000000000000002, 0.69999999999999996, 1.0);
        // device 555, IC IC89, analog/basic/strongarm_comparator.hpp:30
        I(cpphdl_n935, Vss) <+ cpphdl_channel(V(EVALUATE, Vss), V(cpphdl_n935, Vss), 0.0080000000000000002, 0.69999999999999996, 1.0);
        // device 556, IC IC89, analog/basic/strongarm_comparator.hpp:33
        I(cpphdl_n947, cpphdl_n933) <+ cpphdl_channel(V(cpphdl_n953, cpphdl_n933), V(cpphdl_n947, cpphdl_n933), 0.0040000000000000001, 0.69999999999999996, 1.0);
        // device 557, IC IC89, analog/basic/strongarm_comparator.hpp:34
        I(cpphdl_n953, cpphdl_n934) <+ cpphdl_channel(V(cpphdl_n947, cpphdl_n934), V(cpphdl_n953, cpphdl_n934), 0.0040000000000000001, 0.69999999999999996, 1.0);
        // device 558, IC IC89, analog/basic/strongarm_comparator.hpp:35
        I(cpphdl_n953, Vdd) <+ cpphdl_channel(V(cpphdl_n947, Vdd), V(cpphdl_n953, Vdd), 0.002, 0.69999999999999996, -1.0);
        // device 559, IC IC89, analog/basic/strongarm_comparator.hpp:36
        I(cpphdl_n947, Vdd) <+ cpphdl_channel(V(cpphdl_n953, Vdd), V(cpphdl_n947, Vdd), 0.002, 0.69999999999999996, -1.0);
        // device 560, IC IC89, analog/basic/strongarm_comparator.hpp:38
        I(cpphdl_n933, Vdd) <+ cpphdl_channel(V(EVALUATE, Vdd), V(cpphdl_n933, Vdd), 0.002, 0.69999999999999996, -1.0);
        // device 561, IC IC89, analog/basic/strongarm_comparator.hpp:39
        I(cpphdl_n934, Vdd) <+ cpphdl_channel(V(EVALUATE, Vdd), V(cpphdl_n934, Vdd), 0.002, 0.69999999999999996, -1.0);
        // device 562, IC IC89, analog/basic/strongarm_comparator.hpp:40
        I(cpphdl_n953, Vdd) <+ cpphdl_channel(V(EVALUATE, Vdd), V(cpphdl_n953, Vdd), 0.002, 0.69999999999999996, -1.0);
        // device 563, IC IC89, analog/basic/strongarm_comparator.hpp:41
        I(cpphdl_n947, Vdd) <+ cpphdl_channel(V(EVALUATE, Vdd), V(cpphdl_n947, Vdd), 0.002, 0.69999999999999996, -1.0);
        // device 564, IC IC89, analog/basic/strongarm_comparator.hpp:42
        I(cpphdl_n933, Vss) <+ 2.9999999999999998e-14 * ddt(V(cpphdl_n933, Vss)); // Bench initial voltage = 0.0 V.
        // device 565, IC IC89, analog/basic/strongarm_comparator.hpp:43
        I(cpphdl_n934, Vss) <+ 2.9999999999999998e-14 * ddt(V(cpphdl_n934, Vss)); // Bench initial voltage = 0.0 V.
        // device 566, IC IC89, analog/basic/strongarm_comparator.hpp:44
        I(cpphdl_n935, Vss) <+ 2.9999999999999998e-14 * ddt(V(cpphdl_n935, Vss)); // Bench initial voltage = 0.0 V.
        // device 567, IC IC89, analog/basic/strongarm_comparator.hpp:45
        I(cpphdl_n953, Vss) <+ 5.0000000000000002e-14 * ddt(V(cpphdl_n953, Vss)); // Bench initial voltage = 0.0 V.
        // device 568, IC IC89, analog/basic/strongarm_comparator.hpp:46
        I(cpphdl_n947, Vss) <+ 5.0000000000000002e-14 * ddt(V(cpphdl_n947, Vss)); // Bench initial voltage = 0.0 V.
        // device 569, IC IC89, analog/basic/strongarm_comparator.hpp:47
        I(cpphdl_n928, cpphdl_n935) <+ 2e-14 * ddt(V(cpphdl_n928, cpphdl_n935)); // Bench initial voltage = 3.2999999999999998 V.
        // device 570, IC IC89, analog/basic/strongarm_comparator.hpp:48
        I(cpphdl_n929, cpphdl_n935) <+ 2e-14 * ddt(V(cpphdl_n929, cpphdl_n935)); // Bench initial voltage = 3.2999999999999998 V.
        // device 571, IC IC89, analog/basic/strongarm_comparator.hpp:49
        I(cpphdl_n928, cpphdl_n933) <+ 2.9999999999999998e-15 * ddt(V(cpphdl_n928, cpphdl_n933)); // Bench initial voltage = 3.2999999999999998 V.
        // device 572, IC IC89, analog/basic/strongarm_comparator.hpp:50
        I(cpphdl_n929, cpphdl_n934) <+ 2.9999999999999998e-15 * ddt(V(cpphdl_n929, cpphdl_n934)); // Bench initial voltage = 3.2999999999999998 V.
        // device 573, IC IC91, analog/basic/cmos_logic.hpp:15
        I(cpphdl_n2321, Vss) <+ 5.0000000000000002e-14 * ddt(V(cpphdl_n2321, Vss)); // Bench initial voltage = 0.0 V.
        // device 574, IC IC91, analog/basic/cmos_logic.hpp:16
        I(cpphdl_n2321, Vdd) <+ cpphdl_channel(V(cpphdl_n947, Vdd), V(cpphdl_n2321, Vdd), 0.01, 0.69999999999999996, -1.0);
        // device 575, IC IC91, analog/basic/cmos_logic.hpp:17
        I(cpphdl_n2321, Vdd) <+ cpphdl_channel(V(cpphdl_n955, Vdd), V(cpphdl_n2321, Vdd), 0.01, 0.69999999999999996, -1.0);
        // device 576, IC IC91, analog/basic/cmos_logic.hpp:18
        I(cpphdl_n2321, cpphdl_n950) <+ cpphdl_channel(V(cpphdl_n947, cpphdl_n950), V(cpphdl_n2321, cpphdl_n950), 0.01, 0.69999999999999996, 1.0);
        // device 577, IC IC91, analog/basic/cmos_logic.hpp:19
        I(cpphdl_n950, Vss) <+ cpphdl_channel(V(cpphdl_n955, Vss), V(cpphdl_n950, Vss), 0.01, 0.69999999999999996, 1.0);
        // device 578, IC IC91, analog/basic/cmos_logic.hpp:20
        I(cpphdl_n2321, Vss) <+ V(cpphdl_n2321, Vss) / 1000000000.0;
        // device 579, IC IC91, analog/basic/cmos_logic.hpp:21
        I(cpphdl_n950, Vss) <+ V(cpphdl_n950, Vss) / 1000000000.0;
        // device 580, IC IC92, analog/basic/cmos_logic.hpp:15
        I(cpphdl_n955, Vss) <+ 5.0000000000000002e-14 * ddt(V(cpphdl_n955, Vss)); // Bench initial voltage = 0.0 V.
        // device 581, IC IC92, analog/basic/cmos_logic.hpp:16
        I(cpphdl_n955, Vdd) <+ cpphdl_channel(V(cpphdl_n953, Vdd), V(cpphdl_n955, Vdd), 0.01, 0.69999999999999996, -1.0);
        // device 582, IC IC92, analog/basic/cmos_logic.hpp:17
        I(cpphdl_n955, Vdd) <+ cpphdl_channel(V(cpphdl_n2321, Vdd), V(cpphdl_n955, Vdd), 0.01, 0.69999999999999996, -1.0);
        // device 583, IC IC92, analog/basic/cmos_logic.hpp:18
        I(cpphdl_n955, cpphdl_n956) <+ cpphdl_channel(V(cpphdl_n953, cpphdl_n956), V(cpphdl_n955, cpphdl_n956), 0.01, 0.69999999999999996, 1.0);
        // device 584, IC IC92, analog/basic/cmos_logic.hpp:19
        I(cpphdl_n956, Vss) <+ cpphdl_channel(V(cpphdl_n2321, Vss), V(cpphdl_n956, Vss), 0.01, 0.69999999999999996, 1.0);
        // device 585, IC IC92, analog/basic/cmos_logic.hpp:20
        I(cpphdl_n955, Vss) <+ V(cpphdl_n955, Vss) / 1000000000.0;
        // device 586, IC IC92, analog/basic/cmos_logic.hpp:21
        I(cpphdl_n956, Vss) <+ V(cpphdl_n956, Vss) / 1000000000.0;
        // device 587, IC IC90, analog/basic/nand_latch.hpp:34
        I(cpphdl_n947, Vss) <+ 2.9999999999999998e-15 * ddt(V(cpphdl_n947, Vss)); // Bench initial voltage = 0.0 V.
        // device 588, IC IC90, analog/basic/nand_latch.hpp:35
        I(cpphdl_n953, Vss) <+ 2.9999999999999998e-15 * ddt(V(cpphdl_n953, Vss)); // Bench initial voltage = 0.0 V.
        // device 589, IC IC93, analog/basic/inverter.hpp:11
        I(cpphdl_n961, Vdd) <+ cpphdl_channel(V(CLEAR, Vdd), V(cpphdl_n961, Vdd), 0.01, 0.69999999999999996, -1.0);
        // device 590, IC IC93, analog/basic/inverter.hpp:12
        I(cpphdl_n961, Vss) <+ cpphdl_channel(V(CLEAR, Vss), V(cpphdl_n961, Vss), 0.01, 0.69999999999999996, 1.0);
        // device 591, IC IC90, analog/basic/nand_latch.hpp:56
        I(cpphdl_n961, Vss) <+ 2.9999999999999998e-15 * ddt(V(cpphdl_n961, Vss)); // Bench initial voltage = 0.0 V.
        // device 592, IC IC90, analog/basic/nand_latch.hpp:57
        I(cpphdl_n2321, Vss) <+ cpphdl_channel(V(CLEAR, Vss), V(cpphdl_n2321, Vss), 0.050000000000000003, 0.69999999999999996, 1.0);
        // device 593, IC IC90, analog/basic/nand_latch.hpp:58
        I(cpphdl_n955, Vdd) <+ cpphdl_channel(V(cpphdl_n961, Vdd), V(cpphdl_n955, Vdd), 0.050000000000000003, 0.69999999999999996, -1.0);
        // device 594, IC IC96, analog/basic/inverter.hpp:11
        I(cpphdl_n985, Vdd) <+ cpphdl_channel(V(TRACK5, Vdd), V(cpphdl_n985, Vdd), 0.0040000000000000001, 0.69999999999999996, -1.0);
        // device 595, IC IC96, analog/basic/inverter.hpp:12
        I(cpphdl_n985, Vss) <+ cpphdl_channel(V(TRACK5, Vss), V(cpphdl_n985, Vss), 0.0040000000000000001, 0.69999999999999996, 1.0);
        // device 596, IC IC95, analog/basic/mos_track_hold.hpp:30
        I(cpphdl_n985, Vss) <+ 2e-14 * ddt(V(cpphdl_n985, Vss)); // Bench initial voltage = 3.2999999999999998 V.
        // device 597, IC IC95, analog/basic/mos_track_hold.hpp:31
        I(cpphdl_n2179, cpphdl_n1039) <+ cpphdl_channel(V(TRACK5, cpphdl_n1039), V(cpphdl_n2179, cpphdl_n1039), 0.080000000000000002, 0.69999999999999996, 1.0);
        // device 598, IC IC95, analog/basic/mos_track_hold.hpp:32
        I(cpphdl_n1039, cpphdl_n2179) <+ cpphdl_channel(V(cpphdl_n985, cpphdl_n2179), V(cpphdl_n1039, cpphdl_n2179), 0.040000000000000001, 0.69999999999999996, -1.0);
        // device 599, IC IC95, analog/basic/mos_track_hold.hpp:36
        I(cpphdl_n1039, cpphdl_n1039) <+ cpphdl_channel(V(cpphdl_n985, cpphdl_n1039), V(cpphdl_n1039, cpphdl_n1039), 0.040000000000000001, 0.69999999999999996, 1.0);
        // device 600, IC IC95, analog/basic/mos_track_hold.hpp:37
        I(cpphdl_n1039, cpphdl_n1039) <+ cpphdl_channel(V(TRACK5, cpphdl_n1039), V(cpphdl_n1039, cpphdl_n1039), 0.02, 0.69999999999999996, -1.0);
        // device 601, IC IC95, analog/basic/mos_track_hold.hpp:38
        I(cpphdl_n1039, Vss) <+ 2e-12 * ddt(V(cpphdl_n1039, Vss)); // Bench initial voltage = 1.6499999999999999 V.
        // device 602, IC IC95, analog/basic/mos_track_hold.hpp:39
        I(Vss, cpphdl_n1039) <+ V(Vss, cpphdl_n1039) / 1000000000.0;
        // device 603, IC IC95, analog/basic/mos_track_hold.hpp:40
        I(TRACK5, cpphdl_n1039) <+ 8.0000000000000006e-15 * ddt(V(TRACK5, cpphdl_n1039)); // Bench initial voltage = -1.6499999999999999 V.
        // device 604, IC IC95, analog/basic/mos_track_hold.hpp:41
        I(cpphdl_n985, cpphdl_n1039) <+ 8.0000000000000006e-15 * ddt(V(cpphdl_n985, cpphdl_n1039)); // Bench initial voltage = 1.6499999999999999 V.
        // device 605, IC IC95, analog/basic/mos_track_hold.hpp:42
        I(cpphdl_n2179, cpphdl_n1039) <+ 4.0000000000000003e-15 * ddt(V(cpphdl_n2179, cpphdl_n1039)); // Bench initial voltage = 0.0 V.
        // device 606, IC IC98, analog/basic/inverter.hpp:11
        I(cpphdl_n1000, Vdd) <+ cpphdl_channel(V(BIT_N5_0, Vdd), V(cpphdl_n1000, Vdd), 0.080000000000000002, 0.69999999999999996, -1.0);
        // device 607, IC IC98, analog/basic/inverter.hpp:12
        I(cpphdl_n1000, Vss) <+ cpphdl_channel(V(BIT_N5_0, Vss), V(cpphdl_n1000, Vss), 0.080000000000000002, 0.69999999999999996, 1.0);
        // device 608, IC IC97, analog/basic/mos_r2r_dac.hpp:27
        I(cpphdl_n1000, Vss) <+ 2.9999999999999998e-15 * ddt(V(cpphdl_n1000, Vss)); // Bench initial voltage = 0.0 V.
        // device 609, IC IC97, analog/basic/mos_r2r_dac.hpp:28
        I(cpphdl_n1000, cpphdl_n1029) <+ V(cpphdl_n1000, cpphdl_n1029) / 20000.0;
        // device 610, IC IC97, analog/basic/mos_r2r_dac.hpp:29
        I(cpphdl_n1029, Vss) <+ 2.9999999999999998e-15 * ddt(V(cpphdl_n1029, Vss)); // Bench initial voltage = 0.0 V.
        // device 611, IC IC99, analog/basic/inverter.hpp:11
        I(cpphdl_n1004, Vdd) <+ cpphdl_channel(V(BIT_N5_1, Vdd), V(cpphdl_n1004, Vdd), 0.080000000000000002, 0.69999999999999996, -1.0);
        // device 612, IC IC99, analog/basic/inverter.hpp:12
        I(cpphdl_n1004, Vss) <+ cpphdl_channel(V(BIT_N5_1, Vss), V(cpphdl_n1004, Vss), 0.080000000000000002, 0.69999999999999996, 1.0);
        // device 613, IC IC97, analog/basic/mos_r2r_dac.hpp:27
        I(cpphdl_n1004, Vss) <+ 2.9999999999999998e-15 * ddt(V(cpphdl_n1004, Vss)); // Bench initial voltage = 0.0 V.
        // device 614, IC IC97, analog/basic/mos_r2r_dac.hpp:28
        I(cpphdl_n1004, cpphdl_n1030) <+ V(cpphdl_n1004, cpphdl_n1030) / 20000.0;
        // device 615, IC IC97, analog/basic/mos_r2r_dac.hpp:29
        I(cpphdl_n1030, Vss) <+ 2.9999999999999998e-15 * ddt(V(cpphdl_n1030, Vss)); // Bench initial voltage = 0.0 V.
        // device 616, IC IC97, analog/basic/mos_r2r_dac.hpp:31
        I(cpphdl_n1029, cpphdl_n1030) <+ V(cpphdl_n1029, cpphdl_n1030) / 10000.0;
        // device 617, IC IC100, analog/basic/inverter.hpp:11
        I(cpphdl_n1008, Vdd) <+ cpphdl_channel(V(BIT_N5_2, Vdd), V(cpphdl_n1008, Vdd), 0.080000000000000002, 0.69999999999999996, -1.0);
        // device 618, IC IC100, analog/basic/inverter.hpp:12
        I(cpphdl_n1008, Vss) <+ cpphdl_channel(V(BIT_N5_2, Vss), V(cpphdl_n1008, Vss), 0.080000000000000002, 0.69999999999999996, 1.0);
        // device 619, IC IC97, analog/basic/mos_r2r_dac.hpp:27
        I(cpphdl_n1008, Vss) <+ 2.9999999999999998e-15 * ddt(V(cpphdl_n1008, Vss)); // Bench initial voltage = 0.0 V.
        // device 620, IC IC97, analog/basic/mos_r2r_dac.hpp:28
        I(cpphdl_n1008, cpphdl_n1031) <+ V(cpphdl_n1008, cpphdl_n1031) / 20000.0;
        // device 621, IC IC97, analog/basic/mos_r2r_dac.hpp:29
        I(cpphdl_n1031, Vss) <+ 2.9999999999999998e-15 * ddt(V(cpphdl_n1031, Vss)); // Bench initial voltage = 0.0 V.
        // device 622, IC IC97, analog/basic/mos_r2r_dac.hpp:31
        I(cpphdl_n1030, cpphdl_n1031) <+ V(cpphdl_n1030, cpphdl_n1031) / 10000.0;
        // device 623, IC IC101, analog/basic/inverter.hpp:11
        I(cpphdl_n1012, Vdd) <+ cpphdl_channel(V(BIT_N5_3, Vdd), V(cpphdl_n1012, Vdd), 0.080000000000000002, 0.69999999999999996, -1.0);
        // device 624, IC IC101, analog/basic/inverter.hpp:12
        I(cpphdl_n1012, Vss) <+ cpphdl_channel(V(BIT_N5_3, Vss), V(cpphdl_n1012, Vss), 0.080000000000000002, 0.69999999999999996, 1.0);
        // device 625, IC IC97, analog/basic/mos_r2r_dac.hpp:27
        I(cpphdl_n1012, Vss) <+ 2.9999999999999998e-15 * ddt(V(cpphdl_n1012, Vss)); // Bench initial voltage = 0.0 V.
        // device 626, IC IC97, analog/basic/mos_r2r_dac.hpp:28
        I(cpphdl_n1012, cpphdl_n1032) <+ V(cpphdl_n1012, cpphdl_n1032) / 20000.0;
        // device 627, IC IC97, analog/basic/mos_r2r_dac.hpp:29
        I(cpphdl_n1032, Vss) <+ 2.9999999999999998e-15 * ddt(V(cpphdl_n1032, Vss)); // Bench initial voltage = 0.0 V.
        // device 628, IC IC97, analog/basic/mos_r2r_dac.hpp:31
        I(cpphdl_n1031, cpphdl_n1032) <+ V(cpphdl_n1031, cpphdl_n1032) / 10000.0;
        // device 629, IC IC102, analog/basic/inverter.hpp:11
        I(cpphdl_n1016, Vdd) <+ cpphdl_channel(V(BIT_N5_4, Vdd), V(cpphdl_n1016, Vdd), 0.080000000000000002, 0.69999999999999996, -1.0);
        // device 630, IC IC102, analog/basic/inverter.hpp:12
        I(cpphdl_n1016, Vss) <+ cpphdl_channel(V(BIT_N5_4, Vss), V(cpphdl_n1016, Vss), 0.080000000000000002, 0.69999999999999996, 1.0);
        // device 631, IC IC97, analog/basic/mos_r2r_dac.hpp:27
        I(cpphdl_n1016, Vss) <+ 2.9999999999999998e-15 * ddt(V(cpphdl_n1016, Vss)); // Bench initial voltage = 0.0 V.
        // device 632, IC IC97, analog/basic/mos_r2r_dac.hpp:28
        I(cpphdl_n1016, cpphdl_n1033) <+ V(cpphdl_n1016, cpphdl_n1033) / 20000.0;
        // device 633, IC IC97, analog/basic/mos_r2r_dac.hpp:29
        I(cpphdl_n1033, Vss) <+ 2.9999999999999998e-15 * ddt(V(cpphdl_n1033, Vss)); // Bench initial voltage = 0.0 V.
        // device 634, IC IC97, analog/basic/mos_r2r_dac.hpp:31
        I(cpphdl_n1032, cpphdl_n1033) <+ V(cpphdl_n1032, cpphdl_n1033) / 10000.0;
        // device 635, IC IC103, analog/basic/inverter.hpp:11
        I(cpphdl_n1020, Vdd) <+ cpphdl_channel(V(BIT_N5_5, Vdd), V(cpphdl_n1020, Vdd), 0.080000000000000002, 0.69999999999999996, -1.0);
        // device 636, IC IC103, analog/basic/inverter.hpp:12
        I(cpphdl_n1020, Vss) <+ cpphdl_channel(V(BIT_N5_5, Vss), V(cpphdl_n1020, Vss), 0.080000000000000002, 0.69999999999999996, 1.0);
        // device 637, IC IC97, analog/basic/mos_r2r_dac.hpp:27
        I(cpphdl_n1020, Vss) <+ 2.9999999999999998e-15 * ddt(V(cpphdl_n1020, Vss)); // Bench initial voltage = 0.0 V.
        // device 638, IC IC97, analog/basic/mos_r2r_dac.hpp:28
        I(cpphdl_n1020, cpphdl_n1034) <+ V(cpphdl_n1020, cpphdl_n1034) / 20000.0;
        // device 639, IC IC97, analog/basic/mos_r2r_dac.hpp:29
        I(cpphdl_n1034, Vss) <+ 2.9999999999999998e-15 * ddt(V(cpphdl_n1034, Vss)); // Bench initial voltage = 0.0 V.
        // device 640, IC IC97, analog/basic/mos_r2r_dac.hpp:31
        I(cpphdl_n1033, cpphdl_n1034) <+ V(cpphdl_n1033, cpphdl_n1034) / 10000.0;
        // device 641, IC IC104, analog/basic/inverter.hpp:11
        I(cpphdl_n1024, Vdd) <+ cpphdl_channel(V(BIT_N5_6, Vdd), V(cpphdl_n1024, Vdd), 0.080000000000000002, 0.69999999999999996, -1.0);
        // device 642, IC IC104, analog/basic/inverter.hpp:12
        I(cpphdl_n1024, Vss) <+ cpphdl_channel(V(BIT_N5_6, Vss), V(cpphdl_n1024, Vss), 0.080000000000000002, 0.69999999999999996, 1.0);
        // device 643, IC IC97, analog/basic/mos_r2r_dac.hpp:27
        I(cpphdl_n1024, Vss) <+ 2.9999999999999998e-15 * ddt(V(cpphdl_n1024, Vss)); // Bench initial voltage = 0.0 V.
        // device 644, IC IC97, analog/basic/mos_r2r_dac.hpp:28
        I(cpphdl_n1024, cpphdl_n1035) <+ V(cpphdl_n1024, cpphdl_n1035) / 20000.0;
        // device 645, IC IC97, analog/basic/mos_r2r_dac.hpp:29
        I(cpphdl_n1035, Vss) <+ 2.9999999999999998e-15 * ddt(V(cpphdl_n1035, Vss)); // Bench initial voltage = 0.0 V.
        // device 646, IC IC97, analog/basic/mos_r2r_dac.hpp:31
        I(cpphdl_n1034, cpphdl_n1035) <+ V(cpphdl_n1034, cpphdl_n1035) / 10000.0;
        // device 647, IC IC105, analog/basic/inverter.hpp:11
        I(cpphdl_n1028, Vdd) <+ cpphdl_channel(V(BIT_N5_7, Vdd), V(cpphdl_n1028, Vdd), 0.080000000000000002, 0.69999999999999996, -1.0);
        // device 648, IC IC105, analog/basic/inverter.hpp:12
        I(cpphdl_n1028, Vss) <+ cpphdl_channel(V(BIT_N5_7, Vss), V(cpphdl_n1028, Vss), 0.080000000000000002, 0.69999999999999996, 1.0);
        // device 649, IC IC97, analog/basic/mos_r2r_dac.hpp:27
        I(cpphdl_n1028, Vss) <+ 2.9999999999999998e-15 * ddt(V(cpphdl_n1028, Vss)); // Bench initial voltage = 0.0 V.
        // device 650, IC IC97, analog/basic/mos_r2r_dac.hpp:28
        I(cpphdl_n1028, cpphdl_n1040) <+ V(cpphdl_n1028, cpphdl_n1040) / 20000.0;
        // device 651, IC IC97, analog/basic/mos_r2r_dac.hpp:29
        I(cpphdl_n1040, Vss) <+ 2.9999999999999998e-15 * ddt(V(cpphdl_n1040, Vss)); // Bench initial voltage = 0.0 V.
        // device 652, IC IC97, analog/basic/mos_r2r_dac.hpp:31
        I(cpphdl_n1035, cpphdl_n1040) <+ V(cpphdl_n1035, cpphdl_n1040) / 10000.0;
        // device 653, IC IC97, analog/basic/mos_r2r_dac.hpp:33
        I(Vss, cpphdl_n1029) <+ V(Vss, cpphdl_n1029) / 20000.0;
        // device 654, IC IC106, analog/basic/nmos_resistor_amplifier.hpp:23
        I(Vdd, cpphdl_n1049) <+ V(Vdd, cpphdl_n1049) / 1000.0;
        // device 655, IC IC106, analog/basic/nmos_resistor_amplifier.hpp:24
        I(Vdd, cpphdl_n1048) <+ V(Vdd, cpphdl_n1048) / 1000.0;
        // device 656, IC IC106, analog/basic/nmos_resistor_amplifier.hpp:25
        I(cpphdl_n1049, cpphdl_n1043) <+ cpphdl_channel(V(cpphdl_n1039, cpphdl_n1043), V(cpphdl_n1049, cpphdl_n1043), 0.014999999999999999, 0.69999999999999996, 1.0);
        // device 657, IC IC106, analog/basic/nmos_resistor_amplifier.hpp:26
        I(cpphdl_n1048, cpphdl_n1044) <+ cpphdl_channel(V(cpphdl_n1040, cpphdl_n1044), V(cpphdl_n1048, cpphdl_n1044), 0.014999999999999999, 0.69999999999999996, 1.0);
        // device 658, IC IC106, analog/basic/nmos_resistor_amplifier.hpp:27
        I(cpphdl_n1045, cpphdl_n1043) <+ V(cpphdl_n1045, cpphdl_n1043) / 50.0;
        // device 659, IC IC106, analog/basic/nmos_resistor_amplifier.hpp:28
        I(cpphdl_n1045, cpphdl_n1044) <+ V(cpphdl_n1045, cpphdl_n1044) / 50.0;
        // device 660, IC IC106, analog/basic/nmos_resistor_amplifier.hpp:29
        I(Vss, cpphdl_n1045) <+ V(Vss, cpphdl_n1045) / 150.0;
        // device 661, IC IC106, analog/basic/nmos_resistor_amplifier.hpp:30
        I(cpphdl_n1049, Vdd) <+ 2.9999999999999998e-13 * ddt(V(cpphdl_n1049, Vdd)); // Bench initial voltage = 0.0 V.
        // device 662, IC IC106, analog/basic/nmos_resistor_amplifier.hpp:31
        I(cpphdl_n1048, Vdd) <+ 2.9999999999999998e-13 * ddt(V(cpphdl_n1048, Vdd)); // Bench initial voltage = 0.0 V.
        // device 663, IC IC106, analog/basic/nmos_resistor_amplifier.hpp:32
        I(cpphdl_n1045, Vss) <+ 4e-14 * ddt(V(cpphdl_n1045, Vss)); // Bench initial voltage = 0.0 V.
        // device 664, IC IC106, analog/basic/nmos_resistor_amplifier.hpp:34
        I(cpphdl_n1039, cpphdl_n1043) <+ 2e-14 * ddt(V(cpphdl_n1039, cpphdl_n1043)); // Bench initial voltage = 1.6499999999999999 V.
        // device 665, IC IC106, analog/basic/nmos_resistor_amplifier.hpp:35
        I(cpphdl_n1040, cpphdl_n1044) <+ 2e-14 * ddt(V(cpphdl_n1040, cpphdl_n1044)); // Bench initial voltage = 0.0 V.
        // device 666, IC IC106, analog/basic/nmos_resistor_amplifier.hpp:36
        I(cpphdl_n1039, cpphdl_n1049) <+ 2.9999999999999998e-15 * ddt(V(cpphdl_n1039, cpphdl_n1049)); // Bench initial voltage = -1.6499999999999999 V.
        // device 667, IC IC106, analog/basic/nmos_resistor_amplifier.hpp:37
        I(cpphdl_n1040, cpphdl_n1048) <+ 2.9999999999999998e-15 * ddt(V(cpphdl_n1040, cpphdl_n1048)); // Bench initial voltage = -3.2999999999999998 V.
        // device 668, IC IC107, analog/basic/strongarm_comparator.hpp:28
        I(cpphdl_n1053, cpphdl_n1055) <+ cpphdl_channel(V(cpphdl_n1048, cpphdl_n1055), V(cpphdl_n1053, cpphdl_n1055), 0.0080000000000000002, 0.69999999999999996, 1.0);
        // device 669, IC IC107, analog/basic/strongarm_comparator.hpp:29
        I(cpphdl_n1054, cpphdl_n1055) <+ cpphdl_channel(V(cpphdl_n1049, cpphdl_n1055), V(cpphdl_n1054, cpphdl_n1055), 0.0080000000000000002, 0.69999999999999996, 1.0);
        // device 670, IC IC107, analog/basic/strongarm_comparator.hpp:30
        I(cpphdl_n1055, Vss) <+ cpphdl_channel(V(EVALUATE, Vss), V(cpphdl_n1055, Vss), 0.0080000000000000002, 0.69999999999999996, 1.0);
        // device 671, IC IC107, analog/basic/strongarm_comparator.hpp:33
        I(cpphdl_n1067, cpphdl_n1053) <+ cpphdl_channel(V(cpphdl_n1073, cpphdl_n1053), V(cpphdl_n1067, cpphdl_n1053), 0.0040000000000000001, 0.69999999999999996, 1.0);
        // device 672, IC IC107, analog/basic/strongarm_comparator.hpp:34
        I(cpphdl_n1073, cpphdl_n1054) <+ cpphdl_channel(V(cpphdl_n1067, cpphdl_n1054), V(cpphdl_n1073, cpphdl_n1054), 0.0040000000000000001, 0.69999999999999996, 1.0);
        // device 673, IC IC107, analog/basic/strongarm_comparator.hpp:35
        I(cpphdl_n1073, Vdd) <+ cpphdl_channel(V(cpphdl_n1067, Vdd), V(cpphdl_n1073, Vdd), 0.002, 0.69999999999999996, -1.0);
        // device 674, IC IC107, analog/basic/strongarm_comparator.hpp:36
        I(cpphdl_n1067, Vdd) <+ cpphdl_channel(V(cpphdl_n1073, Vdd), V(cpphdl_n1067, Vdd), 0.002, 0.69999999999999996, -1.0);
        // device 675, IC IC107, analog/basic/strongarm_comparator.hpp:38
        I(cpphdl_n1053, Vdd) <+ cpphdl_channel(V(EVALUATE, Vdd), V(cpphdl_n1053, Vdd), 0.002, 0.69999999999999996, -1.0);
        // device 676, IC IC107, analog/basic/strongarm_comparator.hpp:39
        I(cpphdl_n1054, Vdd) <+ cpphdl_channel(V(EVALUATE, Vdd), V(cpphdl_n1054, Vdd), 0.002, 0.69999999999999996, -1.0);
        // device 677, IC IC107, analog/basic/strongarm_comparator.hpp:40
        I(cpphdl_n1073, Vdd) <+ cpphdl_channel(V(EVALUATE, Vdd), V(cpphdl_n1073, Vdd), 0.002, 0.69999999999999996, -1.0);
        // device 678, IC IC107, analog/basic/strongarm_comparator.hpp:41
        I(cpphdl_n1067, Vdd) <+ cpphdl_channel(V(EVALUATE, Vdd), V(cpphdl_n1067, Vdd), 0.002, 0.69999999999999996, -1.0);
        // device 679, IC IC107, analog/basic/strongarm_comparator.hpp:42
        I(cpphdl_n1053, Vss) <+ 2.9999999999999998e-14 * ddt(V(cpphdl_n1053, Vss)); // Bench initial voltage = 0.0 V.
        // device 680, IC IC107, analog/basic/strongarm_comparator.hpp:43
        I(cpphdl_n1054, Vss) <+ 2.9999999999999998e-14 * ddt(V(cpphdl_n1054, Vss)); // Bench initial voltage = 0.0 V.
        // device 681, IC IC107, analog/basic/strongarm_comparator.hpp:44
        I(cpphdl_n1055, Vss) <+ 2.9999999999999998e-14 * ddt(V(cpphdl_n1055, Vss)); // Bench initial voltage = 0.0 V.
        // device 682, IC IC107, analog/basic/strongarm_comparator.hpp:45
        I(cpphdl_n1073, Vss) <+ 5.0000000000000002e-14 * ddt(V(cpphdl_n1073, Vss)); // Bench initial voltage = 0.0 V.
        // device 683, IC IC107, analog/basic/strongarm_comparator.hpp:46
        I(cpphdl_n1067, Vss) <+ 5.0000000000000002e-14 * ddt(V(cpphdl_n1067, Vss)); // Bench initial voltage = 0.0 V.
        // device 684, IC IC107, analog/basic/strongarm_comparator.hpp:47
        I(cpphdl_n1048, cpphdl_n1055) <+ 2e-14 * ddt(V(cpphdl_n1048, cpphdl_n1055)); // Bench initial voltage = 3.2999999999999998 V.
        // device 685, IC IC107, analog/basic/strongarm_comparator.hpp:48
        I(cpphdl_n1049, cpphdl_n1055) <+ 2e-14 * ddt(V(cpphdl_n1049, cpphdl_n1055)); // Bench initial voltage = 3.2999999999999998 V.
        // device 686, IC IC107, analog/basic/strongarm_comparator.hpp:49
        I(cpphdl_n1048, cpphdl_n1053) <+ 2.9999999999999998e-15 * ddt(V(cpphdl_n1048, cpphdl_n1053)); // Bench initial voltage = 3.2999999999999998 V.
        // device 687, IC IC107, analog/basic/strongarm_comparator.hpp:50
        I(cpphdl_n1049, cpphdl_n1054) <+ 2.9999999999999998e-15 * ddt(V(cpphdl_n1049, cpphdl_n1054)); // Bench initial voltage = 3.2999999999999998 V.
        // device 688, IC IC109, analog/basic/cmos_logic.hpp:15
        I(cpphdl_n2326, Vss) <+ 5.0000000000000002e-14 * ddt(V(cpphdl_n2326, Vss)); // Bench initial voltage = 0.0 V.
        // device 689, IC IC109, analog/basic/cmos_logic.hpp:16
        I(cpphdl_n2326, Vdd) <+ cpphdl_channel(V(cpphdl_n1067, Vdd), V(cpphdl_n2326, Vdd), 0.01, 0.69999999999999996, -1.0);
        // device 690, IC IC109, analog/basic/cmos_logic.hpp:17
        I(cpphdl_n2326, Vdd) <+ cpphdl_channel(V(cpphdl_n1075, Vdd), V(cpphdl_n2326, Vdd), 0.01, 0.69999999999999996, -1.0);
        // device 691, IC IC109, analog/basic/cmos_logic.hpp:18
        I(cpphdl_n2326, cpphdl_n1070) <+ cpphdl_channel(V(cpphdl_n1067, cpphdl_n1070), V(cpphdl_n2326, cpphdl_n1070), 0.01, 0.69999999999999996, 1.0);
        // device 692, IC IC109, analog/basic/cmos_logic.hpp:19
        I(cpphdl_n1070, Vss) <+ cpphdl_channel(V(cpphdl_n1075, Vss), V(cpphdl_n1070, Vss), 0.01, 0.69999999999999996, 1.0);
        // device 693, IC IC109, analog/basic/cmos_logic.hpp:20
        I(cpphdl_n2326, Vss) <+ V(cpphdl_n2326, Vss) / 1000000000.0;
        // device 694, IC IC109, analog/basic/cmos_logic.hpp:21
        I(cpphdl_n1070, Vss) <+ V(cpphdl_n1070, Vss) / 1000000000.0;
        // device 695, IC IC110, analog/basic/cmos_logic.hpp:15
        I(cpphdl_n1075, Vss) <+ 5.0000000000000002e-14 * ddt(V(cpphdl_n1075, Vss)); // Bench initial voltage = 0.0 V.
        // device 696, IC IC110, analog/basic/cmos_logic.hpp:16
        I(cpphdl_n1075, Vdd) <+ cpphdl_channel(V(cpphdl_n1073, Vdd), V(cpphdl_n1075, Vdd), 0.01, 0.69999999999999996, -1.0);
        // device 697, IC IC110, analog/basic/cmos_logic.hpp:17
        I(cpphdl_n1075, Vdd) <+ cpphdl_channel(V(cpphdl_n2326, Vdd), V(cpphdl_n1075, Vdd), 0.01, 0.69999999999999996, -1.0);
        // device 698, IC IC110, analog/basic/cmos_logic.hpp:18
        I(cpphdl_n1075, cpphdl_n1076) <+ cpphdl_channel(V(cpphdl_n1073, cpphdl_n1076), V(cpphdl_n1075, cpphdl_n1076), 0.01, 0.69999999999999996, 1.0);
        // device 699, IC IC110, analog/basic/cmos_logic.hpp:19
        I(cpphdl_n1076, Vss) <+ cpphdl_channel(V(cpphdl_n2326, Vss), V(cpphdl_n1076, Vss), 0.01, 0.69999999999999996, 1.0);
        // device 700, IC IC110, analog/basic/cmos_logic.hpp:20
        I(cpphdl_n1075, Vss) <+ V(cpphdl_n1075, Vss) / 1000000000.0;
        // device 701, IC IC110, analog/basic/cmos_logic.hpp:21
        I(cpphdl_n1076, Vss) <+ V(cpphdl_n1076, Vss) / 1000000000.0;
        // device 702, IC IC108, analog/basic/nand_latch.hpp:34
        I(cpphdl_n1067, Vss) <+ 2.9999999999999998e-15 * ddt(V(cpphdl_n1067, Vss)); // Bench initial voltage = 0.0 V.
        // device 703, IC IC108, analog/basic/nand_latch.hpp:35
        I(cpphdl_n1073, Vss) <+ 2.9999999999999998e-15 * ddt(V(cpphdl_n1073, Vss)); // Bench initial voltage = 0.0 V.
        // device 704, IC IC111, analog/basic/inverter.hpp:11
        I(cpphdl_n1081, Vdd) <+ cpphdl_channel(V(CLEAR, Vdd), V(cpphdl_n1081, Vdd), 0.01, 0.69999999999999996, -1.0);
        // device 705, IC IC111, analog/basic/inverter.hpp:12
        I(cpphdl_n1081, Vss) <+ cpphdl_channel(V(CLEAR, Vss), V(cpphdl_n1081, Vss), 0.01, 0.69999999999999996, 1.0);
        // device 706, IC IC108, analog/basic/nand_latch.hpp:56
        I(cpphdl_n1081, Vss) <+ 2.9999999999999998e-15 * ddt(V(cpphdl_n1081, Vss)); // Bench initial voltage = 0.0 V.
        // device 707, IC IC108, analog/basic/nand_latch.hpp:57
        I(cpphdl_n2326, Vss) <+ cpphdl_channel(V(CLEAR, Vss), V(cpphdl_n2326, Vss), 0.050000000000000003, 0.69999999999999996, 1.0);
        // device 708, IC IC108, analog/basic/nand_latch.hpp:58
        I(cpphdl_n1075, Vdd) <+ cpphdl_channel(V(cpphdl_n1081, Vdd), V(cpphdl_n1075, Vdd), 0.050000000000000003, 0.69999999999999996, -1.0);
        // device 709, IC IC114, analog/basic/inverter.hpp:11
        I(cpphdl_n1105, Vdd) <+ cpphdl_channel(V(TRACK6, Vdd), V(cpphdl_n1105, Vdd), 0.0040000000000000001, 0.69999999999999996, -1.0);
        // device 710, IC IC114, analog/basic/inverter.hpp:12
        I(cpphdl_n1105, Vss) <+ cpphdl_channel(V(TRACK6, Vss), V(cpphdl_n1105, Vss), 0.0040000000000000001, 0.69999999999999996, 1.0);
        // device 711, IC IC113, analog/basic/mos_track_hold.hpp:30
        I(cpphdl_n1105, Vss) <+ 2e-14 * ddt(V(cpphdl_n1105, Vss)); // Bench initial voltage = 3.2999999999999998 V.
        // device 712, IC IC113, analog/basic/mos_track_hold.hpp:31
        I(cpphdl_n2179, cpphdl_n1159) <+ cpphdl_channel(V(TRACK6, cpphdl_n1159), V(cpphdl_n2179, cpphdl_n1159), 0.080000000000000002, 0.69999999999999996, 1.0);
        // device 713, IC IC113, analog/basic/mos_track_hold.hpp:32
        I(cpphdl_n1159, cpphdl_n2179) <+ cpphdl_channel(V(cpphdl_n1105, cpphdl_n2179), V(cpphdl_n1159, cpphdl_n2179), 0.040000000000000001, 0.69999999999999996, -1.0);
        // device 714, IC IC113, analog/basic/mos_track_hold.hpp:36
        I(cpphdl_n1159, cpphdl_n1159) <+ cpphdl_channel(V(cpphdl_n1105, cpphdl_n1159), V(cpphdl_n1159, cpphdl_n1159), 0.040000000000000001, 0.69999999999999996, 1.0);
        // device 715, IC IC113, analog/basic/mos_track_hold.hpp:37
        I(cpphdl_n1159, cpphdl_n1159) <+ cpphdl_channel(V(TRACK6, cpphdl_n1159), V(cpphdl_n1159, cpphdl_n1159), 0.02, 0.69999999999999996, -1.0);
        // device 716, IC IC113, analog/basic/mos_track_hold.hpp:38
        I(cpphdl_n1159, Vss) <+ 2e-12 * ddt(V(cpphdl_n1159, Vss)); // Bench initial voltage = 1.6499999999999999 V.
        // device 717, IC IC113, analog/basic/mos_track_hold.hpp:39
        I(Vss, cpphdl_n1159) <+ V(Vss, cpphdl_n1159) / 1000000000.0;
        // device 718, IC IC113, analog/basic/mos_track_hold.hpp:40
        I(TRACK6, cpphdl_n1159) <+ 8.0000000000000006e-15 * ddt(V(TRACK6, cpphdl_n1159)); // Bench initial voltage = -1.6499999999999999 V.
        // device 719, IC IC113, analog/basic/mos_track_hold.hpp:41
        I(cpphdl_n1105, cpphdl_n1159) <+ 8.0000000000000006e-15 * ddt(V(cpphdl_n1105, cpphdl_n1159)); // Bench initial voltage = 1.6499999999999999 V.
        // device 720, IC IC113, analog/basic/mos_track_hold.hpp:42
        I(cpphdl_n2179, cpphdl_n1159) <+ 4.0000000000000003e-15 * ddt(V(cpphdl_n2179, cpphdl_n1159)); // Bench initial voltage = 0.0 V.
        // device 721, IC IC116, analog/basic/inverter.hpp:11
        I(cpphdl_n1120, Vdd) <+ cpphdl_channel(V(BIT_N6_0, Vdd), V(cpphdl_n1120, Vdd), 0.080000000000000002, 0.69999999999999996, -1.0);
        // device 722, IC IC116, analog/basic/inverter.hpp:12
        I(cpphdl_n1120, Vss) <+ cpphdl_channel(V(BIT_N6_0, Vss), V(cpphdl_n1120, Vss), 0.080000000000000002, 0.69999999999999996, 1.0);
        // device 723, IC IC115, analog/basic/mos_r2r_dac.hpp:27
        I(cpphdl_n1120, Vss) <+ 2.9999999999999998e-15 * ddt(V(cpphdl_n1120, Vss)); // Bench initial voltage = 0.0 V.
        // device 724, IC IC115, analog/basic/mos_r2r_dac.hpp:28
        I(cpphdl_n1120, cpphdl_n1149) <+ V(cpphdl_n1120, cpphdl_n1149) / 20000.0;
        // device 725, IC IC115, analog/basic/mos_r2r_dac.hpp:29
        I(cpphdl_n1149, Vss) <+ 2.9999999999999998e-15 * ddt(V(cpphdl_n1149, Vss)); // Bench initial voltage = 0.0 V.
        // device 726, IC IC117, analog/basic/inverter.hpp:11
        I(cpphdl_n1124, Vdd) <+ cpphdl_channel(V(BIT_N6_1, Vdd), V(cpphdl_n1124, Vdd), 0.080000000000000002, 0.69999999999999996, -1.0);
        // device 727, IC IC117, analog/basic/inverter.hpp:12
        I(cpphdl_n1124, Vss) <+ cpphdl_channel(V(BIT_N6_1, Vss), V(cpphdl_n1124, Vss), 0.080000000000000002, 0.69999999999999996, 1.0);
        // device 728, IC IC115, analog/basic/mos_r2r_dac.hpp:27
        I(cpphdl_n1124, Vss) <+ 2.9999999999999998e-15 * ddt(V(cpphdl_n1124, Vss)); // Bench initial voltage = 0.0 V.
        // device 729, IC IC115, analog/basic/mos_r2r_dac.hpp:28
        I(cpphdl_n1124, cpphdl_n1150) <+ V(cpphdl_n1124, cpphdl_n1150) / 20000.0;
        // device 730, IC IC115, analog/basic/mos_r2r_dac.hpp:29
        I(cpphdl_n1150, Vss) <+ 2.9999999999999998e-15 * ddt(V(cpphdl_n1150, Vss)); // Bench initial voltage = 0.0 V.
        // device 731, IC IC115, analog/basic/mos_r2r_dac.hpp:31
        I(cpphdl_n1149, cpphdl_n1150) <+ V(cpphdl_n1149, cpphdl_n1150) / 10000.0;
        // device 732, IC IC118, analog/basic/inverter.hpp:11
        I(cpphdl_n1128, Vdd) <+ cpphdl_channel(V(BIT_N6_2, Vdd), V(cpphdl_n1128, Vdd), 0.080000000000000002, 0.69999999999999996, -1.0);
        // device 733, IC IC118, analog/basic/inverter.hpp:12
        I(cpphdl_n1128, Vss) <+ cpphdl_channel(V(BIT_N6_2, Vss), V(cpphdl_n1128, Vss), 0.080000000000000002, 0.69999999999999996, 1.0);
        // device 734, IC IC115, analog/basic/mos_r2r_dac.hpp:27
        I(cpphdl_n1128, Vss) <+ 2.9999999999999998e-15 * ddt(V(cpphdl_n1128, Vss)); // Bench initial voltage = 0.0 V.
        // device 735, IC IC115, analog/basic/mos_r2r_dac.hpp:28
        I(cpphdl_n1128, cpphdl_n1151) <+ V(cpphdl_n1128, cpphdl_n1151) / 20000.0;
        // device 736, IC IC115, analog/basic/mos_r2r_dac.hpp:29
        I(cpphdl_n1151, Vss) <+ 2.9999999999999998e-15 * ddt(V(cpphdl_n1151, Vss)); // Bench initial voltage = 0.0 V.
        // device 737, IC IC115, analog/basic/mos_r2r_dac.hpp:31
        I(cpphdl_n1150, cpphdl_n1151) <+ V(cpphdl_n1150, cpphdl_n1151) / 10000.0;
        // device 738, IC IC119, analog/basic/inverter.hpp:11
        I(cpphdl_n1132, Vdd) <+ cpphdl_channel(V(BIT_N6_3, Vdd), V(cpphdl_n1132, Vdd), 0.080000000000000002, 0.69999999999999996, -1.0);
        // device 739, IC IC119, analog/basic/inverter.hpp:12
        I(cpphdl_n1132, Vss) <+ cpphdl_channel(V(BIT_N6_3, Vss), V(cpphdl_n1132, Vss), 0.080000000000000002, 0.69999999999999996, 1.0);
        // device 740, IC IC115, analog/basic/mos_r2r_dac.hpp:27
        I(cpphdl_n1132, Vss) <+ 2.9999999999999998e-15 * ddt(V(cpphdl_n1132, Vss)); // Bench initial voltage = 0.0 V.
        // device 741, IC IC115, analog/basic/mos_r2r_dac.hpp:28
        I(cpphdl_n1132, cpphdl_n1152) <+ V(cpphdl_n1132, cpphdl_n1152) / 20000.0;
        // device 742, IC IC115, analog/basic/mos_r2r_dac.hpp:29
        I(cpphdl_n1152, Vss) <+ 2.9999999999999998e-15 * ddt(V(cpphdl_n1152, Vss)); // Bench initial voltage = 0.0 V.
        // device 743, IC IC115, analog/basic/mos_r2r_dac.hpp:31
        I(cpphdl_n1151, cpphdl_n1152) <+ V(cpphdl_n1151, cpphdl_n1152) / 10000.0;
        // device 744, IC IC120, analog/basic/inverter.hpp:11
        I(cpphdl_n1136, Vdd) <+ cpphdl_channel(V(BIT_N6_4, Vdd), V(cpphdl_n1136, Vdd), 0.080000000000000002, 0.69999999999999996, -1.0);
        // device 745, IC IC120, analog/basic/inverter.hpp:12
        I(cpphdl_n1136, Vss) <+ cpphdl_channel(V(BIT_N6_4, Vss), V(cpphdl_n1136, Vss), 0.080000000000000002, 0.69999999999999996, 1.0);
        // device 746, IC IC115, analog/basic/mos_r2r_dac.hpp:27
        I(cpphdl_n1136, Vss) <+ 2.9999999999999998e-15 * ddt(V(cpphdl_n1136, Vss)); // Bench initial voltage = 0.0 V.
        // device 747, IC IC115, analog/basic/mos_r2r_dac.hpp:28
        I(cpphdl_n1136, cpphdl_n1153) <+ V(cpphdl_n1136, cpphdl_n1153) / 20000.0;
        // device 748, IC IC115, analog/basic/mos_r2r_dac.hpp:29
        I(cpphdl_n1153, Vss) <+ 2.9999999999999998e-15 * ddt(V(cpphdl_n1153, Vss)); // Bench initial voltage = 0.0 V.
        // device 749, IC IC115, analog/basic/mos_r2r_dac.hpp:31
        I(cpphdl_n1152, cpphdl_n1153) <+ V(cpphdl_n1152, cpphdl_n1153) / 10000.0;
        // device 750, IC IC121, analog/basic/inverter.hpp:11
        I(cpphdl_n1140, Vdd) <+ cpphdl_channel(V(BIT_N6_5, Vdd), V(cpphdl_n1140, Vdd), 0.080000000000000002, 0.69999999999999996, -1.0);
        // device 751, IC IC121, analog/basic/inverter.hpp:12
        I(cpphdl_n1140, Vss) <+ cpphdl_channel(V(BIT_N6_5, Vss), V(cpphdl_n1140, Vss), 0.080000000000000002, 0.69999999999999996, 1.0);
        // device 752, IC IC115, analog/basic/mos_r2r_dac.hpp:27
        I(cpphdl_n1140, Vss) <+ 2.9999999999999998e-15 * ddt(V(cpphdl_n1140, Vss)); // Bench initial voltage = 0.0 V.
        // device 753, IC IC115, analog/basic/mos_r2r_dac.hpp:28
        I(cpphdl_n1140, cpphdl_n1154) <+ V(cpphdl_n1140, cpphdl_n1154) / 20000.0;
        // device 754, IC IC115, analog/basic/mos_r2r_dac.hpp:29
        I(cpphdl_n1154, Vss) <+ 2.9999999999999998e-15 * ddt(V(cpphdl_n1154, Vss)); // Bench initial voltage = 0.0 V.
        // device 755, IC IC115, analog/basic/mos_r2r_dac.hpp:31
        I(cpphdl_n1153, cpphdl_n1154) <+ V(cpphdl_n1153, cpphdl_n1154) / 10000.0;
        // device 756, IC IC122, analog/basic/inverter.hpp:11
        I(cpphdl_n1144, Vdd) <+ cpphdl_channel(V(BIT_N6_6, Vdd), V(cpphdl_n1144, Vdd), 0.080000000000000002, 0.69999999999999996, -1.0);
        // device 757, IC IC122, analog/basic/inverter.hpp:12
        I(cpphdl_n1144, Vss) <+ cpphdl_channel(V(BIT_N6_6, Vss), V(cpphdl_n1144, Vss), 0.080000000000000002, 0.69999999999999996, 1.0);
        // device 758, IC IC115, analog/basic/mos_r2r_dac.hpp:27
        I(cpphdl_n1144, Vss) <+ 2.9999999999999998e-15 * ddt(V(cpphdl_n1144, Vss)); // Bench initial voltage = 0.0 V.
        // device 759, IC IC115, analog/basic/mos_r2r_dac.hpp:28
        I(cpphdl_n1144, cpphdl_n1155) <+ V(cpphdl_n1144, cpphdl_n1155) / 20000.0;
        // device 760, IC IC115, analog/basic/mos_r2r_dac.hpp:29
        I(cpphdl_n1155, Vss) <+ 2.9999999999999998e-15 * ddt(V(cpphdl_n1155, Vss)); // Bench initial voltage = 0.0 V.
        // device 761, IC IC115, analog/basic/mos_r2r_dac.hpp:31
        I(cpphdl_n1154, cpphdl_n1155) <+ V(cpphdl_n1154, cpphdl_n1155) / 10000.0;
        // device 762, IC IC123, analog/basic/inverter.hpp:11
        I(cpphdl_n1148, Vdd) <+ cpphdl_channel(V(BIT_N6_7, Vdd), V(cpphdl_n1148, Vdd), 0.080000000000000002, 0.69999999999999996, -1.0);
        // device 763, IC IC123, analog/basic/inverter.hpp:12
        I(cpphdl_n1148, Vss) <+ cpphdl_channel(V(BIT_N6_7, Vss), V(cpphdl_n1148, Vss), 0.080000000000000002, 0.69999999999999996, 1.0);
        // device 764, IC IC115, analog/basic/mos_r2r_dac.hpp:27
        I(cpphdl_n1148, Vss) <+ 2.9999999999999998e-15 * ddt(V(cpphdl_n1148, Vss)); // Bench initial voltage = 0.0 V.
        // device 765, IC IC115, analog/basic/mos_r2r_dac.hpp:28
        I(cpphdl_n1148, cpphdl_n1160) <+ V(cpphdl_n1148, cpphdl_n1160) / 20000.0;
        // device 766, IC IC115, analog/basic/mos_r2r_dac.hpp:29
        I(cpphdl_n1160, Vss) <+ 2.9999999999999998e-15 * ddt(V(cpphdl_n1160, Vss)); // Bench initial voltage = 0.0 V.
        // device 767, IC IC115, analog/basic/mos_r2r_dac.hpp:31
        I(cpphdl_n1155, cpphdl_n1160) <+ V(cpphdl_n1155, cpphdl_n1160) / 10000.0;
        // device 768, IC IC115, analog/basic/mos_r2r_dac.hpp:33
        I(Vss, cpphdl_n1149) <+ V(Vss, cpphdl_n1149) / 20000.0;
        // device 769, IC IC124, analog/basic/nmos_resistor_amplifier.hpp:23
        I(Vdd, cpphdl_n1169) <+ V(Vdd, cpphdl_n1169) / 1000.0;
        // device 770, IC IC124, analog/basic/nmos_resistor_amplifier.hpp:24
        I(Vdd, cpphdl_n1168) <+ V(Vdd, cpphdl_n1168) / 1000.0;
        // device 771, IC IC124, analog/basic/nmos_resistor_amplifier.hpp:25
        I(cpphdl_n1169, cpphdl_n1163) <+ cpphdl_channel(V(cpphdl_n1159, cpphdl_n1163), V(cpphdl_n1169, cpphdl_n1163), 0.014999999999999999, 0.69999999999999996, 1.0);
        // device 772, IC IC124, analog/basic/nmos_resistor_amplifier.hpp:26
        I(cpphdl_n1168, cpphdl_n1164) <+ cpphdl_channel(V(cpphdl_n1160, cpphdl_n1164), V(cpphdl_n1168, cpphdl_n1164), 0.014999999999999999, 0.69999999999999996, 1.0);
        // device 773, IC IC124, analog/basic/nmos_resistor_amplifier.hpp:27
        I(cpphdl_n1165, cpphdl_n1163) <+ V(cpphdl_n1165, cpphdl_n1163) / 50.0;
        // device 774, IC IC124, analog/basic/nmos_resistor_amplifier.hpp:28
        I(cpphdl_n1165, cpphdl_n1164) <+ V(cpphdl_n1165, cpphdl_n1164) / 50.0;
        // device 775, IC IC124, analog/basic/nmos_resistor_amplifier.hpp:29
        I(Vss, cpphdl_n1165) <+ V(Vss, cpphdl_n1165) / 150.0;
        // device 776, IC IC124, analog/basic/nmos_resistor_amplifier.hpp:30
        I(cpphdl_n1169, Vdd) <+ 2.9999999999999998e-13 * ddt(V(cpphdl_n1169, Vdd)); // Bench initial voltage = 0.0 V.
        // device 777, IC IC124, analog/basic/nmos_resistor_amplifier.hpp:31
        I(cpphdl_n1168, Vdd) <+ 2.9999999999999998e-13 * ddt(V(cpphdl_n1168, Vdd)); // Bench initial voltage = 0.0 V.
        // device 778, IC IC124, analog/basic/nmos_resistor_amplifier.hpp:32
        I(cpphdl_n1165, Vss) <+ 4e-14 * ddt(V(cpphdl_n1165, Vss)); // Bench initial voltage = 0.0 V.
        // device 779, IC IC124, analog/basic/nmos_resistor_amplifier.hpp:34
        I(cpphdl_n1159, cpphdl_n1163) <+ 2e-14 * ddt(V(cpphdl_n1159, cpphdl_n1163)); // Bench initial voltage = 1.6499999999999999 V.
        // device 780, IC IC124, analog/basic/nmos_resistor_amplifier.hpp:35
        I(cpphdl_n1160, cpphdl_n1164) <+ 2e-14 * ddt(V(cpphdl_n1160, cpphdl_n1164)); // Bench initial voltage = 0.0 V.
        // device 781, IC IC124, analog/basic/nmos_resistor_amplifier.hpp:36
        I(cpphdl_n1159, cpphdl_n1169) <+ 2.9999999999999998e-15 * ddt(V(cpphdl_n1159, cpphdl_n1169)); // Bench initial voltage = -1.6499999999999999 V.
        // device 782, IC IC124, analog/basic/nmos_resistor_amplifier.hpp:37
        I(cpphdl_n1160, cpphdl_n1168) <+ 2.9999999999999998e-15 * ddt(V(cpphdl_n1160, cpphdl_n1168)); // Bench initial voltage = -3.2999999999999998 V.
        // device 783, IC IC125, analog/basic/strongarm_comparator.hpp:28
        I(cpphdl_n1173, cpphdl_n1175) <+ cpphdl_channel(V(cpphdl_n1168, cpphdl_n1175), V(cpphdl_n1173, cpphdl_n1175), 0.0080000000000000002, 0.69999999999999996, 1.0);
        // device 784, IC IC125, analog/basic/strongarm_comparator.hpp:29
        I(cpphdl_n1174, cpphdl_n1175) <+ cpphdl_channel(V(cpphdl_n1169, cpphdl_n1175), V(cpphdl_n1174, cpphdl_n1175), 0.0080000000000000002, 0.69999999999999996, 1.0);
        // device 785, IC IC125, analog/basic/strongarm_comparator.hpp:30
        I(cpphdl_n1175, Vss) <+ cpphdl_channel(V(EVALUATE, Vss), V(cpphdl_n1175, Vss), 0.0080000000000000002, 0.69999999999999996, 1.0);
        // device 786, IC IC125, analog/basic/strongarm_comparator.hpp:33
        I(cpphdl_n1187, cpphdl_n1173) <+ cpphdl_channel(V(cpphdl_n1193, cpphdl_n1173), V(cpphdl_n1187, cpphdl_n1173), 0.0040000000000000001, 0.69999999999999996, 1.0);
        // device 787, IC IC125, analog/basic/strongarm_comparator.hpp:34
        I(cpphdl_n1193, cpphdl_n1174) <+ cpphdl_channel(V(cpphdl_n1187, cpphdl_n1174), V(cpphdl_n1193, cpphdl_n1174), 0.0040000000000000001, 0.69999999999999996, 1.0);
        // device 788, IC IC125, analog/basic/strongarm_comparator.hpp:35
        I(cpphdl_n1193, Vdd) <+ cpphdl_channel(V(cpphdl_n1187, Vdd), V(cpphdl_n1193, Vdd), 0.002, 0.69999999999999996, -1.0);
        // device 789, IC IC125, analog/basic/strongarm_comparator.hpp:36
        I(cpphdl_n1187, Vdd) <+ cpphdl_channel(V(cpphdl_n1193, Vdd), V(cpphdl_n1187, Vdd), 0.002, 0.69999999999999996, -1.0);
        // device 790, IC IC125, analog/basic/strongarm_comparator.hpp:38
        I(cpphdl_n1173, Vdd) <+ cpphdl_channel(V(EVALUATE, Vdd), V(cpphdl_n1173, Vdd), 0.002, 0.69999999999999996, -1.0);
        // device 791, IC IC125, analog/basic/strongarm_comparator.hpp:39
        I(cpphdl_n1174, Vdd) <+ cpphdl_channel(V(EVALUATE, Vdd), V(cpphdl_n1174, Vdd), 0.002, 0.69999999999999996, -1.0);
        // device 792, IC IC125, analog/basic/strongarm_comparator.hpp:40
        I(cpphdl_n1193, Vdd) <+ cpphdl_channel(V(EVALUATE, Vdd), V(cpphdl_n1193, Vdd), 0.002, 0.69999999999999996, -1.0);
        // device 793, IC IC125, analog/basic/strongarm_comparator.hpp:41
        I(cpphdl_n1187, Vdd) <+ cpphdl_channel(V(EVALUATE, Vdd), V(cpphdl_n1187, Vdd), 0.002, 0.69999999999999996, -1.0);
        // device 794, IC IC125, analog/basic/strongarm_comparator.hpp:42
        I(cpphdl_n1173, Vss) <+ 2.9999999999999998e-14 * ddt(V(cpphdl_n1173, Vss)); // Bench initial voltage = 0.0 V.
        // device 795, IC IC125, analog/basic/strongarm_comparator.hpp:43
        I(cpphdl_n1174, Vss) <+ 2.9999999999999998e-14 * ddt(V(cpphdl_n1174, Vss)); // Bench initial voltage = 0.0 V.
        // device 796, IC IC125, analog/basic/strongarm_comparator.hpp:44
        I(cpphdl_n1175, Vss) <+ 2.9999999999999998e-14 * ddt(V(cpphdl_n1175, Vss)); // Bench initial voltage = 0.0 V.
        // device 797, IC IC125, analog/basic/strongarm_comparator.hpp:45
        I(cpphdl_n1193, Vss) <+ 5.0000000000000002e-14 * ddt(V(cpphdl_n1193, Vss)); // Bench initial voltage = 0.0 V.
        // device 798, IC IC125, analog/basic/strongarm_comparator.hpp:46
        I(cpphdl_n1187, Vss) <+ 5.0000000000000002e-14 * ddt(V(cpphdl_n1187, Vss)); // Bench initial voltage = 0.0 V.
        // device 799, IC IC125, analog/basic/strongarm_comparator.hpp:47
        I(cpphdl_n1168, cpphdl_n1175) <+ 2e-14 * ddt(V(cpphdl_n1168, cpphdl_n1175)); // Bench initial voltage = 3.2999999999999998 V.
        // device 800, IC IC125, analog/basic/strongarm_comparator.hpp:48
        I(cpphdl_n1169, cpphdl_n1175) <+ 2e-14 * ddt(V(cpphdl_n1169, cpphdl_n1175)); // Bench initial voltage = 3.2999999999999998 V.
        // device 801, IC IC125, analog/basic/strongarm_comparator.hpp:49
        I(cpphdl_n1168, cpphdl_n1173) <+ 2.9999999999999998e-15 * ddt(V(cpphdl_n1168, cpphdl_n1173)); // Bench initial voltage = 3.2999999999999998 V.
        // device 802, IC IC125, analog/basic/strongarm_comparator.hpp:50
        I(cpphdl_n1169, cpphdl_n1174) <+ 2.9999999999999998e-15 * ddt(V(cpphdl_n1169, cpphdl_n1174)); // Bench initial voltage = 3.2999999999999998 V.
        // device 803, IC IC127, analog/basic/cmos_logic.hpp:15
        I(cpphdl_n2331, Vss) <+ 5.0000000000000002e-14 * ddt(V(cpphdl_n2331, Vss)); // Bench initial voltage = 0.0 V.
        // device 804, IC IC127, analog/basic/cmos_logic.hpp:16
        I(cpphdl_n2331, Vdd) <+ cpphdl_channel(V(cpphdl_n1187, Vdd), V(cpphdl_n2331, Vdd), 0.01, 0.69999999999999996, -1.0);
        // device 805, IC IC127, analog/basic/cmos_logic.hpp:17
        I(cpphdl_n2331, Vdd) <+ cpphdl_channel(V(cpphdl_n1195, Vdd), V(cpphdl_n2331, Vdd), 0.01, 0.69999999999999996, -1.0);
        // device 806, IC IC127, analog/basic/cmos_logic.hpp:18
        I(cpphdl_n2331, cpphdl_n1190) <+ cpphdl_channel(V(cpphdl_n1187, cpphdl_n1190), V(cpphdl_n2331, cpphdl_n1190), 0.01, 0.69999999999999996, 1.0);
        // device 807, IC IC127, analog/basic/cmos_logic.hpp:19
        I(cpphdl_n1190, Vss) <+ cpphdl_channel(V(cpphdl_n1195, Vss), V(cpphdl_n1190, Vss), 0.01, 0.69999999999999996, 1.0);
        // device 808, IC IC127, analog/basic/cmos_logic.hpp:20
        I(cpphdl_n2331, Vss) <+ V(cpphdl_n2331, Vss) / 1000000000.0;
        // device 809, IC IC127, analog/basic/cmos_logic.hpp:21
        I(cpphdl_n1190, Vss) <+ V(cpphdl_n1190, Vss) / 1000000000.0;
        // device 810, IC IC128, analog/basic/cmos_logic.hpp:15
        I(cpphdl_n1195, Vss) <+ 5.0000000000000002e-14 * ddt(V(cpphdl_n1195, Vss)); // Bench initial voltage = 0.0 V.
        // device 811, IC IC128, analog/basic/cmos_logic.hpp:16
        I(cpphdl_n1195, Vdd) <+ cpphdl_channel(V(cpphdl_n1193, Vdd), V(cpphdl_n1195, Vdd), 0.01, 0.69999999999999996, -1.0);
        // device 812, IC IC128, analog/basic/cmos_logic.hpp:17
        I(cpphdl_n1195, Vdd) <+ cpphdl_channel(V(cpphdl_n2331, Vdd), V(cpphdl_n1195, Vdd), 0.01, 0.69999999999999996, -1.0);
        // device 813, IC IC128, analog/basic/cmos_logic.hpp:18
        I(cpphdl_n1195, cpphdl_n1196) <+ cpphdl_channel(V(cpphdl_n1193, cpphdl_n1196), V(cpphdl_n1195, cpphdl_n1196), 0.01, 0.69999999999999996, 1.0);
        // device 814, IC IC128, analog/basic/cmos_logic.hpp:19
        I(cpphdl_n1196, Vss) <+ cpphdl_channel(V(cpphdl_n2331, Vss), V(cpphdl_n1196, Vss), 0.01, 0.69999999999999996, 1.0);
        // device 815, IC IC128, analog/basic/cmos_logic.hpp:20
        I(cpphdl_n1195, Vss) <+ V(cpphdl_n1195, Vss) / 1000000000.0;
        // device 816, IC IC128, analog/basic/cmos_logic.hpp:21
        I(cpphdl_n1196, Vss) <+ V(cpphdl_n1196, Vss) / 1000000000.0;
        // device 817, IC IC126, analog/basic/nand_latch.hpp:34
        I(cpphdl_n1187, Vss) <+ 2.9999999999999998e-15 * ddt(V(cpphdl_n1187, Vss)); // Bench initial voltage = 0.0 V.
        // device 818, IC IC126, analog/basic/nand_latch.hpp:35
        I(cpphdl_n1193, Vss) <+ 2.9999999999999998e-15 * ddt(V(cpphdl_n1193, Vss)); // Bench initial voltage = 0.0 V.
        // device 819, IC IC129, analog/basic/inverter.hpp:11
        I(cpphdl_n1201, Vdd) <+ cpphdl_channel(V(CLEAR, Vdd), V(cpphdl_n1201, Vdd), 0.01, 0.69999999999999996, -1.0);
        // device 820, IC IC129, analog/basic/inverter.hpp:12
        I(cpphdl_n1201, Vss) <+ cpphdl_channel(V(CLEAR, Vss), V(cpphdl_n1201, Vss), 0.01, 0.69999999999999996, 1.0);
        // device 821, IC IC126, analog/basic/nand_latch.hpp:56
        I(cpphdl_n1201, Vss) <+ 2.9999999999999998e-15 * ddt(V(cpphdl_n1201, Vss)); // Bench initial voltage = 0.0 V.
        // device 822, IC IC126, analog/basic/nand_latch.hpp:57
        I(cpphdl_n2331, Vss) <+ cpphdl_channel(V(CLEAR, Vss), V(cpphdl_n2331, Vss), 0.050000000000000003, 0.69999999999999996, 1.0);
        // device 823, IC IC126, analog/basic/nand_latch.hpp:58
        I(cpphdl_n1195, Vdd) <+ cpphdl_channel(V(cpphdl_n1201, Vdd), V(cpphdl_n1195, Vdd), 0.050000000000000003, 0.69999999999999996, -1.0);
        // device 824, IC IC132, analog/basic/inverter.hpp:11
        I(cpphdl_n1225, Vdd) <+ cpphdl_channel(V(TRACK7, Vdd), V(cpphdl_n1225, Vdd), 0.0040000000000000001, 0.69999999999999996, -1.0);
        // device 825, IC IC132, analog/basic/inverter.hpp:12
        I(cpphdl_n1225, Vss) <+ cpphdl_channel(V(TRACK7, Vss), V(cpphdl_n1225, Vss), 0.0040000000000000001, 0.69999999999999996, 1.0);
        // device 826, IC IC131, analog/basic/mos_track_hold.hpp:30
        I(cpphdl_n1225, Vss) <+ 2e-14 * ddt(V(cpphdl_n1225, Vss)); // Bench initial voltage = 3.2999999999999998 V.
        // device 827, IC IC131, analog/basic/mos_track_hold.hpp:31
        I(cpphdl_n2179, cpphdl_n1279) <+ cpphdl_channel(V(TRACK7, cpphdl_n1279), V(cpphdl_n2179, cpphdl_n1279), 0.080000000000000002, 0.69999999999999996, 1.0);
        // device 828, IC IC131, analog/basic/mos_track_hold.hpp:32
        I(cpphdl_n1279, cpphdl_n2179) <+ cpphdl_channel(V(cpphdl_n1225, cpphdl_n2179), V(cpphdl_n1279, cpphdl_n2179), 0.040000000000000001, 0.69999999999999996, -1.0);
        // device 829, IC IC131, analog/basic/mos_track_hold.hpp:36
        I(cpphdl_n1279, cpphdl_n1279) <+ cpphdl_channel(V(cpphdl_n1225, cpphdl_n1279), V(cpphdl_n1279, cpphdl_n1279), 0.040000000000000001, 0.69999999999999996, 1.0);
        // device 830, IC IC131, analog/basic/mos_track_hold.hpp:37
        I(cpphdl_n1279, cpphdl_n1279) <+ cpphdl_channel(V(TRACK7, cpphdl_n1279), V(cpphdl_n1279, cpphdl_n1279), 0.02, 0.69999999999999996, -1.0);
        // device 831, IC IC131, analog/basic/mos_track_hold.hpp:38
        I(cpphdl_n1279, Vss) <+ 2e-12 * ddt(V(cpphdl_n1279, Vss)); // Bench initial voltage = 1.6499999999999999 V.
        // device 832, IC IC131, analog/basic/mos_track_hold.hpp:39
        I(Vss, cpphdl_n1279) <+ V(Vss, cpphdl_n1279) / 1000000000.0;
        // device 833, IC IC131, analog/basic/mos_track_hold.hpp:40
        I(TRACK7, cpphdl_n1279) <+ 8.0000000000000006e-15 * ddt(V(TRACK7, cpphdl_n1279)); // Bench initial voltage = -1.6499999999999999 V.
        // device 834, IC IC131, analog/basic/mos_track_hold.hpp:41
        I(cpphdl_n1225, cpphdl_n1279) <+ 8.0000000000000006e-15 * ddt(V(cpphdl_n1225, cpphdl_n1279)); // Bench initial voltage = 1.6499999999999999 V.
        // device 835, IC IC131, analog/basic/mos_track_hold.hpp:42
        I(cpphdl_n2179, cpphdl_n1279) <+ 4.0000000000000003e-15 * ddt(V(cpphdl_n2179, cpphdl_n1279)); // Bench initial voltage = 0.0 V.
        // device 836, IC IC134, analog/basic/inverter.hpp:11
        I(cpphdl_n1240, Vdd) <+ cpphdl_channel(V(BIT_N7_0, Vdd), V(cpphdl_n1240, Vdd), 0.080000000000000002, 0.69999999999999996, -1.0);
        // device 837, IC IC134, analog/basic/inverter.hpp:12
        I(cpphdl_n1240, Vss) <+ cpphdl_channel(V(BIT_N7_0, Vss), V(cpphdl_n1240, Vss), 0.080000000000000002, 0.69999999999999996, 1.0);
        // device 838, IC IC133, analog/basic/mos_r2r_dac.hpp:27
        I(cpphdl_n1240, Vss) <+ 2.9999999999999998e-15 * ddt(V(cpphdl_n1240, Vss)); // Bench initial voltage = 0.0 V.
        // device 839, IC IC133, analog/basic/mos_r2r_dac.hpp:28
        I(cpphdl_n1240, cpphdl_n1269) <+ V(cpphdl_n1240, cpphdl_n1269) / 20000.0;
        // device 840, IC IC133, analog/basic/mos_r2r_dac.hpp:29
        I(cpphdl_n1269, Vss) <+ 2.9999999999999998e-15 * ddt(V(cpphdl_n1269, Vss)); // Bench initial voltage = 0.0 V.
        // device 841, IC IC135, analog/basic/inverter.hpp:11
        I(cpphdl_n1244, Vdd) <+ cpphdl_channel(V(BIT_N7_1, Vdd), V(cpphdl_n1244, Vdd), 0.080000000000000002, 0.69999999999999996, -1.0);
        // device 842, IC IC135, analog/basic/inverter.hpp:12
        I(cpphdl_n1244, Vss) <+ cpphdl_channel(V(BIT_N7_1, Vss), V(cpphdl_n1244, Vss), 0.080000000000000002, 0.69999999999999996, 1.0);
        // device 843, IC IC133, analog/basic/mos_r2r_dac.hpp:27
        I(cpphdl_n1244, Vss) <+ 2.9999999999999998e-15 * ddt(V(cpphdl_n1244, Vss)); // Bench initial voltage = 0.0 V.
        // device 844, IC IC133, analog/basic/mos_r2r_dac.hpp:28
        I(cpphdl_n1244, cpphdl_n1270) <+ V(cpphdl_n1244, cpphdl_n1270) / 20000.0;
        // device 845, IC IC133, analog/basic/mos_r2r_dac.hpp:29
        I(cpphdl_n1270, Vss) <+ 2.9999999999999998e-15 * ddt(V(cpphdl_n1270, Vss)); // Bench initial voltage = 0.0 V.
        // device 846, IC IC133, analog/basic/mos_r2r_dac.hpp:31
        I(cpphdl_n1269, cpphdl_n1270) <+ V(cpphdl_n1269, cpphdl_n1270) / 10000.0;
        // device 847, IC IC136, analog/basic/inverter.hpp:11
        I(cpphdl_n1248, Vdd) <+ cpphdl_channel(V(BIT_N7_2, Vdd), V(cpphdl_n1248, Vdd), 0.080000000000000002, 0.69999999999999996, -1.0);
        // device 848, IC IC136, analog/basic/inverter.hpp:12
        I(cpphdl_n1248, Vss) <+ cpphdl_channel(V(BIT_N7_2, Vss), V(cpphdl_n1248, Vss), 0.080000000000000002, 0.69999999999999996, 1.0);
        // device 849, IC IC133, analog/basic/mos_r2r_dac.hpp:27
        I(cpphdl_n1248, Vss) <+ 2.9999999999999998e-15 * ddt(V(cpphdl_n1248, Vss)); // Bench initial voltage = 0.0 V.
        // device 850, IC IC133, analog/basic/mos_r2r_dac.hpp:28
        I(cpphdl_n1248, cpphdl_n1271) <+ V(cpphdl_n1248, cpphdl_n1271) / 20000.0;
        // device 851, IC IC133, analog/basic/mos_r2r_dac.hpp:29
        I(cpphdl_n1271, Vss) <+ 2.9999999999999998e-15 * ddt(V(cpphdl_n1271, Vss)); // Bench initial voltage = 0.0 V.
        // device 852, IC IC133, analog/basic/mos_r2r_dac.hpp:31
        I(cpphdl_n1270, cpphdl_n1271) <+ V(cpphdl_n1270, cpphdl_n1271) / 10000.0;
        // device 853, IC IC137, analog/basic/inverter.hpp:11
        I(cpphdl_n1252, Vdd) <+ cpphdl_channel(V(BIT_N7_3, Vdd), V(cpphdl_n1252, Vdd), 0.080000000000000002, 0.69999999999999996, -1.0);
        // device 854, IC IC137, analog/basic/inverter.hpp:12
        I(cpphdl_n1252, Vss) <+ cpphdl_channel(V(BIT_N7_3, Vss), V(cpphdl_n1252, Vss), 0.080000000000000002, 0.69999999999999996, 1.0);
        // device 855, IC IC133, analog/basic/mos_r2r_dac.hpp:27
        I(cpphdl_n1252, Vss) <+ 2.9999999999999998e-15 * ddt(V(cpphdl_n1252, Vss)); // Bench initial voltage = 0.0 V.
        // device 856, IC IC133, analog/basic/mos_r2r_dac.hpp:28
        I(cpphdl_n1252, cpphdl_n1272) <+ V(cpphdl_n1252, cpphdl_n1272) / 20000.0;
        // device 857, IC IC133, analog/basic/mos_r2r_dac.hpp:29
        I(cpphdl_n1272, Vss) <+ 2.9999999999999998e-15 * ddt(V(cpphdl_n1272, Vss)); // Bench initial voltage = 0.0 V.
        // device 858, IC IC133, analog/basic/mos_r2r_dac.hpp:31
        I(cpphdl_n1271, cpphdl_n1272) <+ V(cpphdl_n1271, cpphdl_n1272) / 10000.0;
        // device 859, IC IC138, analog/basic/inverter.hpp:11
        I(cpphdl_n1256, Vdd) <+ cpphdl_channel(V(BIT_N7_4, Vdd), V(cpphdl_n1256, Vdd), 0.080000000000000002, 0.69999999999999996, -1.0);
        // device 860, IC IC138, analog/basic/inverter.hpp:12
        I(cpphdl_n1256, Vss) <+ cpphdl_channel(V(BIT_N7_4, Vss), V(cpphdl_n1256, Vss), 0.080000000000000002, 0.69999999999999996, 1.0);
        // device 861, IC IC133, analog/basic/mos_r2r_dac.hpp:27
        I(cpphdl_n1256, Vss) <+ 2.9999999999999998e-15 * ddt(V(cpphdl_n1256, Vss)); // Bench initial voltage = 0.0 V.
        // device 862, IC IC133, analog/basic/mos_r2r_dac.hpp:28
        I(cpphdl_n1256, cpphdl_n1273) <+ V(cpphdl_n1256, cpphdl_n1273) / 20000.0;
        // device 863, IC IC133, analog/basic/mos_r2r_dac.hpp:29
        I(cpphdl_n1273, Vss) <+ 2.9999999999999998e-15 * ddt(V(cpphdl_n1273, Vss)); // Bench initial voltage = 0.0 V.
        // device 864, IC IC133, analog/basic/mos_r2r_dac.hpp:31
        I(cpphdl_n1272, cpphdl_n1273) <+ V(cpphdl_n1272, cpphdl_n1273) / 10000.0;
        // device 865, IC IC139, analog/basic/inverter.hpp:11
        I(cpphdl_n1260, Vdd) <+ cpphdl_channel(V(BIT_N7_5, Vdd), V(cpphdl_n1260, Vdd), 0.080000000000000002, 0.69999999999999996, -1.0);
        // device 866, IC IC139, analog/basic/inverter.hpp:12
        I(cpphdl_n1260, Vss) <+ cpphdl_channel(V(BIT_N7_5, Vss), V(cpphdl_n1260, Vss), 0.080000000000000002, 0.69999999999999996, 1.0);
        // device 867, IC IC133, analog/basic/mos_r2r_dac.hpp:27
        I(cpphdl_n1260, Vss) <+ 2.9999999999999998e-15 * ddt(V(cpphdl_n1260, Vss)); // Bench initial voltage = 0.0 V.
        // device 868, IC IC133, analog/basic/mos_r2r_dac.hpp:28
        I(cpphdl_n1260, cpphdl_n1274) <+ V(cpphdl_n1260, cpphdl_n1274) / 20000.0;
        // device 869, IC IC133, analog/basic/mos_r2r_dac.hpp:29
        I(cpphdl_n1274, Vss) <+ 2.9999999999999998e-15 * ddt(V(cpphdl_n1274, Vss)); // Bench initial voltage = 0.0 V.
        // device 870, IC IC133, analog/basic/mos_r2r_dac.hpp:31
        I(cpphdl_n1273, cpphdl_n1274) <+ V(cpphdl_n1273, cpphdl_n1274) / 10000.0;
        // device 871, IC IC140, analog/basic/inverter.hpp:11
        I(cpphdl_n1264, Vdd) <+ cpphdl_channel(V(BIT_N7_6, Vdd), V(cpphdl_n1264, Vdd), 0.080000000000000002, 0.69999999999999996, -1.0);
        // device 872, IC IC140, analog/basic/inverter.hpp:12
        I(cpphdl_n1264, Vss) <+ cpphdl_channel(V(BIT_N7_6, Vss), V(cpphdl_n1264, Vss), 0.080000000000000002, 0.69999999999999996, 1.0);
        // device 873, IC IC133, analog/basic/mos_r2r_dac.hpp:27
        I(cpphdl_n1264, Vss) <+ 2.9999999999999998e-15 * ddt(V(cpphdl_n1264, Vss)); // Bench initial voltage = 0.0 V.
        // device 874, IC IC133, analog/basic/mos_r2r_dac.hpp:28
        I(cpphdl_n1264, cpphdl_n1275) <+ V(cpphdl_n1264, cpphdl_n1275) / 20000.0;
        // device 875, IC IC133, analog/basic/mos_r2r_dac.hpp:29
        I(cpphdl_n1275, Vss) <+ 2.9999999999999998e-15 * ddt(V(cpphdl_n1275, Vss)); // Bench initial voltage = 0.0 V.
        // device 876, IC IC133, analog/basic/mos_r2r_dac.hpp:31
        I(cpphdl_n1274, cpphdl_n1275) <+ V(cpphdl_n1274, cpphdl_n1275) / 10000.0;
        // device 877, IC IC141, analog/basic/inverter.hpp:11
        I(cpphdl_n1268, Vdd) <+ cpphdl_channel(V(BIT_N7_7, Vdd), V(cpphdl_n1268, Vdd), 0.080000000000000002, 0.69999999999999996, -1.0);
        // device 878, IC IC141, analog/basic/inverter.hpp:12
        I(cpphdl_n1268, Vss) <+ cpphdl_channel(V(BIT_N7_7, Vss), V(cpphdl_n1268, Vss), 0.080000000000000002, 0.69999999999999996, 1.0);
        // device 879, IC IC133, analog/basic/mos_r2r_dac.hpp:27
        I(cpphdl_n1268, Vss) <+ 2.9999999999999998e-15 * ddt(V(cpphdl_n1268, Vss)); // Bench initial voltage = 0.0 V.
        // device 880, IC IC133, analog/basic/mos_r2r_dac.hpp:28
        I(cpphdl_n1268, cpphdl_n1280) <+ V(cpphdl_n1268, cpphdl_n1280) / 20000.0;
        // device 881, IC IC133, analog/basic/mos_r2r_dac.hpp:29
        I(cpphdl_n1280, Vss) <+ 2.9999999999999998e-15 * ddt(V(cpphdl_n1280, Vss)); // Bench initial voltage = 0.0 V.
        // device 882, IC IC133, analog/basic/mos_r2r_dac.hpp:31
        I(cpphdl_n1275, cpphdl_n1280) <+ V(cpphdl_n1275, cpphdl_n1280) / 10000.0;
        // device 883, IC IC133, analog/basic/mos_r2r_dac.hpp:33
        I(Vss, cpphdl_n1269) <+ V(Vss, cpphdl_n1269) / 20000.0;
        // device 884, IC IC142, analog/basic/nmos_resistor_amplifier.hpp:23
        I(Vdd, cpphdl_n1289) <+ V(Vdd, cpphdl_n1289) / 1000.0;
        // device 885, IC IC142, analog/basic/nmos_resistor_amplifier.hpp:24
        I(Vdd, cpphdl_n1288) <+ V(Vdd, cpphdl_n1288) / 1000.0;
        // device 886, IC IC142, analog/basic/nmos_resistor_amplifier.hpp:25
        I(cpphdl_n1289, cpphdl_n1283) <+ cpphdl_channel(V(cpphdl_n1279, cpphdl_n1283), V(cpphdl_n1289, cpphdl_n1283), 0.014999999999999999, 0.69999999999999996, 1.0);
        // device 887, IC IC142, analog/basic/nmos_resistor_amplifier.hpp:26
        I(cpphdl_n1288, cpphdl_n1284) <+ cpphdl_channel(V(cpphdl_n1280, cpphdl_n1284), V(cpphdl_n1288, cpphdl_n1284), 0.014999999999999999, 0.69999999999999996, 1.0);
        // device 888, IC IC142, analog/basic/nmos_resistor_amplifier.hpp:27
        I(cpphdl_n1285, cpphdl_n1283) <+ V(cpphdl_n1285, cpphdl_n1283) / 50.0;
        // device 889, IC IC142, analog/basic/nmos_resistor_amplifier.hpp:28
        I(cpphdl_n1285, cpphdl_n1284) <+ V(cpphdl_n1285, cpphdl_n1284) / 50.0;
        // device 890, IC IC142, analog/basic/nmos_resistor_amplifier.hpp:29
        I(Vss, cpphdl_n1285) <+ V(Vss, cpphdl_n1285) / 150.0;
        // device 891, IC IC142, analog/basic/nmos_resistor_amplifier.hpp:30
        I(cpphdl_n1289, Vdd) <+ 2.9999999999999998e-13 * ddt(V(cpphdl_n1289, Vdd)); // Bench initial voltage = 0.0 V.
        // device 892, IC IC142, analog/basic/nmos_resistor_amplifier.hpp:31
        I(cpphdl_n1288, Vdd) <+ 2.9999999999999998e-13 * ddt(V(cpphdl_n1288, Vdd)); // Bench initial voltage = 0.0 V.
        // device 893, IC IC142, analog/basic/nmos_resistor_amplifier.hpp:32
        I(cpphdl_n1285, Vss) <+ 4e-14 * ddt(V(cpphdl_n1285, Vss)); // Bench initial voltage = 0.0 V.
        // device 894, IC IC142, analog/basic/nmos_resistor_amplifier.hpp:34
        I(cpphdl_n1279, cpphdl_n1283) <+ 2e-14 * ddt(V(cpphdl_n1279, cpphdl_n1283)); // Bench initial voltage = 1.6499999999999999 V.
        // device 895, IC IC142, analog/basic/nmos_resistor_amplifier.hpp:35
        I(cpphdl_n1280, cpphdl_n1284) <+ 2e-14 * ddt(V(cpphdl_n1280, cpphdl_n1284)); // Bench initial voltage = 0.0 V.
        // device 896, IC IC142, analog/basic/nmos_resistor_amplifier.hpp:36
        I(cpphdl_n1279, cpphdl_n1289) <+ 2.9999999999999998e-15 * ddt(V(cpphdl_n1279, cpphdl_n1289)); // Bench initial voltage = -1.6499999999999999 V.
        // device 897, IC IC142, analog/basic/nmos_resistor_amplifier.hpp:37
        I(cpphdl_n1280, cpphdl_n1288) <+ 2.9999999999999998e-15 * ddt(V(cpphdl_n1280, cpphdl_n1288)); // Bench initial voltage = -3.2999999999999998 V.
        // device 898, IC IC143, analog/basic/strongarm_comparator.hpp:28
        I(cpphdl_n1293, cpphdl_n1295) <+ cpphdl_channel(V(cpphdl_n1288, cpphdl_n1295), V(cpphdl_n1293, cpphdl_n1295), 0.0080000000000000002, 0.69999999999999996, 1.0);
        // device 899, IC IC143, analog/basic/strongarm_comparator.hpp:29
        I(cpphdl_n1294, cpphdl_n1295) <+ cpphdl_channel(V(cpphdl_n1289, cpphdl_n1295), V(cpphdl_n1294, cpphdl_n1295), 0.0080000000000000002, 0.69999999999999996, 1.0);
        // device 900, IC IC143, analog/basic/strongarm_comparator.hpp:30
        I(cpphdl_n1295, Vss) <+ cpphdl_channel(V(EVALUATE, Vss), V(cpphdl_n1295, Vss), 0.0080000000000000002, 0.69999999999999996, 1.0);
        // device 901, IC IC143, analog/basic/strongarm_comparator.hpp:33
        I(cpphdl_n1307, cpphdl_n1293) <+ cpphdl_channel(V(cpphdl_n1313, cpphdl_n1293), V(cpphdl_n1307, cpphdl_n1293), 0.0040000000000000001, 0.69999999999999996, 1.0);
        // device 902, IC IC143, analog/basic/strongarm_comparator.hpp:34
        I(cpphdl_n1313, cpphdl_n1294) <+ cpphdl_channel(V(cpphdl_n1307, cpphdl_n1294), V(cpphdl_n1313, cpphdl_n1294), 0.0040000000000000001, 0.69999999999999996, 1.0);
        // device 903, IC IC143, analog/basic/strongarm_comparator.hpp:35
        I(cpphdl_n1313, Vdd) <+ cpphdl_channel(V(cpphdl_n1307, Vdd), V(cpphdl_n1313, Vdd), 0.002, 0.69999999999999996, -1.0);
        // device 904, IC IC143, analog/basic/strongarm_comparator.hpp:36
        I(cpphdl_n1307, Vdd) <+ cpphdl_channel(V(cpphdl_n1313, Vdd), V(cpphdl_n1307, Vdd), 0.002, 0.69999999999999996, -1.0);
        // device 905, IC IC143, analog/basic/strongarm_comparator.hpp:38
        I(cpphdl_n1293, Vdd) <+ cpphdl_channel(V(EVALUATE, Vdd), V(cpphdl_n1293, Vdd), 0.002, 0.69999999999999996, -1.0);
        // device 906, IC IC143, analog/basic/strongarm_comparator.hpp:39
        I(cpphdl_n1294, Vdd) <+ cpphdl_channel(V(EVALUATE, Vdd), V(cpphdl_n1294, Vdd), 0.002, 0.69999999999999996, -1.0);
        // device 907, IC IC143, analog/basic/strongarm_comparator.hpp:40
        I(cpphdl_n1313, Vdd) <+ cpphdl_channel(V(EVALUATE, Vdd), V(cpphdl_n1313, Vdd), 0.002, 0.69999999999999996, -1.0);
        // device 908, IC IC143, analog/basic/strongarm_comparator.hpp:41
        I(cpphdl_n1307, Vdd) <+ cpphdl_channel(V(EVALUATE, Vdd), V(cpphdl_n1307, Vdd), 0.002, 0.69999999999999996, -1.0);
        // device 909, IC IC143, analog/basic/strongarm_comparator.hpp:42
        I(cpphdl_n1293, Vss) <+ 2.9999999999999998e-14 * ddt(V(cpphdl_n1293, Vss)); // Bench initial voltage = 0.0 V.
        // device 910, IC IC143, analog/basic/strongarm_comparator.hpp:43
        I(cpphdl_n1294, Vss) <+ 2.9999999999999998e-14 * ddt(V(cpphdl_n1294, Vss)); // Bench initial voltage = 0.0 V.
        // device 911, IC IC143, analog/basic/strongarm_comparator.hpp:44
        I(cpphdl_n1295, Vss) <+ 2.9999999999999998e-14 * ddt(V(cpphdl_n1295, Vss)); // Bench initial voltage = 0.0 V.
        // device 912, IC IC143, analog/basic/strongarm_comparator.hpp:45
        I(cpphdl_n1313, Vss) <+ 5.0000000000000002e-14 * ddt(V(cpphdl_n1313, Vss)); // Bench initial voltage = 0.0 V.
        // device 913, IC IC143, analog/basic/strongarm_comparator.hpp:46
        I(cpphdl_n1307, Vss) <+ 5.0000000000000002e-14 * ddt(V(cpphdl_n1307, Vss)); // Bench initial voltage = 0.0 V.
        // device 914, IC IC143, analog/basic/strongarm_comparator.hpp:47
        I(cpphdl_n1288, cpphdl_n1295) <+ 2e-14 * ddt(V(cpphdl_n1288, cpphdl_n1295)); // Bench initial voltage = 3.2999999999999998 V.
        // device 915, IC IC143, analog/basic/strongarm_comparator.hpp:48
        I(cpphdl_n1289, cpphdl_n1295) <+ 2e-14 * ddt(V(cpphdl_n1289, cpphdl_n1295)); // Bench initial voltage = 3.2999999999999998 V.
        // device 916, IC IC143, analog/basic/strongarm_comparator.hpp:49
        I(cpphdl_n1288, cpphdl_n1293) <+ 2.9999999999999998e-15 * ddt(V(cpphdl_n1288, cpphdl_n1293)); // Bench initial voltage = 3.2999999999999998 V.
        // device 917, IC IC143, analog/basic/strongarm_comparator.hpp:50
        I(cpphdl_n1289, cpphdl_n1294) <+ 2.9999999999999998e-15 * ddt(V(cpphdl_n1289, cpphdl_n1294)); // Bench initial voltage = 3.2999999999999998 V.
        // device 918, IC IC145, analog/basic/cmos_logic.hpp:15
        I(cpphdl_n2336, Vss) <+ 5.0000000000000002e-14 * ddt(V(cpphdl_n2336, Vss)); // Bench initial voltage = 0.0 V.
        // device 919, IC IC145, analog/basic/cmos_logic.hpp:16
        I(cpphdl_n2336, Vdd) <+ cpphdl_channel(V(cpphdl_n1307, Vdd), V(cpphdl_n2336, Vdd), 0.01, 0.69999999999999996, -1.0);
        // device 920, IC IC145, analog/basic/cmos_logic.hpp:17
        I(cpphdl_n2336, Vdd) <+ cpphdl_channel(V(cpphdl_n1315, Vdd), V(cpphdl_n2336, Vdd), 0.01, 0.69999999999999996, -1.0);
        // device 921, IC IC145, analog/basic/cmos_logic.hpp:18
        I(cpphdl_n2336, cpphdl_n1310) <+ cpphdl_channel(V(cpphdl_n1307, cpphdl_n1310), V(cpphdl_n2336, cpphdl_n1310), 0.01, 0.69999999999999996, 1.0);
        // device 922, IC IC145, analog/basic/cmos_logic.hpp:19
        I(cpphdl_n1310, Vss) <+ cpphdl_channel(V(cpphdl_n1315, Vss), V(cpphdl_n1310, Vss), 0.01, 0.69999999999999996, 1.0);
        // device 923, IC IC145, analog/basic/cmos_logic.hpp:20
        I(cpphdl_n2336, Vss) <+ V(cpphdl_n2336, Vss) / 1000000000.0;
        // device 924, IC IC145, analog/basic/cmos_logic.hpp:21
        I(cpphdl_n1310, Vss) <+ V(cpphdl_n1310, Vss) / 1000000000.0;
        // device 925, IC IC146, analog/basic/cmos_logic.hpp:15
        I(cpphdl_n1315, Vss) <+ 5.0000000000000002e-14 * ddt(V(cpphdl_n1315, Vss)); // Bench initial voltage = 0.0 V.
        // device 926, IC IC146, analog/basic/cmos_logic.hpp:16
        I(cpphdl_n1315, Vdd) <+ cpphdl_channel(V(cpphdl_n1313, Vdd), V(cpphdl_n1315, Vdd), 0.01, 0.69999999999999996, -1.0);
        // device 927, IC IC146, analog/basic/cmos_logic.hpp:17
        I(cpphdl_n1315, Vdd) <+ cpphdl_channel(V(cpphdl_n2336, Vdd), V(cpphdl_n1315, Vdd), 0.01, 0.69999999999999996, -1.0);
        // device 928, IC IC146, analog/basic/cmos_logic.hpp:18
        I(cpphdl_n1315, cpphdl_n1316) <+ cpphdl_channel(V(cpphdl_n1313, cpphdl_n1316), V(cpphdl_n1315, cpphdl_n1316), 0.01, 0.69999999999999996, 1.0);
        // device 929, IC IC146, analog/basic/cmos_logic.hpp:19
        I(cpphdl_n1316, Vss) <+ cpphdl_channel(V(cpphdl_n2336, Vss), V(cpphdl_n1316, Vss), 0.01, 0.69999999999999996, 1.0);
        // device 930, IC IC146, analog/basic/cmos_logic.hpp:20
        I(cpphdl_n1315, Vss) <+ V(cpphdl_n1315, Vss) / 1000000000.0;
        // device 931, IC IC146, analog/basic/cmos_logic.hpp:21
        I(cpphdl_n1316, Vss) <+ V(cpphdl_n1316, Vss) / 1000000000.0;
        // device 932, IC IC144, analog/basic/nand_latch.hpp:34
        I(cpphdl_n1307, Vss) <+ 2.9999999999999998e-15 * ddt(V(cpphdl_n1307, Vss)); // Bench initial voltage = 0.0 V.
        // device 933, IC IC144, analog/basic/nand_latch.hpp:35
        I(cpphdl_n1313, Vss) <+ 2.9999999999999998e-15 * ddt(V(cpphdl_n1313, Vss)); // Bench initial voltage = 0.0 V.
        // device 934, IC IC147, analog/basic/inverter.hpp:11
        I(cpphdl_n1321, Vdd) <+ cpphdl_channel(V(CLEAR, Vdd), V(cpphdl_n1321, Vdd), 0.01, 0.69999999999999996, -1.0);
        // device 935, IC IC147, analog/basic/inverter.hpp:12
        I(cpphdl_n1321, Vss) <+ cpphdl_channel(V(CLEAR, Vss), V(cpphdl_n1321, Vss), 0.01, 0.69999999999999996, 1.0);
        // device 936, IC IC144, analog/basic/nand_latch.hpp:56
        I(cpphdl_n1321, Vss) <+ 2.9999999999999998e-15 * ddt(V(cpphdl_n1321, Vss)); // Bench initial voltage = 0.0 V.
        // device 937, IC IC144, analog/basic/nand_latch.hpp:57
        I(cpphdl_n2336, Vss) <+ cpphdl_channel(V(CLEAR, Vss), V(cpphdl_n2336, Vss), 0.050000000000000003, 0.69999999999999996, 1.0);
        // device 938, IC IC144, analog/basic/nand_latch.hpp:58
        I(cpphdl_n1315, Vdd) <+ cpphdl_channel(V(cpphdl_n1321, Vdd), V(cpphdl_n1315, Vdd), 0.050000000000000003, 0.69999999999999996, -1.0);
        // device 939, IC IC150, analog/basic/inverter.hpp:11
        I(cpphdl_n1345, Vdd) <+ cpphdl_channel(V(TRACK8, Vdd), V(cpphdl_n1345, Vdd), 0.0040000000000000001, 0.69999999999999996, -1.0);
        // device 940, IC IC150, analog/basic/inverter.hpp:12
        I(cpphdl_n1345, Vss) <+ cpphdl_channel(V(TRACK8, Vss), V(cpphdl_n1345, Vss), 0.0040000000000000001, 0.69999999999999996, 1.0);
        // device 941, IC IC149, analog/basic/mos_track_hold.hpp:30
        I(cpphdl_n1345, Vss) <+ 2e-14 * ddt(V(cpphdl_n1345, Vss)); // Bench initial voltage = 3.2999999999999998 V.
        // device 942, IC IC149, analog/basic/mos_track_hold.hpp:31
        I(cpphdl_n2179, cpphdl_n1399) <+ cpphdl_channel(V(TRACK8, cpphdl_n1399), V(cpphdl_n2179, cpphdl_n1399), 0.080000000000000002, 0.69999999999999996, 1.0);
        // device 943, IC IC149, analog/basic/mos_track_hold.hpp:32
        I(cpphdl_n1399, cpphdl_n2179) <+ cpphdl_channel(V(cpphdl_n1345, cpphdl_n2179), V(cpphdl_n1399, cpphdl_n2179), 0.040000000000000001, 0.69999999999999996, -1.0);
        // device 944, IC IC149, analog/basic/mos_track_hold.hpp:36
        I(cpphdl_n1399, cpphdl_n1399) <+ cpphdl_channel(V(cpphdl_n1345, cpphdl_n1399), V(cpphdl_n1399, cpphdl_n1399), 0.040000000000000001, 0.69999999999999996, 1.0);
        // device 945, IC IC149, analog/basic/mos_track_hold.hpp:37
        I(cpphdl_n1399, cpphdl_n1399) <+ cpphdl_channel(V(TRACK8, cpphdl_n1399), V(cpphdl_n1399, cpphdl_n1399), 0.02, 0.69999999999999996, -1.0);
        // device 946, IC IC149, analog/basic/mos_track_hold.hpp:38
        I(cpphdl_n1399, Vss) <+ 2e-12 * ddt(V(cpphdl_n1399, Vss)); // Bench initial voltage = 1.6499999999999999 V.
        // device 947, IC IC149, analog/basic/mos_track_hold.hpp:39
        I(Vss, cpphdl_n1399) <+ V(Vss, cpphdl_n1399) / 1000000000.0;
        // device 948, IC IC149, analog/basic/mos_track_hold.hpp:40
        I(TRACK8, cpphdl_n1399) <+ 8.0000000000000006e-15 * ddt(V(TRACK8, cpphdl_n1399)); // Bench initial voltage = -1.6499999999999999 V.
        // device 949, IC IC149, analog/basic/mos_track_hold.hpp:41
        I(cpphdl_n1345, cpphdl_n1399) <+ 8.0000000000000006e-15 * ddt(V(cpphdl_n1345, cpphdl_n1399)); // Bench initial voltage = 1.6499999999999999 V.
        // device 950, IC IC149, analog/basic/mos_track_hold.hpp:42
        I(cpphdl_n2179, cpphdl_n1399) <+ 4.0000000000000003e-15 * ddt(V(cpphdl_n2179, cpphdl_n1399)); // Bench initial voltage = 0.0 V.
        // device 951, IC IC152, analog/basic/inverter.hpp:11
        I(cpphdl_n1360, Vdd) <+ cpphdl_channel(V(BIT_N8_0, Vdd), V(cpphdl_n1360, Vdd), 0.080000000000000002, 0.69999999999999996, -1.0);
        // device 952, IC IC152, analog/basic/inverter.hpp:12
        I(cpphdl_n1360, Vss) <+ cpphdl_channel(V(BIT_N8_0, Vss), V(cpphdl_n1360, Vss), 0.080000000000000002, 0.69999999999999996, 1.0);
        // device 953, IC IC151, analog/basic/mos_r2r_dac.hpp:27
        I(cpphdl_n1360, Vss) <+ 2.9999999999999998e-15 * ddt(V(cpphdl_n1360, Vss)); // Bench initial voltage = 0.0 V.
        // device 954, IC IC151, analog/basic/mos_r2r_dac.hpp:28
        I(cpphdl_n1360, cpphdl_n1389) <+ V(cpphdl_n1360, cpphdl_n1389) / 20000.0;
        // device 955, IC IC151, analog/basic/mos_r2r_dac.hpp:29
        I(cpphdl_n1389, Vss) <+ 2.9999999999999998e-15 * ddt(V(cpphdl_n1389, Vss)); // Bench initial voltage = 0.0 V.
        // device 956, IC IC153, analog/basic/inverter.hpp:11
        I(cpphdl_n1364, Vdd) <+ cpphdl_channel(V(BIT_N8_1, Vdd), V(cpphdl_n1364, Vdd), 0.080000000000000002, 0.69999999999999996, -1.0);
        // device 957, IC IC153, analog/basic/inverter.hpp:12
        I(cpphdl_n1364, Vss) <+ cpphdl_channel(V(BIT_N8_1, Vss), V(cpphdl_n1364, Vss), 0.080000000000000002, 0.69999999999999996, 1.0);
        // device 958, IC IC151, analog/basic/mos_r2r_dac.hpp:27
        I(cpphdl_n1364, Vss) <+ 2.9999999999999998e-15 * ddt(V(cpphdl_n1364, Vss)); // Bench initial voltage = 0.0 V.
        // device 959, IC IC151, analog/basic/mos_r2r_dac.hpp:28
        I(cpphdl_n1364, cpphdl_n1390) <+ V(cpphdl_n1364, cpphdl_n1390) / 20000.0;
        // device 960, IC IC151, analog/basic/mos_r2r_dac.hpp:29
        I(cpphdl_n1390, Vss) <+ 2.9999999999999998e-15 * ddt(V(cpphdl_n1390, Vss)); // Bench initial voltage = 0.0 V.
        // device 961, IC IC151, analog/basic/mos_r2r_dac.hpp:31
        I(cpphdl_n1389, cpphdl_n1390) <+ V(cpphdl_n1389, cpphdl_n1390) / 10000.0;
        // device 962, IC IC154, analog/basic/inverter.hpp:11
        I(cpphdl_n1368, Vdd) <+ cpphdl_channel(V(BIT_N8_2, Vdd), V(cpphdl_n1368, Vdd), 0.080000000000000002, 0.69999999999999996, -1.0);
        // device 963, IC IC154, analog/basic/inverter.hpp:12
        I(cpphdl_n1368, Vss) <+ cpphdl_channel(V(BIT_N8_2, Vss), V(cpphdl_n1368, Vss), 0.080000000000000002, 0.69999999999999996, 1.0);
        // device 964, IC IC151, analog/basic/mos_r2r_dac.hpp:27
        I(cpphdl_n1368, Vss) <+ 2.9999999999999998e-15 * ddt(V(cpphdl_n1368, Vss)); // Bench initial voltage = 0.0 V.
        // device 965, IC IC151, analog/basic/mos_r2r_dac.hpp:28
        I(cpphdl_n1368, cpphdl_n1391) <+ V(cpphdl_n1368, cpphdl_n1391) / 20000.0;
        // device 966, IC IC151, analog/basic/mos_r2r_dac.hpp:29
        I(cpphdl_n1391, Vss) <+ 2.9999999999999998e-15 * ddt(V(cpphdl_n1391, Vss)); // Bench initial voltage = 0.0 V.
        // device 967, IC IC151, analog/basic/mos_r2r_dac.hpp:31
        I(cpphdl_n1390, cpphdl_n1391) <+ V(cpphdl_n1390, cpphdl_n1391) / 10000.0;
        // device 968, IC IC155, analog/basic/inverter.hpp:11
        I(cpphdl_n1372, Vdd) <+ cpphdl_channel(V(BIT_N8_3, Vdd), V(cpphdl_n1372, Vdd), 0.080000000000000002, 0.69999999999999996, -1.0);
        // device 969, IC IC155, analog/basic/inverter.hpp:12
        I(cpphdl_n1372, Vss) <+ cpphdl_channel(V(BIT_N8_3, Vss), V(cpphdl_n1372, Vss), 0.080000000000000002, 0.69999999999999996, 1.0);
        // device 970, IC IC151, analog/basic/mos_r2r_dac.hpp:27
        I(cpphdl_n1372, Vss) <+ 2.9999999999999998e-15 * ddt(V(cpphdl_n1372, Vss)); // Bench initial voltage = 0.0 V.
        // device 971, IC IC151, analog/basic/mos_r2r_dac.hpp:28
        I(cpphdl_n1372, cpphdl_n1392) <+ V(cpphdl_n1372, cpphdl_n1392) / 20000.0;
        // device 972, IC IC151, analog/basic/mos_r2r_dac.hpp:29
        I(cpphdl_n1392, Vss) <+ 2.9999999999999998e-15 * ddt(V(cpphdl_n1392, Vss)); // Bench initial voltage = 0.0 V.
        // device 973, IC IC151, analog/basic/mos_r2r_dac.hpp:31
        I(cpphdl_n1391, cpphdl_n1392) <+ V(cpphdl_n1391, cpphdl_n1392) / 10000.0;
        // device 974, IC IC156, analog/basic/inverter.hpp:11
        I(cpphdl_n1376, Vdd) <+ cpphdl_channel(V(BIT_N8_4, Vdd), V(cpphdl_n1376, Vdd), 0.080000000000000002, 0.69999999999999996, -1.0);
        // device 975, IC IC156, analog/basic/inverter.hpp:12
        I(cpphdl_n1376, Vss) <+ cpphdl_channel(V(BIT_N8_4, Vss), V(cpphdl_n1376, Vss), 0.080000000000000002, 0.69999999999999996, 1.0);
        // device 976, IC IC151, analog/basic/mos_r2r_dac.hpp:27
        I(cpphdl_n1376, Vss) <+ 2.9999999999999998e-15 * ddt(V(cpphdl_n1376, Vss)); // Bench initial voltage = 0.0 V.
        // device 977, IC IC151, analog/basic/mos_r2r_dac.hpp:28
        I(cpphdl_n1376, cpphdl_n1393) <+ V(cpphdl_n1376, cpphdl_n1393) / 20000.0;
        // device 978, IC IC151, analog/basic/mos_r2r_dac.hpp:29
        I(cpphdl_n1393, Vss) <+ 2.9999999999999998e-15 * ddt(V(cpphdl_n1393, Vss)); // Bench initial voltage = 0.0 V.
        // device 979, IC IC151, analog/basic/mos_r2r_dac.hpp:31
        I(cpphdl_n1392, cpphdl_n1393) <+ V(cpphdl_n1392, cpphdl_n1393) / 10000.0;
        // device 980, IC IC157, analog/basic/inverter.hpp:11
        I(cpphdl_n1380, Vdd) <+ cpphdl_channel(V(BIT_N8_5, Vdd), V(cpphdl_n1380, Vdd), 0.080000000000000002, 0.69999999999999996, -1.0);
        // device 981, IC IC157, analog/basic/inverter.hpp:12
        I(cpphdl_n1380, Vss) <+ cpphdl_channel(V(BIT_N8_5, Vss), V(cpphdl_n1380, Vss), 0.080000000000000002, 0.69999999999999996, 1.0);
        // device 982, IC IC151, analog/basic/mos_r2r_dac.hpp:27
        I(cpphdl_n1380, Vss) <+ 2.9999999999999998e-15 * ddt(V(cpphdl_n1380, Vss)); // Bench initial voltage = 0.0 V.
        // device 983, IC IC151, analog/basic/mos_r2r_dac.hpp:28
        I(cpphdl_n1380, cpphdl_n1394) <+ V(cpphdl_n1380, cpphdl_n1394) / 20000.0;
        // device 984, IC IC151, analog/basic/mos_r2r_dac.hpp:29
        I(cpphdl_n1394, Vss) <+ 2.9999999999999998e-15 * ddt(V(cpphdl_n1394, Vss)); // Bench initial voltage = 0.0 V.
        // device 985, IC IC151, analog/basic/mos_r2r_dac.hpp:31
        I(cpphdl_n1393, cpphdl_n1394) <+ V(cpphdl_n1393, cpphdl_n1394) / 10000.0;
        // device 986, IC IC158, analog/basic/inverter.hpp:11
        I(cpphdl_n1384, Vdd) <+ cpphdl_channel(V(BIT_N8_6, Vdd), V(cpphdl_n1384, Vdd), 0.080000000000000002, 0.69999999999999996, -1.0);
        // device 987, IC IC158, analog/basic/inverter.hpp:12
        I(cpphdl_n1384, Vss) <+ cpphdl_channel(V(BIT_N8_6, Vss), V(cpphdl_n1384, Vss), 0.080000000000000002, 0.69999999999999996, 1.0);
        // device 988, IC IC151, analog/basic/mos_r2r_dac.hpp:27
        I(cpphdl_n1384, Vss) <+ 2.9999999999999998e-15 * ddt(V(cpphdl_n1384, Vss)); // Bench initial voltage = 0.0 V.
        // device 989, IC IC151, analog/basic/mos_r2r_dac.hpp:28
        I(cpphdl_n1384, cpphdl_n1395) <+ V(cpphdl_n1384, cpphdl_n1395) / 20000.0;
        // device 990, IC IC151, analog/basic/mos_r2r_dac.hpp:29
        I(cpphdl_n1395, Vss) <+ 2.9999999999999998e-15 * ddt(V(cpphdl_n1395, Vss)); // Bench initial voltage = 0.0 V.
        // device 991, IC IC151, analog/basic/mos_r2r_dac.hpp:31
        I(cpphdl_n1394, cpphdl_n1395) <+ V(cpphdl_n1394, cpphdl_n1395) / 10000.0;
        // device 992, IC IC159, analog/basic/inverter.hpp:11
        I(cpphdl_n1388, Vdd) <+ cpphdl_channel(V(BIT_N8_7, Vdd), V(cpphdl_n1388, Vdd), 0.080000000000000002, 0.69999999999999996, -1.0);
        // device 993, IC IC159, analog/basic/inverter.hpp:12
        I(cpphdl_n1388, Vss) <+ cpphdl_channel(V(BIT_N8_7, Vss), V(cpphdl_n1388, Vss), 0.080000000000000002, 0.69999999999999996, 1.0);
        // device 994, IC IC151, analog/basic/mos_r2r_dac.hpp:27
        I(cpphdl_n1388, Vss) <+ 2.9999999999999998e-15 * ddt(V(cpphdl_n1388, Vss)); // Bench initial voltage = 0.0 V.
        // device 995, IC IC151, analog/basic/mos_r2r_dac.hpp:28
        I(cpphdl_n1388, cpphdl_n1400) <+ V(cpphdl_n1388, cpphdl_n1400) / 20000.0;
        // device 996, IC IC151, analog/basic/mos_r2r_dac.hpp:29
        I(cpphdl_n1400, Vss) <+ 2.9999999999999998e-15 * ddt(V(cpphdl_n1400, Vss)); // Bench initial voltage = 0.0 V.
        // device 997, IC IC151, analog/basic/mos_r2r_dac.hpp:31
        I(cpphdl_n1395, cpphdl_n1400) <+ V(cpphdl_n1395, cpphdl_n1400) / 10000.0;
        // device 998, IC IC151, analog/basic/mos_r2r_dac.hpp:33
        I(Vss, cpphdl_n1389) <+ V(Vss, cpphdl_n1389) / 20000.0;
        // device 999, IC IC160, analog/basic/nmos_resistor_amplifier.hpp:23
        I(Vdd, cpphdl_n1409) <+ V(Vdd, cpphdl_n1409) / 1000.0;
        // device 1000, IC IC160, analog/basic/nmos_resistor_amplifier.hpp:24
        I(Vdd, cpphdl_n1408) <+ V(Vdd, cpphdl_n1408) / 1000.0;
        // device 1001, IC IC160, analog/basic/nmos_resistor_amplifier.hpp:25
        I(cpphdl_n1409, cpphdl_n1403) <+ cpphdl_channel(V(cpphdl_n1399, cpphdl_n1403), V(cpphdl_n1409, cpphdl_n1403), 0.014999999999999999, 0.69999999999999996, 1.0);
        // device 1002, IC IC160, analog/basic/nmos_resistor_amplifier.hpp:26
        I(cpphdl_n1408, cpphdl_n1404) <+ cpphdl_channel(V(cpphdl_n1400, cpphdl_n1404), V(cpphdl_n1408, cpphdl_n1404), 0.014999999999999999, 0.69999999999999996, 1.0);
        // device 1003, IC IC160, analog/basic/nmos_resistor_amplifier.hpp:27
        I(cpphdl_n1405, cpphdl_n1403) <+ V(cpphdl_n1405, cpphdl_n1403) / 50.0;
        // device 1004, IC IC160, analog/basic/nmos_resistor_amplifier.hpp:28
        I(cpphdl_n1405, cpphdl_n1404) <+ V(cpphdl_n1405, cpphdl_n1404) / 50.0;
        // device 1005, IC IC160, analog/basic/nmos_resistor_amplifier.hpp:29
        I(Vss, cpphdl_n1405) <+ V(Vss, cpphdl_n1405) / 150.0;
        // device 1006, IC IC160, analog/basic/nmos_resistor_amplifier.hpp:30
        I(cpphdl_n1409, Vdd) <+ 2.9999999999999998e-13 * ddt(V(cpphdl_n1409, Vdd)); // Bench initial voltage = 0.0 V.
        // device 1007, IC IC160, analog/basic/nmos_resistor_amplifier.hpp:31
        I(cpphdl_n1408, Vdd) <+ 2.9999999999999998e-13 * ddt(V(cpphdl_n1408, Vdd)); // Bench initial voltage = 0.0 V.
        // device 1008, IC IC160, analog/basic/nmos_resistor_amplifier.hpp:32
        I(cpphdl_n1405, Vss) <+ 4e-14 * ddt(V(cpphdl_n1405, Vss)); // Bench initial voltage = 0.0 V.
        // device 1009, IC IC160, analog/basic/nmos_resistor_amplifier.hpp:34
        I(cpphdl_n1399, cpphdl_n1403) <+ 2e-14 * ddt(V(cpphdl_n1399, cpphdl_n1403)); // Bench initial voltage = 1.6499999999999999 V.
        // device 1010, IC IC160, analog/basic/nmos_resistor_amplifier.hpp:35
        I(cpphdl_n1400, cpphdl_n1404) <+ 2e-14 * ddt(V(cpphdl_n1400, cpphdl_n1404)); // Bench initial voltage = 0.0 V.
        // device 1011, IC IC160, analog/basic/nmos_resistor_amplifier.hpp:36
        I(cpphdl_n1399, cpphdl_n1409) <+ 2.9999999999999998e-15 * ddt(V(cpphdl_n1399, cpphdl_n1409)); // Bench initial voltage = -1.6499999999999999 V.
        // device 1012, IC IC160, analog/basic/nmos_resistor_amplifier.hpp:37
        I(cpphdl_n1400, cpphdl_n1408) <+ 2.9999999999999998e-15 * ddt(V(cpphdl_n1400, cpphdl_n1408)); // Bench initial voltage = -3.2999999999999998 V.
        // device 1013, IC IC161, analog/basic/strongarm_comparator.hpp:28
        I(cpphdl_n1413, cpphdl_n1415) <+ cpphdl_channel(V(cpphdl_n1408, cpphdl_n1415), V(cpphdl_n1413, cpphdl_n1415), 0.0080000000000000002, 0.69999999999999996, 1.0);
        // device 1014, IC IC161, analog/basic/strongarm_comparator.hpp:29
        I(cpphdl_n1414, cpphdl_n1415) <+ cpphdl_channel(V(cpphdl_n1409, cpphdl_n1415), V(cpphdl_n1414, cpphdl_n1415), 0.0080000000000000002, 0.69999999999999996, 1.0);
        // device 1015, IC IC161, analog/basic/strongarm_comparator.hpp:30
        I(cpphdl_n1415, Vss) <+ cpphdl_channel(V(EVALUATE, Vss), V(cpphdl_n1415, Vss), 0.0080000000000000002, 0.69999999999999996, 1.0);
        // device 1016, IC IC161, analog/basic/strongarm_comparator.hpp:33
        I(cpphdl_n1427, cpphdl_n1413) <+ cpphdl_channel(V(cpphdl_n1433, cpphdl_n1413), V(cpphdl_n1427, cpphdl_n1413), 0.0040000000000000001, 0.69999999999999996, 1.0);
        // device 1017, IC IC161, analog/basic/strongarm_comparator.hpp:34
        I(cpphdl_n1433, cpphdl_n1414) <+ cpphdl_channel(V(cpphdl_n1427, cpphdl_n1414), V(cpphdl_n1433, cpphdl_n1414), 0.0040000000000000001, 0.69999999999999996, 1.0);
        // device 1018, IC IC161, analog/basic/strongarm_comparator.hpp:35
        I(cpphdl_n1433, Vdd) <+ cpphdl_channel(V(cpphdl_n1427, Vdd), V(cpphdl_n1433, Vdd), 0.002, 0.69999999999999996, -1.0);
        // device 1019, IC IC161, analog/basic/strongarm_comparator.hpp:36
        I(cpphdl_n1427, Vdd) <+ cpphdl_channel(V(cpphdl_n1433, Vdd), V(cpphdl_n1427, Vdd), 0.002, 0.69999999999999996, -1.0);
        // device 1020, IC IC161, analog/basic/strongarm_comparator.hpp:38
        I(cpphdl_n1413, Vdd) <+ cpphdl_channel(V(EVALUATE, Vdd), V(cpphdl_n1413, Vdd), 0.002, 0.69999999999999996, -1.0);
        // device 1021, IC IC161, analog/basic/strongarm_comparator.hpp:39
        I(cpphdl_n1414, Vdd) <+ cpphdl_channel(V(EVALUATE, Vdd), V(cpphdl_n1414, Vdd), 0.002, 0.69999999999999996, -1.0);
        // device 1022, IC IC161, analog/basic/strongarm_comparator.hpp:40
        I(cpphdl_n1433, Vdd) <+ cpphdl_channel(V(EVALUATE, Vdd), V(cpphdl_n1433, Vdd), 0.002, 0.69999999999999996, -1.0);
        // device 1023, IC IC161, analog/basic/strongarm_comparator.hpp:41
        I(cpphdl_n1427, Vdd) <+ cpphdl_channel(V(EVALUATE, Vdd), V(cpphdl_n1427, Vdd), 0.002, 0.69999999999999996, -1.0);
        // device 1024, IC IC161, analog/basic/strongarm_comparator.hpp:42
        I(cpphdl_n1413, Vss) <+ 2.9999999999999998e-14 * ddt(V(cpphdl_n1413, Vss)); // Bench initial voltage = 0.0 V.
        // device 1025, IC IC161, analog/basic/strongarm_comparator.hpp:43
        I(cpphdl_n1414, Vss) <+ 2.9999999999999998e-14 * ddt(V(cpphdl_n1414, Vss)); // Bench initial voltage = 0.0 V.
        // device 1026, IC IC161, analog/basic/strongarm_comparator.hpp:44
        I(cpphdl_n1415, Vss) <+ 2.9999999999999998e-14 * ddt(V(cpphdl_n1415, Vss)); // Bench initial voltage = 0.0 V.
        // device 1027, IC IC161, analog/basic/strongarm_comparator.hpp:45
        I(cpphdl_n1433, Vss) <+ 5.0000000000000002e-14 * ddt(V(cpphdl_n1433, Vss)); // Bench initial voltage = 0.0 V.
        // device 1028, IC IC161, analog/basic/strongarm_comparator.hpp:46
        I(cpphdl_n1427, Vss) <+ 5.0000000000000002e-14 * ddt(V(cpphdl_n1427, Vss)); // Bench initial voltage = 0.0 V.
        // device 1029, IC IC161, analog/basic/strongarm_comparator.hpp:47
        I(cpphdl_n1408, cpphdl_n1415) <+ 2e-14 * ddt(V(cpphdl_n1408, cpphdl_n1415)); // Bench initial voltage = 3.2999999999999998 V.
        // device 1030, IC IC161, analog/basic/strongarm_comparator.hpp:48
        I(cpphdl_n1409, cpphdl_n1415) <+ 2e-14 * ddt(V(cpphdl_n1409, cpphdl_n1415)); // Bench initial voltage = 3.2999999999999998 V.
        // device 1031, IC IC161, analog/basic/strongarm_comparator.hpp:49
        I(cpphdl_n1408, cpphdl_n1413) <+ 2.9999999999999998e-15 * ddt(V(cpphdl_n1408, cpphdl_n1413)); // Bench initial voltage = 3.2999999999999998 V.
        // device 1032, IC IC161, analog/basic/strongarm_comparator.hpp:50
        I(cpphdl_n1409, cpphdl_n1414) <+ 2.9999999999999998e-15 * ddt(V(cpphdl_n1409, cpphdl_n1414)); // Bench initial voltage = 3.2999999999999998 V.
        // device 1033, IC IC163, analog/basic/cmos_logic.hpp:15
        I(cpphdl_n2341, Vss) <+ 5.0000000000000002e-14 * ddt(V(cpphdl_n2341, Vss)); // Bench initial voltage = 0.0 V.
        // device 1034, IC IC163, analog/basic/cmos_logic.hpp:16
        I(cpphdl_n2341, Vdd) <+ cpphdl_channel(V(cpphdl_n1427, Vdd), V(cpphdl_n2341, Vdd), 0.01, 0.69999999999999996, -1.0);
        // device 1035, IC IC163, analog/basic/cmos_logic.hpp:17
        I(cpphdl_n2341, Vdd) <+ cpphdl_channel(V(cpphdl_n1435, Vdd), V(cpphdl_n2341, Vdd), 0.01, 0.69999999999999996, -1.0);
        // device 1036, IC IC163, analog/basic/cmos_logic.hpp:18
        I(cpphdl_n2341, cpphdl_n1430) <+ cpphdl_channel(V(cpphdl_n1427, cpphdl_n1430), V(cpphdl_n2341, cpphdl_n1430), 0.01, 0.69999999999999996, 1.0);
        // device 1037, IC IC163, analog/basic/cmos_logic.hpp:19
        I(cpphdl_n1430, Vss) <+ cpphdl_channel(V(cpphdl_n1435, Vss), V(cpphdl_n1430, Vss), 0.01, 0.69999999999999996, 1.0);
        // device 1038, IC IC163, analog/basic/cmos_logic.hpp:20
        I(cpphdl_n2341, Vss) <+ V(cpphdl_n2341, Vss) / 1000000000.0;
        // device 1039, IC IC163, analog/basic/cmos_logic.hpp:21
        I(cpphdl_n1430, Vss) <+ V(cpphdl_n1430, Vss) / 1000000000.0;
        // device 1040, IC IC164, analog/basic/cmos_logic.hpp:15
        I(cpphdl_n1435, Vss) <+ 5.0000000000000002e-14 * ddt(V(cpphdl_n1435, Vss)); // Bench initial voltage = 0.0 V.
        // device 1041, IC IC164, analog/basic/cmos_logic.hpp:16
        I(cpphdl_n1435, Vdd) <+ cpphdl_channel(V(cpphdl_n1433, Vdd), V(cpphdl_n1435, Vdd), 0.01, 0.69999999999999996, -1.0);
        // device 1042, IC IC164, analog/basic/cmos_logic.hpp:17
        I(cpphdl_n1435, Vdd) <+ cpphdl_channel(V(cpphdl_n2341, Vdd), V(cpphdl_n1435, Vdd), 0.01, 0.69999999999999996, -1.0);
        // device 1043, IC IC164, analog/basic/cmos_logic.hpp:18
        I(cpphdl_n1435, cpphdl_n1436) <+ cpphdl_channel(V(cpphdl_n1433, cpphdl_n1436), V(cpphdl_n1435, cpphdl_n1436), 0.01, 0.69999999999999996, 1.0);
        // device 1044, IC IC164, analog/basic/cmos_logic.hpp:19
        I(cpphdl_n1436, Vss) <+ cpphdl_channel(V(cpphdl_n2341, Vss), V(cpphdl_n1436, Vss), 0.01, 0.69999999999999996, 1.0);
        // device 1045, IC IC164, analog/basic/cmos_logic.hpp:20
        I(cpphdl_n1435, Vss) <+ V(cpphdl_n1435, Vss) / 1000000000.0;
        // device 1046, IC IC164, analog/basic/cmos_logic.hpp:21
        I(cpphdl_n1436, Vss) <+ V(cpphdl_n1436, Vss) / 1000000000.0;
        // device 1047, IC IC162, analog/basic/nand_latch.hpp:34
        I(cpphdl_n1427, Vss) <+ 2.9999999999999998e-15 * ddt(V(cpphdl_n1427, Vss)); // Bench initial voltage = 0.0 V.
        // device 1048, IC IC162, analog/basic/nand_latch.hpp:35
        I(cpphdl_n1433, Vss) <+ 2.9999999999999998e-15 * ddt(V(cpphdl_n1433, Vss)); // Bench initial voltage = 0.0 V.
        // device 1049, IC IC165, analog/basic/inverter.hpp:11
        I(cpphdl_n1441, Vdd) <+ cpphdl_channel(V(CLEAR, Vdd), V(cpphdl_n1441, Vdd), 0.01, 0.69999999999999996, -1.0);
        // device 1050, IC IC165, analog/basic/inverter.hpp:12
        I(cpphdl_n1441, Vss) <+ cpphdl_channel(V(CLEAR, Vss), V(cpphdl_n1441, Vss), 0.01, 0.69999999999999996, 1.0);
        // device 1051, IC IC162, analog/basic/nand_latch.hpp:56
        I(cpphdl_n1441, Vss) <+ 2.9999999999999998e-15 * ddt(V(cpphdl_n1441, Vss)); // Bench initial voltage = 0.0 V.
        // device 1052, IC IC162, analog/basic/nand_latch.hpp:57
        I(cpphdl_n2341, Vss) <+ cpphdl_channel(V(CLEAR, Vss), V(cpphdl_n2341, Vss), 0.050000000000000003, 0.69999999999999996, 1.0);
        // device 1053, IC IC162, analog/basic/nand_latch.hpp:58
        I(cpphdl_n1435, Vdd) <+ cpphdl_channel(V(cpphdl_n1441, Vdd), V(cpphdl_n1435, Vdd), 0.050000000000000003, 0.69999999999999996, -1.0);
        // device 1054, IC IC168, analog/basic/inverter.hpp:11
        I(cpphdl_n1465, Vdd) <+ cpphdl_channel(V(TRACK9, Vdd), V(cpphdl_n1465, Vdd), 0.0040000000000000001, 0.69999999999999996, -1.0);
        // device 1055, IC IC168, analog/basic/inverter.hpp:12
        I(cpphdl_n1465, Vss) <+ cpphdl_channel(V(TRACK9, Vss), V(cpphdl_n1465, Vss), 0.0040000000000000001, 0.69999999999999996, 1.0);
        // device 1056, IC IC167, analog/basic/mos_track_hold.hpp:30
        I(cpphdl_n1465, Vss) <+ 2e-14 * ddt(V(cpphdl_n1465, Vss)); // Bench initial voltage = 3.2999999999999998 V.
        // device 1057, IC IC167, analog/basic/mos_track_hold.hpp:31
        I(cpphdl_n2179, cpphdl_n1519) <+ cpphdl_channel(V(TRACK9, cpphdl_n1519), V(cpphdl_n2179, cpphdl_n1519), 0.080000000000000002, 0.69999999999999996, 1.0);
        // device 1058, IC IC167, analog/basic/mos_track_hold.hpp:32
        I(cpphdl_n1519, cpphdl_n2179) <+ cpphdl_channel(V(cpphdl_n1465, cpphdl_n2179), V(cpphdl_n1519, cpphdl_n2179), 0.040000000000000001, 0.69999999999999996, -1.0);
        // device 1059, IC IC167, analog/basic/mos_track_hold.hpp:36
        I(cpphdl_n1519, cpphdl_n1519) <+ cpphdl_channel(V(cpphdl_n1465, cpphdl_n1519), V(cpphdl_n1519, cpphdl_n1519), 0.040000000000000001, 0.69999999999999996, 1.0);
        // device 1060, IC IC167, analog/basic/mos_track_hold.hpp:37
        I(cpphdl_n1519, cpphdl_n1519) <+ cpphdl_channel(V(TRACK9, cpphdl_n1519), V(cpphdl_n1519, cpphdl_n1519), 0.02, 0.69999999999999996, -1.0);
        // device 1061, IC IC167, analog/basic/mos_track_hold.hpp:38
        I(cpphdl_n1519, Vss) <+ 2e-12 * ddt(V(cpphdl_n1519, Vss)); // Bench initial voltage = 1.6499999999999999 V.
        // device 1062, IC IC167, analog/basic/mos_track_hold.hpp:39
        I(Vss, cpphdl_n1519) <+ V(Vss, cpphdl_n1519) / 1000000000.0;
        // device 1063, IC IC167, analog/basic/mos_track_hold.hpp:40
        I(TRACK9, cpphdl_n1519) <+ 8.0000000000000006e-15 * ddt(V(TRACK9, cpphdl_n1519)); // Bench initial voltage = -1.6499999999999999 V.
        // device 1064, IC IC167, analog/basic/mos_track_hold.hpp:41
        I(cpphdl_n1465, cpphdl_n1519) <+ 8.0000000000000006e-15 * ddt(V(cpphdl_n1465, cpphdl_n1519)); // Bench initial voltage = 1.6499999999999999 V.
        // device 1065, IC IC167, analog/basic/mos_track_hold.hpp:42
        I(cpphdl_n2179, cpphdl_n1519) <+ 4.0000000000000003e-15 * ddt(V(cpphdl_n2179, cpphdl_n1519)); // Bench initial voltage = 0.0 V.
        // device 1066, IC IC170, analog/basic/inverter.hpp:11
        I(cpphdl_n1480, Vdd) <+ cpphdl_channel(V(BIT_N9_0, Vdd), V(cpphdl_n1480, Vdd), 0.080000000000000002, 0.69999999999999996, -1.0);
        // device 1067, IC IC170, analog/basic/inverter.hpp:12
        I(cpphdl_n1480, Vss) <+ cpphdl_channel(V(BIT_N9_0, Vss), V(cpphdl_n1480, Vss), 0.080000000000000002, 0.69999999999999996, 1.0);
        // device 1068, IC IC169, analog/basic/mos_r2r_dac.hpp:27
        I(cpphdl_n1480, Vss) <+ 2.9999999999999998e-15 * ddt(V(cpphdl_n1480, Vss)); // Bench initial voltage = 0.0 V.
        // device 1069, IC IC169, analog/basic/mos_r2r_dac.hpp:28
        I(cpphdl_n1480, cpphdl_n1509) <+ V(cpphdl_n1480, cpphdl_n1509) / 20000.0;
        // device 1070, IC IC169, analog/basic/mos_r2r_dac.hpp:29
        I(cpphdl_n1509, Vss) <+ 2.9999999999999998e-15 * ddt(V(cpphdl_n1509, Vss)); // Bench initial voltage = 0.0 V.
        // device 1071, IC IC171, analog/basic/inverter.hpp:11
        I(cpphdl_n1484, Vdd) <+ cpphdl_channel(V(BIT_N9_1, Vdd), V(cpphdl_n1484, Vdd), 0.080000000000000002, 0.69999999999999996, -1.0);
        // device 1072, IC IC171, analog/basic/inverter.hpp:12
        I(cpphdl_n1484, Vss) <+ cpphdl_channel(V(BIT_N9_1, Vss), V(cpphdl_n1484, Vss), 0.080000000000000002, 0.69999999999999996, 1.0);
        // device 1073, IC IC169, analog/basic/mos_r2r_dac.hpp:27
        I(cpphdl_n1484, Vss) <+ 2.9999999999999998e-15 * ddt(V(cpphdl_n1484, Vss)); // Bench initial voltage = 0.0 V.
        // device 1074, IC IC169, analog/basic/mos_r2r_dac.hpp:28
        I(cpphdl_n1484, cpphdl_n1510) <+ V(cpphdl_n1484, cpphdl_n1510) / 20000.0;
        // device 1075, IC IC169, analog/basic/mos_r2r_dac.hpp:29
        I(cpphdl_n1510, Vss) <+ 2.9999999999999998e-15 * ddt(V(cpphdl_n1510, Vss)); // Bench initial voltage = 0.0 V.
        // device 1076, IC IC169, analog/basic/mos_r2r_dac.hpp:31
        I(cpphdl_n1509, cpphdl_n1510) <+ V(cpphdl_n1509, cpphdl_n1510) / 10000.0;
        // device 1077, IC IC172, analog/basic/inverter.hpp:11
        I(cpphdl_n1488, Vdd) <+ cpphdl_channel(V(BIT_N9_2, Vdd), V(cpphdl_n1488, Vdd), 0.080000000000000002, 0.69999999999999996, -1.0);
        // device 1078, IC IC172, analog/basic/inverter.hpp:12
        I(cpphdl_n1488, Vss) <+ cpphdl_channel(V(BIT_N9_2, Vss), V(cpphdl_n1488, Vss), 0.080000000000000002, 0.69999999999999996, 1.0);
        // device 1079, IC IC169, analog/basic/mos_r2r_dac.hpp:27
        I(cpphdl_n1488, Vss) <+ 2.9999999999999998e-15 * ddt(V(cpphdl_n1488, Vss)); // Bench initial voltage = 0.0 V.
        // device 1080, IC IC169, analog/basic/mos_r2r_dac.hpp:28
        I(cpphdl_n1488, cpphdl_n1511) <+ V(cpphdl_n1488, cpphdl_n1511) / 20000.0;
        // device 1081, IC IC169, analog/basic/mos_r2r_dac.hpp:29
        I(cpphdl_n1511, Vss) <+ 2.9999999999999998e-15 * ddt(V(cpphdl_n1511, Vss)); // Bench initial voltage = 0.0 V.
        // device 1082, IC IC169, analog/basic/mos_r2r_dac.hpp:31
        I(cpphdl_n1510, cpphdl_n1511) <+ V(cpphdl_n1510, cpphdl_n1511) / 10000.0;
        // device 1083, IC IC173, analog/basic/inverter.hpp:11
        I(cpphdl_n1492, Vdd) <+ cpphdl_channel(V(BIT_N9_3, Vdd), V(cpphdl_n1492, Vdd), 0.080000000000000002, 0.69999999999999996, -1.0);
        // device 1084, IC IC173, analog/basic/inverter.hpp:12
        I(cpphdl_n1492, Vss) <+ cpphdl_channel(V(BIT_N9_3, Vss), V(cpphdl_n1492, Vss), 0.080000000000000002, 0.69999999999999996, 1.0);
        // device 1085, IC IC169, analog/basic/mos_r2r_dac.hpp:27
        I(cpphdl_n1492, Vss) <+ 2.9999999999999998e-15 * ddt(V(cpphdl_n1492, Vss)); // Bench initial voltage = 0.0 V.
        // device 1086, IC IC169, analog/basic/mos_r2r_dac.hpp:28
        I(cpphdl_n1492, cpphdl_n1512) <+ V(cpphdl_n1492, cpphdl_n1512) / 20000.0;
        // device 1087, IC IC169, analog/basic/mos_r2r_dac.hpp:29
        I(cpphdl_n1512, Vss) <+ 2.9999999999999998e-15 * ddt(V(cpphdl_n1512, Vss)); // Bench initial voltage = 0.0 V.
        // device 1088, IC IC169, analog/basic/mos_r2r_dac.hpp:31
        I(cpphdl_n1511, cpphdl_n1512) <+ V(cpphdl_n1511, cpphdl_n1512) / 10000.0;
        // device 1089, IC IC174, analog/basic/inverter.hpp:11
        I(cpphdl_n1496, Vdd) <+ cpphdl_channel(V(BIT_N9_4, Vdd), V(cpphdl_n1496, Vdd), 0.080000000000000002, 0.69999999999999996, -1.0);
        // device 1090, IC IC174, analog/basic/inverter.hpp:12
        I(cpphdl_n1496, Vss) <+ cpphdl_channel(V(BIT_N9_4, Vss), V(cpphdl_n1496, Vss), 0.080000000000000002, 0.69999999999999996, 1.0);
        // device 1091, IC IC169, analog/basic/mos_r2r_dac.hpp:27
        I(cpphdl_n1496, Vss) <+ 2.9999999999999998e-15 * ddt(V(cpphdl_n1496, Vss)); // Bench initial voltage = 0.0 V.
        // device 1092, IC IC169, analog/basic/mos_r2r_dac.hpp:28
        I(cpphdl_n1496, cpphdl_n1513) <+ V(cpphdl_n1496, cpphdl_n1513) / 20000.0;
        // device 1093, IC IC169, analog/basic/mos_r2r_dac.hpp:29
        I(cpphdl_n1513, Vss) <+ 2.9999999999999998e-15 * ddt(V(cpphdl_n1513, Vss)); // Bench initial voltage = 0.0 V.
        // device 1094, IC IC169, analog/basic/mos_r2r_dac.hpp:31
        I(cpphdl_n1512, cpphdl_n1513) <+ V(cpphdl_n1512, cpphdl_n1513) / 10000.0;
        // device 1095, IC IC175, analog/basic/inverter.hpp:11
        I(cpphdl_n1500, Vdd) <+ cpphdl_channel(V(BIT_N9_5, Vdd), V(cpphdl_n1500, Vdd), 0.080000000000000002, 0.69999999999999996, -1.0);
        // device 1096, IC IC175, analog/basic/inverter.hpp:12
        I(cpphdl_n1500, Vss) <+ cpphdl_channel(V(BIT_N9_5, Vss), V(cpphdl_n1500, Vss), 0.080000000000000002, 0.69999999999999996, 1.0);
        // device 1097, IC IC169, analog/basic/mos_r2r_dac.hpp:27
        I(cpphdl_n1500, Vss) <+ 2.9999999999999998e-15 * ddt(V(cpphdl_n1500, Vss)); // Bench initial voltage = 0.0 V.
        // device 1098, IC IC169, analog/basic/mos_r2r_dac.hpp:28
        I(cpphdl_n1500, cpphdl_n1514) <+ V(cpphdl_n1500, cpphdl_n1514) / 20000.0;
        // device 1099, IC IC169, analog/basic/mos_r2r_dac.hpp:29
        I(cpphdl_n1514, Vss) <+ 2.9999999999999998e-15 * ddt(V(cpphdl_n1514, Vss)); // Bench initial voltage = 0.0 V.
        // device 1100, IC IC169, analog/basic/mos_r2r_dac.hpp:31
        I(cpphdl_n1513, cpphdl_n1514) <+ V(cpphdl_n1513, cpphdl_n1514) / 10000.0;
        // device 1101, IC IC176, analog/basic/inverter.hpp:11
        I(cpphdl_n1504, Vdd) <+ cpphdl_channel(V(BIT_N9_6, Vdd), V(cpphdl_n1504, Vdd), 0.080000000000000002, 0.69999999999999996, -1.0);
        // device 1102, IC IC176, analog/basic/inverter.hpp:12
        I(cpphdl_n1504, Vss) <+ cpphdl_channel(V(BIT_N9_6, Vss), V(cpphdl_n1504, Vss), 0.080000000000000002, 0.69999999999999996, 1.0);
        // device 1103, IC IC169, analog/basic/mos_r2r_dac.hpp:27
        I(cpphdl_n1504, Vss) <+ 2.9999999999999998e-15 * ddt(V(cpphdl_n1504, Vss)); // Bench initial voltage = 0.0 V.
        // device 1104, IC IC169, analog/basic/mos_r2r_dac.hpp:28
        I(cpphdl_n1504, cpphdl_n1515) <+ V(cpphdl_n1504, cpphdl_n1515) / 20000.0;
        // device 1105, IC IC169, analog/basic/mos_r2r_dac.hpp:29
        I(cpphdl_n1515, Vss) <+ 2.9999999999999998e-15 * ddt(V(cpphdl_n1515, Vss)); // Bench initial voltage = 0.0 V.
        // device 1106, IC IC169, analog/basic/mos_r2r_dac.hpp:31
        I(cpphdl_n1514, cpphdl_n1515) <+ V(cpphdl_n1514, cpphdl_n1515) / 10000.0;
        // device 1107, IC IC177, analog/basic/inverter.hpp:11
        I(cpphdl_n1508, Vdd) <+ cpphdl_channel(V(BIT_N9_7, Vdd), V(cpphdl_n1508, Vdd), 0.080000000000000002, 0.69999999999999996, -1.0);
        // device 1108, IC IC177, analog/basic/inverter.hpp:12
        I(cpphdl_n1508, Vss) <+ cpphdl_channel(V(BIT_N9_7, Vss), V(cpphdl_n1508, Vss), 0.080000000000000002, 0.69999999999999996, 1.0);
        // device 1109, IC IC169, analog/basic/mos_r2r_dac.hpp:27
        I(cpphdl_n1508, Vss) <+ 2.9999999999999998e-15 * ddt(V(cpphdl_n1508, Vss)); // Bench initial voltage = 0.0 V.
        // device 1110, IC IC169, analog/basic/mos_r2r_dac.hpp:28
        I(cpphdl_n1508, cpphdl_n1520) <+ V(cpphdl_n1508, cpphdl_n1520) / 20000.0;
        // device 1111, IC IC169, analog/basic/mos_r2r_dac.hpp:29
        I(cpphdl_n1520, Vss) <+ 2.9999999999999998e-15 * ddt(V(cpphdl_n1520, Vss)); // Bench initial voltage = 0.0 V.
        // device 1112, IC IC169, analog/basic/mos_r2r_dac.hpp:31
        I(cpphdl_n1515, cpphdl_n1520) <+ V(cpphdl_n1515, cpphdl_n1520) / 10000.0;
        // device 1113, IC IC169, analog/basic/mos_r2r_dac.hpp:33
        I(Vss, cpphdl_n1509) <+ V(Vss, cpphdl_n1509) / 20000.0;
        // device 1114, IC IC178, analog/basic/nmos_resistor_amplifier.hpp:23
        I(Vdd, cpphdl_n1529) <+ V(Vdd, cpphdl_n1529) / 1000.0;
        // device 1115, IC IC178, analog/basic/nmos_resistor_amplifier.hpp:24
        I(Vdd, cpphdl_n1528) <+ V(Vdd, cpphdl_n1528) / 1000.0;
        // device 1116, IC IC178, analog/basic/nmos_resistor_amplifier.hpp:25
        I(cpphdl_n1529, cpphdl_n1523) <+ cpphdl_channel(V(cpphdl_n1519, cpphdl_n1523), V(cpphdl_n1529, cpphdl_n1523), 0.014999999999999999, 0.69999999999999996, 1.0);
        // device 1117, IC IC178, analog/basic/nmos_resistor_amplifier.hpp:26
        I(cpphdl_n1528, cpphdl_n1524) <+ cpphdl_channel(V(cpphdl_n1520, cpphdl_n1524), V(cpphdl_n1528, cpphdl_n1524), 0.014999999999999999, 0.69999999999999996, 1.0);
        // device 1118, IC IC178, analog/basic/nmos_resistor_amplifier.hpp:27
        I(cpphdl_n1525, cpphdl_n1523) <+ V(cpphdl_n1525, cpphdl_n1523) / 50.0;
        // device 1119, IC IC178, analog/basic/nmos_resistor_amplifier.hpp:28
        I(cpphdl_n1525, cpphdl_n1524) <+ V(cpphdl_n1525, cpphdl_n1524) / 50.0;
        // device 1120, IC IC178, analog/basic/nmos_resistor_amplifier.hpp:29
        I(Vss, cpphdl_n1525) <+ V(Vss, cpphdl_n1525) / 150.0;
        // device 1121, IC IC178, analog/basic/nmos_resistor_amplifier.hpp:30
        I(cpphdl_n1529, Vdd) <+ 2.9999999999999998e-13 * ddt(V(cpphdl_n1529, Vdd)); // Bench initial voltage = 0.0 V.
        // device 1122, IC IC178, analog/basic/nmos_resistor_amplifier.hpp:31
        I(cpphdl_n1528, Vdd) <+ 2.9999999999999998e-13 * ddt(V(cpphdl_n1528, Vdd)); // Bench initial voltage = 0.0 V.
        // device 1123, IC IC178, analog/basic/nmos_resistor_amplifier.hpp:32
        I(cpphdl_n1525, Vss) <+ 4e-14 * ddt(V(cpphdl_n1525, Vss)); // Bench initial voltage = 0.0 V.
        // device 1124, IC IC178, analog/basic/nmos_resistor_amplifier.hpp:34
        I(cpphdl_n1519, cpphdl_n1523) <+ 2e-14 * ddt(V(cpphdl_n1519, cpphdl_n1523)); // Bench initial voltage = 1.6499999999999999 V.
        // device 1125, IC IC178, analog/basic/nmos_resistor_amplifier.hpp:35
        I(cpphdl_n1520, cpphdl_n1524) <+ 2e-14 * ddt(V(cpphdl_n1520, cpphdl_n1524)); // Bench initial voltage = 0.0 V.
        // device 1126, IC IC178, analog/basic/nmos_resistor_amplifier.hpp:36
        I(cpphdl_n1519, cpphdl_n1529) <+ 2.9999999999999998e-15 * ddt(V(cpphdl_n1519, cpphdl_n1529)); // Bench initial voltage = -1.6499999999999999 V.
        // device 1127, IC IC178, analog/basic/nmos_resistor_amplifier.hpp:37
        I(cpphdl_n1520, cpphdl_n1528) <+ 2.9999999999999998e-15 * ddt(V(cpphdl_n1520, cpphdl_n1528)); // Bench initial voltage = -3.2999999999999998 V.
        // device 1128, IC IC179, analog/basic/strongarm_comparator.hpp:28
        I(cpphdl_n1533, cpphdl_n1535) <+ cpphdl_channel(V(cpphdl_n1528, cpphdl_n1535), V(cpphdl_n1533, cpphdl_n1535), 0.0080000000000000002, 0.69999999999999996, 1.0);
        // device 1129, IC IC179, analog/basic/strongarm_comparator.hpp:29
        I(cpphdl_n1534, cpphdl_n1535) <+ cpphdl_channel(V(cpphdl_n1529, cpphdl_n1535), V(cpphdl_n1534, cpphdl_n1535), 0.0080000000000000002, 0.69999999999999996, 1.0);
        // device 1130, IC IC179, analog/basic/strongarm_comparator.hpp:30
        I(cpphdl_n1535, Vss) <+ cpphdl_channel(V(EVALUATE, Vss), V(cpphdl_n1535, Vss), 0.0080000000000000002, 0.69999999999999996, 1.0);
        // device 1131, IC IC179, analog/basic/strongarm_comparator.hpp:33
        I(cpphdl_n1547, cpphdl_n1533) <+ cpphdl_channel(V(cpphdl_n1553, cpphdl_n1533), V(cpphdl_n1547, cpphdl_n1533), 0.0040000000000000001, 0.69999999999999996, 1.0);
        // device 1132, IC IC179, analog/basic/strongarm_comparator.hpp:34
        I(cpphdl_n1553, cpphdl_n1534) <+ cpphdl_channel(V(cpphdl_n1547, cpphdl_n1534), V(cpphdl_n1553, cpphdl_n1534), 0.0040000000000000001, 0.69999999999999996, 1.0);
        // device 1133, IC IC179, analog/basic/strongarm_comparator.hpp:35
        I(cpphdl_n1553, Vdd) <+ cpphdl_channel(V(cpphdl_n1547, Vdd), V(cpphdl_n1553, Vdd), 0.002, 0.69999999999999996, -1.0);
        // device 1134, IC IC179, analog/basic/strongarm_comparator.hpp:36
        I(cpphdl_n1547, Vdd) <+ cpphdl_channel(V(cpphdl_n1553, Vdd), V(cpphdl_n1547, Vdd), 0.002, 0.69999999999999996, -1.0);
        // device 1135, IC IC179, analog/basic/strongarm_comparator.hpp:38
        I(cpphdl_n1533, Vdd) <+ cpphdl_channel(V(EVALUATE, Vdd), V(cpphdl_n1533, Vdd), 0.002, 0.69999999999999996, -1.0);
        // device 1136, IC IC179, analog/basic/strongarm_comparator.hpp:39
        I(cpphdl_n1534, Vdd) <+ cpphdl_channel(V(EVALUATE, Vdd), V(cpphdl_n1534, Vdd), 0.002, 0.69999999999999996, -1.0);
        // device 1137, IC IC179, analog/basic/strongarm_comparator.hpp:40
        I(cpphdl_n1553, Vdd) <+ cpphdl_channel(V(EVALUATE, Vdd), V(cpphdl_n1553, Vdd), 0.002, 0.69999999999999996, -1.0);
        // device 1138, IC IC179, analog/basic/strongarm_comparator.hpp:41
        I(cpphdl_n1547, Vdd) <+ cpphdl_channel(V(EVALUATE, Vdd), V(cpphdl_n1547, Vdd), 0.002, 0.69999999999999996, -1.0);
        // device 1139, IC IC179, analog/basic/strongarm_comparator.hpp:42
        I(cpphdl_n1533, Vss) <+ 2.9999999999999998e-14 * ddt(V(cpphdl_n1533, Vss)); // Bench initial voltage = 0.0 V.
        // device 1140, IC IC179, analog/basic/strongarm_comparator.hpp:43
        I(cpphdl_n1534, Vss) <+ 2.9999999999999998e-14 * ddt(V(cpphdl_n1534, Vss)); // Bench initial voltage = 0.0 V.
        // device 1141, IC IC179, analog/basic/strongarm_comparator.hpp:44
        I(cpphdl_n1535, Vss) <+ 2.9999999999999998e-14 * ddt(V(cpphdl_n1535, Vss)); // Bench initial voltage = 0.0 V.
        // device 1142, IC IC179, analog/basic/strongarm_comparator.hpp:45
        I(cpphdl_n1553, Vss) <+ 5.0000000000000002e-14 * ddt(V(cpphdl_n1553, Vss)); // Bench initial voltage = 0.0 V.
        // device 1143, IC IC179, analog/basic/strongarm_comparator.hpp:46
        I(cpphdl_n1547, Vss) <+ 5.0000000000000002e-14 * ddt(V(cpphdl_n1547, Vss)); // Bench initial voltage = 0.0 V.
        // device 1144, IC IC179, analog/basic/strongarm_comparator.hpp:47
        I(cpphdl_n1528, cpphdl_n1535) <+ 2e-14 * ddt(V(cpphdl_n1528, cpphdl_n1535)); // Bench initial voltage = 3.2999999999999998 V.
        // device 1145, IC IC179, analog/basic/strongarm_comparator.hpp:48
        I(cpphdl_n1529, cpphdl_n1535) <+ 2e-14 * ddt(V(cpphdl_n1529, cpphdl_n1535)); // Bench initial voltage = 3.2999999999999998 V.
        // device 1146, IC IC179, analog/basic/strongarm_comparator.hpp:49
        I(cpphdl_n1528, cpphdl_n1533) <+ 2.9999999999999998e-15 * ddt(V(cpphdl_n1528, cpphdl_n1533)); // Bench initial voltage = 3.2999999999999998 V.
        // device 1147, IC IC179, analog/basic/strongarm_comparator.hpp:50
        I(cpphdl_n1529, cpphdl_n1534) <+ 2.9999999999999998e-15 * ddt(V(cpphdl_n1529, cpphdl_n1534)); // Bench initial voltage = 3.2999999999999998 V.
        // device 1148, IC IC181, analog/basic/cmos_logic.hpp:15
        I(cpphdl_n2346, Vss) <+ 5.0000000000000002e-14 * ddt(V(cpphdl_n2346, Vss)); // Bench initial voltage = 0.0 V.
        // device 1149, IC IC181, analog/basic/cmos_logic.hpp:16
        I(cpphdl_n2346, Vdd) <+ cpphdl_channel(V(cpphdl_n1547, Vdd), V(cpphdl_n2346, Vdd), 0.01, 0.69999999999999996, -1.0);
        // device 1150, IC IC181, analog/basic/cmos_logic.hpp:17
        I(cpphdl_n2346, Vdd) <+ cpphdl_channel(V(cpphdl_n1555, Vdd), V(cpphdl_n2346, Vdd), 0.01, 0.69999999999999996, -1.0);
        // device 1151, IC IC181, analog/basic/cmos_logic.hpp:18
        I(cpphdl_n2346, cpphdl_n1550) <+ cpphdl_channel(V(cpphdl_n1547, cpphdl_n1550), V(cpphdl_n2346, cpphdl_n1550), 0.01, 0.69999999999999996, 1.0);
        // device 1152, IC IC181, analog/basic/cmos_logic.hpp:19
        I(cpphdl_n1550, Vss) <+ cpphdl_channel(V(cpphdl_n1555, Vss), V(cpphdl_n1550, Vss), 0.01, 0.69999999999999996, 1.0);
        // device 1153, IC IC181, analog/basic/cmos_logic.hpp:20
        I(cpphdl_n2346, Vss) <+ V(cpphdl_n2346, Vss) / 1000000000.0;
        // device 1154, IC IC181, analog/basic/cmos_logic.hpp:21
        I(cpphdl_n1550, Vss) <+ V(cpphdl_n1550, Vss) / 1000000000.0;
        // device 1155, IC IC182, analog/basic/cmos_logic.hpp:15
        I(cpphdl_n1555, Vss) <+ 5.0000000000000002e-14 * ddt(V(cpphdl_n1555, Vss)); // Bench initial voltage = 0.0 V.
        // device 1156, IC IC182, analog/basic/cmos_logic.hpp:16
        I(cpphdl_n1555, Vdd) <+ cpphdl_channel(V(cpphdl_n1553, Vdd), V(cpphdl_n1555, Vdd), 0.01, 0.69999999999999996, -1.0);
        // device 1157, IC IC182, analog/basic/cmos_logic.hpp:17
        I(cpphdl_n1555, Vdd) <+ cpphdl_channel(V(cpphdl_n2346, Vdd), V(cpphdl_n1555, Vdd), 0.01, 0.69999999999999996, -1.0);
        // device 1158, IC IC182, analog/basic/cmos_logic.hpp:18
        I(cpphdl_n1555, cpphdl_n1556) <+ cpphdl_channel(V(cpphdl_n1553, cpphdl_n1556), V(cpphdl_n1555, cpphdl_n1556), 0.01, 0.69999999999999996, 1.0);
        // device 1159, IC IC182, analog/basic/cmos_logic.hpp:19
        I(cpphdl_n1556, Vss) <+ cpphdl_channel(V(cpphdl_n2346, Vss), V(cpphdl_n1556, Vss), 0.01, 0.69999999999999996, 1.0);
        // device 1160, IC IC182, analog/basic/cmos_logic.hpp:20
        I(cpphdl_n1555, Vss) <+ V(cpphdl_n1555, Vss) / 1000000000.0;
        // device 1161, IC IC182, analog/basic/cmos_logic.hpp:21
        I(cpphdl_n1556, Vss) <+ V(cpphdl_n1556, Vss) / 1000000000.0;
        // device 1162, IC IC180, analog/basic/nand_latch.hpp:34
        I(cpphdl_n1547, Vss) <+ 2.9999999999999998e-15 * ddt(V(cpphdl_n1547, Vss)); // Bench initial voltage = 0.0 V.
        // device 1163, IC IC180, analog/basic/nand_latch.hpp:35
        I(cpphdl_n1553, Vss) <+ 2.9999999999999998e-15 * ddt(V(cpphdl_n1553, Vss)); // Bench initial voltage = 0.0 V.
        // device 1164, IC IC183, analog/basic/inverter.hpp:11
        I(cpphdl_n1561, Vdd) <+ cpphdl_channel(V(CLEAR, Vdd), V(cpphdl_n1561, Vdd), 0.01, 0.69999999999999996, -1.0);
        // device 1165, IC IC183, analog/basic/inverter.hpp:12
        I(cpphdl_n1561, Vss) <+ cpphdl_channel(V(CLEAR, Vss), V(cpphdl_n1561, Vss), 0.01, 0.69999999999999996, 1.0);
        // device 1166, IC IC180, analog/basic/nand_latch.hpp:56
        I(cpphdl_n1561, Vss) <+ 2.9999999999999998e-15 * ddt(V(cpphdl_n1561, Vss)); // Bench initial voltage = 0.0 V.
        // device 1167, IC IC180, analog/basic/nand_latch.hpp:57
        I(cpphdl_n2346, Vss) <+ cpphdl_channel(V(CLEAR, Vss), V(cpphdl_n2346, Vss), 0.050000000000000003, 0.69999999999999996, 1.0);
        // device 1168, IC IC180, analog/basic/nand_latch.hpp:58
        I(cpphdl_n1555, Vdd) <+ cpphdl_channel(V(cpphdl_n1561, Vdd), V(cpphdl_n1555, Vdd), 0.050000000000000003, 0.69999999999999996, -1.0);
        // device 1169, IC IC186, analog/basic/inverter.hpp:11
        I(cpphdl_n1585, Vdd) <+ cpphdl_channel(V(TRACK10, Vdd), V(cpphdl_n1585, Vdd), 0.0040000000000000001, 0.69999999999999996, -1.0);
        // device 1170, IC IC186, analog/basic/inverter.hpp:12
        I(cpphdl_n1585, Vss) <+ cpphdl_channel(V(TRACK10, Vss), V(cpphdl_n1585, Vss), 0.0040000000000000001, 0.69999999999999996, 1.0);
        // device 1171, IC IC185, analog/basic/mos_track_hold.hpp:30
        I(cpphdl_n1585, Vss) <+ 2e-14 * ddt(V(cpphdl_n1585, Vss)); // Bench initial voltage = 3.2999999999999998 V.
        // device 1172, IC IC185, analog/basic/mos_track_hold.hpp:31
        I(cpphdl_n2179, cpphdl_n1639) <+ cpphdl_channel(V(TRACK10, cpphdl_n1639), V(cpphdl_n2179, cpphdl_n1639), 0.080000000000000002, 0.69999999999999996, 1.0);
        // device 1173, IC IC185, analog/basic/mos_track_hold.hpp:32
        I(cpphdl_n1639, cpphdl_n2179) <+ cpphdl_channel(V(cpphdl_n1585, cpphdl_n2179), V(cpphdl_n1639, cpphdl_n2179), 0.040000000000000001, 0.69999999999999996, -1.0);
        // device 1174, IC IC185, analog/basic/mos_track_hold.hpp:36
        I(cpphdl_n1639, cpphdl_n1639) <+ cpphdl_channel(V(cpphdl_n1585, cpphdl_n1639), V(cpphdl_n1639, cpphdl_n1639), 0.040000000000000001, 0.69999999999999996, 1.0);
        // device 1175, IC IC185, analog/basic/mos_track_hold.hpp:37
        I(cpphdl_n1639, cpphdl_n1639) <+ cpphdl_channel(V(TRACK10, cpphdl_n1639), V(cpphdl_n1639, cpphdl_n1639), 0.02, 0.69999999999999996, -1.0);
        // device 1176, IC IC185, analog/basic/mos_track_hold.hpp:38
        I(cpphdl_n1639, Vss) <+ 2e-12 * ddt(V(cpphdl_n1639, Vss)); // Bench initial voltage = 1.6499999999999999 V.
        // device 1177, IC IC185, analog/basic/mos_track_hold.hpp:39
        I(Vss, cpphdl_n1639) <+ V(Vss, cpphdl_n1639) / 1000000000.0;
        // device 1178, IC IC185, analog/basic/mos_track_hold.hpp:40
        I(TRACK10, cpphdl_n1639) <+ 8.0000000000000006e-15 * ddt(V(TRACK10, cpphdl_n1639)); // Bench initial voltage = -1.6499999999999999 V.
        // device 1179, IC IC185, analog/basic/mos_track_hold.hpp:41
        I(cpphdl_n1585, cpphdl_n1639) <+ 8.0000000000000006e-15 * ddt(V(cpphdl_n1585, cpphdl_n1639)); // Bench initial voltage = 1.6499999999999999 V.
        // device 1180, IC IC185, analog/basic/mos_track_hold.hpp:42
        I(cpphdl_n2179, cpphdl_n1639) <+ 4.0000000000000003e-15 * ddt(V(cpphdl_n2179, cpphdl_n1639)); // Bench initial voltage = 0.0 V.
        // device 1181, IC IC188, analog/basic/inverter.hpp:11
        I(cpphdl_n1600, Vdd) <+ cpphdl_channel(V(BIT_N10_0, Vdd), V(cpphdl_n1600, Vdd), 0.080000000000000002, 0.69999999999999996, -1.0);
        // device 1182, IC IC188, analog/basic/inverter.hpp:12
        I(cpphdl_n1600, Vss) <+ cpphdl_channel(V(BIT_N10_0, Vss), V(cpphdl_n1600, Vss), 0.080000000000000002, 0.69999999999999996, 1.0);
        // device 1183, IC IC187, analog/basic/mos_r2r_dac.hpp:27
        I(cpphdl_n1600, Vss) <+ 2.9999999999999998e-15 * ddt(V(cpphdl_n1600, Vss)); // Bench initial voltage = 0.0 V.
        // device 1184, IC IC187, analog/basic/mos_r2r_dac.hpp:28
        I(cpphdl_n1600, cpphdl_n1629) <+ V(cpphdl_n1600, cpphdl_n1629) / 20000.0;
        // device 1185, IC IC187, analog/basic/mos_r2r_dac.hpp:29
        I(cpphdl_n1629, Vss) <+ 2.9999999999999998e-15 * ddt(V(cpphdl_n1629, Vss)); // Bench initial voltage = 0.0 V.
        // device 1186, IC IC189, analog/basic/inverter.hpp:11
        I(cpphdl_n1604, Vdd) <+ cpphdl_channel(V(BIT_N10_1, Vdd), V(cpphdl_n1604, Vdd), 0.080000000000000002, 0.69999999999999996, -1.0);
        // device 1187, IC IC189, analog/basic/inverter.hpp:12
        I(cpphdl_n1604, Vss) <+ cpphdl_channel(V(BIT_N10_1, Vss), V(cpphdl_n1604, Vss), 0.080000000000000002, 0.69999999999999996, 1.0);
        // device 1188, IC IC187, analog/basic/mos_r2r_dac.hpp:27
        I(cpphdl_n1604, Vss) <+ 2.9999999999999998e-15 * ddt(V(cpphdl_n1604, Vss)); // Bench initial voltage = 0.0 V.
        // device 1189, IC IC187, analog/basic/mos_r2r_dac.hpp:28
        I(cpphdl_n1604, cpphdl_n1630) <+ V(cpphdl_n1604, cpphdl_n1630) / 20000.0;
        // device 1190, IC IC187, analog/basic/mos_r2r_dac.hpp:29
        I(cpphdl_n1630, Vss) <+ 2.9999999999999998e-15 * ddt(V(cpphdl_n1630, Vss)); // Bench initial voltage = 0.0 V.
        // device 1191, IC IC187, analog/basic/mos_r2r_dac.hpp:31
        I(cpphdl_n1629, cpphdl_n1630) <+ V(cpphdl_n1629, cpphdl_n1630) / 10000.0;
        // device 1192, IC IC190, analog/basic/inverter.hpp:11
        I(cpphdl_n1608, Vdd) <+ cpphdl_channel(V(BIT_N10_2, Vdd), V(cpphdl_n1608, Vdd), 0.080000000000000002, 0.69999999999999996, -1.0);
        // device 1193, IC IC190, analog/basic/inverter.hpp:12
        I(cpphdl_n1608, Vss) <+ cpphdl_channel(V(BIT_N10_2, Vss), V(cpphdl_n1608, Vss), 0.080000000000000002, 0.69999999999999996, 1.0);
        // device 1194, IC IC187, analog/basic/mos_r2r_dac.hpp:27
        I(cpphdl_n1608, Vss) <+ 2.9999999999999998e-15 * ddt(V(cpphdl_n1608, Vss)); // Bench initial voltage = 0.0 V.
        // device 1195, IC IC187, analog/basic/mos_r2r_dac.hpp:28
        I(cpphdl_n1608, cpphdl_n1631) <+ V(cpphdl_n1608, cpphdl_n1631) / 20000.0;
        // device 1196, IC IC187, analog/basic/mos_r2r_dac.hpp:29
        I(cpphdl_n1631, Vss) <+ 2.9999999999999998e-15 * ddt(V(cpphdl_n1631, Vss)); // Bench initial voltage = 0.0 V.
        // device 1197, IC IC187, analog/basic/mos_r2r_dac.hpp:31
        I(cpphdl_n1630, cpphdl_n1631) <+ V(cpphdl_n1630, cpphdl_n1631) / 10000.0;
        // device 1198, IC IC191, analog/basic/inverter.hpp:11
        I(cpphdl_n1612, Vdd) <+ cpphdl_channel(V(BIT_N10_3, Vdd), V(cpphdl_n1612, Vdd), 0.080000000000000002, 0.69999999999999996, -1.0);
        // device 1199, IC IC191, analog/basic/inverter.hpp:12
        I(cpphdl_n1612, Vss) <+ cpphdl_channel(V(BIT_N10_3, Vss), V(cpphdl_n1612, Vss), 0.080000000000000002, 0.69999999999999996, 1.0);
        // device 1200, IC IC187, analog/basic/mos_r2r_dac.hpp:27
        I(cpphdl_n1612, Vss) <+ 2.9999999999999998e-15 * ddt(V(cpphdl_n1612, Vss)); // Bench initial voltage = 0.0 V.
        // device 1201, IC IC187, analog/basic/mos_r2r_dac.hpp:28
        I(cpphdl_n1612, cpphdl_n1632) <+ V(cpphdl_n1612, cpphdl_n1632) / 20000.0;
        // device 1202, IC IC187, analog/basic/mos_r2r_dac.hpp:29
        I(cpphdl_n1632, Vss) <+ 2.9999999999999998e-15 * ddt(V(cpphdl_n1632, Vss)); // Bench initial voltage = 0.0 V.
        // device 1203, IC IC187, analog/basic/mos_r2r_dac.hpp:31
        I(cpphdl_n1631, cpphdl_n1632) <+ V(cpphdl_n1631, cpphdl_n1632) / 10000.0;
        // device 1204, IC IC192, analog/basic/inverter.hpp:11
        I(cpphdl_n1616, Vdd) <+ cpphdl_channel(V(BIT_N10_4, Vdd), V(cpphdl_n1616, Vdd), 0.080000000000000002, 0.69999999999999996, -1.0);
        // device 1205, IC IC192, analog/basic/inverter.hpp:12
        I(cpphdl_n1616, Vss) <+ cpphdl_channel(V(BIT_N10_4, Vss), V(cpphdl_n1616, Vss), 0.080000000000000002, 0.69999999999999996, 1.0);
        // device 1206, IC IC187, analog/basic/mos_r2r_dac.hpp:27
        I(cpphdl_n1616, Vss) <+ 2.9999999999999998e-15 * ddt(V(cpphdl_n1616, Vss)); // Bench initial voltage = 0.0 V.
        // device 1207, IC IC187, analog/basic/mos_r2r_dac.hpp:28
        I(cpphdl_n1616, cpphdl_n1633) <+ V(cpphdl_n1616, cpphdl_n1633) / 20000.0;
        // device 1208, IC IC187, analog/basic/mos_r2r_dac.hpp:29
        I(cpphdl_n1633, Vss) <+ 2.9999999999999998e-15 * ddt(V(cpphdl_n1633, Vss)); // Bench initial voltage = 0.0 V.
        // device 1209, IC IC187, analog/basic/mos_r2r_dac.hpp:31
        I(cpphdl_n1632, cpphdl_n1633) <+ V(cpphdl_n1632, cpphdl_n1633) / 10000.0;
        // device 1210, IC IC193, analog/basic/inverter.hpp:11
        I(cpphdl_n1620, Vdd) <+ cpphdl_channel(V(BIT_N10_5, Vdd), V(cpphdl_n1620, Vdd), 0.080000000000000002, 0.69999999999999996, -1.0);
        // device 1211, IC IC193, analog/basic/inverter.hpp:12
        I(cpphdl_n1620, Vss) <+ cpphdl_channel(V(BIT_N10_5, Vss), V(cpphdl_n1620, Vss), 0.080000000000000002, 0.69999999999999996, 1.0);
        // device 1212, IC IC187, analog/basic/mos_r2r_dac.hpp:27
        I(cpphdl_n1620, Vss) <+ 2.9999999999999998e-15 * ddt(V(cpphdl_n1620, Vss)); // Bench initial voltage = 0.0 V.
        // device 1213, IC IC187, analog/basic/mos_r2r_dac.hpp:28
        I(cpphdl_n1620, cpphdl_n1634) <+ V(cpphdl_n1620, cpphdl_n1634) / 20000.0;
        // device 1214, IC IC187, analog/basic/mos_r2r_dac.hpp:29
        I(cpphdl_n1634, Vss) <+ 2.9999999999999998e-15 * ddt(V(cpphdl_n1634, Vss)); // Bench initial voltage = 0.0 V.
        // device 1215, IC IC187, analog/basic/mos_r2r_dac.hpp:31
        I(cpphdl_n1633, cpphdl_n1634) <+ V(cpphdl_n1633, cpphdl_n1634) / 10000.0;
        // device 1216, IC IC194, analog/basic/inverter.hpp:11
        I(cpphdl_n1624, Vdd) <+ cpphdl_channel(V(BIT_N10_6, Vdd), V(cpphdl_n1624, Vdd), 0.080000000000000002, 0.69999999999999996, -1.0);
        // device 1217, IC IC194, analog/basic/inverter.hpp:12
        I(cpphdl_n1624, Vss) <+ cpphdl_channel(V(BIT_N10_6, Vss), V(cpphdl_n1624, Vss), 0.080000000000000002, 0.69999999999999996, 1.0);
        // device 1218, IC IC187, analog/basic/mos_r2r_dac.hpp:27
        I(cpphdl_n1624, Vss) <+ 2.9999999999999998e-15 * ddt(V(cpphdl_n1624, Vss)); // Bench initial voltage = 0.0 V.
        // device 1219, IC IC187, analog/basic/mos_r2r_dac.hpp:28
        I(cpphdl_n1624, cpphdl_n1635) <+ V(cpphdl_n1624, cpphdl_n1635) / 20000.0;
        // device 1220, IC IC187, analog/basic/mos_r2r_dac.hpp:29
        I(cpphdl_n1635, Vss) <+ 2.9999999999999998e-15 * ddt(V(cpphdl_n1635, Vss)); // Bench initial voltage = 0.0 V.
        // device 1221, IC IC187, analog/basic/mos_r2r_dac.hpp:31
        I(cpphdl_n1634, cpphdl_n1635) <+ V(cpphdl_n1634, cpphdl_n1635) / 10000.0;
        // device 1222, IC IC195, analog/basic/inverter.hpp:11
        I(cpphdl_n1628, Vdd) <+ cpphdl_channel(V(BIT_N10_7, Vdd), V(cpphdl_n1628, Vdd), 0.080000000000000002, 0.69999999999999996, -1.0);
        // device 1223, IC IC195, analog/basic/inverter.hpp:12
        I(cpphdl_n1628, Vss) <+ cpphdl_channel(V(BIT_N10_7, Vss), V(cpphdl_n1628, Vss), 0.080000000000000002, 0.69999999999999996, 1.0);
        // device 1224, IC IC187, analog/basic/mos_r2r_dac.hpp:27
        I(cpphdl_n1628, Vss) <+ 2.9999999999999998e-15 * ddt(V(cpphdl_n1628, Vss)); // Bench initial voltage = 0.0 V.
        // device 1225, IC IC187, analog/basic/mos_r2r_dac.hpp:28
        I(cpphdl_n1628, cpphdl_n1640) <+ V(cpphdl_n1628, cpphdl_n1640) / 20000.0;
        // device 1226, IC IC187, analog/basic/mos_r2r_dac.hpp:29
        I(cpphdl_n1640, Vss) <+ 2.9999999999999998e-15 * ddt(V(cpphdl_n1640, Vss)); // Bench initial voltage = 0.0 V.
        // device 1227, IC IC187, analog/basic/mos_r2r_dac.hpp:31
        I(cpphdl_n1635, cpphdl_n1640) <+ V(cpphdl_n1635, cpphdl_n1640) / 10000.0;
        // device 1228, IC IC187, analog/basic/mos_r2r_dac.hpp:33
        I(Vss, cpphdl_n1629) <+ V(Vss, cpphdl_n1629) / 20000.0;
        // device 1229, IC IC196, analog/basic/nmos_resistor_amplifier.hpp:23
        I(Vdd, cpphdl_n1649) <+ V(Vdd, cpphdl_n1649) / 1000.0;
        // device 1230, IC IC196, analog/basic/nmos_resistor_amplifier.hpp:24
        I(Vdd, cpphdl_n1648) <+ V(Vdd, cpphdl_n1648) / 1000.0;
        // device 1231, IC IC196, analog/basic/nmos_resistor_amplifier.hpp:25
        I(cpphdl_n1649, cpphdl_n1643) <+ cpphdl_channel(V(cpphdl_n1639, cpphdl_n1643), V(cpphdl_n1649, cpphdl_n1643), 0.014999999999999999, 0.69999999999999996, 1.0);
        // device 1232, IC IC196, analog/basic/nmos_resistor_amplifier.hpp:26
        I(cpphdl_n1648, cpphdl_n1644) <+ cpphdl_channel(V(cpphdl_n1640, cpphdl_n1644), V(cpphdl_n1648, cpphdl_n1644), 0.014999999999999999, 0.69999999999999996, 1.0);
        // device 1233, IC IC196, analog/basic/nmos_resistor_amplifier.hpp:27
        I(cpphdl_n1645, cpphdl_n1643) <+ V(cpphdl_n1645, cpphdl_n1643) / 50.0;
        // device 1234, IC IC196, analog/basic/nmos_resistor_amplifier.hpp:28
        I(cpphdl_n1645, cpphdl_n1644) <+ V(cpphdl_n1645, cpphdl_n1644) / 50.0;
        // device 1235, IC IC196, analog/basic/nmos_resistor_amplifier.hpp:29
        I(Vss, cpphdl_n1645) <+ V(Vss, cpphdl_n1645) / 150.0;
        // device 1236, IC IC196, analog/basic/nmos_resistor_amplifier.hpp:30
        I(cpphdl_n1649, Vdd) <+ 2.9999999999999998e-13 * ddt(V(cpphdl_n1649, Vdd)); // Bench initial voltage = 0.0 V.
        // device 1237, IC IC196, analog/basic/nmos_resistor_amplifier.hpp:31
        I(cpphdl_n1648, Vdd) <+ 2.9999999999999998e-13 * ddt(V(cpphdl_n1648, Vdd)); // Bench initial voltage = 0.0 V.
        // device 1238, IC IC196, analog/basic/nmos_resistor_amplifier.hpp:32
        I(cpphdl_n1645, Vss) <+ 4e-14 * ddt(V(cpphdl_n1645, Vss)); // Bench initial voltage = 0.0 V.
        // device 1239, IC IC196, analog/basic/nmos_resistor_amplifier.hpp:34
        I(cpphdl_n1639, cpphdl_n1643) <+ 2e-14 * ddt(V(cpphdl_n1639, cpphdl_n1643)); // Bench initial voltage = 1.6499999999999999 V.
        // device 1240, IC IC196, analog/basic/nmos_resistor_amplifier.hpp:35
        I(cpphdl_n1640, cpphdl_n1644) <+ 2e-14 * ddt(V(cpphdl_n1640, cpphdl_n1644)); // Bench initial voltage = 0.0 V.
        // device 1241, IC IC196, analog/basic/nmos_resistor_amplifier.hpp:36
        I(cpphdl_n1639, cpphdl_n1649) <+ 2.9999999999999998e-15 * ddt(V(cpphdl_n1639, cpphdl_n1649)); // Bench initial voltage = -1.6499999999999999 V.
        // device 1242, IC IC196, analog/basic/nmos_resistor_amplifier.hpp:37
        I(cpphdl_n1640, cpphdl_n1648) <+ 2.9999999999999998e-15 * ddt(V(cpphdl_n1640, cpphdl_n1648)); // Bench initial voltage = -3.2999999999999998 V.
        // device 1243, IC IC197, analog/basic/strongarm_comparator.hpp:28
        I(cpphdl_n1653, cpphdl_n1655) <+ cpphdl_channel(V(cpphdl_n1648, cpphdl_n1655), V(cpphdl_n1653, cpphdl_n1655), 0.0080000000000000002, 0.69999999999999996, 1.0);
        // device 1244, IC IC197, analog/basic/strongarm_comparator.hpp:29
        I(cpphdl_n1654, cpphdl_n1655) <+ cpphdl_channel(V(cpphdl_n1649, cpphdl_n1655), V(cpphdl_n1654, cpphdl_n1655), 0.0080000000000000002, 0.69999999999999996, 1.0);
        // device 1245, IC IC197, analog/basic/strongarm_comparator.hpp:30
        I(cpphdl_n1655, Vss) <+ cpphdl_channel(V(EVALUATE, Vss), V(cpphdl_n1655, Vss), 0.0080000000000000002, 0.69999999999999996, 1.0);
        // device 1246, IC IC197, analog/basic/strongarm_comparator.hpp:33
        I(cpphdl_n1667, cpphdl_n1653) <+ cpphdl_channel(V(cpphdl_n1673, cpphdl_n1653), V(cpphdl_n1667, cpphdl_n1653), 0.0040000000000000001, 0.69999999999999996, 1.0);
        // device 1247, IC IC197, analog/basic/strongarm_comparator.hpp:34
        I(cpphdl_n1673, cpphdl_n1654) <+ cpphdl_channel(V(cpphdl_n1667, cpphdl_n1654), V(cpphdl_n1673, cpphdl_n1654), 0.0040000000000000001, 0.69999999999999996, 1.0);
        // device 1248, IC IC197, analog/basic/strongarm_comparator.hpp:35
        I(cpphdl_n1673, Vdd) <+ cpphdl_channel(V(cpphdl_n1667, Vdd), V(cpphdl_n1673, Vdd), 0.002, 0.69999999999999996, -1.0);
        // device 1249, IC IC197, analog/basic/strongarm_comparator.hpp:36
        I(cpphdl_n1667, Vdd) <+ cpphdl_channel(V(cpphdl_n1673, Vdd), V(cpphdl_n1667, Vdd), 0.002, 0.69999999999999996, -1.0);
        // device 1250, IC IC197, analog/basic/strongarm_comparator.hpp:38
        I(cpphdl_n1653, Vdd) <+ cpphdl_channel(V(EVALUATE, Vdd), V(cpphdl_n1653, Vdd), 0.002, 0.69999999999999996, -1.0);
        // device 1251, IC IC197, analog/basic/strongarm_comparator.hpp:39
        I(cpphdl_n1654, Vdd) <+ cpphdl_channel(V(EVALUATE, Vdd), V(cpphdl_n1654, Vdd), 0.002, 0.69999999999999996, -1.0);
        // device 1252, IC IC197, analog/basic/strongarm_comparator.hpp:40
        I(cpphdl_n1673, Vdd) <+ cpphdl_channel(V(EVALUATE, Vdd), V(cpphdl_n1673, Vdd), 0.002, 0.69999999999999996, -1.0);
        // device 1253, IC IC197, analog/basic/strongarm_comparator.hpp:41
        I(cpphdl_n1667, Vdd) <+ cpphdl_channel(V(EVALUATE, Vdd), V(cpphdl_n1667, Vdd), 0.002, 0.69999999999999996, -1.0);
        // device 1254, IC IC197, analog/basic/strongarm_comparator.hpp:42
        I(cpphdl_n1653, Vss) <+ 2.9999999999999998e-14 * ddt(V(cpphdl_n1653, Vss)); // Bench initial voltage = 0.0 V.
        // device 1255, IC IC197, analog/basic/strongarm_comparator.hpp:43
        I(cpphdl_n1654, Vss) <+ 2.9999999999999998e-14 * ddt(V(cpphdl_n1654, Vss)); // Bench initial voltage = 0.0 V.
        // device 1256, IC IC197, analog/basic/strongarm_comparator.hpp:44
        I(cpphdl_n1655, Vss) <+ 2.9999999999999998e-14 * ddt(V(cpphdl_n1655, Vss)); // Bench initial voltage = 0.0 V.
        // device 1257, IC IC197, analog/basic/strongarm_comparator.hpp:45
        I(cpphdl_n1673, Vss) <+ 5.0000000000000002e-14 * ddt(V(cpphdl_n1673, Vss)); // Bench initial voltage = 0.0 V.
        // device 1258, IC IC197, analog/basic/strongarm_comparator.hpp:46
        I(cpphdl_n1667, Vss) <+ 5.0000000000000002e-14 * ddt(V(cpphdl_n1667, Vss)); // Bench initial voltage = 0.0 V.
        // device 1259, IC IC197, analog/basic/strongarm_comparator.hpp:47
        I(cpphdl_n1648, cpphdl_n1655) <+ 2e-14 * ddt(V(cpphdl_n1648, cpphdl_n1655)); // Bench initial voltage = 3.2999999999999998 V.
        // device 1260, IC IC197, analog/basic/strongarm_comparator.hpp:48
        I(cpphdl_n1649, cpphdl_n1655) <+ 2e-14 * ddt(V(cpphdl_n1649, cpphdl_n1655)); // Bench initial voltage = 3.2999999999999998 V.
        // device 1261, IC IC197, analog/basic/strongarm_comparator.hpp:49
        I(cpphdl_n1648, cpphdl_n1653) <+ 2.9999999999999998e-15 * ddt(V(cpphdl_n1648, cpphdl_n1653)); // Bench initial voltage = 3.2999999999999998 V.
        // device 1262, IC IC197, analog/basic/strongarm_comparator.hpp:50
        I(cpphdl_n1649, cpphdl_n1654) <+ 2.9999999999999998e-15 * ddt(V(cpphdl_n1649, cpphdl_n1654)); // Bench initial voltage = 3.2999999999999998 V.
        // device 1263, IC IC199, analog/basic/cmos_logic.hpp:15
        I(cpphdl_n2351, Vss) <+ 5.0000000000000002e-14 * ddt(V(cpphdl_n2351, Vss)); // Bench initial voltage = 0.0 V.
        // device 1264, IC IC199, analog/basic/cmos_logic.hpp:16
        I(cpphdl_n2351, Vdd) <+ cpphdl_channel(V(cpphdl_n1667, Vdd), V(cpphdl_n2351, Vdd), 0.01, 0.69999999999999996, -1.0);
        // device 1265, IC IC199, analog/basic/cmos_logic.hpp:17
        I(cpphdl_n2351, Vdd) <+ cpphdl_channel(V(cpphdl_n1675, Vdd), V(cpphdl_n2351, Vdd), 0.01, 0.69999999999999996, -1.0);
        // device 1266, IC IC199, analog/basic/cmos_logic.hpp:18
        I(cpphdl_n2351, cpphdl_n1670) <+ cpphdl_channel(V(cpphdl_n1667, cpphdl_n1670), V(cpphdl_n2351, cpphdl_n1670), 0.01, 0.69999999999999996, 1.0);
        // device 1267, IC IC199, analog/basic/cmos_logic.hpp:19
        I(cpphdl_n1670, Vss) <+ cpphdl_channel(V(cpphdl_n1675, Vss), V(cpphdl_n1670, Vss), 0.01, 0.69999999999999996, 1.0);
        // device 1268, IC IC199, analog/basic/cmos_logic.hpp:20
        I(cpphdl_n2351, Vss) <+ V(cpphdl_n2351, Vss) / 1000000000.0;
        // device 1269, IC IC199, analog/basic/cmos_logic.hpp:21
        I(cpphdl_n1670, Vss) <+ V(cpphdl_n1670, Vss) / 1000000000.0;
        // device 1270, IC IC200, analog/basic/cmos_logic.hpp:15
        I(cpphdl_n1675, Vss) <+ 5.0000000000000002e-14 * ddt(V(cpphdl_n1675, Vss)); // Bench initial voltage = 0.0 V.
        // device 1271, IC IC200, analog/basic/cmos_logic.hpp:16
        I(cpphdl_n1675, Vdd) <+ cpphdl_channel(V(cpphdl_n1673, Vdd), V(cpphdl_n1675, Vdd), 0.01, 0.69999999999999996, -1.0);
        // device 1272, IC IC200, analog/basic/cmos_logic.hpp:17
        I(cpphdl_n1675, Vdd) <+ cpphdl_channel(V(cpphdl_n2351, Vdd), V(cpphdl_n1675, Vdd), 0.01, 0.69999999999999996, -1.0);
        // device 1273, IC IC200, analog/basic/cmos_logic.hpp:18
        I(cpphdl_n1675, cpphdl_n1676) <+ cpphdl_channel(V(cpphdl_n1673, cpphdl_n1676), V(cpphdl_n1675, cpphdl_n1676), 0.01, 0.69999999999999996, 1.0);
        // device 1274, IC IC200, analog/basic/cmos_logic.hpp:19
        I(cpphdl_n1676, Vss) <+ cpphdl_channel(V(cpphdl_n2351, Vss), V(cpphdl_n1676, Vss), 0.01, 0.69999999999999996, 1.0);
        // device 1275, IC IC200, analog/basic/cmos_logic.hpp:20
        I(cpphdl_n1675, Vss) <+ V(cpphdl_n1675, Vss) / 1000000000.0;
        // device 1276, IC IC200, analog/basic/cmos_logic.hpp:21
        I(cpphdl_n1676, Vss) <+ V(cpphdl_n1676, Vss) / 1000000000.0;
        // device 1277, IC IC198, analog/basic/nand_latch.hpp:34
        I(cpphdl_n1667, Vss) <+ 2.9999999999999998e-15 * ddt(V(cpphdl_n1667, Vss)); // Bench initial voltage = 0.0 V.
        // device 1278, IC IC198, analog/basic/nand_latch.hpp:35
        I(cpphdl_n1673, Vss) <+ 2.9999999999999998e-15 * ddt(V(cpphdl_n1673, Vss)); // Bench initial voltage = 0.0 V.
        // device 1279, IC IC201, analog/basic/inverter.hpp:11
        I(cpphdl_n1681, Vdd) <+ cpphdl_channel(V(CLEAR, Vdd), V(cpphdl_n1681, Vdd), 0.01, 0.69999999999999996, -1.0);
        // device 1280, IC IC201, analog/basic/inverter.hpp:12
        I(cpphdl_n1681, Vss) <+ cpphdl_channel(V(CLEAR, Vss), V(cpphdl_n1681, Vss), 0.01, 0.69999999999999996, 1.0);
        // device 1281, IC IC198, analog/basic/nand_latch.hpp:56
        I(cpphdl_n1681, Vss) <+ 2.9999999999999998e-15 * ddt(V(cpphdl_n1681, Vss)); // Bench initial voltage = 0.0 V.
        // device 1282, IC IC198, analog/basic/nand_latch.hpp:57
        I(cpphdl_n2351, Vss) <+ cpphdl_channel(V(CLEAR, Vss), V(cpphdl_n2351, Vss), 0.050000000000000003, 0.69999999999999996, 1.0);
        // device 1283, IC IC198, analog/basic/nand_latch.hpp:58
        I(cpphdl_n1675, Vdd) <+ cpphdl_channel(V(cpphdl_n1681, Vdd), V(cpphdl_n1675, Vdd), 0.050000000000000003, 0.69999999999999996, -1.0);
        // device 1284, IC IC204, analog/basic/inverter.hpp:11
        I(cpphdl_n1705, Vdd) <+ cpphdl_channel(V(TRACK11, Vdd), V(cpphdl_n1705, Vdd), 0.0040000000000000001, 0.69999999999999996, -1.0);
        // device 1285, IC IC204, analog/basic/inverter.hpp:12
        I(cpphdl_n1705, Vss) <+ cpphdl_channel(V(TRACK11, Vss), V(cpphdl_n1705, Vss), 0.0040000000000000001, 0.69999999999999996, 1.0);
        // device 1286, IC IC203, analog/basic/mos_track_hold.hpp:30
        I(cpphdl_n1705, Vss) <+ 2e-14 * ddt(V(cpphdl_n1705, Vss)); // Bench initial voltage = 3.2999999999999998 V.
        // device 1287, IC IC203, analog/basic/mos_track_hold.hpp:31
        I(cpphdl_n2179, cpphdl_n1759) <+ cpphdl_channel(V(TRACK11, cpphdl_n1759), V(cpphdl_n2179, cpphdl_n1759), 0.080000000000000002, 0.69999999999999996, 1.0);
        // device 1288, IC IC203, analog/basic/mos_track_hold.hpp:32
        I(cpphdl_n1759, cpphdl_n2179) <+ cpphdl_channel(V(cpphdl_n1705, cpphdl_n2179), V(cpphdl_n1759, cpphdl_n2179), 0.040000000000000001, 0.69999999999999996, -1.0);
        // device 1289, IC IC203, analog/basic/mos_track_hold.hpp:36
        I(cpphdl_n1759, cpphdl_n1759) <+ cpphdl_channel(V(cpphdl_n1705, cpphdl_n1759), V(cpphdl_n1759, cpphdl_n1759), 0.040000000000000001, 0.69999999999999996, 1.0);
        // device 1290, IC IC203, analog/basic/mos_track_hold.hpp:37
        I(cpphdl_n1759, cpphdl_n1759) <+ cpphdl_channel(V(TRACK11, cpphdl_n1759), V(cpphdl_n1759, cpphdl_n1759), 0.02, 0.69999999999999996, -1.0);
        // device 1291, IC IC203, analog/basic/mos_track_hold.hpp:38
        I(cpphdl_n1759, Vss) <+ 2e-12 * ddt(V(cpphdl_n1759, Vss)); // Bench initial voltage = 1.6499999999999999 V.
        // device 1292, IC IC203, analog/basic/mos_track_hold.hpp:39
        I(Vss, cpphdl_n1759) <+ V(Vss, cpphdl_n1759) / 1000000000.0;
        // device 1293, IC IC203, analog/basic/mos_track_hold.hpp:40
        I(TRACK11, cpphdl_n1759) <+ 8.0000000000000006e-15 * ddt(V(TRACK11, cpphdl_n1759)); // Bench initial voltage = -1.6499999999999999 V.
        // device 1294, IC IC203, analog/basic/mos_track_hold.hpp:41
        I(cpphdl_n1705, cpphdl_n1759) <+ 8.0000000000000006e-15 * ddt(V(cpphdl_n1705, cpphdl_n1759)); // Bench initial voltage = 1.6499999999999999 V.
        // device 1295, IC IC203, analog/basic/mos_track_hold.hpp:42
        I(cpphdl_n2179, cpphdl_n1759) <+ 4.0000000000000003e-15 * ddt(V(cpphdl_n2179, cpphdl_n1759)); // Bench initial voltage = 0.0 V.
        // device 1296, IC IC206, analog/basic/inverter.hpp:11
        I(cpphdl_n1720, Vdd) <+ cpphdl_channel(V(BIT_N11_0, Vdd), V(cpphdl_n1720, Vdd), 0.080000000000000002, 0.69999999999999996, -1.0);
        // device 1297, IC IC206, analog/basic/inverter.hpp:12
        I(cpphdl_n1720, Vss) <+ cpphdl_channel(V(BIT_N11_0, Vss), V(cpphdl_n1720, Vss), 0.080000000000000002, 0.69999999999999996, 1.0);
        // device 1298, IC IC205, analog/basic/mos_r2r_dac.hpp:27
        I(cpphdl_n1720, Vss) <+ 2.9999999999999998e-15 * ddt(V(cpphdl_n1720, Vss)); // Bench initial voltage = 0.0 V.
        // device 1299, IC IC205, analog/basic/mos_r2r_dac.hpp:28
        I(cpphdl_n1720, cpphdl_n1749) <+ V(cpphdl_n1720, cpphdl_n1749) / 20000.0;
        // device 1300, IC IC205, analog/basic/mos_r2r_dac.hpp:29
        I(cpphdl_n1749, Vss) <+ 2.9999999999999998e-15 * ddt(V(cpphdl_n1749, Vss)); // Bench initial voltage = 0.0 V.
        // device 1301, IC IC207, analog/basic/inverter.hpp:11
        I(cpphdl_n1724, Vdd) <+ cpphdl_channel(V(BIT_N11_1, Vdd), V(cpphdl_n1724, Vdd), 0.080000000000000002, 0.69999999999999996, -1.0);
        // device 1302, IC IC207, analog/basic/inverter.hpp:12
        I(cpphdl_n1724, Vss) <+ cpphdl_channel(V(BIT_N11_1, Vss), V(cpphdl_n1724, Vss), 0.080000000000000002, 0.69999999999999996, 1.0);
        // device 1303, IC IC205, analog/basic/mos_r2r_dac.hpp:27
        I(cpphdl_n1724, Vss) <+ 2.9999999999999998e-15 * ddt(V(cpphdl_n1724, Vss)); // Bench initial voltage = 0.0 V.
        // device 1304, IC IC205, analog/basic/mos_r2r_dac.hpp:28
        I(cpphdl_n1724, cpphdl_n1750) <+ V(cpphdl_n1724, cpphdl_n1750) / 20000.0;
        // device 1305, IC IC205, analog/basic/mos_r2r_dac.hpp:29
        I(cpphdl_n1750, Vss) <+ 2.9999999999999998e-15 * ddt(V(cpphdl_n1750, Vss)); // Bench initial voltage = 0.0 V.
        // device 1306, IC IC205, analog/basic/mos_r2r_dac.hpp:31
        I(cpphdl_n1749, cpphdl_n1750) <+ V(cpphdl_n1749, cpphdl_n1750) / 10000.0;
        // device 1307, IC IC208, analog/basic/inverter.hpp:11
        I(cpphdl_n1728, Vdd) <+ cpphdl_channel(V(BIT_N11_2, Vdd), V(cpphdl_n1728, Vdd), 0.080000000000000002, 0.69999999999999996, -1.0);
        // device 1308, IC IC208, analog/basic/inverter.hpp:12
        I(cpphdl_n1728, Vss) <+ cpphdl_channel(V(BIT_N11_2, Vss), V(cpphdl_n1728, Vss), 0.080000000000000002, 0.69999999999999996, 1.0);
        // device 1309, IC IC205, analog/basic/mos_r2r_dac.hpp:27
        I(cpphdl_n1728, Vss) <+ 2.9999999999999998e-15 * ddt(V(cpphdl_n1728, Vss)); // Bench initial voltage = 0.0 V.
        // device 1310, IC IC205, analog/basic/mos_r2r_dac.hpp:28
        I(cpphdl_n1728, cpphdl_n1751) <+ V(cpphdl_n1728, cpphdl_n1751) / 20000.0;
        // device 1311, IC IC205, analog/basic/mos_r2r_dac.hpp:29
        I(cpphdl_n1751, Vss) <+ 2.9999999999999998e-15 * ddt(V(cpphdl_n1751, Vss)); // Bench initial voltage = 0.0 V.
        // device 1312, IC IC205, analog/basic/mos_r2r_dac.hpp:31
        I(cpphdl_n1750, cpphdl_n1751) <+ V(cpphdl_n1750, cpphdl_n1751) / 10000.0;
        // device 1313, IC IC209, analog/basic/inverter.hpp:11
        I(cpphdl_n1732, Vdd) <+ cpphdl_channel(V(BIT_N11_3, Vdd), V(cpphdl_n1732, Vdd), 0.080000000000000002, 0.69999999999999996, -1.0);
        // device 1314, IC IC209, analog/basic/inverter.hpp:12
        I(cpphdl_n1732, Vss) <+ cpphdl_channel(V(BIT_N11_3, Vss), V(cpphdl_n1732, Vss), 0.080000000000000002, 0.69999999999999996, 1.0);
        // device 1315, IC IC205, analog/basic/mos_r2r_dac.hpp:27
        I(cpphdl_n1732, Vss) <+ 2.9999999999999998e-15 * ddt(V(cpphdl_n1732, Vss)); // Bench initial voltage = 0.0 V.
        // device 1316, IC IC205, analog/basic/mos_r2r_dac.hpp:28
        I(cpphdl_n1732, cpphdl_n1752) <+ V(cpphdl_n1732, cpphdl_n1752) / 20000.0;
        // device 1317, IC IC205, analog/basic/mos_r2r_dac.hpp:29
        I(cpphdl_n1752, Vss) <+ 2.9999999999999998e-15 * ddt(V(cpphdl_n1752, Vss)); // Bench initial voltage = 0.0 V.
        // device 1318, IC IC205, analog/basic/mos_r2r_dac.hpp:31
        I(cpphdl_n1751, cpphdl_n1752) <+ V(cpphdl_n1751, cpphdl_n1752) / 10000.0;
        // device 1319, IC IC210, analog/basic/inverter.hpp:11
        I(cpphdl_n1736, Vdd) <+ cpphdl_channel(V(BIT_N11_4, Vdd), V(cpphdl_n1736, Vdd), 0.080000000000000002, 0.69999999999999996, -1.0);
        // device 1320, IC IC210, analog/basic/inverter.hpp:12
        I(cpphdl_n1736, Vss) <+ cpphdl_channel(V(BIT_N11_4, Vss), V(cpphdl_n1736, Vss), 0.080000000000000002, 0.69999999999999996, 1.0);
        // device 1321, IC IC205, analog/basic/mos_r2r_dac.hpp:27
        I(cpphdl_n1736, Vss) <+ 2.9999999999999998e-15 * ddt(V(cpphdl_n1736, Vss)); // Bench initial voltage = 0.0 V.
        // device 1322, IC IC205, analog/basic/mos_r2r_dac.hpp:28
        I(cpphdl_n1736, cpphdl_n1753) <+ V(cpphdl_n1736, cpphdl_n1753) / 20000.0;
        // device 1323, IC IC205, analog/basic/mos_r2r_dac.hpp:29
        I(cpphdl_n1753, Vss) <+ 2.9999999999999998e-15 * ddt(V(cpphdl_n1753, Vss)); // Bench initial voltage = 0.0 V.
        // device 1324, IC IC205, analog/basic/mos_r2r_dac.hpp:31
        I(cpphdl_n1752, cpphdl_n1753) <+ V(cpphdl_n1752, cpphdl_n1753) / 10000.0;
        // device 1325, IC IC211, analog/basic/inverter.hpp:11
        I(cpphdl_n1740, Vdd) <+ cpphdl_channel(V(BIT_N11_5, Vdd), V(cpphdl_n1740, Vdd), 0.080000000000000002, 0.69999999999999996, -1.0);
        // device 1326, IC IC211, analog/basic/inverter.hpp:12
        I(cpphdl_n1740, Vss) <+ cpphdl_channel(V(BIT_N11_5, Vss), V(cpphdl_n1740, Vss), 0.080000000000000002, 0.69999999999999996, 1.0);
        // device 1327, IC IC205, analog/basic/mos_r2r_dac.hpp:27
        I(cpphdl_n1740, Vss) <+ 2.9999999999999998e-15 * ddt(V(cpphdl_n1740, Vss)); // Bench initial voltage = 0.0 V.
        // device 1328, IC IC205, analog/basic/mos_r2r_dac.hpp:28
        I(cpphdl_n1740, cpphdl_n1754) <+ V(cpphdl_n1740, cpphdl_n1754) / 20000.0;
        // device 1329, IC IC205, analog/basic/mos_r2r_dac.hpp:29
        I(cpphdl_n1754, Vss) <+ 2.9999999999999998e-15 * ddt(V(cpphdl_n1754, Vss)); // Bench initial voltage = 0.0 V.
        // device 1330, IC IC205, analog/basic/mos_r2r_dac.hpp:31
        I(cpphdl_n1753, cpphdl_n1754) <+ V(cpphdl_n1753, cpphdl_n1754) / 10000.0;
        // device 1331, IC IC212, analog/basic/inverter.hpp:11
        I(cpphdl_n1744, Vdd) <+ cpphdl_channel(V(BIT_N11_6, Vdd), V(cpphdl_n1744, Vdd), 0.080000000000000002, 0.69999999999999996, -1.0);
        // device 1332, IC IC212, analog/basic/inverter.hpp:12
        I(cpphdl_n1744, Vss) <+ cpphdl_channel(V(BIT_N11_6, Vss), V(cpphdl_n1744, Vss), 0.080000000000000002, 0.69999999999999996, 1.0);
        // device 1333, IC IC205, analog/basic/mos_r2r_dac.hpp:27
        I(cpphdl_n1744, Vss) <+ 2.9999999999999998e-15 * ddt(V(cpphdl_n1744, Vss)); // Bench initial voltage = 0.0 V.
        // device 1334, IC IC205, analog/basic/mos_r2r_dac.hpp:28
        I(cpphdl_n1744, cpphdl_n1755) <+ V(cpphdl_n1744, cpphdl_n1755) / 20000.0;
        // device 1335, IC IC205, analog/basic/mos_r2r_dac.hpp:29
        I(cpphdl_n1755, Vss) <+ 2.9999999999999998e-15 * ddt(V(cpphdl_n1755, Vss)); // Bench initial voltage = 0.0 V.
        // device 1336, IC IC205, analog/basic/mos_r2r_dac.hpp:31
        I(cpphdl_n1754, cpphdl_n1755) <+ V(cpphdl_n1754, cpphdl_n1755) / 10000.0;
        // device 1337, IC IC213, analog/basic/inverter.hpp:11
        I(cpphdl_n1748, Vdd) <+ cpphdl_channel(V(BIT_N11_7, Vdd), V(cpphdl_n1748, Vdd), 0.080000000000000002, 0.69999999999999996, -1.0);
        // device 1338, IC IC213, analog/basic/inverter.hpp:12
        I(cpphdl_n1748, Vss) <+ cpphdl_channel(V(BIT_N11_7, Vss), V(cpphdl_n1748, Vss), 0.080000000000000002, 0.69999999999999996, 1.0);
        // device 1339, IC IC205, analog/basic/mos_r2r_dac.hpp:27
        I(cpphdl_n1748, Vss) <+ 2.9999999999999998e-15 * ddt(V(cpphdl_n1748, Vss)); // Bench initial voltage = 0.0 V.
        // device 1340, IC IC205, analog/basic/mos_r2r_dac.hpp:28
        I(cpphdl_n1748, cpphdl_n1760) <+ V(cpphdl_n1748, cpphdl_n1760) / 20000.0;
        // device 1341, IC IC205, analog/basic/mos_r2r_dac.hpp:29
        I(cpphdl_n1760, Vss) <+ 2.9999999999999998e-15 * ddt(V(cpphdl_n1760, Vss)); // Bench initial voltage = 0.0 V.
        // device 1342, IC IC205, analog/basic/mos_r2r_dac.hpp:31
        I(cpphdl_n1755, cpphdl_n1760) <+ V(cpphdl_n1755, cpphdl_n1760) / 10000.0;
        // device 1343, IC IC205, analog/basic/mos_r2r_dac.hpp:33
        I(Vss, cpphdl_n1749) <+ V(Vss, cpphdl_n1749) / 20000.0;
        // device 1344, IC IC214, analog/basic/nmos_resistor_amplifier.hpp:23
        I(Vdd, cpphdl_n1769) <+ V(Vdd, cpphdl_n1769) / 1000.0;
        // device 1345, IC IC214, analog/basic/nmos_resistor_amplifier.hpp:24
        I(Vdd, cpphdl_n1768) <+ V(Vdd, cpphdl_n1768) / 1000.0;
        // device 1346, IC IC214, analog/basic/nmos_resistor_amplifier.hpp:25
        I(cpphdl_n1769, cpphdl_n1763) <+ cpphdl_channel(V(cpphdl_n1759, cpphdl_n1763), V(cpphdl_n1769, cpphdl_n1763), 0.014999999999999999, 0.69999999999999996, 1.0);
        // device 1347, IC IC214, analog/basic/nmos_resistor_amplifier.hpp:26
        I(cpphdl_n1768, cpphdl_n1764) <+ cpphdl_channel(V(cpphdl_n1760, cpphdl_n1764), V(cpphdl_n1768, cpphdl_n1764), 0.014999999999999999, 0.69999999999999996, 1.0);
        // device 1348, IC IC214, analog/basic/nmos_resistor_amplifier.hpp:27
        I(cpphdl_n1765, cpphdl_n1763) <+ V(cpphdl_n1765, cpphdl_n1763) / 50.0;
        // device 1349, IC IC214, analog/basic/nmos_resistor_amplifier.hpp:28
        I(cpphdl_n1765, cpphdl_n1764) <+ V(cpphdl_n1765, cpphdl_n1764) / 50.0;
        // device 1350, IC IC214, analog/basic/nmos_resistor_amplifier.hpp:29
        I(Vss, cpphdl_n1765) <+ V(Vss, cpphdl_n1765) / 150.0;
        // device 1351, IC IC214, analog/basic/nmos_resistor_amplifier.hpp:30
        I(cpphdl_n1769, Vdd) <+ 2.9999999999999998e-13 * ddt(V(cpphdl_n1769, Vdd)); // Bench initial voltage = 0.0 V.
        // device 1352, IC IC214, analog/basic/nmos_resistor_amplifier.hpp:31
        I(cpphdl_n1768, Vdd) <+ 2.9999999999999998e-13 * ddt(V(cpphdl_n1768, Vdd)); // Bench initial voltage = 0.0 V.
        // device 1353, IC IC214, analog/basic/nmos_resistor_amplifier.hpp:32
        I(cpphdl_n1765, Vss) <+ 4e-14 * ddt(V(cpphdl_n1765, Vss)); // Bench initial voltage = 0.0 V.
        // device 1354, IC IC214, analog/basic/nmos_resistor_amplifier.hpp:34
        I(cpphdl_n1759, cpphdl_n1763) <+ 2e-14 * ddt(V(cpphdl_n1759, cpphdl_n1763)); // Bench initial voltage = 1.6499999999999999 V.
        // device 1355, IC IC214, analog/basic/nmos_resistor_amplifier.hpp:35
        I(cpphdl_n1760, cpphdl_n1764) <+ 2e-14 * ddt(V(cpphdl_n1760, cpphdl_n1764)); // Bench initial voltage = 0.0 V.
        // device 1356, IC IC214, analog/basic/nmos_resistor_amplifier.hpp:36
        I(cpphdl_n1759, cpphdl_n1769) <+ 2.9999999999999998e-15 * ddt(V(cpphdl_n1759, cpphdl_n1769)); // Bench initial voltage = -1.6499999999999999 V.
        // device 1357, IC IC214, analog/basic/nmos_resistor_amplifier.hpp:37
        I(cpphdl_n1760, cpphdl_n1768) <+ 2.9999999999999998e-15 * ddt(V(cpphdl_n1760, cpphdl_n1768)); // Bench initial voltage = -3.2999999999999998 V.
        // device 1358, IC IC215, analog/basic/strongarm_comparator.hpp:28
        I(cpphdl_n1773, cpphdl_n1775) <+ cpphdl_channel(V(cpphdl_n1768, cpphdl_n1775), V(cpphdl_n1773, cpphdl_n1775), 0.0080000000000000002, 0.69999999999999996, 1.0);
        // device 1359, IC IC215, analog/basic/strongarm_comparator.hpp:29
        I(cpphdl_n1774, cpphdl_n1775) <+ cpphdl_channel(V(cpphdl_n1769, cpphdl_n1775), V(cpphdl_n1774, cpphdl_n1775), 0.0080000000000000002, 0.69999999999999996, 1.0);
        // device 1360, IC IC215, analog/basic/strongarm_comparator.hpp:30
        I(cpphdl_n1775, Vss) <+ cpphdl_channel(V(EVALUATE, Vss), V(cpphdl_n1775, Vss), 0.0080000000000000002, 0.69999999999999996, 1.0);
        // device 1361, IC IC215, analog/basic/strongarm_comparator.hpp:33
        I(cpphdl_n1787, cpphdl_n1773) <+ cpphdl_channel(V(cpphdl_n1793, cpphdl_n1773), V(cpphdl_n1787, cpphdl_n1773), 0.0040000000000000001, 0.69999999999999996, 1.0);
        // device 1362, IC IC215, analog/basic/strongarm_comparator.hpp:34
        I(cpphdl_n1793, cpphdl_n1774) <+ cpphdl_channel(V(cpphdl_n1787, cpphdl_n1774), V(cpphdl_n1793, cpphdl_n1774), 0.0040000000000000001, 0.69999999999999996, 1.0);
        // device 1363, IC IC215, analog/basic/strongarm_comparator.hpp:35
        I(cpphdl_n1793, Vdd) <+ cpphdl_channel(V(cpphdl_n1787, Vdd), V(cpphdl_n1793, Vdd), 0.002, 0.69999999999999996, -1.0);
        // device 1364, IC IC215, analog/basic/strongarm_comparator.hpp:36
        I(cpphdl_n1787, Vdd) <+ cpphdl_channel(V(cpphdl_n1793, Vdd), V(cpphdl_n1787, Vdd), 0.002, 0.69999999999999996, -1.0);
        // device 1365, IC IC215, analog/basic/strongarm_comparator.hpp:38
        I(cpphdl_n1773, Vdd) <+ cpphdl_channel(V(EVALUATE, Vdd), V(cpphdl_n1773, Vdd), 0.002, 0.69999999999999996, -1.0);
        // device 1366, IC IC215, analog/basic/strongarm_comparator.hpp:39
        I(cpphdl_n1774, Vdd) <+ cpphdl_channel(V(EVALUATE, Vdd), V(cpphdl_n1774, Vdd), 0.002, 0.69999999999999996, -1.0);
        // device 1367, IC IC215, analog/basic/strongarm_comparator.hpp:40
        I(cpphdl_n1793, Vdd) <+ cpphdl_channel(V(EVALUATE, Vdd), V(cpphdl_n1793, Vdd), 0.002, 0.69999999999999996, -1.0);
        // device 1368, IC IC215, analog/basic/strongarm_comparator.hpp:41
        I(cpphdl_n1787, Vdd) <+ cpphdl_channel(V(EVALUATE, Vdd), V(cpphdl_n1787, Vdd), 0.002, 0.69999999999999996, -1.0);
        // device 1369, IC IC215, analog/basic/strongarm_comparator.hpp:42
        I(cpphdl_n1773, Vss) <+ 2.9999999999999998e-14 * ddt(V(cpphdl_n1773, Vss)); // Bench initial voltage = 0.0 V.
        // device 1370, IC IC215, analog/basic/strongarm_comparator.hpp:43
        I(cpphdl_n1774, Vss) <+ 2.9999999999999998e-14 * ddt(V(cpphdl_n1774, Vss)); // Bench initial voltage = 0.0 V.
        // device 1371, IC IC215, analog/basic/strongarm_comparator.hpp:44
        I(cpphdl_n1775, Vss) <+ 2.9999999999999998e-14 * ddt(V(cpphdl_n1775, Vss)); // Bench initial voltage = 0.0 V.
        // device 1372, IC IC215, analog/basic/strongarm_comparator.hpp:45
        I(cpphdl_n1793, Vss) <+ 5.0000000000000002e-14 * ddt(V(cpphdl_n1793, Vss)); // Bench initial voltage = 0.0 V.
        // device 1373, IC IC215, analog/basic/strongarm_comparator.hpp:46
        I(cpphdl_n1787, Vss) <+ 5.0000000000000002e-14 * ddt(V(cpphdl_n1787, Vss)); // Bench initial voltage = 0.0 V.
        // device 1374, IC IC215, analog/basic/strongarm_comparator.hpp:47
        I(cpphdl_n1768, cpphdl_n1775) <+ 2e-14 * ddt(V(cpphdl_n1768, cpphdl_n1775)); // Bench initial voltage = 3.2999999999999998 V.
        // device 1375, IC IC215, analog/basic/strongarm_comparator.hpp:48
        I(cpphdl_n1769, cpphdl_n1775) <+ 2e-14 * ddt(V(cpphdl_n1769, cpphdl_n1775)); // Bench initial voltage = 3.2999999999999998 V.
        // device 1376, IC IC215, analog/basic/strongarm_comparator.hpp:49
        I(cpphdl_n1768, cpphdl_n1773) <+ 2.9999999999999998e-15 * ddt(V(cpphdl_n1768, cpphdl_n1773)); // Bench initial voltage = 3.2999999999999998 V.
        // device 1377, IC IC215, analog/basic/strongarm_comparator.hpp:50
        I(cpphdl_n1769, cpphdl_n1774) <+ 2.9999999999999998e-15 * ddt(V(cpphdl_n1769, cpphdl_n1774)); // Bench initial voltage = 3.2999999999999998 V.
        // device 1378, IC IC217, analog/basic/cmos_logic.hpp:15
        I(cpphdl_n2356, Vss) <+ 5.0000000000000002e-14 * ddt(V(cpphdl_n2356, Vss)); // Bench initial voltage = 0.0 V.
        // device 1379, IC IC217, analog/basic/cmos_logic.hpp:16
        I(cpphdl_n2356, Vdd) <+ cpphdl_channel(V(cpphdl_n1787, Vdd), V(cpphdl_n2356, Vdd), 0.01, 0.69999999999999996, -1.0);
        // device 1380, IC IC217, analog/basic/cmos_logic.hpp:17
        I(cpphdl_n2356, Vdd) <+ cpphdl_channel(V(cpphdl_n1795, Vdd), V(cpphdl_n2356, Vdd), 0.01, 0.69999999999999996, -1.0);
        // device 1381, IC IC217, analog/basic/cmos_logic.hpp:18
        I(cpphdl_n2356, cpphdl_n1790) <+ cpphdl_channel(V(cpphdl_n1787, cpphdl_n1790), V(cpphdl_n2356, cpphdl_n1790), 0.01, 0.69999999999999996, 1.0);
        // device 1382, IC IC217, analog/basic/cmos_logic.hpp:19
        I(cpphdl_n1790, Vss) <+ cpphdl_channel(V(cpphdl_n1795, Vss), V(cpphdl_n1790, Vss), 0.01, 0.69999999999999996, 1.0);
        // device 1383, IC IC217, analog/basic/cmos_logic.hpp:20
        I(cpphdl_n2356, Vss) <+ V(cpphdl_n2356, Vss) / 1000000000.0;
        // device 1384, IC IC217, analog/basic/cmos_logic.hpp:21
        I(cpphdl_n1790, Vss) <+ V(cpphdl_n1790, Vss) / 1000000000.0;
        // device 1385, IC IC218, analog/basic/cmos_logic.hpp:15
        I(cpphdl_n1795, Vss) <+ 5.0000000000000002e-14 * ddt(V(cpphdl_n1795, Vss)); // Bench initial voltage = 0.0 V.
        // device 1386, IC IC218, analog/basic/cmos_logic.hpp:16
        I(cpphdl_n1795, Vdd) <+ cpphdl_channel(V(cpphdl_n1793, Vdd), V(cpphdl_n1795, Vdd), 0.01, 0.69999999999999996, -1.0);
        // device 1387, IC IC218, analog/basic/cmos_logic.hpp:17
        I(cpphdl_n1795, Vdd) <+ cpphdl_channel(V(cpphdl_n2356, Vdd), V(cpphdl_n1795, Vdd), 0.01, 0.69999999999999996, -1.0);
        // device 1388, IC IC218, analog/basic/cmos_logic.hpp:18
        I(cpphdl_n1795, cpphdl_n1796) <+ cpphdl_channel(V(cpphdl_n1793, cpphdl_n1796), V(cpphdl_n1795, cpphdl_n1796), 0.01, 0.69999999999999996, 1.0);
        // device 1389, IC IC218, analog/basic/cmos_logic.hpp:19
        I(cpphdl_n1796, Vss) <+ cpphdl_channel(V(cpphdl_n2356, Vss), V(cpphdl_n1796, Vss), 0.01, 0.69999999999999996, 1.0);
        // device 1390, IC IC218, analog/basic/cmos_logic.hpp:20
        I(cpphdl_n1795, Vss) <+ V(cpphdl_n1795, Vss) / 1000000000.0;
        // device 1391, IC IC218, analog/basic/cmos_logic.hpp:21
        I(cpphdl_n1796, Vss) <+ V(cpphdl_n1796, Vss) / 1000000000.0;
        // device 1392, IC IC216, analog/basic/nand_latch.hpp:34
        I(cpphdl_n1787, Vss) <+ 2.9999999999999998e-15 * ddt(V(cpphdl_n1787, Vss)); // Bench initial voltage = 0.0 V.
        // device 1393, IC IC216, analog/basic/nand_latch.hpp:35
        I(cpphdl_n1793, Vss) <+ 2.9999999999999998e-15 * ddt(V(cpphdl_n1793, Vss)); // Bench initial voltage = 0.0 V.
        // device 1394, IC IC219, analog/basic/inverter.hpp:11
        I(cpphdl_n1801, Vdd) <+ cpphdl_channel(V(CLEAR, Vdd), V(cpphdl_n1801, Vdd), 0.01, 0.69999999999999996, -1.0);
        // device 1395, IC IC219, analog/basic/inverter.hpp:12
        I(cpphdl_n1801, Vss) <+ cpphdl_channel(V(CLEAR, Vss), V(cpphdl_n1801, Vss), 0.01, 0.69999999999999996, 1.0);
        // device 1396, IC IC216, analog/basic/nand_latch.hpp:56
        I(cpphdl_n1801, Vss) <+ 2.9999999999999998e-15 * ddt(V(cpphdl_n1801, Vss)); // Bench initial voltage = 0.0 V.
        // device 1397, IC IC216, analog/basic/nand_latch.hpp:57
        I(cpphdl_n2356, Vss) <+ cpphdl_channel(V(CLEAR, Vss), V(cpphdl_n2356, Vss), 0.050000000000000003, 0.69999999999999996, 1.0);
        // device 1398, IC IC216, analog/basic/nand_latch.hpp:58
        I(cpphdl_n1795, Vdd) <+ cpphdl_channel(V(cpphdl_n1801, Vdd), V(cpphdl_n1795, Vdd), 0.050000000000000003, 0.69999999999999996, -1.0);
        // device 1399, IC IC222, analog/basic/inverter.hpp:11
        I(cpphdl_n1825, Vdd) <+ cpphdl_channel(V(TRACK12, Vdd), V(cpphdl_n1825, Vdd), 0.0040000000000000001, 0.69999999999999996, -1.0);
        // device 1400, IC IC222, analog/basic/inverter.hpp:12
        I(cpphdl_n1825, Vss) <+ cpphdl_channel(V(TRACK12, Vss), V(cpphdl_n1825, Vss), 0.0040000000000000001, 0.69999999999999996, 1.0);
        // device 1401, IC IC221, analog/basic/mos_track_hold.hpp:30
        I(cpphdl_n1825, Vss) <+ 2e-14 * ddt(V(cpphdl_n1825, Vss)); // Bench initial voltage = 3.2999999999999998 V.
        // device 1402, IC IC221, analog/basic/mos_track_hold.hpp:31
        I(cpphdl_n2179, cpphdl_n1879) <+ cpphdl_channel(V(TRACK12, cpphdl_n1879), V(cpphdl_n2179, cpphdl_n1879), 0.080000000000000002, 0.69999999999999996, 1.0);
        // device 1403, IC IC221, analog/basic/mos_track_hold.hpp:32
        I(cpphdl_n1879, cpphdl_n2179) <+ cpphdl_channel(V(cpphdl_n1825, cpphdl_n2179), V(cpphdl_n1879, cpphdl_n2179), 0.040000000000000001, 0.69999999999999996, -1.0);
        // device 1404, IC IC221, analog/basic/mos_track_hold.hpp:36
        I(cpphdl_n1879, cpphdl_n1879) <+ cpphdl_channel(V(cpphdl_n1825, cpphdl_n1879), V(cpphdl_n1879, cpphdl_n1879), 0.040000000000000001, 0.69999999999999996, 1.0);
        // device 1405, IC IC221, analog/basic/mos_track_hold.hpp:37
        I(cpphdl_n1879, cpphdl_n1879) <+ cpphdl_channel(V(TRACK12, cpphdl_n1879), V(cpphdl_n1879, cpphdl_n1879), 0.02, 0.69999999999999996, -1.0);
        // device 1406, IC IC221, analog/basic/mos_track_hold.hpp:38
        I(cpphdl_n1879, Vss) <+ 2e-12 * ddt(V(cpphdl_n1879, Vss)); // Bench initial voltage = 1.6499999999999999 V.
        // device 1407, IC IC221, analog/basic/mos_track_hold.hpp:39
        I(Vss, cpphdl_n1879) <+ V(Vss, cpphdl_n1879) / 1000000000.0;
        // device 1408, IC IC221, analog/basic/mos_track_hold.hpp:40
        I(TRACK12, cpphdl_n1879) <+ 8.0000000000000006e-15 * ddt(V(TRACK12, cpphdl_n1879)); // Bench initial voltage = -1.6499999999999999 V.
        // device 1409, IC IC221, analog/basic/mos_track_hold.hpp:41
        I(cpphdl_n1825, cpphdl_n1879) <+ 8.0000000000000006e-15 * ddt(V(cpphdl_n1825, cpphdl_n1879)); // Bench initial voltage = 1.6499999999999999 V.
        // device 1410, IC IC221, analog/basic/mos_track_hold.hpp:42
        I(cpphdl_n2179, cpphdl_n1879) <+ 4.0000000000000003e-15 * ddt(V(cpphdl_n2179, cpphdl_n1879)); // Bench initial voltage = 0.0 V.
        // device 1411, IC IC224, analog/basic/inverter.hpp:11
        I(cpphdl_n1840, Vdd) <+ cpphdl_channel(V(BIT_N12_0, Vdd), V(cpphdl_n1840, Vdd), 0.080000000000000002, 0.69999999999999996, -1.0);
        // device 1412, IC IC224, analog/basic/inverter.hpp:12
        I(cpphdl_n1840, Vss) <+ cpphdl_channel(V(BIT_N12_0, Vss), V(cpphdl_n1840, Vss), 0.080000000000000002, 0.69999999999999996, 1.0);
        // device 1413, IC IC223, analog/basic/mos_r2r_dac.hpp:27
        I(cpphdl_n1840, Vss) <+ 2.9999999999999998e-15 * ddt(V(cpphdl_n1840, Vss)); // Bench initial voltage = 0.0 V.
        // device 1414, IC IC223, analog/basic/mos_r2r_dac.hpp:28
        I(cpphdl_n1840, cpphdl_n1869) <+ V(cpphdl_n1840, cpphdl_n1869) / 20000.0;
        // device 1415, IC IC223, analog/basic/mos_r2r_dac.hpp:29
        I(cpphdl_n1869, Vss) <+ 2.9999999999999998e-15 * ddt(V(cpphdl_n1869, Vss)); // Bench initial voltage = 0.0 V.
        // device 1416, IC IC225, analog/basic/inverter.hpp:11
        I(cpphdl_n1844, Vdd) <+ cpphdl_channel(V(BIT_N12_1, Vdd), V(cpphdl_n1844, Vdd), 0.080000000000000002, 0.69999999999999996, -1.0);
        // device 1417, IC IC225, analog/basic/inverter.hpp:12
        I(cpphdl_n1844, Vss) <+ cpphdl_channel(V(BIT_N12_1, Vss), V(cpphdl_n1844, Vss), 0.080000000000000002, 0.69999999999999996, 1.0);
        // device 1418, IC IC223, analog/basic/mos_r2r_dac.hpp:27
        I(cpphdl_n1844, Vss) <+ 2.9999999999999998e-15 * ddt(V(cpphdl_n1844, Vss)); // Bench initial voltage = 0.0 V.
        // device 1419, IC IC223, analog/basic/mos_r2r_dac.hpp:28
        I(cpphdl_n1844, cpphdl_n1870) <+ V(cpphdl_n1844, cpphdl_n1870) / 20000.0;
        // device 1420, IC IC223, analog/basic/mos_r2r_dac.hpp:29
        I(cpphdl_n1870, Vss) <+ 2.9999999999999998e-15 * ddt(V(cpphdl_n1870, Vss)); // Bench initial voltage = 0.0 V.
        // device 1421, IC IC223, analog/basic/mos_r2r_dac.hpp:31
        I(cpphdl_n1869, cpphdl_n1870) <+ V(cpphdl_n1869, cpphdl_n1870) / 10000.0;
        // device 1422, IC IC226, analog/basic/inverter.hpp:11
        I(cpphdl_n1848, Vdd) <+ cpphdl_channel(V(BIT_N12_2, Vdd), V(cpphdl_n1848, Vdd), 0.080000000000000002, 0.69999999999999996, -1.0);
        // device 1423, IC IC226, analog/basic/inverter.hpp:12
        I(cpphdl_n1848, Vss) <+ cpphdl_channel(V(BIT_N12_2, Vss), V(cpphdl_n1848, Vss), 0.080000000000000002, 0.69999999999999996, 1.0);
        // device 1424, IC IC223, analog/basic/mos_r2r_dac.hpp:27
        I(cpphdl_n1848, Vss) <+ 2.9999999999999998e-15 * ddt(V(cpphdl_n1848, Vss)); // Bench initial voltage = 0.0 V.
        // device 1425, IC IC223, analog/basic/mos_r2r_dac.hpp:28
        I(cpphdl_n1848, cpphdl_n1871) <+ V(cpphdl_n1848, cpphdl_n1871) / 20000.0;
        // device 1426, IC IC223, analog/basic/mos_r2r_dac.hpp:29
        I(cpphdl_n1871, Vss) <+ 2.9999999999999998e-15 * ddt(V(cpphdl_n1871, Vss)); // Bench initial voltage = 0.0 V.
        // device 1427, IC IC223, analog/basic/mos_r2r_dac.hpp:31
        I(cpphdl_n1870, cpphdl_n1871) <+ V(cpphdl_n1870, cpphdl_n1871) / 10000.0;
        // device 1428, IC IC227, analog/basic/inverter.hpp:11
        I(cpphdl_n1852, Vdd) <+ cpphdl_channel(V(BIT_N12_3, Vdd), V(cpphdl_n1852, Vdd), 0.080000000000000002, 0.69999999999999996, -1.0);
        // device 1429, IC IC227, analog/basic/inverter.hpp:12
        I(cpphdl_n1852, Vss) <+ cpphdl_channel(V(BIT_N12_3, Vss), V(cpphdl_n1852, Vss), 0.080000000000000002, 0.69999999999999996, 1.0);
        // device 1430, IC IC223, analog/basic/mos_r2r_dac.hpp:27
        I(cpphdl_n1852, Vss) <+ 2.9999999999999998e-15 * ddt(V(cpphdl_n1852, Vss)); // Bench initial voltage = 0.0 V.
        // device 1431, IC IC223, analog/basic/mos_r2r_dac.hpp:28
        I(cpphdl_n1852, cpphdl_n1872) <+ V(cpphdl_n1852, cpphdl_n1872) / 20000.0;
        // device 1432, IC IC223, analog/basic/mos_r2r_dac.hpp:29
        I(cpphdl_n1872, Vss) <+ 2.9999999999999998e-15 * ddt(V(cpphdl_n1872, Vss)); // Bench initial voltage = 0.0 V.
        // device 1433, IC IC223, analog/basic/mos_r2r_dac.hpp:31
        I(cpphdl_n1871, cpphdl_n1872) <+ V(cpphdl_n1871, cpphdl_n1872) / 10000.0;
        // device 1434, IC IC228, analog/basic/inverter.hpp:11
        I(cpphdl_n1856, Vdd) <+ cpphdl_channel(V(BIT_N12_4, Vdd), V(cpphdl_n1856, Vdd), 0.080000000000000002, 0.69999999999999996, -1.0);
        // device 1435, IC IC228, analog/basic/inverter.hpp:12
        I(cpphdl_n1856, Vss) <+ cpphdl_channel(V(BIT_N12_4, Vss), V(cpphdl_n1856, Vss), 0.080000000000000002, 0.69999999999999996, 1.0);
        // device 1436, IC IC223, analog/basic/mos_r2r_dac.hpp:27
        I(cpphdl_n1856, Vss) <+ 2.9999999999999998e-15 * ddt(V(cpphdl_n1856, Vss)); // Bench initial voltage = 0.0 V.
        // device 1437, IC IC223, analog/basic/mos_r2r_dac.hpp:28
        I(cpphdl_n1856, cpphdl_n1873) <+ V(cpphdl_n1856, cpphdl_n1873) / 20000.0;
        // device 1438, IC IC223, analog/basic/mos_r2r_dac.hpp:29
        I(cpphdl_n1873, Vss) <+ 2.9999999999999998e-15 * ddt(V(cpphdl_n1873, Vss)); // Bench initial voltage = 0.0 V.
        // device 1439, IC IC223, analog/basic/mos_r2r_dac.hpp:31
        I(cpphdl_n1872, cpphdl_n1873) <+ V(cpphdl_n1872, cpphdl_n1873) / 10000.0;
        // device 1440, IC IC229, analog/basic/inverter.hpp:11
        I(cpphdl_n1860, Vdd) <+ cpphdl_channel(V(BIT_N12_5, Vdd), V(cpphdl_n1860, Vdd), 0.080000000000000002, 0.69999999999999996, -1.0);
        // device 1441, IC IC229, analog/basic/inverter.hpp:12
        I(cpphdl_n1860, Vss) <+ cpphdl_channel(V(BIT_N12_5, Vss), V(cpphdl_n1860, Vss), 0.080000000000000002, 0.69999999999999996, 1.0);
        // device 1442, IC IC223, analog/basic/mos_r2r_dac.hpp:27
        I(cpphdl_n1860, Vss) <+ 2.9999999999999998e-15 * ddt(V(cpphdl_n1860, Vss)); // Bench initial voltage = 0.0 V.
        // device 1443, IC IC223, analog/basic/mos_r2r_dac.hpp:28
        I(cpphdl_n1860, cpphdl_n1874) <+ V(cpphdl_n1860, cpphdl_n1874) / 20000.0;
        // device 1444, IC IC223, analog/basic/mos_r2r_dac.hpp:29
        I(cpphdl_n1874, Vss) <+ 2.9999999999999998e-15 * ddt(V(cpphdl_n1874, Vss)); // Bench initial voltage = 0.0 V.
        // device 1445, IC IC223, analog/basic/mos_r2r_dac.hpp:31
        I(cpphdl_n1873, cpphdl_n1874) <+ V(cpphdl_n1873, cpphdl_n1874) / 10000.0;
        // device 1446, IC IC230, analog/basic/inverter.hpp:11
        I(cpphdl_n1864, Vdd) <+ cpphdl_channel(V(BIT_N12_6, Vdd), V(cpphdl_n1864, Vdd), 0.080000000000000002, 0.69999999999999996, -1.0);
        // device 1447, IC IC230, analog/basic/inverter.hpp:12
        I(cpphdl_n1864, Vss) <+ cpphdl_channel(V(BIT_N12_6, Vss), V(cpphdl_n1864, Vss), 0.080000000000000002, 0.69999999999999996, 1.0);
        // device 1448, IC IC223, analog/basic/mos_r2r_dac.hpp:27
        I(cpphdl_n1864, Vss) <+ 2.9999999999999998e-15 * ddt(V(cpphdl_n1864, Vss)); // Bench initial voltage = 0.0 V.
        // device 1449, IC IC223, analog/basic/mos_r2r_dac.hpp:28
        I(cpphdl_n1864, cpphdl_n1875) <+ V(cpphdl_n1864, cpphdl_n1875) / 20000.0;
        // device 1450, IC IC223, analog/basic/mos_r2r_dac.hpp:29
        I(cpphdl_n1875, Vss) <+ 2.9999999999999998e-15 * ddt(V(cpphdl_n1875, Vss)); // Bench initial voltage = 0.0 V.
        // device 1451, IC IC223, analog/basic/mos_r2r_dac.hpp:31
        I(cpphdl_n1874, cpphdl_n1875) <+ V(cpphdl_n1874, cpphdl_n1875) / 10000.0;
        // device 1452, IC IC231, analog/basic/inverter.hpp:11
        I(cpphdl_n1868, Vdd) <+ cpphdl_channel(V(BIT_N12_7, Vdd), V(cpphdl_n1868, Vdd), 0.080000000000000002, 0.69999999999999996, -1.0);
        // device 1453, IC IC231, analog/basic/inverter.hpp:12
        I(cpphdl_n1868, Vss) <+ cpphdl_channel(V(BIT_N12_7, Vss), V(cpphdl_n1868, Vss), 0.080000000000000002, 0.69999999999999996, 1.0);
        // device 1454, IC IC223, analog/basic/mos_r2r_dac.hpp:27
        I(cpphdl_n1868, Vss) <+ 2.9999999999999998e-15 * ddt(V(cpphdl_n1868, Vss)); // Bench initial voltage = 0.0 V.
        // device 1455, IC IC223, analog/basic/mos_r2r_dac.hpp:28
        I(cpphdl_n1868, cpphdl_n1880) <+ V(cpphdl_n1868, cpphdl_n1880) / 20000.0;
        // device 1456, IC IC223, analog/basic/mos_r2r_dac.hpp:29
        I(cpphdl_n1880, Vss) <+ 2.9999999999999998e-15 * ddt(V(cpphdl_n1880, Vss)); // Bench initial voltage = 0.0 V.
        // device 1457, IC IC223, analog/basic/mos_r2r_dac.hpp:31
        I(cpphdl_n1875, cpphdl_n1880) <+ V(cpphdl_n1875, cpphdl_n1880) / 10000.0;
        // device 1458, IC IC223, analog/basic/mos_r2r_dac.hpp:33
        I(Vss, cpphdl_n1869) <+ V(Vss, cpphdl_n1869) / 20000.0;
        // device 1459, IC IC232, analog/basic/nmos_resistor_amplifier.hpp:23
        I(Vdd, cpphdl_n1889) <+ V(Vdd, cpphdl_n1889) / 1000.0;
        // device 1460, IC IC232, analog/basic/nmos_resistor_amplifier.hpp:24
        I(Vdd, cpphdl_n1888) <+ V(Vdd, cpphdl_n1888) / 1000.0;
        // device 1461, IC IC232, analog/basic/nmos_resistor_amplifier.hpp:25
        I(cpphdl_n1889, cpphdl_n1883) <+ cpphdl_channel(V(cpphdl_n1879, cpphdl_n1883), V(cpphdl_n1889, cpphdl_n1883), 0.014999999999999999, 0.69999999999999996, 1.0);
        // device 1462, IC IC232, analog/basic/nmos_resistor_amplifier.hpp:26
        I(cpphdl_n1888, cpphdl_n1884) <+ cpphdl_channel(V(cpphdl_n1880, cpphdl_n1884), V(cpphdl_n1888, cpphdl_n1884), 0.014999999999999999, 0.69999999999999996, 1.0);
        // device 1463, IC IC232, analog/basic/nmos_resistor_amplifier.hpp:27
        I(cpphdl_n1885, cpphdl_n1883) <+ V(cpphdl_n1885, cpphdl_n1883) / 50.0;
        // device 1464, IC IC232, analog/basic/nmos_resistor_amplifier.hpp:28
        I(cpphdl_n1885, cpphdl_n1884) <+ V(cpphdl_n1885, cpphdl_n1884) / 50.0;
        // device 1465, IC IC232, analog/basic/nmos_resistor_amplifier.hpp:29
        I(Vss, cpphdl_n1885) <+ V(Vss, cpphdl_n1885) / 150.0;
        // device 1466, IC IC232, analog/basic/nmos_resistor_amplifier.hpp:30
        I(cpphdl_n1889, Vdd) <+ 2.9999999999999998e-13 * ddt(V(cpphdl_n1889, Vdd)); // Bench initial voltage = 0.0 V.
        // device 1467, IC IC232, analog/basic/nmos_resistor_amplifier.hpp:31
        I(cpphdl_n1888, Vdd) <+ 2.9999999999999998e-13 * ddt(V(cpphdl_n1888, Vdd)); // Bench initial voltage = 0.0 V.
        // device 1468, IC IC232, analog/basic/nmos_resistor_amplifier.hpp:32
        I(cpphdl_n1885, Vss) <+ 4e-14 * ddt(V(cpphdl_n1885, Vss)); // Bench initial voltage = 0.0 V.
        // device 1469, IC IC232, analog/basic/nmos_resistor_amplifier.hpp:34
        I(cpphdl_n1879, cpphdl_n1883) <+ 2e-14 * ddt(V(cpphdl_n1879, cpphdl_n1883)); // Bench initial voltage = 1.6499999999999999 V.
        // device 1470, IC IC232, analog/basic/nmos_resistor_amplifier.hpp:35
        I(cpphdl_n1880, cpphdl_n1884) <+ 2e-14 * ddt(V(cpphdl_n1880, cpphdl_n1884)); // Bench initial voltage = 0.0 V.
        // device 1471, IC IC232, analog/basic/nmos_resistor_amplifier.hpp:36
        I(cpphdl_n1879, cpphdl_n1889) <+ 2.9999999999999998e-15 * ddt(V(cpphdl_n1879, cpphdl_n1889)); // Bench initial voltage = -1.6499999999999999 V.
        // device 1472, IC IC232, analog/basic/nmos_resistor_amplifier.hpp:37
        I(cpphdl_n1880, cpphdl_n1888) <+ 2.9999999999999998e-15 * ddt(V(cpphdl_n1880, cpphdl_n1888)); // Bench initial voltage = -3.2999999999999998 V.
        // device 1473, IC IC233, analog/basic/strongarm_comparator.hpp:28
        I(cpphdl_n1893, cpphdl_n1895) <+ cpphdl_channel(V(cpphdl_n1888, cpphdl_n1895), V(cpphdl_n1893, cpphdl_n1895), 0.0080000000000000002, 0.69999999999999996, 1.0);
        // device 1474, IC IC233, analog/basic/strongarm_comparator.hpp:29
        I(cpphdl_n1894, cpphdl_n1895) <+ cpphdl_channel(V(cpphdl_n1889, cpphdl_n1895), V(cpphdl_n1894, cpphdl_n1895), 0.0080000000000000002, 0.69999999999999996, 1.0);
        // device 1475, IC IC233, analog/basic/strongarm_comparator.hpp:30
        I(cpphdl_n1895, Vss) <+ cpphdl_channel(V(EVALUATE, Vss), V(cpphdl_n1895, Vss), 0.0080000000000000002, 0.69999999999999996, 1.0);
        // device 1476, IC IC233, analog/basic/strongarm_comparator.hpp:33
        I(cpphdl_n1907, cpphdl_n1893) <+ cpphdl_channel(V(cpphdl_n1913, cpphdl_n1893), V(cpphdl_n1907, cpphdl_n1893), 0.0040000000000000001, 0.69999999999999996, 1.0);
        // device 1477, IC IC233, analog/basic/strongarm_comparator.hpp:34
        I(cpphdl_n1913, cpphdl_n1894) <+ cpphdl_channel(V(cpphdl_n1907, cpphdl_n1894), V(cpphdl_n1913, cpphdl_n1894), 0.0040000000000000001, 0.69999999999999996, 1.0);
        // device 1478, IC IC233, analog/basic/strongarm_comparator.hpp:35
        I(cpphdl_n1913, Vdd) <+ cpphdl_channel(V(cpphdl_n1907, Vdd), V(cpphdl_n1913, Vdd), 0.002, 0.69999999999999996, -1.0);
        // device 1479, IC IC233, analog/basic/strongarm_comparator.hpp:36
        I(cpphdl_n1907, Vdd) <+ cpphdl_channel(V(cpphdl_n1913, Vdd), V(cpphdl_n1907, Vdd), 0.002, 0.69999999999999996, -1.0);
        // device 1480, IC IC233, analog/basic/strongarm_comparator.hpp:38
        I(cpphdl_n1893, Vdd) <+ cpphdl_channel(V(EVALUATE, Vdd), V(cpphdl_n1893, Vdd), 0.002, 0.69999999999999996, -1.0);
        // device 1481, IC IC233, analog/basic/strongarm_comparator.hpp:39
        I(cpphdl_n1894, Vdd) <+ cpphdl_channel(V(EVALUATE, Vdd), V(cpphdl_n1894, Vdd), 0.002, 0.69999999999999996, -1.0);
        // device 1482, IC IC233, analog/basic/strongarm_comparator.hpp:40
        I(cpphdl_n1913, Vdd) <+ cpphdl_channel(V(EVALUATE, Vdd), V(cpphdl_n1913, Vdd), 0.002, 0.69999999999999996, -1.0);
        // device 1483, IC IC233, analog/basic/strongarm_comparator.hpp:41
        I(cpphdl_n1907, Vdd) <+ cpphdl_channel(V(EVALUATE, Vdd), V(cpphdl_n1907, Vdd), 0.002, 0.69999999999999996, -1.0);
        // device 1484, IC IC233, analog/basic/strongarm_comparator.hpp:42
        I(cpphdl_n1893, Vss) <+ 2.9999999999999998e-14 * ddt(V(cpphdl_n1893, Vss)); // Bench initial voltage = 0.0 V.
        // device 1485, IC IC233, analog/basic/strongarm_comparator.hpp:43
        I(cpphdl_n1894, Vss) <+ 2.9999999999999998e-14 * ddt(V(cpphdl_n1894, Vss)); // Bench initial voltage = 0.0 V.
        // device 1486, IC IC233, analog/basic/strongarm_comparator.hpp:44
        I(cpphdl_n1895, Vss) <+ 2.9999999999999998e-14 * ddt(V(cpphdl_n1895, Vss)); // Bench initial voltage = 0.0 V.
        // device 1487, IC IC233, analog/basic/strongarm_comparator.hpp:45
        I(cpphdl_n1913, Vss) <+ 5.0000000000000002e-14 * ddt(V(cpphdl_n1913, Vss)); // Bench initial voltage = 0.0 V.
        // device 1488, IC IC233, analog/basic/strongarm_comparator.hpp:46
        I(cpphdl_n1907, Vss) <+ 5.0000000000000002e-14 * ddt(V(cpphdl_n1907, Vss)); // Bench initial voltage = 0.0 V.
        // device 1489, IC IC233, analog/basic/strongarm_comparator.hpp:47
        I(cpphdl_n1888, cpphdl_n1895) <+ 2e-14 * ddt(V(cpphdl_n1888, cpphdl_n1895)); // Bench initial voltage = 3.2999999999999998 V.
        // device 1490, IC IC233, analog/basic/strongarm_comparator.hpp:48
        I(cpphdl_n1889, cpphdl_n1895) <+ 2e-14 * ddt(V(cpphdl_n1889, cpphdl_n1895)); // Bench initial voltage = 3.2999999999999998 V.
        // device 1491, IC IC233, analog/basic/strongarm_comparator.hpp:49
        I(cpphdl_n1888, cpphdl_n1893) <+ 2.9999999999999998e-15 * ddt(V(cpphdl_n1888, cpphdl_n1893)); // Bench initial voltage = 3.2999999999999998 V.
        // device 1492, IC IC233, analog/basic/strongarm_comparator.hpp:50
        I(cpphdl_n1889, cpphdl_n1894) <+ 2.9999999999999998e-15 * ddt(V(cpphdl_n1889, cpphdl_n1894)); // Bench initial voltage = 3.2999999999999998 V.
        // device 1493, IC IC235, analog/basic/cmos_logic.hpp:15
        I(cpphdl_n2361, Vss) <+ 5.0000000000000002e-14 * ddt(V(cpphdl_n2361, Vss)); // Bench initial voltage = 0.0 V.
        // device 1494, IC IC235, analog/basic/cmos_logic.hpp:16
        I(cpphdl_n2361, Vdd) <+ cpphdl_channel(V(cpphdl_n1907, Vdd), V(cpphdl_n2361, Vdd), 0.01, 0.69999999999999996, -1.0);
        // device 1495, IC IC235, analog/basic/cmos_logic.hpp:17
        I(cpphdl_n2361, Vdd) <+ cpphdl_channel(V(cpphdl_n1915, Vdd), V(cpphdl_n2361, Vdd), 0.01, 0.69999999999999996, -1.0);
        // device 1496, IC IC235, analog/basic/cmos_logic.hpp:18
        I(cpphdl_n2361, cpphdl_n1910) <+ cpphdl_channel(V(cpphdl_n1907, cpphdl_n1910), V(cpphdl_n2361, cpphdl_n1910), 0.01, 0.69999999999999996, 1.0);
        // device 1497, IC IC235, analog/basic/cmos_logic.hpp:19
        I(cpphdl_n1910, Vss) <+ cpphdl_channel(V(cpphdl_n1915, Vss), V(cpphdl_n1910, Vss), 0.01, 0.69999999999999996, 1.0);
        // device 1498, IC IC235, analog/basic/cmos_logic.hpp:20
        I(cpphdl_n2361, Vss) <+ V(cpphdl_n2361, Vss) / 1000000000.0;
        // device 1499, IC IC235, analog/basic/cmos_logic.hpp:21
        I(cpphdl_n1910, Vss) <+ V(cpphdl_n1910, Vss) / 1000000000.0;
        // device 1500, IC IC236, analog/basic/cmos_logic.hpp:15
        I(cpphdl_n1915, Vss) <+ 5.0000000000000002e-14 * ddt(V(cpphdl_n1915, Vss)); // Bench initial voltage = 0.0 V.
        // device 1501, IC IC236, analog/basic/cmos_logic.hpp:16
        I(cpphdl_n1915, Vdd) <+ cpphdl_channel(V(cpphdl_n1913, Vdd), V(cpphdl_n1915, Vdd), 0.01, 0.69999999999999996, -1.0);
        // device 1502, IC IC236, analog/basic/cmos_logic.hpp:17
        I(cpphdl_n1915, Vdd) <+ cpphdl_channel(V(cpphdl_n2361, Vdd), V(cpphdl_n1915, Vdd), 0.01, 0.69999999999999996, -1.0);
        // device 1503, IC IC236, analog/basic/cmos_logic.hpp:18
        I(cpphdl_n1915, cpphdl_n1916) <+ cpphdl_channel(V(cpphdl_n1913, cpphdl_n1916), V(cpphdl_n1915, cpphdl_n1916), 0.01, 0.69999999999999996, 1.0);
        // device 1504, IC IC236, analog/basic/cmos_logic.hpp:19
        I(cpphdl_n1916, Vss) <+ cpphdl_channel(V(cpphdl_n2361, Vss), V(cpphdl_n1916, Vss), 0.01, 0.69999999999999996, 1.0);
        // device 1505, IC IC236, analog/basic/cmos_logic.hpp:20
        I(cpphdl_n1915, Vss) <+ V(cpphdl_n1915, Vss) / 1000000000.0;
        // device 1506, IC IC236, analog/basic/cmos_logic.hpp:21
        I(cpphdl_n1916, Vss) <+ V(cpphdl_n1916, Vss) / 1000000000.0;
        // device 1507, IC IC234, analog/basic/nand_latch.hpp:34
        I(cpphdl_n1907, Vss) <+ 2.9999999999999998e-15 * ddt(V(cpphdl_n1907, Vss)); // Bench initial voltage = 0.0 V.
        // device 1508, IC IC234, analog/basic/nand_latch.hpp:35
        I(cpphdl_n1913, Vss) <+ 2.9999999999999998e-15 * ddt(V(cpphdl_n1913, Vss)); // Bench initial voltage = 0.0 V.
        // device 1509, IC IC237, analog/basic/inverter.hpp:11
        I(cpphdl_n1921, Vdd) <+ cpphdl_channel(V(CLEAR, Vdd), V(cpphdl_n1921, Vdd), 0.01, 0.69999999999999996, -1.0);
        // device 1510, IC IC237, analog/basic/inverter.hpp:12
        I(cpphdl_n1921, Vss) <+ cpphdl_channel(V(CLEAR, Vss), V(cpphdl_n1921, Vss), 0.01, 0.69999999999999996, 1.0);
        // device 1511, IC IC234, analog/basic/nand_latch.hpp:56
        I(cpphdl_n1921, Vss) <+ 2.9999999999999998e-15 * ddt(V(cpphdl_n1921, Vss)); // Bench initial voltage = 0.0 V.
        // device 1512, IC IC234, analog/basic/nand_latch.hpp:57
        I(cpphdl_n2361, Vss) <+ cpphdl_channel(V(CLEAR, Vss), V(cpphdl_n2361, Vss), 0.050000000000000003, 0.69999999999999996, 1.0);
        // device 1513, IC IC234, analog/basic/nand_latch.hpp:58
        I(cpphdl_n1915, Vdd) <+ cpphdl_channel(V(cpphdl_n1921, Vdd), V(cpphdl_n1915, Vdd), 0.050000000000000003, 0.69999999999999996, -1.0);
        // device 1514, IC IC240, analog/basic/inverter.hpp:11
        I(cpphdl_n1945, Vdd) <+ cpphdl_channel(V(TRACK13, Vdd), V(cpphdl_n1945, Vdd), 0.0040000000000000001, 0.69999999999999996, -1.0);
        // device 1515, IC IC240, analog/basic/inverter.hpp:12
        I(cpphdl_n1945, Vss) <+ cpphdl_channel(V(TRACK13, Vss), V(cpphdl_n1945, Vss), 0.0040000000000000001, 0.69999999999999996, 1.0);
        // device 1516, IC IC239, analog/basic/mos_track_hold.hpp:30
        I(cpphdl_n1945, Vss) <+ 2e-14 * ddt(V(cpphdl_n1945, Vss)); // Bench initial voltage = 3.2999999999999998 V.
        // device 1517, IC IC239, analog/basic/mos_track_hold.hpp:31
        I(cpphdl_n2179, cpphdl_n1999) <+ cpphdl_channel(V(TRACK13, cpphdl_n1999), V(cpphdl_n2179, cpphdl_n1999), 0.080000000000000002, 0.69999999999999996, 1.0);
        // device 1518, IC IC239, analog/basic/mos_track_hold.hpp:32
        I(cpphdl_n1999, cpphdl_n2179) <+ cpphdl_channel(V(cpphdl_n1945, cpphdl_n2179), V(cpphdl_n1999, cpphdl_n2179), 0.040000000000000001, 0.69999999999999996, -1.0);
        // device 1519, IC IC239, analog/basic/mos_track_hold.hpp:36
        I(cpphdl_n1999, cpphdl_n1999) <+ cpphdl_channel(V(cpphdl_n1945, cpphdl_n1999), V(cpphdl_n1999, cpphdl_n1999), 0.040000000000000001, 0.69999999999999996, 1.0);
        // device 1520, IC IC239, analog/basic/mos_track_hold.hpp:37
        I(cpphdl_n1999, cpphdl_n1999) <+ cpphdl_channel(V(TRACK13, cpphdl_n1999), V(cpphdl_n1999, cpphdl_n1999), 0.02, 0.69999999999999996, -1.0);
        // device 1521, IC IC239, analog/basic/mos_track_hold.hpp:38
        I(cpphdl_n1999, Vss) <+ 2e-12 * ddt(V(cpphdl_n1999, Vss)); // Bench initial voltage = 1.6499999999999999 V.
        // device 1522, IC IC239, analog/basic/mos_track_hold.hpp:39
        I(Vss, cpphdl_n1999) <+ V(Vss, cpphdl_n1999) / 1000000000.0;
        // device 1523, IC IC239, analog/basic/mos_track_hold.hpp:40
        I(TRACK13, cpphdl_n1999) <+ 8.0000000000000006e-15 * ddt(V(TRACK13, cpphdl_n1999)); // Bench initial voltage = -1.6499999999999999 V.
        // device 1524, IC IC239, analog/basic/mos_track_hold.hpp:41
        I(cpphdl_n1945, cpphdl_n1999) <+ 8.0000000000000006e-15 * ddt(V(cpphdl_n1945, cpphdl_n1999)); // Bench initial voltage = 1.6499999999999999 V.
        // device 1525, IC IC239, analog/basic/mos_track_hold.hpp:42
        I(cpphdl_n2179, cpphdl_n1999) <+ 4.0000000000000003e-15 * ddt(V(cpphdl_n2179, cpphdl_n1999)); // Bench initial voltage = 0.0 V.
        // device 1526, IC IC242, analog/basic/inverter.hpp:11
        I(cpphdl_n1960, Vdd) <+ cpphdl_channel(V(BIT_N13_0, Vdd), V(cpphdl_n1960, Vdd), 0.080000000000000002, 0.69999999999999996, -1.0);
        // device 1527, IC IC242, analog/basic/inverter.hpp:12
        I(cpphdl_n1960, Vss) <+ cpphdl_channel(V(BIT_N13_0, Vss), V(cpphdl_n1960, Vss), 0.080000000000000002, 0.69999999999999996, 1.0);
        // device 1528, IC IC241, analog/basic/mos_r2r_dac.hpp:27
        I(cpphdl_n1960, Vss) <+ 2.9999999999999998e-15 * ddt(V(cpphdl_n1960, Vss)); // Bench initial voltage = 0.0 V.
        // device 1529, IC IC241, analog/basic/mos_r2r_dac.hpp:28
        I(cpphdl_n1960, cpphdl_n1989) <+ V(cpphdl_n1960, cpphdl_n1989) / 20000.0;
        // device 1530, IC IC241, analog/basic/mos_r2r_dac.hpp:29
        I(cpphdl_n1989, Vss) <+ 2.9999999999999998e-15 * ddt(V(cpphdl_n1989, Vss)); // Bench initial voltage = 0.0 V.
        // device 1531, IC IC243, analog/basic/inverter.hpp:11
        I(cpphdl_n1964, Vdd) <+ cpphdl_channel(V(BIT_N13_1, Vdd), V(cpphdl_n1964, Vdd), 0.080000000000000002, 0.69999999999999996, -1.0);
        // device 1532, IC IC243, analog/basic/inverter.hpp:12
        I(cpphdl_n1964, Vss) <+ cpphdl_channel(V(BIT_N13_1, Vss), V(cpphdl_n1964, Vss), 0.080000000000000002, 0.69999999999999996, 1.0);
        // device 1533, IC IC241, analog/basic/mos_r2r_dac.hpp:27
        I(cpphdl_n1964, Vss) <+ 2.9999999999999998e-15 * ddt(V(cpphdl_n1964, Vss)); // Bench initial voltage = 0.0 V.
        // device 1534, IC IC241, analog/basic/mos_r2r_dac.hpp:28
        I(cpphdl_n1964, cpphdl_n1990) <+ V(cpphdl_n1964, cpphdl_n1990) / 20000.0;
        // device 1535, IC IC241, analog/basic/mos_r2r_dac.hpp:29
        I(cpphdl_n1990, Vss) <+ 2.9999999999999998e-15 * ddt(V(cpphdl_n1990, Vss)); // Bench initial voltage = 0.0 V.
        // device 1536, IC IC241, analog/basic/mos_r2r_dac.hpp:31
        I(cpphdl_n1989, cpphdl_n1990) <+ V(cpphdl_n1989, cpphdl_n1990) / 10000.0;
        // device 1537, IC IC244, analog/basic/inverter.hpp:11
        I(cpphdl_n1968, Vdd) <+ cpphdl_channel(V(BIT_N13_2, Vdd), V(cpphdl_n1968, Vdd), 0.080000000000000002, 0.69999999999999996, -1.0);
        // device 1538, IC IC244, analog/basic/inverter.hpp:12
        I(cpphdl_n1968, Vss) <+ cpphdl_channel(V(BIT_N13_2, Vss), V(cpphdl_n1968, Vss), 0.080000000000000002, 0.69999999999999996, 1.0);
        // device 1539, IC IC241, analog/basic/mos_r2r_dac.hpp:27
        I(cpphdl_n1968, Vss) <+ 2.9999999999999998e-15 * ddt(V(cpphdl_n1968, Vss)); // Bench initial voltage = 0.0 V.
        // device 1540, IC IC241, analog/basic/mos_r2r_dac.hpp:28
        I(cpphdl_n1968, cpphdl_n1991) <+ V(cpphdl_n1968, cpphdl_n1991) / 20000.0;
        // device 1541, IC IC241, analog/basic/mos_r2r_dac.hpp:29
        I(cpphdl_n1991, Vss) <+ 2.9999999999999998e-15 * ddt(V(cpphdl_n1991, Vss)); // Bench initial voltage = 0.0 V.
        // device 1542, IC IC241, analog/basic/mos_r2r_dac.hpp:31
        I(cpphdl_n1990, cpphdl_n1991) <+ V(cpphdl_n1990, cpphdl_n1991) / 10000.0;
        // device 1543, IC IC245, analog/basic/inverter.hpp:11
        I(cpphdl_n1972, Vdd) <+ cpphdl_channel(V(BIT_N13_3, Vdd), V(cpphdl_n1972, Vdd), 0.080000000000000002, 0.69999999999999996, -1.0);
        // device 1544, IC IC245, analog/basic/inverter.hpp:12
        I(cpphdl_n1972, Vss) <+ cpphdl_channel(V(BIT_N13_3, Vss), V(cpphdl_n1972, Vss), 0.080000000000000002, 0.69999999999999996, 1.0);
        // device 1545, IC IC241, analog/basic/mos_r2r_dac.hpp:27
        I(cpphdl_n1972, Vss) <+ 2.9999999999999998e-15 * ddt(V(cpphdl_n1972, Vss)); // Bench initial voltage = 0.0 V.
        // device 1546, IC IC241, analog/basic/mos_r2r_dac.hpp:28
        I(cpphdl_n1972, cpphdl_n1992) <+ V(cpphdl_n1972, cpphdl_n1992) / 20000.0;
        // device 1547, IC IC241, analog/basic/mos_r2r_dac.hpp:29
        I(cpphdl_n1992, Vss) <+ 2.9999999999999998e-15 * ddt(V(cpphdl_n1992, Vss)); // Bench initial voltage = 0.0 V.
        // device 1548, IC IC241, analog/basic/mos_r2r_dac.hpp:31
        I(cpphdl_n1991, cpphdl_n1992) <+ V(cpphdl_n1991, cpphdl_n1992) / 10000.0;
        // device 1549, IC IC246, analog/basic/inverter.hpp:11
        I(cpphdl_n1976, Vdd) <+ cpphdl_channel(V(BIT_N13_4, Vdd), V(cpphdl_n1976, Vdd), 0.080000000000000002, 0.69999999999999996, -1.0);
        // device 1550, IC IC246, analog/basic/inverter.hpp:12
        I(cpphdl_n1976, Vss) <+ cpphdl_channel(V(BIT_N13_4, Vss), V(cpphdl_n1976, Vss), 0.080000000000000002, 0.69999999999999996, 1.0);
        // device 1551, IC IC241, analog/basic/mos_r2r_dac.hpp:27
        I(cpphdl_n1976, Vss) <+ 2.9999999999999998e-15 * ddt(V(cpphdl_n1976, Vss)); // Bench initial voltage = 0.0 V.
        // device 1552, IC IC241, analog/basic/mos_r2r_dac.hpp:28
        I(cpphdl_n1976, cpphdl_n1993) <+ V(cpphdl_n1976, cpphdl_n1993) / 20000.0;
        // device 1553, IC IC241, analog/basic/mos_r2r_dac.hpp:29
        I(cpphdl_n1993, Vss) <+ 2.9999999999999998e-15 * ddt(V(cpphdl_n1993, Vss)); // Bench initial voltage = 0.0 V.
        // device 1554, IC IC241, analog/basic/mos_r2r_dac.hpp:31
        I(cpphdl_n1992, cpphdl_n1993) <+ V(cpphdl_n1992, cpphdl_n1993) / 10000.0;
        // device 1555, IC IC247, analog/basic/inverter.hpp:11
        I(cpphdl_n1980, Vdd) <+ cpphdl_channel(V(BIT_N13_5, Vdd), V(cpphdl_n1980, Vdd), 0.080000000000000002, 0.69999999999999996, -1.0);
        // device 1556, IC IC247, analog/basic/inverter.hpp:12
        I(cpphdl_n1980, Vss) <+ cpphdl_channel(V(BIT_N13_5, Vss), V(cpphdl_n1980, Vss), 0.080000000000000002, 0.69999999999999996, 1.0);
        // device 1557, IC IC241, analog/basic/mos_r2r_dac.hpp:27
        I(cpphdl_n1980, Vss) <+ 2.9999999999999998e-15 * ddt(V(cpphdl_n1980, Vss)); // Bench initial voltage = 0.0 V.
        // device 1558, IC IC241, analog/basic/mos_r2r_dac.hpp:28
        I(cpphdl_n1980, cpphdl_n1994) <+ V(cpphdl_n1980, cpphdl_n1994) / 20000.0;
        // device 1559, IC IC241, analog/basic/mos_r2r_dac.hpp:29
        I(cpphdl_n1994, Vss) <+ 2.9999999999999998e-15 * ddt(V(cpphdl_n1994, Vss)); // Bench initial voltage = 0.0 V.
        // device 1560, IC IC241, analog/basic/mos_r2r_dac.hpp:31
        I(cpphdl_n1993, cpphdl_n1994) <+ V(cpphdl_n1993, cpphdl_n1994) / 10000.0;
        // device 1561, IC IC248, analog/basic/inverter.hpp:11
        I(cpphdl_n1984, Vdd) <+ cpphdl_channel(V(BIT_N13_6, Vdd), V(cpphdl_n1984, Vdd), 0.080000000000000002, 0.69999999999999996, -1.0);
        // device 1562, IC IC248, analog/basic/inverter.hpp:12
        I(cpphdl_n1984, Vss) <+ cpphdl_channel(V(BIT_N13_6, Vss), V(cpphdl_n1984, Vss), 0.080000000000000002, 0.69999999999999996, 1.0);
        // device 1563, IC IC241, analog/basic/mos_r2r_dac.hpp:27
        I(cpphdl_n1984, Vss) <+ 2.9999999999999998e-15 * ddt(V(cpphdl_n1984, Vss)); // Bench initial voltage = 0.0 V.
        // device 1564, IC IC241, analog/basic/mos_r2r_dac.hpp:28
        I(cpphdl_n1984, cpphdl_n1995) <+ V(cpphdl_n1984, cpphdl_n1995) / 20000.0;
        // device 1565, IC IC241, analog/basic/mos_r2r_dac.hpp:29
        I(cpphdl_n1995, Vss) <+ 2.9999999999999998e-15 * ddt(V(cpphdl_n1995, Vss)); // Bench initial voltage = 0.0 V.
        // device 1566, IC IC241, analog/basic/mos_r2r_dac.hpp:31
        I(cpphdl_n1994, cpphdl_n1995) <+ V(cpphdl_n1994, cpphdl_n1995) / 10000.0;
        // device 1567, IC IC249, analog/basic/inverter.hpp:11
        I(cpphdl_n1988, Vdd) <+ cpphdl_channel(V(BIT_N13_7, Vdd), V(cpphdl_n1988, Vdd), 0.080000000000000002, 0.69999999999999996, -1.0);
        // device 1568, IC IC249, analog/basic/inverter.hpp:12
        I(cpphdl_n1988, Vss) <+ cpphdl_channel(V(BIT_N13_7, Vss), V(cpphdl_n1988, Vss), 0.080000000000000002, 0.69999999999999996, 1.0);
        // device 1569, IC IC241, analog/basic/mos_r2r_dac.hpp:27
        I(cpphdl_n1988, Vss) <+ 2.9999999999999998e-15 * ddt(V(cpphdl_n1988, Vss)); // Bench initial voltage = 0.0 V.
        // device 1570, IC IC241, analog/basic/mos_r2r_dac.hpp:28
        I(cpphdl_n1988, cpphdl_n2000) <+ V(cpphdl_n1988, cpphdl_n2000) / 20000.0;
        // device 1571, IC IC241, analog/basic/mos_r2r_dac.hpp:29
        I(cpphdl_n2000, Vss) <+ 2.9999999999999998e-15 * ddt(V(cpphdl_n2000, Vss)); // Bench initial voltage = 0.0 V.
        // device 1572, IC IC241, analog/basic/mos_r2r_dac.hpp:31
        I(cpphdl_n1995, cpphdl_n2000) <+ V(cpphdl_n1995, cpphdl_n2000) / 10000.0;
        // device 1573, IC IC241, analog/basic/mos_r2r_dac.hpp:33
        I(Vss, cpphdl_n1989) <+ V(Vss, cpphdl_n1989) / 20000.0;
        // device 1574, IC IC250, analog/basic/nmos_resistor_amplifier.hpp:23
        I(Vdd, cpphdl_n2009) <+ V(Vdd, cpphdl_n2009) / 1000.0;
        // device 1575, IC IC250, analog/basic/nmos_resistor_amplifier.hpp:24
        I(Vdd, cpphdl_n2008) <+ V(Vdd, cpphdl_n2008) / 1000.0;
        // device 1576, IC IC250, analog/basic/nmos_resistor_amplifier.hpp:25
        I(cpphdl_n2009, cpphdl_n2003) <+ cpphdl_channel(V(cpphdl_n1999, cpphdl_n2003), V(cpphdl_n2009, cpphdl_n2003), 0.014999999999999999, 0.69999999999999996, 1.0);
        // device 1577, IC IC250, analog/basic/nmos_resistor_amplifier.hpp:26
        I(cpphdl_n2008, cpphdl_n2004) <+ cpphdl_channel(V(cpphdl_n2000, cpphdl_n2004), V(cpphdl_n2008, cpphdl_n2004), 0.014999999999999999, 0.69999999999999996, 1.0);
        // device 1578, IC IC250, analog/basic/nmos_resistor_amplifier.hpp:27
        I(cpphdl_n2005, cpphdl_n2003) <+ V(cpphdl_n2005, cpphdl_n2003) / 50.0;
        // device 1579, IC IC250, analog/basic/nmos_resistor_amplifier.hpp:28
        I(cpphdl_n2005, cpphdl_n2004) <+ V(cpphdl_n2005, cpphdl_n2004) / 50.0;
        // device 1580, IC IC250, analog/basic/nmos_resistor_amplifier.hpp:29
        I(Vss, cpphdl_n2005) <+ V(Vss, cpphdl_n2005) / 150.0;
        // device 1581, IC IC250, analog/basic/nmos_resistor_amplifier.hpp:30
        I(cpphdl_n2009, Vdd) <+ 2.9999999999999998e-13 * ddt(V(cpphdl_n2009, Vdd)); // Bench initial voltage = 0.0 V.
        // device 1582, IC IC250, analog/basic/nmos_resistor_amplifier.hpp:31
        I(cpphdl_n2008, Vdd) <+ 2.9999999999999998e-13 * ddt(V(cpphdl_n2008, Vdd)); // Bench initial voltage = 0.0 V.
        // device 1583, IC IC250, analog/basic/nmos_resistor_amplifier.hpp:32
        I(cpphdl_n2005, Vss) <+ 4e-14 * ddt(V(cpphdl_n2005, Vss)); // Bench initial voltage = 0.0 V.
        // device 1584, IC IC250, analog/basic/nmos_resistor_amplifier.hpp:34
        I(cpphdl_n1999, cpphdl_n2003) <+ 2e-14 * ddt(V(cpphdl_n1999, cpphdl_n2003)); // Bench initial voltage = 1.6499999999999999 V.
        // device 1585, IC IC250, analog/basic/nmos_resistor_amplifier.hpp:35
        I(cpphdl_n2000, cpphdl_n2004) <+ 2e-14 * ddt(V(cpphdl_n2000, cpphdl_n2004)); // Bench initial voltage = 0.0 V.
        // device 1586, IC IC250, analog/basic/nmos_resistor_amplifier.hpp:36
        I(cpphdl_n1999, cpphdl_n2009) <+ 2.9999999999999998e-15 * ddt(V(cpphdl_n1999, cpphdl_n2009)); // Bench initial voltage = -1.6499999999999999 V.
        // device 1587, IC IC250, analog/basic/nmos_resistor_amplifier.hpp:37
        I(cpphdl_n2000, cpphdl_n2008) <+ 2.9999999999999998e-15 * ddt(V(cpphdl_n2000, cpphdl_n2008)); // Bench initial voltage = -3.2999999999999998 V.
        // device 1588, IC IC251, analog/basic/strongarm_comparator.hpp:28
        I(cpphdl_n2013, cpphdl_n2015) <+ cpphdl_channel(V(cpphdl_n2008, cpphdl_n2015), V(cpphdl_n2013, cpphdl_n2015), 0.0080000000000000002, 0.69999999999999996, 1.0);
        // device 1589, IC IC251, analog/basic/strongarm_comparator.hpp:29
        I(cpphdl_n2014, cpphdl_n2015) <+ cpphdl_channel(V(cpphdl_n2009, cpphdl_n2015), V(cpphdl_n2014, cpphdl_n2015), 0.0080000000000000002, 0.69999999999999996, 1.0);
        // device 1590, IC IC251, analog/basic/strongarm_comparator.hpp:30
        I(cpphdl_n2015, Vss) <+ cpphdl_channel(V(EVALUATE, Vss), V(cpphdl_n2015, Vss), 0.0080000000000000002, 0.69999999999999996, 1.0);
        // device 1591, IC IC251, analog/basic/strongarm_comparator.hpp:33
        I(cpphdl_n2027, cpphdl_n2013) <+ cpphdl_channel(V(cpphdl_n2033, cpphdl_n2013), V(cpphdl_n2027, cpphdl_n2013), 0.0040000000000000001, 0.69999999999999996, 1.0);
        // device 1592, IC IC251, analog/basic/strongarm_comparator.hpp:34
        I(cpphdl_n2033, cpphdl_n2014) <+ cpphdl_channel(V(cpphdl_n2027, cpphdl_n2014), V(cpphdl_n2033, cpphdl_n2014), 0.0040000000000000001, 0.69999999999999996, 1.0);
        // device 1593, IC IC251, analog/basic/strongarm_comparator.hpp:35
        I(cpphdl_n2033, Vdd) <+ cpphdl_channel(V(cpphdl_n2027, Vdd), V(cpphdl_n2033, Vdd), 0.002, 0.69999999999999996, -1.0);
        // device 1594, IC IC251, analog/basic/strongarm_comparator.hpp:36
        I(cpphdl_n2027, Vdd) <+ cpphdl_channel(V(cpphdl_n2033, Vdd), V(cpphdl_n2027, Vdd), 0.002, 0.69999999999999996, -1.0);
        // device 1595, IC IC251, analog/basic/strongarm_comparator.hpp:38
        I(cpphdl_n2013, Vdd) <+ cpphdl_channel(V(EVALUATE, Vdd), V(cpphdl_n2013, Vdd), 0.002, 0.69999999999999996, -1.0);
        // device 1596, IC IC251, analog/basic/strongarm_comparator.hpp:39
        I(cpphdl_n2014, Vdd) <+ cpphdl_channel(V(EVALUATE, Vdd), V(cpphdl_n2014, Vdd), 0.002, 0.69999999999999996, -1.0);
        // device 1597, IC IC251, analog/basic/strongarm_comparator.hpp:40
        I(cpphdl_n2033, Vdd) <+ cpphdl_channel(V(EVALUATE, Vdd), V(cpphdl_n2033, Vdd), 0.002, 0.69999999999999996, -1.0);
        // device 1598, IC IC251, analog/basic/strongarm_comparator.hpp:41
        I(cpphdl_n2027, Vdd) <+ cpphdl_channel(V(EVALUATE, Vdd), V(cpphdl_n2027, Vdd), 0.002, 0.69999999999999996, -1.0);
        // device 1599, IC IC251, analog/basic/strongarm_comparator.hpp:42
        I(cpphdl_n2013, Vss) <+ 2.9999999999999998e-14 * ddt(V(cpphdl_n2013, Vss)); // Bench initial voltage = 0.0 V.
        // device 1600, IC IC251, analog/basic/strongarm_comparator.hpp:43
        I(cpphdl_n2014, Vss) <+ 2.9999999999999998e-14 * ddt(V(cpphdl_n2014, Vss)); // Bench initial voltage = 0.0 V.
        // device 1601, IC IC251, analog/basic/strongarm_comparator.hpp:44
        I(cpphdl_n2015, Vss) <+ 2.9999999999999998e-14 * ddt(V(cpphdl_n2015, Vss)); // Bench initial voltage = 0.0 V.
        // device 1602, IC IC251, analog/basic/strongarm_comparator.hpp:45
        I(cpphdl_n2033, Vss) <+ 5.0000000000000002e-14 * ddt(V(cpphdl_n2033, Vss)); // Bench initial voltage = 0.0 V.
        // device 1603, IC IC251, analog/basic/strongarm_comparator.hpp:46
        I(cpphdl_n2027, Vss) <+ 5.0000000000000002e-14 * ddt(V(cpphdl_n2027, Vss)); // Bench initial voltage = 0.0 V.
        // device 1604, IC IC251, analog/basic/strongarm_comparator.hpp:47
        I(cpphdl_n2008, cpphdl_n2015) <+ 2e-14 * ddt(V(cpphdl_n2008, cpphdl_n2015)); // Bench initial voltage = 3.2999999999999998 V.
        // device 1605, IC IC251, analog/basic/strongarm_comparator.hpp:48
        I(cpphdl_n2009, cpphdl_n2015) <+ 2e-14 * ddt(V(cpphdl_n2009, cpphdl_n2015)); // Bench initial voltage = 3.2999999999999998 V.
        // device 1606, IC IC251, analog/basic/strongarm_comparator.hpp:49
        I(cpphdl_n2008, cpphdl_n2013) <+ 2.9999999999999998e-15 * ddt(V(cpphdl_n2008, cpphdl_n2013)); // Bench initial voltage = 3.2999999999999998 V.
        // device 1607, IC IC251, analog/basic/strongarm_comparator.hpp:50
        I(cpphdl_n2009, cpphdl_n2014) <+ 2.9999999999999998e-15 * ddt(V(cpphdl_n2009, cpphdl_n2014)); // Bench initial voltage = 3.2999999999999998 V.
        // device 1608, IC IC253, analog/basic/cmos_logic.hpp:15
        I(cpphdl_n2366, Vss) <+ 5.0000000000000002e-14 * ddt(V(cpphdl_n2366, Vss)); // Bench initial voltage = 0.0 V.
        // device 1609, IC IC253, analog/basic/cmos_logic.hpp:16
        I(cpphdl_n2366, Vdd) <+ cpphdl_channel(V(cpphdl_n2027, Vdd), V(cpphdl_n2366, Vdd), 0.01, 0.69999999999999996, -1.0);
        // device 1610, IC IC253, analog/basic/cmos_logic.hpp:17
        I(cpphdl_n2366, Vdd) <+ cpphdl_channel(V(cpphdl_n2035, Vdd), V(cpphdl_n2366, Vdd), 0.01, 0.69999999999999996, -1.0);
        // device 1611, IC IC253, analog/basic/cmos_logic.hpp:18
        I(cpphdl_n2366, cpphdl_n2030) <+ cpphdl_channel(V(cpphdl_n2027, cpphdl_n2030), V(cpphdl_n2366, cpphdl_n2030), 0.01, 0.69999999999999996, 1.0);
        // device 1612, IC IC253, analog/basic/cmos_logic.hpp:19
        I(cpphdl_n2030, Vss) <+ cpphdl_channel(V(cpphdl_n2035, Vss), V(cpphdl_n2030, Vss), 0.01, 0.69999999999999996, 1.0);
        // device 1613, IC IC253, analog/basic/cmos_logic.hpp:20
        I(cpphdl_n2366, Vss) <+ V(cpphdl_n2366, Vss) / 1000000000.0;
        // device 1614, IC IC253, analog/basic/cmos_logic.hpp:21
        I(cpphdl_n2030, Vss) <+ V(cpphdl_n2030, Vss) / 1000000000.0;
        // device 1615, IC IC254, analog/basic/cmos_logic.hpp:15
        I(cpphdl_n2035, Vss) <+ 5.0000000000000002e-14 * ddt(V(cpphdl_n2035, Vss)); // Bench initial voltage = 0.0 V.
        // device 1616, IC IC254, analog/basic/cmos_logic.hpp:16
        I(cpphdl_n2035, Vdd) <+ cpphdl_channel(V(cpphdl_n2033, Vdd), V(cpphdl_n2035, Vdd), 0.01, 0.69999999999999996, -1.0);
        // device 1617, IC IC254, analog/basic/cmos_logic.hpp:17
        I(cpphdl_n2035, Vdd) <+ cpphdl_channel(V(cpphdl_n2366, Vdd), V(cpphdl_n2035, Vdd), 0.01, 0.69999999999999996, -1.0);
        // device 1618, IC IC254, analog/basic/cmos_logic.hpp:18
        I(cpphdl_n2035, cpphdl_n2036) <+ cpphdl_channel(V(cpphdl_n2033, cpphdl_n2036), V(cpphdl_n2035, cpphdl_n2036), 0.01, 0.69999999999999996, 1.0);
        // device 1619, IC IC254, analog/basic/cmos_logic.hpp:19
        I(cpphdl_n2036, Vss) <+ cpphdl_channel(V(cpphdl_n2366, Vss), V(cpphdl_n2036, Vss), 0.01, 0.69999999999999996, 1.0);
        // device 1620, IC IC254, analog/basic/cmos_logic.hpp:20
        I(cpphdl_n2035, Vss) <+ V(cpphdl_n2035, Vss) / 1000000000.0;
        // device 1621, IC IC254, analog/basic/cmos_logic.hpp:21
        I(cpphdl_n2036, Vss) <+ V(cpphdl_n2036, Vss) / 1000000000.0;
        // device 1622, IC IC252, analog/basic/nand_latch.hpp:34
        I(cpphdl_n2027, Vss) <+ 2.9999999999999998e-15 * ddt(V(cpphdl_n2027, Vss)); // Bench initial voltage = 0.0 V.
        // device 1623, IC IC252, analog/basic/nand_latch.hpp:35
        I(cpphdl_n2033, Vss) <+ 2.9999999999999998e-15 * ddt(V(cpphdl_n2033, Vss)); // Bench initial voltage = 0.0 V.
        // device 1624, IC IC255, analog/basic/inverter.hpp:11
        I(cpphdl_n2041, Vdd) <+ cpphdl_channel(V(CLEAR, Vdd), V(cpphdl_n2041, Vdd), 0.01, 0.69999999999999996, -1.0);
        // device 1625, IC IC255, analog/basic/inverter.hpp:12
        I(cpphdl_n2041, Vss) <+ cpphdl_channel(V(CLEAR, Vss), V(cpphdl_n2041, Vss), 0.01, 0.69999999999999996, 1.0);
        // device 1626, IC IC252, analog/basic/nand_latch.hpp:56
        I(cpphdl_n2041, Vss) <+ 2.9999999999999998e-15 * ddt(V(cpphdl_n2041, Vss)); // Bench initial voltage = 0.0 V.
        // device 1627, IC IC252, analog/basic/nand_latch.hpp:57
        I(cpphdl_n2366, Vss) <+ cpphdl_channel(V(CLEAR, Vss), V(cpphdl_n2366, Vss), 0.050000000000000003, 0.69999999999999996, 1.0);
        // device 1628, IC IC252, analog/basic/nand_latch.hpp:58
        I(cpphdl_n2035, Vdd) <+ cpphdl_channel(V(cpphdl_n2041, Vdd), V(cpphdl_n2035, Vdd), 0.050000000000000003, 0.69999999999999996, -1.0);
        // device 1629, IC IC258, analog/basic/inverter.hpp:11
        I(cpphdl_n2065, Vdd) <+ cpphdl_channel(V(TRACK14, Vdd), V(cpphdl_n2065, Vdd), 0.0040000000000000001, 0.69999999999999996, -1.0);
        // device 1630, IC IC258, analog/basic/inverter.hpp:12
        I(cpphdl_n2065, Vss) <+ cpphdl_channel(V(TRACK14, Vss), V(cpphdl_n2065, Vss), 0.0040000000000000001, 0.69999999999999996, 1.0);
        // device 1631, IC IC257, analog/basic/mos_track_hold.hpp:30
        I(cpphdl_n2065, Vss) <+ 2e-14 * ddt(V(cpphdl_n2065, Vss)); // Bench initial voltage = 3.2999999999999998 V.
        // device 1632, IC IC257, analog/basic/mos_track_hold.hpp:31
        I(cpphdl_n2179, cpphdl_n2119) <+ cpphdl_channel(V(TRACK14, cpphdl_n2119), V(cpphdl_n2179, cpphdl_n2119), 0.080000000000000002, 0.69999999999999996, 1.0);
        // device 1633, IC IC257, analog/basic/mos_track_hold.hpp:32
        I(cpphdl_n2119, cpphdl_n2179) <+ cpphdl_channel(V(cpphdl_n2065, cpphdl_n2179), V(cpphdl_n2119, cpphdl_n2179), 0.040000000000000001, 0.69999999999999996, -1.0);
        // device 1634, IC IC257, analog/basic/mos_track_hold.hpp:36
        I(cpphdl_n2119, cpphdl_n2119) <+ cpphdl_channel(V(cpphdl_n2065, cpphdl_n2119), V(cpphdl_n2119, cpphdl_n2119), 0.040000000000000001, 0.69999999999999996, 1.0);
        // device 1635, IC IC257, analog/basic/mos_track_hold.hpp:37
        I(cpphdl_n2119, cpphdl_n2119) <+ cpphdl_channel(V(TRACK14, cpphdl_n2119), V(cpphdl_n2119, cpphdl_n2119), 0.02, 0.69999999999999996, -1.0);
        // device 1636, IC IC257, analog/basic/mos_track_hold.hpp:38
        I(cpphdl_n2119, Vss) <+ 2e-12 * ddt(V(cpphdl_n2119, Vss)); // Bench initial voltage = 1.6499999999999999 V.
        // device 1637, IC IC257, analog/basic/mos_track_hold.hpp:39
        I(Vss, cpphdl_n2119) <+ V(Vss, cpphdl_n2119) / 1000000000.0;
        // device 1638, IC IC257, analog/basic/mos_track_hold.hpp:40
        I(TRACK14, cpphdl_n2119) <+ 8.0000000000000006e-15 * ddt(V(TRACK14, cpphdl_n2119)); // Bench initial voltage = -1.6499999999999999 V.
        // device 1639, IC IC257, analog/basic/mos_track_hold.hpp:41
        I(cpphdl_n2065, cpphdl_n2119) <+ 8.0000000000000006e-15 * ddt(V(cpphdl_n2065, cpphdl_n2119)); // Bench initial voltage = 1.6499999999999999 V.
        // device 1640, IC IC257, analog/basic/mos_track_hold.hpp:42
        I(cpphdl_n2179, cpphdl_n2119) <+ 4.0000000000000003e-15 * ddt(V(cpphdl_n2179, cpphdl_n2119)); // Bench initial voltage = 0.0 V.
        // device 1641, IC IC260, analog/basic/inverter.hpp:11
        I(cpphdl_n2080, Vdd) <+ cpphdl_channel(V(BIT_N14_0, Vdd), V(cpphdl_n2080, Vdd), 0.080000000000000002, 0.69999999999999996, -1.0);
        // device 1642, IC IC260, analog/basic/inverter.hpp:12
        I(cpphdl_n2080, Vss) <+ cpphdl_channel(V(BIT_N14_0, Vss), V(cpphdl_n2080, Vss), 0.080000000000000002, 0.69999999999999996, 1.0);
        // device 1643, IC IC259, analog/basic/mos_r2r_dac.hpp:27
        I(cpphdl_n2080, Vss) <+ 2.9999999999999998e-15 * ddt(V(cpphdl_n2080, Vss)); // Bench initial voltage = 0.0 V.
        // device 1644, IC IC259, analog/basic/mos_r2r_dac.hpp:28
        I(cpphdl_n2080, cpphdl_n2109) <+ V(cpphdl_n2080, cpphdl_n2109) / 20000.0;
        // device 1645, IC IC259, analog/basic/mos_r2r_dac.hpp:29
        I(cpphdl_n2109, Vss) <+ 2.9999999999999998e-15 * ddt(V(cpphdl_n2109, Vss)); // Bench initial voltage = 0.0 V.
        // device 1646, IC IC261, analog/basic/inverter.hpp:11
        I(cpphdl_n2084, Vdd) <+ cpphdl_channel(V(BIT_N14_1, Vdd), V(cpphdl_n2084, Vdd), 0.080000000000000002, 0.69999999999999996, -1.0);
        // device 1647, IC IC261, analog/basic/inverter.hpp:12
        I(cpphdl_n2084, Vss) <+ cpphdl_channel(V(BIT_N14_1, Vss), V(cpphdl_n2084, Vss), 0.080000000000000002, 0.69999999999999996, 1.0);
        // device 1648, IC IC259, analog/basic/mos_r2r_dac.hpp:27
        I(cpphdl_n2084, Vss) <+ 2.9999999999999998e-15 * ddt(V(cpphdl_n2084, Vss)); // Bench initial voltage = 0.0 V.
        // device 1649, IC IC259, analog/basic/mos_r2r_dac.hpp:28
        I(cpphdl_n2084, cpphdl_n2110) <+ V(cpphdl_n2084, cpphdl_n2110) / 20000.0;
        // device 1650, IC IC259, analog/basic/mos_r2r_dac.hpp:29
        I(cpphdl_n2110, Vss) <+ 2.9999999999999998e-15 * ddt(V(cpphdl_n2110, Vss)); // Bench initial voltage = 0.0 V.
        // device 1651, IC IC259, analog/basic/mos_r2r_dac.hpp:31
        I(cpphdl_n2109, cpphdl_n2110) <+ V(cpphdl_n2109, cpphdl_n2110) / 10000.0;
        // device 1652, IC IC262, analog/basic/inverter.hpp:11
        I(cpphdl_n2088, Vdd) <+ cpphdl_channel(V(BIT_N14_2, Vdd), V(cpphdl_n2088, Vdd), 0.080000000000000002, 0.69999999999999996, -1.0);
        // device 1653, IC IC262, analog/basic/inverter.hpp:12
        I(cpphdl_n2088, Vss) <+ cpphdl_channel(V(BIT_N14_2, Vss), V(cpphdl_n2088, Vss), 0.080000000000000002, 0.69999999999999996, 1.0);
        // device 1654, IC IC259, analog/basic/mos_r2r_dac.hpp:27
        I(cpphdl_n2088, Vss) <+ 2.9999999999999998e-15 * ddt(V(cpphdl_n2088, Vss)); // Bench initial voltage = 0.0 V.
        // device 1655, IC IC259, analog/basic/mos_r2r_dac.hpp:28
        I(cpphdl_n2088, cpphdl_n2111) <+ V(cpphdl_n2088, cpphdl_n2111) / 20000.0;
        // device 1656, IC IC259, analog/basic/mos_r2r_dac.hpp:29
        I(cpphdl_n2111, Vss) <+ 2.9999999999999998e-15 * ddt(V(cpphdl_n2111, Vss)); // Bench initial voltage = 0.0 V.
        // device 1657, IC IC259, analog/basic/mos_r2r_dac.hpp:31
        I(cpphdl_n2110, cpphdl_n2111) <+ V(cpphdl_n2110, cpphdl_n2111) / 10000.0;
        // device 1658, IC IC263, analog/basic/inverter.hpp:11
        I(cpphdl_n2092, Vdd) <+ cpphdl_channel(V(BIT_N14_3, Vdd), V(cpphdl_n2092, Vdd), 0.080000000000000002, 0.69999999999999996, -1.0);
        // device 1659, IC IC263, analog/basic/inverter.hpp:12
        I(cpphdl_n2092, Vss) <+ cpphdl_channel(V(BIT_N14_3, Vss), V(cpphdl_n2092, Vss), 0.080000000000000002, 0.69999999999999996, 1.0);
        // device 1660, IC IC259, analog/basic/mos_r2r_dac.hpp:27
        I(cpphdl_n2092, Vss) <+ 2.9999999999999998e-15 * ddt(V(cpphdl_n2092, Vss)); // Bench initial voltage = 0.0 V.
        // device 1661, IC IC259, analog/basic/mos_r2r_dac.hpp:28
        I(cpphdl_n2092, cpphdl_n2112) <+ V(cpphdl_n2092, cpphdl_n2112) / 20000.0;
        // device 1662, IC IC259, analog/basic/mos_r2r_dac.hpp:29
        I(cpphdl_n2112, Vss) <+ 2.9999999999999998e-15 * ddt(V(cpphdl_n2112, Vss)); // Bench initial voltage = 0.0 V.
        // device 1663, IC IC259, analog/basic/mos_r2r_dac.hpp:31
        I(cpphdl_n2111, cpphdl_n2112) <+ V(cpphdl_n2111, cpphdl_n2112) / 10000.0;
        // device 1664, IC IC264, analog/basic/inverter.hpp:11
        I(cpphdl_n2096, Vdd) <+ cpphdl_channel(V(BIT_N14_4, Vdd), V(cpphdl_n2096, Vdd), 0.080000000000000002, 0.69999999999999996, -1.0);
        // device 1665, IC IC264, analog/basic/inverter.hpp:12
        I(cpphdl_n2096, Vss) <+ cpphdl_channel(V(BIT_N14_4, Vss), V(cpphdl_n2096, Vss), 0.080000000000000002, 0.69999999999999996, 1.0);
        // device 1666, IC IC259, analog/basic/mos_r2r_dac.hpp:27
        I(cpphdl_n2096, Vss) <+ 2.9999999999999998e-15 * ddt(V(cpphdl_n2096, Vss)); // Bench initial voltage = 0.0 V.
        // device 1667, IC IC259, analog/basic/mos_r2r_dac.hpp:28
        I(cpphdl_n2096, cpphdl_n2113) <+ V(cpphdl_n2096, cpphdl_n2113) / 20000.0;
        // device 1668, IC IC259, analog/basic/mos_r2r_dac.hpp:29
        I(cpphdl_n2113, Vss) <+ 2.9999999999999998e-15 * ddt(V(cpphdl_n2113, Vss)); // Bench initial voltage = 0.0 V.
        // device 1669, IC IC259, analog/basic/mos_r2r_dac.hpp:31
        I(cpphdl_n2112, cpphdl_n2113) <+ V(cpphdl_n2112, cpphdl_n2113) / 10000.0;
        // device 1670, IC IC265, analog/basic/inverter.hpp:11
        I(cpphdl_n2100, Vdd) <+ cpphdl_channel(V(BIT_N14_5, Vdd), V(cpphdl_n2100, Vdd), 0.080000000000000002, 0.69999999999999996, -1.0);
        // device 1671, IC IC265, analog/basic/inverter.hpp:12
        I(cpphdl_n2100, Vss) <+ cpphdl_channel(V(BIT_N14_5, Vss), V(cpphdl_n2100, Vss), 0.080000000000000002, 0.69999999999999996, 1.0);
        // device 1672, IC IC259, analog/basic/mos_r2r_dac.hpp:27
        I(cpphdl_n2100, Vss) <+ 2.9999999999999998e-15 * ddt(V(cpphdl_n2100, Vss)); // Bench initial voltage = 0.0 V.
        // device 1673, IC IC259, analog/basic/mos_r2r_dac.hpp:28
        I(cpphdl_n2100, cpphdl_n2114) <+ V(cpphdl_n2100, cpphdl_n2114) / 20000.0;
        // device 1674, IC IC259, analog/basic/mos_r2r_dac.hpp:29
        I(cpphdl_n2114, Vss) <+ 2.9999999999999998e-15 * ddt(V(cpphdl_n2114, Vss)); // Bench initial voltage = 0.0 V.
        // device 1675, IC IC259, analog/basic/mos_r2r_dac.hpp:31
        I(cpphdl_n2113, cpphdl_n2114) <+ V(cpphdl_n2113, cpphdl_n2114) / 10000.0;
        // device 1676, IC IC266, analog/basic/inverter.hpp:11
        I(cpphdl_n2104, Vdd) <+ cpphdl_channel(V(BIT_N14_6, Vdd), V(cpphdl_n2104, Vdd), 0.080000000000000002, 0.69999999999999996, -1.0);
        // device 1677, IC IC266, analog/basic/inverter.hpp:12
        I(cpphdl_n2104, Vss) <+ cpphdl_channel(V(BIT_N14_6, Vss), V(cpphdl_n2104, Vss), 0.080000000000000002, 0.69999999999999996, 1.0);
        // device 1678, IC IC259, analog/basic/mos_r2r_dac.hpp:27
        I(cpphdl_n2104, Vss) <+ 2.9999999999999998e-15 * ddt(V(cpphdl_n2104, Vss)); // Bench initial voltage = 0.0 V.
        // device 1679, IC IC259, analog/basic/mos_r2r_dac.hpp:28
        I(cpphdl_n2104, cpphdl_n2115) <+ V(cpphdl_n2104, cpphdl_n2115) / 20000.0;
        // device 1680, IC IC259, analog/basic/mos_r2r_dac.hpp:29
        I(cpphdl_n2115, Vss) <+ 2.9999999999999998e-15 * ddt(V(cpphdl_n2115, Vss)); // Bench initial voltage = 0.0 V.
        // device 1681, IC IC259, analog/basic/mos_r2r_dac.hpp:31
        I(cpphdl_n2114, cpphdl_n2115) <+ V(cpphdl_n2114, cpphdl_n2115) / 10000.0;
        // device 1682, IC IC267, analog/basic/inverter.hpp:11
        I(cpphdl_n2108, Vdd) <+ cpphdl_channel(V(BIT_N14_7, Vdd), V(cpphdl_n2108, Vdd), 0.080000000000000002, 0.69999999999999996, -1.0);
        // device 1683, IC IC267, analog/basic/inverter.hpp:12
        I(cpphdl_n2108, Vss) <+ cpphdl_channel(V(BIT_N14_7, Vss), V(cpphdl_n2108, Vss), 0.080000000000000002, 0.69999999999999996, 1.0);
        // device 1684, IC IC259, analog/basic/mos_r2r_dac.hpp:27
        I(cpphdl_n2108, Vss) <+ 2.9999999999999998e-15 * ddt(V(cpphdl_n2108, Vss)); // Bench initial voltage = 0.0 V.
        // device 1685, IC IC259, analog/basic/mos_r2r_dac.hpp:28
        I(cpphdl_n2108, cpphdl_n2120) <+ V(cpphdl_n2108, cpphdl_n2120) / 20000.0;
        // device 1686, IC IC259, analog/basic/mos_r2r_dac.hpp:29
        I(cpphdl_n2120, Vss) <+ 2.9999999999999998e-15 * ddt(V(cpphdl_n2120, Vss)); // Bench initial voltage = 0.0 V.
        // device 1687, IC IC259, analog/basic/mos_r2r_dac.hpp:31
        I(cpphdl_n2115, cpphdl_n2120) <+ V(cpphdl_n2115, cpphdl_n2120) / 10000.0;
        // device 1688, IC IC259, analog/basic/mos_r2r_dac.hpp:33
        I(Vss, cpphdl_n2109) <+ V(Vss, cpphdl_n2109) / 20000.0;
        // device 1689, IC IC268, analog/basic/nmos_resistor_amplifier.hpp:23
        I(Vdd, cpphdl_n2129) <+ V(Vdd, cpphdl_n2129) / 1000.0;
        // device 1690, IC IC268, analog/basic/nmos_resistor_amplifier.hpp:24
        I(Vdd, cpphdl_n2128) <+ V(Vdd, cpphdl_n2128) / 1000.0;
        // device 1691, IC IC268, analog/basic/nmos_resistor_amplifier.hpp:25
        I(cpphdl_n2129, cpphdl_n2123) <+ cpphdl_channel(V(cpphdl_n2119, cpphdl_n2123), V(cpphdl_n2129, cpphdl_n2123), 0.014999999999999999, 0.69999999999999996, 1.0);
        // device 1692, IC IC268, analog/basic/nmos_resistor_amplifier.hpp:26
        I(cpphdl_n2128, cpphdl_n2124) <+ cpphdl_channel(V(cpphdl_n2120, cpphdl_n2124), V(cpphdl_n2128, cpphdl_n2124), 0.014999999999999999, 0.69999999999999996, 1.0);
        // device 1693, IC IC268, analog/basic/nmos_resistor_amplifier.hpp:27
        I(cpphdl_n2125, cpphdl_n2123) <+ V(cpphdl_n2125, cpphdl_n2123) / 50.0;
        // device 1694, IC IC268, analog/basic/nmos_resistor_amplifier.hpp:28
        I(cpphdl_n2125, cpphdl_n2124) <+ V(cpphdl_n2125, cpphdl_n2124) / 50.0;
        // device 1695, IC IC268, analog/basic/nmos_resistor_amplifier.hpp:29
        I(Vss, cpphdl_n2125) <+ V(Vss, cpphdl_n2125) / 150.0;
        // device 1696, IC IC268, analog/basic/nmos_resistor_amplifier.hpp:30
        I(cpphdl_n2129, Vdd) <+ 2.9999999999999998e-13 * ddt(V(cpphdl_n2129, Vdd)); // Bench initial voltage = 0.0 V.
        // device 1697, IC IC268, analog/basic/nmos_resistor_amplifier.hpp:31
        I(cpphdl_n2128, Vdd) <+ 2.9999999999999998e-13 * ddt(V(cpphdl_n2128, Vdd)); // Bench initial voltage = 0.0 V.
        // device 1698, IC IC268, analog/basic/nmos_resistor_amplifier.hpp:32
        I(cpphdl_n2125, Vss) <+ 4e-14 * ddt(V(cpphdl_n2125, Vss)); // Bench initial voltage = 0.0 V.
        // device 1699, IC IC268, analog/basic/nmos_resistor_amplifier.hpp:34
        I(cpphdl_n2119, cpphdl_n2123) <+ 2e-14 * ddt(V(cpphdl_n2119, cpphdl_n2123)); // Bench initial voltage = 1.6499999999999999 V.
        // device 1700, IC IC268, analog/basic/nmos_resistor_amplifier.hpp:35
        I(cpphdl_n2120, cpphdl_n2124) <+ 2e-14 * ddt(V(cpphdl_n2120, cpphdl_n2124)); // Bench initial voltage = 0.0 V.
        // device 1701, IC IC268, analog/basic/nmos_resistor_amplifier.hpp:36
        I(cpphdl_n2119, cpphdl_n2129) <+ 2.9999999999999998e-15 * ddt(V(cpphdl_n2119, cpphdl_n2129)); // Bench initial voltage = -1.6499999999999999 V.
        // device 1702, IC IC268, analog/basic/nmos_resistor_amplifier.hpp:37
        I(cpphdl_n2120, cpphdl_n2128) <+ 2.9999999999999998e-15 * ddt(V(cpphdl_n2120, cpphdl_n2128)); // Bench initial voltage = -3.2999999999999998 V.
        // device 1703, IC IC269, analog/basic/strongarm_comparator.hpp:28
        I(cpphdl_n2133, cpphdl_n2135) <+ cpphdl_channel(V(cpphdl_n2128, cpphdl_n2135), V(cpphdl_n2133, cpphdl_n2135), 0.0080000000000000002, 0.69999999999999996, 1.0);
        // device 1704, IC IC269, analog/basic/strongarm_comparator.hpp:29
        I(cpphdl_n2134, cpphdl_n2135) <+ cpphdl_channel(V(cpphdl_n2129, cpphdl_n2135), V(cpphdl_n2134, cpphdl_n2135), 0.0080000000000000002, 0.69999999999999996, 1.0);
        // device 1705, IC IC269, analog/basic/strongarm_comparator.hpp:30
        I(cpphdl_n2135, Vss) <+ cpphdl_channel(V(EVALUATE, Vss), V(cpphdl_n2135, Vss), 0.0080000000000000002, 0.69999999999999996, 1.0);
        // device 1706, IC IC269, analog/basic/strongarm_comparator.hpp:33
        I(cpphdl_n2147, cpphdl_n2133) <+ cpphdl_channel(V(cpphdl_n2153, cpphdl_n2133), V(cpphdl_n2147, cpphdl_n2133), 0.0040000000000000001, 0.69999999999999996, 1.0);
        // device 1707, IC IC269, analog/basic/strongarm_comparator.hpp:34
        I(cpphdl_n2153, cpphdl_n2134) <+ cpphdl_channel(V(cpphdl_n2147, cpphdl_n2134), V(cpphdl_n2153, cpphdl_n2134), 0.0040000000000000001, 0.69999999999999996, 1.0);
        // device 1708, IC IC269, analog/basic/strongarm_comparator.hpp:35
        I(cpphdl_n2153, Vdd) <+ cpphdl_channel(V(cpphdl_n2147, Vdd), V(cpphdl_n2153, Vdd), 0.002, 0.69999999999999996, -1.0);
        // device 1709, IC IC269, analog/basic/strongarm_comparator.hpp:36
        I(cpphdl_n2147, Vdd) <+ cpphdl_channel(V(cpphdl_n2153, Vdd), V(cpphdl_n2147, Vdd), 0.002, 0.69999999999999996, -1.0);
        // device 1710, IC IC269, analog/basic/strongarm_comparator.hpp:38
        I(cpphdl_n2133, Vdd) <+ cpphdl_channel(V(EVALUATE, Vdd), V(cpphdl_n2133, Vdd), 0.002, 0.69999999999999996, -1.0);
        // device 1711, IC IC269, analog/basic/strongarm_comparator.hpp:39
        I(cpphdl_n2134, Vdd) <+ cpphdl_channel(V(EVALUATE, Vdd), V(cpphdl_n2134, Vdd), 0.002, 0.69999999999999996, -1.0);
        // device 1712, IC IC269, analog/basic/strongarm_comparator.hpp:40
        I(cpphdl_n2153, Vdd) <+ cpphdl_channel(V(EVALUATE, Vdd), V(cpphdl_n2153, Vdd), 0.002, 0.69999999999999996, -1.0);
        // device 1713, IC IC269, analog/basic/strongarm_comparator.hpp:41
        I(cpphdl_n2147, Vdd) <+ cpphdl_channel(V(EVALUATE, Vdd), V(cpphdl_n2147, Vdd), 0.002, 0.69999999999999996, -1.0);
        // device 1714, IC IC269, analog/basic/strongarm_comparator.hpp:42
        I(cpphdl_n2133, Vss) <+ 2.9999999999999998e-14 * ddt(V(cpphdl_n2133, Vss)); // Bench initial voltage = 0.0 V.
        // device 1715, IC IC269, analog/basic/strongarm_comparator.hpp:43
        I(cpphdl_n2134, Vss) <+ 2.9999999999999998e-14 * ddt(V(cpphdl_n2134, Vss)); // Bench initial voltage = 0.0 V.
        // device 1716, IC IC269, analog/basic/strongarm_comparator.hpp:44
        I(cpphdl_n2135, Vss) <+ 2.9999999999999998e-14 * ddt(V(cpphdl_n2135, Vss)); // Bench initial voltage = 0.0 V.
        // device 1717, IC IC269, analog/basic/strongarm_comparator.hpp:45
        I(cpphdl_n2153, Vss) <+ 5.0000000000000002e-14 * ddt(V(cpphdl_n2153, Vss)); // Bench initial voltage = 0.0 V.
        // device 1718, IC IC269, analog/basic/strongarm_comparator.hpp:46
        I(cpphdl_n2147, Vss) <+ 5.0000000000000002e-14 * ddt(V(cpphdl_n2147, Vss)); // Bench initial voltage = 0.0 V.
        // device 1719, IC IC269, analog/basic/strongarm_comparator.hpp:47
        I(cpphdl_n2128, cpphdl_n2135) <+ 2e-14 * ddt(V(cpphdl_n2128, cpphdl_n2135)); // Bench initial voltage = 3.2999999999999998 V.
        // device 1720, IC IC269, analog/basic/strongarm_comparator.hpp:48
        I(cpphdl_n2129, cpphdl_n2135) <+ 2e-14 * ddt(V(cpphdl_n2129, cpphdl_n2135)); // Bench initial voltage = 3.2999999999999998 V.
        // device 1721, IC IC269, analog/basic/strongarm_comparator.hpp:49
        I(cpphdl_n2128, cpphdl_n2133) <+ 2.9999999999999998e-15 * ddt(V(cpphdl_n2128, cpphdl_n2133)); // Bench initial voltage = 3.2999999999999998 V.
        // device 1722, IC IC269, analog/basic/strongarm_comparator.hpp:50
        I(cpphdl_n2129, cpphdl_n2134) <+ 2.9999999999999998e-15 * ddt(V(cpphdl_n2129, cpphdl_n2134)); // Bench initial voltage = 3.2999999999999998 V.
        // device 1723, IC IC271, analog/basic/cmos_logic.hpp:15
        I(cpphdl_n2371, Vss) <+ 5.0000000000000002e-14 * ddt(V(cpphdl_n2371, Vss)); // Bench initial voltage = 0.0 V.
        // device 1724, IC IC271, analog/basic/cmos_logic.hpp:16
        I(cpphdl_n2371, Vdd) <+ cpphdl_channel(V(cpphdl_n2147, Vdd), V(cpphdl_n2371, Vdd), 0.01, 0.69999999999999996, -1.0);
        // device 1725, IC IC271, analog/basic/cmos_logic.hpp:17
        I(cpphdl_n2371, Vdd) <+ cpphdl_channel(V(cpphdl_n2155, Vdd), V(cpphdl_n2371, Vdd), 0.01, 0.69999999999999996, -1.0);
        // device 1726, IC IC271, analog/basic/cmos_logic.hpp:18
        I(cpphdl_n2371, cpphdl_n2150) <+ cpphdl_channel(V(cpphdl_n2147, cpphdl_n2150), V(cpphdl_n2371, cpphdl_n2150), 0.01, 0.69999999999999996, 1.0);
        // device 1727, IC IC271, analog/basic/cmos_logic.hpp:19
        I(cpphdl_n2150, Vss) <+ cpphdl_channel(V(cpphdl_n2155, Vss), V(cpphdl_n2150, Vss), 0.01, 0.69999999999999996, 1.0);
        // device 1728, IC IC271, analog/basic/cmos_logic.hpp:20
        I(cpphdl_n2371, Vss) <+ V(cpphdl_n2371, Vss) / 1000000000.0;
        // device 1729, IC IC271, analog/basic/cmos_logic.hpp:21
        I(cpphdl_n2150, Vss) <+ V(cpphdl_n2150, Vss) / 1000000000.0;
        // device 1730, IC IC272, analog/basic/cmos_logic.hpp:15
        I(cpphdl_n2155, Vss) <+ 5.0000000000000002e-14 * ddt(V(cpphdl_n2155, Vss)); // Bench initial voltage = 0.0 V.
        // device 1731, IC IC272, analog/basic/cmos_logic.hpp:16
        I(cpphdl_n2155, Vdd) <+ cpphdl_channel(V(cpphdl_n2153, Vdd), V(cpphdl_n2155, Vdd), 0.01, 0.69999999999999996, -1.0);
        // device 1732, IC IC272, analog/basic/cmos_logic.hpp:17
        I(cpphdl_n2155, Vdd) <+ cpphdl_channel(V(cpphdl_n2371, Vdd), V(cpphdl_n2155, Vdd), 0.01, 0.69999999999999996, -1.0);
        // device 1733, IC IC272, analog/basic/cmos_logic.hpp:18
        I(cpphdl_n2155, cpphdl_n2156) <+ cpphdl_channel(V(cpphdl_n2153, cpphdl_n2156), V(cpphdl_n2155, cpphdl_n2156), 0.01, 0.69999999999999996, 1.0);
        // device 1734, IC IC272, analog/basic/cmos_logic.hpp:19
        I(cpphdl_n2156, Vss) <+ cpphdl_channel(V(cpphdl_n2371, Vss), V(cpphdl_n2156, Vss), 0.01, 0.69999999999999996, 1.0);
        // device 1735, IC IC272, analog/basic/cmos_logic.hpp:20
        I(cpphdl_n2155, Vss) <+ V(cpphdl_n2155, Vss) / 1000000000.0;
        // device 1736, IC IC272, analog/basic/cmos_logic.hpp:21
        I(cpphdl_n2156, Vss) <+ V(cpphdl_n2156, Vss) / 1000000000.0;
        // device 1737, IC IC270, analog/basic/nand_latch.hpp:34
        I(cpphdl_n2147, Vss) <+ 2.9999999999999998e-15 * ddt(V(cpphdl_n2147, Vss)); // Bench initial voltage = 0.0 V.
        // device 1738, IC IC270, analog/basic/nand_latch.hpp:35
        I(cpphdl_n2153, Vss) <+ 2.9999999999999998e-15 * ddt(V(cpphdl_n2153, Vss)); // Bench initial voltage = 0.0 V.
        // device 1739, IC IC273, analog/basic/inverter.hpp:11
        I(cpphdl_n2161, Vdd) <+ cpphdl_channel(V(CLEAR, Vdd), V(cpphdl_n2161, Vdd), 0.01, 0.69999999999999996, -1.0);
        // device 1740, IC IC273, analog/basic/inverter.hpp:12
        I(cpphdl_n2161, Vss) <+ cpphdl_channel(V(CLEAR, Vss), V(cpphdl_n2161, Vss), 0.01, 0.69999999999999996, 1.0);
        // device 1741, IC IC270, analog/basic/nand_latch.hpp:56
        I(cpphdl_n2161, Vss) <+ 2.9999999999999998e-15 * ddt(V(cpphdl_n2161, Vss)); // Bench initial voltage = 0.0 V.
        // device 1742, IC IC270, analog/basic/nand_latch.hpp:57
        I(cpphdl_n2371, Vss) <+ cpphdl_channel(V(CLEAR, Vss), V(cpphdl_n2371, Vss), 0.050000000000000003, 0.69999999999999996, 1.0);
        // device 1743, IC IC270, analog/basic/nand_latch.hpp:58
        I(cpphdl_n2155, Vdd) <+ cpphdl_channel(V(cpphdl_n2161, Vdd), V(cpphdl_n2155, Vdd), 0.050000000000000003, 0.69999999999999996, -1.0);
        // device 1744, IC IC276, analog/basic/inverter.hpp:11
        I(cpphdl_n2185, Vdd) <+ cpphdl_channel(V(TRACK15, Vdd), V(cpphdl_n2185, Vdd), 0.0040000000000000001, 0.69999999999999996, -1.0);
        // device 1745, IC IC276, analog/basic/inverter.hpp:12
        I(cpphdl_n2185, Vss) <+ cpphdl_channel(V(TRACK15, Vss), V(cpphdl_n2185, Vss), 0.0040000000000000001, 0.69999999999999996, 1.0);
        // device 1746, IC IC275, analog/basic/mos_track_hold.hpp:30
        I(cpphdl_n2185, Vss) <+ 2e-14 * ddt(V(cpphdl_n2185, Vss)); // Bench initial voltage = 3.2999999999999998 V.
        // device 1747, IC IC275, analog/basic/mos_track_hold.hpp:31
        I(cpphdl_n2179, cpphdl_n2239) <+ cpphdl_channel(V(TRACK15, cpphdl_n2239), V(cpphdl_n2179, cpphdl_n2239), 0.080000000000000002, 0.69999999999999996, 1.0);
        // device 1748, IC IC275, analog/basic/mos_track_hold.hpp:32
        I(cpphdl_n2239, cpphdl_n2179) <+ cpphdl_channel(V(cpphdl_n2185, cpphdl_n2179), V(cpphdl_n2239, cpphdl_n2179), 0.040000000000000001, 0.69999999999999996, -1.0);
        // device 1749, IC IC275, analog/basic/mos_track_hold.hpp:36
        I(cpphdl_n2239, cpphdl_n2239) <+ cpphdl_channel(V(cpphdl_n2185, cpphdl_n2239), V(cpphdl_n2239, cpphdl_n2239), 0.040000000000000001, 0.69999999999999996, 1.0);
        // device 1750, IC IC275, analog/basic/mos_track_hold.hpp:37
        I(cpphdl_n2239, cpphdl_n2239) <+ cpphdl_channel(V(TRACK15, cpphdl_n2239), V(cpphdl_n2239, cpphdl_n2239), 0.02, 0.69999999999999996, -1.0);
        // device 1751, IC IC275, analog/basic/mos_track_hold.hpp:38
        I(cpphdl_n2239, Vss) <+ 2e-12 * ddt(V(cpphdl_n2239, Vss)); // Bench initial voltage = 1.6499999999999999 V.
        // device 1752, IC IC275, analog/basic/mos_track_hold.hpp:39
        I(Vss, cpphdl_n2239) <+ V(Vss, cpphdl_n2239) / 1000000000.0;
        // device 1753, IC IC275, analog/basic/mos_track_hold.hpp:40
        I(TRACK15, cpphdl_n2239) <+ 8.0000000000000006e-15 * ddt(V(TRACK15, cpphdl_n2239)); // Bench initial voltage = -1.6499999999999999 V.
        // device 1754, IC IC275, analog/basic/mos_track_hold.hpp:41
        I(cpphdl_n2185, cpphdl_n2239) <+ 8.0000000000000006e-15 * ddt(V(cpphdl_n2185, cpphdl_n2239)); // Bench initial voltage = 1.6499999999999999 V.
        // device 1755, IC IC275, analog/basic/mos_track_hold.hpp:42
        I(cpphdl_n2179, cpphdl_n2239) <+ 4.0000000000000003e-15 * ddt(V(cpphdl_n2179, cpphdl_n2239)); // Bench initial voltage = 0.0 V.
        // device 1756, IC IC278, analog/basic/inverter.hpp:11
        I(cpphdl_n2200, Vdd) <+ cpphdl_channel(V(BIT_N15_0, Vdd), V(cpphdl_n2200, Vdd), 0.080000000000000002, 0.69999999999999996, -1.0);
        // device 1757, IC IC278, analog/basic/inverter.hpp:12
        I(cpphdl_n2200, Vss) <+ cpphdl_channel(V(BIT_N15_0, Vss), V(cpphdl_n2200, Vss), 0.080000000000000002, 0.69999999999999996, 1.0);
        // device 1758, IC IC277, analog/basic/mos_r2r_dac.hpp:27
        I(cpphdl_n2200, Vss) <+ 2.9999999999999998e-15 * ddt(V(cpphdl_n2200, Vss)); // Bench initial voltage = 0.0 V.
        // device 1759, IC IC277, analog/basic/mos_r2r_dac.hpp:28
        I(cpphdl_n2200, cpphdl_n2229) <+ V(cpphdl_n2200, cpphdl_n2229) / 20000.0;
        // device 1760, IC IC277, analog/basic/mos_r2r_dac.hpp:29
        I(cpphdl_n2229, Vss) <+ 2.9999999999999998e-15 * ddt(V(cpphdl_n2229, Vss)); // Bench initial voltage = 0.0 V.
        // device 1761, IC IC279, analog/basic/inverter.hpp:11
        I(cpphdl_n2204, Vdd) <+ cpphdl_channel(V(BIT_N15_1, Vdd), V(cpphdl_n2204, Vdd), 0.080000000000000002, 0.69999999999999996, -1.0);
        // device 1762, IC IC279, analog/basic/inverter.hpp:12
        I(cpphdl_n2204, Vss) <+ cpphdl_channel(V(BIT_N15_1, Vss), V(cpphdl_n2204, Vss), 0.080000000000000002, 0.69999999999999996, 1.0);
        // device 1763, IC IC277, analog/basic/mos_r2r_dac.hpp:27
        I(cpphdl_n2204, Vss) <+ 2.9999999999999998e-15 * ddt(V(cpphdl_n2204, Vss)); // Bench initial voltage = 0.0 V.
        // device 1764, IC IC277, analog/basic/mos_r2r_dac.hpp:28
        I(cpphdl_n2204, cpphdl_n2230) <+ V(cpphdl_n2204, cpphdl_n2230) / 20000.0;
        // device 1765, IC IC277, analog/basic/mos_r2r_dac.hpp:29
        I(cpphdl_n2230, Vss) <+ 2.9999999999999998e-15 * ddt(V(cpphdl_n2230, Vss)); // Bench initial voltage = 0.0 V.
        // device 1766, IC IC277, analog/basic/mos_r2r_dac.hpp:31
        I(cpphdl_n2229, cpphdl_n2230) <+ V(cpphdl_n2229, cpphdl_n2230) / 10000.0;
        // device 1767, IC IC280, analog/basic/inverter.hpp:11
        I(cpphdl_n2208, Vdd) <+ cpphdl_channel(V(BIT_N15_2, Vdd), V(cpphdl_n2208, Vdd), 0.080000000000000002, 0.69999999999999996, -1.0);
        // device 1768, IC IC280, analog/basic/inverter.hpp:12
        I(cpphdl_n2208, Vss) <+ cpphdl_channel(V(BIT_N15_2, Vss), V(cpphdl_n2208, Vss), 0.080000000000000002, 0.69999999999999996, 1.0);
        // device 1769, IC IC277, analog/basic/mos_r2r_dac.hpp:27
        I(cpphdl_n2208, Vss) <+ 2.9999999999999998e-15 * ddt(V(cpphdl_n2208, Vss)); // Bench initial voltage = 0.0 V.
        // device 1770, IC IC277, analog/basic/mos_r2r_dac.hpp:28
        I(cpphdl_n2208, cpphdl_n2231) <+ V(cpphdl_n2208, cpphdl_n2231) / 20000.0;
        // device 1771, IC IC277, analog/basic/mos_r2r_dac.hpp:29
        I(cpphdl_n2231, Vss) <+ 2.9999999999999998e-15 * ddt(V(cpphdl_n2231, Vss)); // Bench initial voltage = 0.0 V.
        // device 1772, IC IC277, analog/basic/mos_r2r_dac.hpp:31
        I(cpphdl_n2230, cpphdl_n2231) <+ V(cpphdl_n2230, cpphdl_n2231) / 10000.0;
        // device 1773, IC IC281, analog/basic/inverter.hpp:11
        I(cpphdl_n2212, Vdd) <+ cpphdl_channel(V(BIT_N15_3, Vdd), V(cpphdl_n2212, Vdd), 0.080000000000000002, 0.69999999999999996, -1.0);
        // device 1774, IC IC281, analog/basic/inverter.hpp:12
        I(cpphdl_n2212, Vss) <+ cpphdl_channel(V(BIT_N15_3, Vss), V(cpphdl_n2212, Vss), 0.080000000000000002, 0.69999999999999996, 1.0);
        // device 1775, IC IC277, analog/basic/mos_r2r_dac.hpp:27
        I(cpphdl_n2212, Vss) <+ 2.9999999999999998e-15 * ddt(V(cpphdl_n2212, Vss)); // Bench initial voltage = 0.0 V.
        // device 1776, IC IC277, analog/basic/mos_r2r_dac.hpp:28
        I(cpphdl_n2212, cpphdl_n2232) <+ V(cpphdl_n2212, cpphdl_n2232) / 20000.0;
        // device 1777, IC IC277, analog/basic/mos_r2r_dac.hpp:29
        I(cpphdl_n2232, Vss) <+ 2.9999999999999998e-15 * ddt(V(cpphdl_n2232, Vss)); // Bench initial voltage = 0.0 V.
        // device 1778, IC IC277, analog/basic/mos_r2r_dac.hpp:31
        I(cpphdl_n2231, cpphdl_n2232) <+ V(cpphdl_n2231, cpphdl_n2232) / 10000.0;
        // device 1779, IC IC282, analog/basic/inverter.hpp:11
        I(cpphdl_n2216, Vdd) <+ cpphdl_channel(V(BIT_N15_4, Vdd), V(cpphdl_n2216, Vdd), 0.080000000000000002, 0.69999999999999996, -1.0);
        // device 1780, IC IC282, analog/basic/inverter.hpp:12
        I(cpphdl_n2216, Vss) <+ cpphdl_channel(V(BIT_N15_4, Vss), V(cpphdl_n2216, Vss), 0.080000000000000002, 0.69999999999999996, 1.0);
        // device 1781, IC IC277, analog/basic/mos_r2r_dac.hpp:27
        I(cpphdl_n2216, Vss) <+ 2.9999999999999998e-15 * ddt(V(cpphdl_n2216, Vss)); // Bench initial voltage = 0.0 V.
        // device 1782, IC IC277, analog/basic/mos_r2r_dac.hpp:28
        I(cpphdl_n2216, cpphdl_n2233) <+ V(cpphdl_n2216, cpphdl_n2233) / 20000.0;
        // device 1783, IC IC277, analog/basic/mos_r2r_dac.hpp:29
        I(cpphdl_n2233, Vss) <+ 2.9999999999999998e-15 * ddt(V(cpphdl_n2233, Vss)); // Bench initial voltage = 0.0 V.
        // device 1784, IC IC277, analog/basic/mos_r2r_dac.hpp:31
        I(cpphdl_n2232, cpphdl_n2233) <+ V(cpphdl_n2232, cpphdl_n2233) / 10000.0;
        // device 1785, IC IC283, analog/basic/inverter.hpp:11
        I(cpphdl_n2220, Vdd) <+ cpphdl_channel(V(BIT_N15_5, Vdd), V(cpphdl_n2220, Vdd), 0.080000000000000002, 0.69999999999999996, -1.0);
        // device 1786, IC IC283, analog/basic/inverter.hpp:12
        I(cpphdl_n2220, Vss) <+ cpphdl_channel(V(BIT_N15_5, Vss), V(cpphdl_n2220, Vss), 0.080000000000000002, 0.69999999999999996, 1.0);
        // device 1787, IC IC277, analog/basic/mos_r2r_dac.hpp:27
        I(cpphdl_n2220, Vss) <+ 2.9999999999999998e-15 * ddt(V(cpphdl_n2220, Vss)); // Bench initial voltage = 0.0 V.
        // device 1788, IC IC277, analog/basic/mos_r2r_dac.hpp:28
        I(cpphdl_n2220, cpphdl_n2234) <+ V(cpphdl_n2220, cpphdl_n2234) / 20000.0;
        // device 1789, IC IC277, analog/basic/mos_r2r_dac.hpp:29
        I(cpphdl_n2234, Vss) <+ 2.9999999999999998e-15 * ddt(V(cpphdl_n2234, Vss)); // Bench initial voltage = 0.0 V.
        // device 1790, IC IC277, analog/basic/mos_r2r_dac.hpp:31
        I(cpphdl_n2233, cpphdl_n2234) <+ V(cpphdl_n2233, cpphdl_n2234) / 10000.0;
        // device 1791, IC IC284, analog/basic/inverter.hpp:11
        I(cpphdl_n2224, Vdd) <+ cpphdl_channel(V(BIT_N15_6, Vdd), V(cpphdl_n2224, Vdd), 0.080000000000000002, 0.69999999999999996, -1.0);
        // device 1792, IC IC284, analog/basic/inverter.hpp:12
        I(cpphdl_n2224, Vss) <+ cpphdl_channel(V(BIT_N15_6, Vss), V(cpphdl_n2224, Vss), 0.080000000000000002, 0.69999999999999996, 1.0);
        // device 1793, IC IC277, analog/basic/mos_r2r_dac.hpp:27
        I(cpphdl_n2224, Vss) <+ 2.9999999999999998e-15 * ddt(V(cpphdl_n2224, Vss)); // Bench initial voltage = 0.0 V.
        // device 1794, IC IC277, analog/basic/mos_r2r_dac.hpp:28
        I(cpphdl_n2224, cpphdl_n2235) <+ V(cpphdl_n2224, cpphdl_n2235) / 20000.0;
        // device 1795, IC IC277, analog/basic/mos_r2r_dac.hpp:29
        I(cpphdl_n2235, Vss) <+ 2.9999999999999998e-15 * ddt(V(cpphdl_n2235, Vss)); // Bench initial voltage = 0.0 V.
        // device 1796, IC IC277, analog/basic/mos_r2r_dac.hpp:31
        I(cpphdl_n2234, cpphdl_n2235) <+ V(cpphdl_n2234, cpphdl_n2235) / 10000.0;
        // device 1797, IC IC285, analog/basic/inverter.hpp:11
        I(cpphdl_n2228, Vdd) <+ cpphdl_channel(V(BIT_N15_7, Vdd), V(cpphdl_n2228, Vdd), 0.080000000000000002, 0.69999999999999996, -1.0);
        // device 1798, IC IC285, analog/basic/inverter.hpp:12
        I(cpphdl_n2228, Vss) <+ cpphdl_channel(V(BIT_N15_7, Vss), V(cpphdl_n2228, Vss), 0.080000000000000002, 0.69999999999999996, 1.0);
        // device 1799, IC IC277, analog/basic/mos_r2r_dac.hpp:27
        I(cpphdl_n2228, Vss) <+ 2.9999999999999998e-15 * ddt(V(cpphdl_n2228, Vss)); // Bench initial voltage = 0.0 V.
        // device 1800, IC IC277, analog/basic/mos_r2r_dac.hpp:28
        I(cpphdl_n2228, cpphdl_n2240) <+ V(cpphdl_n2228, cpphdl_n2240) / 20000.0;
        // device 1801, IC IC277, analog/basic/mos_r2r_dac.hpp:29
        I(cpphdl_n2240, Vss) <+ 2.9999999999999998e-15 * ddt(V(cpphdl_n2240, Vss)); // Bench initial voltage = 0.0 V.
        // device 1802, IC IC277, analog/basic/mos_r2r_dac.hpp:31
        I(cpphdl_n2235, cpphdl_n2240) <+ V(cpphdl_n2235, cpphdl_n2240) / 10000.0;
        // device 1803, IC IC277, analog/basic/mos_r2r_dac.hpp:33
        I(Vss, cpphdl_n2229) <+ V(Vss, cpphdl_n2229) / 20000.0;
        // device 1804, IC IC286, analog/basic/nmos_resistor_amplifier.hpp:23
        I(Vdd, cpphdl_n2249) <+ V(Vdd, cpphdl_n2249) / 1000.0;
        // device 1805, IC IC286, analog/basic/nmos_resistor_amplifier.hpp:24
        I(Vdd, cpphdl_n2248) <+ V(Vdd, cpphdl_n2248) / 1000.0;
        // device 1806, IC IC286, analog/basic/nmos_resistor_amplifier.hpp:25
        I(cpphdl_n2249, cpphdl_n2243) <+ cpphdl_channel(V(cpphdl_n2239, cpphdl_n2243), V(cpphdl_n2249, cpphdl_n2243), 0.014999999999999999, 0.69999999999999996, 1.0);
        // device 1807, IC IC286, analog/basic/nmos_resistor_amplifier.hpp:26
        I(cpphdl_n2248, cpphdl_n2244) <+ cpphdl_channel(V(cpphdl_n2240, cpphdl_n2244), V(cpphdl_n2248, cpphdl_n2244), 0.014999999999999999, 0.69999999999999996, 1.0);
        // device 1808, IC IC286, analog/basic/nmos_resistor_amplifier.hpp:27
        I(cpphdl_n2245, cpphdl_n2243) <+ V(cpphdl_n2245, cpphdl_n2243) / 50.0;
        // device 1809, IC IC286, analog/basic/nmos_resistor_amplifier.hpp:28
        I(cpphdl_n2245, cpphdl_n2244) <+ V(cpphdl_n2245, cpphdl_n2244) / 50.0;
        // device 1810, IC IC286, analog/basic/nmos_resistor_amplifier.hpp:29
        I(Vss, cpphdl_n2245) <+ V(Vss, cpphdl_n2245) / 150.0;
        // device 1811, IC IC286, analog/basic/nmos_resistor_amplifier.hpp:30
        I(cpphdl_n2249, Vdd) <+ 2.9999999999999998e-13 * ddt(V(cpphdl_n2249, Vdd)); // Bench initial voltage = 0.0 V.
        // device 1812, IC IC286, analog/basic/nmos_resistor_amplifier.hpp:31
        I(cpphdl_n2248, Vdd) <+ 2.9999999999999998e-13 * ddt(V(cpphdl_n2248, Vdd)); // Bench initial voltage = 0.0 V.
        // device 1813, IC IC286, analog/basic/nmos_resistor_amplifier.hpp:32
        I(cpphdl_n2245, Vss) <+ 4e-14 * ddt(V(cpphdl_n2245, Vss)); // Bench initial voltage = 0.0 V.
        // device 1814, IC IC286, analog/basic/nmos_resistor_amplifier.hpp:34
        I(cpphdl_n2239, cpphdl_n2243) <+ 2e-14 * ddt(V(cpphdl_n2239, cpphdl_n2243)); // Bench initial voltage = 1.6499999999999999 V.
        // device 1815, IC IC286, analog/basic/nmos_resistor_amplifier.hpp:35
        I(cpphdl_n2240, cpphdl_n2244) <+ 2e-14 * ddt(V(cpphdl_n2240, cpphdl_n2244)); // Bench initial voltage = 0.0 V.
        // device 1816, IC IC286, analog/basic/nmos_resistor_amplifier.hpp:36
        I(cpphdl_n2239, cpphdl_n2249) <+ 2.9999999999999998e-15 * ddt(V(cpphdl_n2239, cpphdl_n2249)); // Bench initial voltage = -1.6499999999999999 V.
        // device 1817, IC IC286, analog/basic/nmos_resistor_amplifier.hpp:37
        I(cpphdl_n2240, cpphdl_n2248) <+ 2.9999999999999998e-15 * ddt(V(cpphdl_n2240, cpphdl_n2248)); // Bench initial voltage = -3.2999999999999998 V.
        // device 1818, IC IC287, analog/basic/strongarm_comparator.hpp:28
        I(cpphdl_n2253, cpphdl_n2255) <+ cpphdl_channel(V(cpphdl_n2248, cpphdl_n2255), V(cpphdl_n2253, cpphdl_n2255), 0.0080000000000000002, 0.69999999999999996, 1.0);
        // device 1819, IC IC287, analog/basic/strongarm_comparator.hpp:29
        I(cpphdl_n2254, cpphdl_n2255) <+ cpphdl_channel(V(cpphdl_n2249, cpphdl_n2255), V(cpphdl_n2254, cpphdl_n2255), 0.0080000000000000002, 0.69999999999999996, 1.0);
        // device 1820, IC IC287, analog/basic/strongarm_comparator.hpp:30
        I(cpphdl_n2255, Vss) <+ cpphdl_channel(V(EVALUATE, Vss), V(cpphdl_n2255, Vss), 0.0080000000000000002, 0.69999999999999996, 1.0);
        // device 1821, IC IC287, analog/basic/strongarm_comparator.hpp:33
        I(cpphdl_n2267, cpphdl_n2253) <+ cpphdl_channel(V(cpphdl_n2273, cpphdl_n2253), V(cpphdl_n2267, cpphdl_n2253), 0.0040000000000000001, 0.69999999999999996, 1.0);
        // device 1822, IC IC287, analog/basic/strongarm_comparator.hpp:34
        I(cpphdl_n2273, cpphdl_n2254) <+ cpphdl_channel(V(cpphdl_n2267, cpphdl_n2254), V(cpphdl_n2273, cpphdl_n2254), 0.0040000000000000001, 0.69999999999999996, 1.0);
        // device 1823, IC IC287, analog/basic/strongarm_comparator.hpp:35
        I(cpphdl_n2273, Vdd) <+ cpphdl_channel(V(cpphdl_n2267, Vdd), V(cpphdl_n2273, Vdd), 0.002, 0.69999999999999996, -1.0);
        // device 1824, IC IC287, analog/basic/strongarm_comparator.hpp:36
        I(cpphdl_n2267, Vdd) <+ cpphdl_channel(V(cpphdl_n2273, Vdd), V(cpphdl_n2267, Vdd), 0.002, 0.69999999999999996, -1.0);
        // device 1825, IC IC287, analog/basic/strongarm_comparator.hpp:38
        I(cpphdl_n2253, Vdd) <+ cpphdl_channel(V(EVALUATE, Vdd), V(cpphdl_n2253, Vdd), 0.002, 0.69999999999999996, -1.0);
        // device 1826, IC IC287, analog/basic/strongarm_comparator.hpp:39
        I(cpphdl_n2254, Vdd) <+ cpphdl_channel(V(EVALUATE, Vdd), V(cpphdl_n2254, Vdd), 0.002, 0.69999999999999996, -1.0);
        // device 1827, IC IC287, analog/basic/strongarm_comparator.hpp:40
        I(cpphdl_n2273, Vdd) <+ cpphdl_channel(V(EVALUATE, Vdd), V(cpphdl_n2273, Vdd), 0.002, 0.69999999999999996, -1.0);
        // device 1828, IC IC287, analog/basic/strongarm_comparator.hpp:41
        I(cpphdl_n2267, Vdd) <+ cpphdl_channel(V(EVALUATE, Vdd), V(cpphdl_n2267, Vdd), 0.002, 0.69999999999999996, -1.0);
        // device 1829, IC IC287, analog/basic/strongarm_comparator.hpp:42
        I(cpphdl_n2253, Vss) <+ 2.9999999999999998e-14 * ddt(V(cpphdl_n2253, Vss)); // Bench initial voltage = 0.0 V.
        // device 1830, IC IC287, analog/basic/strongarm_comparator.hpp:43
        I(cpphdl_n2254, Vss) <+ 2.9999999999999998e-14 * ddt(V(cpphdl_n2254, Vss)); // Bench initial voltage = 0.0 V.
        // device 1831, IC IC287, analog/basic/strongarm_comparator.hpp:44
        I(cpphdl_n2255, Vss) <+ 2.9999999999999998e-14 * ddt(V(cpphdl_n2255, Vss)); // Bench initial voltage = 0.0 V.
        // device 1832, IC IC287, analog/basic/strongarm_comparator.hpp:45
        I(cpphdl_n2273, Vss) <+ 5.0000000000000002e-14 * ddt(V(cpphdl_n2273, Vss)); // Bench initial voltage = 0.0 V.
        // device 1833, IC IC287, analog/basic/strongarm_comparator.hpp:46
        I(cpphdl_n2267, Vss) <+ 5.0000000000000002e-14 * ddt(V(cpphdl_n2267, Vss)); // Bench initial voltage = 0.0 V.
        // device 1834, IC IC287, analog/basic/strongarm_comparator.hpp:47
        I(cpphdl_n2248, cpphdl_n2255) <+ 2e-14 * ddt(V(cpphdl_n2248, cpphdl_n2255)); // Bench initial voltage = 3.2999999999999998 V.
        // device 1835, IC IC287, analog/basic/strongarm_comparator.hpp:48
        I(cpphdl_n2249, cpphdl_n2255) <+ 2e-14 * ddt(V(cpphdl_n2249, cpphdl_n2255)); // Bench initial voltage = 3.2999999999999998 V.
        // device 1836, IC IC287, analog/basic/strongarm_comparator.hpp:49
        I(cpphdl_n2248, cpphdl_n2253) <+ 2.9999999999999998e-15 * ddt(V(cpphdl_n2248, cpphdl_n2253)); // Bench initial voltage = 3.2999999999999998 V.
        // device 1837, IC IC287, analog/basic/strongarm_comparator.hpp:50
        I(cpphdl_n2249, cpphdl_n2254) <+ 2.9999999999999998e-15 * ddt(V(cpphdl_n2249, cpphdl_n2254)); // Bench initial voltage = 3.2999999999999998 V.
        // device 1838, IC IC289, analog/basic/cmos_logic.hpp:15
        I(cpphdl_n2376, Vss) <+ 5.0000000000000002e-14 * ddt(V(cpphdl_n2376, Vss)); // Bench initial voltage = 0.0 V.
        // device 1839, IC IC289, analog/basic/cmos_logic.hpp:16
        I(cpphdl_n2376, Vdd) <+ cpphdl_channel(V(cpphdl_n2267, Vdd), V(cpphdl_n2376, Vdd), 0.01, 0.69999999999999996, -1.0);
        // device 1840, IC IC289, analog/basic/cmos_logic.hpp:17
        I(cpphdl_n2376, Vdd) <+ cpphdl_channel(V(cpphdl_n2275, Vdd), V(cpphdl_n2376, Vdd), 0.01, 0.69999999999999996, -1.0);
        // device 1841, IC IC289, analog/basic/cmos_logic.hpp:18
        I(cpphdl_n2376, cpphdl_n2270) <+ cpphdl_channel(V(cpphdl_n2267, cpphdl_n2270), V(cpphdl_n2376, cpphdl_n2270), 0.01, 0.69999999999999996, 1.0);
        // device 1842, IC IC289, analog/basic/cmos_logic.hpp:19
        I(cpphdl_n2270, Vss) <+ cpphdl_channel(V(cpphdl_n2275, Vss), V(cpphdl_n2270, Vss), 0.01, 0.69999999999999996, 1.0);
        // device 1843, IC IC289, analog/basic/cmos_logic.hpp:20
        I(cpphdl_n2376, Vss) <+ V(cpphdl_n2376, Vss) / 1000000000.0;
        // device 1844, IC IC289, analog/basic/cmos_logic.hpp:21
        I(cpphdl_n2270, Vss) <+ V(cpphdl_n2270, Vss) / 1000000000.0;
        // device 1845, IC IC290, analog/basic/cmos_logic.hpp:15
        I(cpphdl_n2275, Vss) <+ 5.0000000000000002e-14 * ddt(V(cpphdl_n2275, Vss)); // Bench initial voltage = 0.0 V.
        // device 1846, IC IC290, analog/basic/cmos_logic.hpp:16
        I(cpphdl_n2275, Vdd) <+ cpphdl_channel(V(cpphdl_n2273, Vdd), V(cpphdl_n2275, Vdd), 0.01, 0.69999999999999996, -1.0);
        // device 1847, IC IC290, analog/basic/cmos_logic.hpp:17
        I(cpphdl_n2275, Vdd) <+ cpphdl_channel(V(cpphdl_n2376, Vdd), V(cpphdl_n2275, Vdd), 0.01, 0.69999999999999996, -1.0);
        // device 1848, IC IC290, analog/basic/cmos_logic.hpp:18
        I(cpphdl_n2275, cpphdl_n2276) <+ cpphdl_channel(V(cpphdl_n2273, cpphdl_n2276), V(cpphdl_n2275, cpphdl_n2276), 0.01, 0.69999999999999996, 1.0);
        // device 1849, IC IC290, analog/basic/cmos_logic.hpp:19
        I(cpphdl_n2276, Vss) <+ cpphdl_channel(V(cpphdl_n2376, Vss), V(cpphdl_n2276, Vss), 0.01, 0.69999999999999996, 1.0);
        // device 1850, IC IC290, analog/basic/cmos_logic.hpp:20
        I(cpphdl_n2275, Vss) <+ V(cpphdl_n2275, Vss) / 1000000000.0;
        // device 1851, IC IC290, analog/basic/cmos_logic.hpp:21
        I(cpphdl_n2276, Vss) <+ V(cpphdl_n2276, Vss) / 1000000000.0;
        // device 1852, IC IC288, analog/basic/nand_latch.hpp:34
        I(cpphdl_n2267, Vss) <+ 2.9999999999999998e-15 * ddt(V(cpphdl_n2267, Vss)); // Bench initial voltage = 0.0 V.
        // device 1853, IC IC288, analog/basic/nand_latch.hpp:35
        I(cpphdl_n2273, Vss) <+ 2.9999999999999998e-15 * ddt(V(cpphdl_n2273, Vss)); // Bench initial voltage = 0.0 V.
        // device 1854, IC IC291, analog/basic/inverter.hpp:11
        I(cpphdl_n2281, Vdd) <+ cpphdl_channel(V(CLEAR, Vdd), V(cpphdl_n2281, Vdd), 0.01, 0.69999999999999996, -1.0);
        // device 1855, IC IC291, analog/basic/inverter.hpp:12
        I(cpphdl_n2281, Vss) <+ cpphdl_channel(V(CLEAR, Vss), V(cpphdl_n2281, Vss), 0.01, 0.69999999999999996, 1.0);
        // device 1856, IC IC288, analog/basic/nand_latch.hpp:56
        I(cpphdl_n2281, Vss) <+ 2.9999999999999998e-15 * ddt(V(cpphdl_n2281, Vss)); // Bench initial voltage = 0.0 V.
        // device 1857, IC IC288, analog/basic/nand_latch.hpp:57
        I(cpphdl_n2376, Vss) <+ cpphdl_channel(V(CLEAR, Vss), V(cpphdl_n2376, Vss), 0.050000000000000003, 0.69999999999999996, 1.0);
        // device 1858, IC IC288, analog/basic/nand_latch.hpp:58
        I(cpphdl_n2275, Vdd) <+ cpphdl_channel(V(cpphdl_n2281, Vdd), V(cpphdl_n2275, Vdd), 0.050000000000000003, 0.69999999999999996, -1.0);
        // device 1859, IC IC292, analog/basic/level_down.hpp:23
        I(cpphdl_n2303, Vlogic) <+ cpphdl_channel(V(Vss, Vlogic), V(cpphdl_n2303, Vlogic), 0.00050000000000000001, 0.34999999999999998, -1.0);
        // device 1860, IC IC292, analog/basic/level_down.hpp:24
        I(cpphdl_n2303, Vss) <+ cpphdl_channel(V(cpphdl_n2301, Vss), V(cpphdl_n2303, Vss), 0.0040000000000000001, 0.69999999999999996, 1.0);
        // device 1861, IC IC292, analog/basic/level_down.hpp:25
        I(CORE_DECISION0, Vlogic) <+ cpphdl_channel(V(cpphdl_n2303, Vlogic), V(CORE_DECISION0, Vlogic), 0.0050000000000000001, 0.34999999999999998, -1.0);
        // device 1862, IC IC292, analog/basic/level_down.hpp:26
        I(CORE_DECISION0, Vss) <+ cpphdl_channel(V(cpphdl_n2303, Vss), V(CORE_DECISION0, Vss), 0.01, 0.34999999999999998, 1.0);
        // device 1863, IC IC292, analog/basic/level_down.hpp:27
        I(cpphdl_n2301, Vss) <+ 5e-15 * ddt(V(cpphdl_n2301, Vss)); // Bench initial voltage = 0.0 V.
        // device 1864, IC IC292, analog/basic/level_down.hpp:28
        I(cpphdl_n2301, Vlogic) <+ 5e-15 * ddt(V(cpphdl_n2301, Vlogic)); // Bench initial voltage = 0.0 V.
        // device 1865, IC IC292, analog/basic/level_down.hpp:29
        I(cpphdl_n2301, cpphdl_n2303) <+ 2.0000000000000002e-15 * ddt(V(cpphdl_n2301, cpphdl_n2303)); // Bench initial voltage = 0.0 V.
        // device 1866, IC IC292, analog/basic/level_down.hpp:30
        I(cpphdl_n2303, Vss) <+ 8e-14 * ddt(V(cpphdl_n2303, Vss)); // Bench initial voltage = 0.0 V.
        // device 1867, IC IC292, analog/basic/level_down.hpp:31
        I(cpphdl_n2303, Vlogic) <+ 5e-15 * ddt(V(cpphdl_n2303, Vlogic)); // Bench initial voltage = 0.0 V.
        // device 1868, IC IC292, analog/basic/level_down.hpp:32
        I(cpphdl_n2303, CORE_DECISION0) <+ 2.0000000000000002e-15 * ddt(V(cpphdl_n2303, CORE_DECISION0)); // Bench initial voltage = 0.0 V.
        // device 1869, IC IC292, analog/basic/level_down.hpp:33
        I(CORE_DECISION0, Vss) <+ 1e-14 * ddt(V(CORE_DECISION0, Vss)); // Bench initial voltage = 0.0 V.
        // device 1870, IC IC293, analog/basic/level_down.hpp:23
        I(cpphdl_n2308, Vlogic) <+ cpphdl_channel(V(Vss, Vlogic), V(cpphdl_n2308, Vlogic), 0.00050000000000000001, 0.34999999999999998, -1.0);
        // device 1871, IC IC293, analog/basic/level_down.hpp:24
        I(cpphdl_n2308, Vss) <+ cpphdl_channel(V(cpphdl_n2306, Vss), V(cpphdl_n2308, Vss), 0.0040000000000000001, 0.69999999999999996, 1.0);
        // device 1872, IC IC293, analog/basic/level_down.hpp:25
        I(CORE_DECISION1, Vlogic) <+ cpphdl_channel(V(cpphdl_n2308, Vlogic), V(CORE_DECISION1, Vlogic), 0.0050000000000000001, 0.34999999999999998, -1.0);
        // device 1873, IC IC293, analog/basic/level_down.hpp:26
        I(CORE_DECISION1, Vss) <+ cpphdl_channel(V(cpphdl_n2308, Vss), V(CORE_DECISION1, Vss), 0.01, 0.34999999999999998, 1.0);
        // device 1874, IC IC293, analog/basic/level_down.hpp:27
        I(cpphdl_n2306, Vss) <+ 5e-15 * ddt(V(cpphdl_n2306, Vss)); // Bench initial voltage = 0.0 V.
        // device 1875, IC IC293, analog/basic/level_down.hpp:28
        I(cpphdl_n2306, Vlogic) <+ 5e-15 * ddt(V(cpphdl_n2306, Vlogic)); // Bench initial voltage = 0.0 V.
        // device 1876, IC IC293, analog/basic/level_down.hpp:29
        I(cpphdl_n2306, cpphdl_n2308) <+ 2.0000000000000002e-15 * ddt(V(cpphdl_n2306, cpphdl_n2308)); // Bench initial voltage = 0.0 V.
        // device 1877, IC IC293, analog/basic/level_down.hpp:30
        I(cpphdl_n2308, Vss) <+ 8e-14 * ddt(V(cpphdl_n2308, Vss)); // Bench initial voltage = 0.0 V.
        // device 1878, IC IC293, analog/basic/level_down.hpp:31
        I(cpphdl_n2308, Vlogic) <+ 5e-15 * ddt(V(cpphdl_n2308, Vlogic)); // Bench initial voltage = 0.0 V.
        // device 1879, IC IC293, analog/basic/level_down.hpp:32
        I(cpphdl_n2308, CORE_DECISION1) <+ 2.0000000000000002e-15 * ddt(V(cpphdl_n2308, CORE_DECISION1)); // Bench initial voltage = 0.0 V.
        // device 1880, IC IC293, analog/basic/level_down.hpp:33
        I(CORE_DECISION1, Vss) <+ 1e-14 * ddt(V(CORE_DECISION1, Vss)); // Bench initial voltage = 0.0 V.
        // device 1881, IC IC294, analog/basic/level_down.hpp:23
        I(cpphdl_n2313, Vlogic) <+ cpphdl_channel(V(Vss, Vlogic), V(cpphdl_n2313, Vlogic), 0.00050000000000000001, 0.34999999999999998, -1.0);
        // device 1882, IC IC294, analog/basic/level_down.hpp:24
        I(cpphdl_n2313, Vss) <+ cpphdl_channel(V(cpphdl_n2311, Vss), V(cpphdl_n2313, Vss), 0.0040000000000000001, 0.69999999999999996, 1.0);
        // device 1883, IC IC294, analog/basic/level_down.hpp:25
        I(CORE_DECISION2, Vlogic) <+ cpphdl_channel(V(cpphdl_n2313, Vlogic), V(CORE_DECISION2, Vlogic), 0.0050000000000000001, 0.34999999999999998, -1.0);
        // device 1884, IC IC294, analog/basic/level_down.hpp:26
        I(CORE_DECISION2, Vss) <+ cpphdl_channel(V(cpphdl_n2313, Vss), V(CORE_DECISION2, Vss), 0.01, 0.34999999999999998, 1.0);
        // device 1885, IC IC294, analog/basic/level_down.hpp:27
        I(cpphdl_n2311, Vss) <+ 5e-15 * ddt(V(cpphdl_n2311, Vss)); // Bench initial voltage = 0.0 V.
        // device 1886, IC IC294, analog/basic/level_down.hpp:28
        I(cpphdl_n2311, Vlogic) <+ 5e-15 * ddt(V(cpphdl_n2311, Vlogic)); // Bench initial voltage = 0.0 V.
        // device 1887, IC IC294, analog/basic/level_down.hpp:29
        I(cpphdl_n2311, cpphdl_n2313) <+ 2.0000000000000002e-15 * ddt(V(cpphdl_n2311, cpphdl_n2313)); // Bench initial voltage = 0.0 V.
        // device 1888, IC IC294, analog/basic/level_down.hpp:30
        I(cpphdl_n2313, Vss) <+ 8e-14 * ddt(V(cpphdl_n2313, Vss)); // Bench initial voltage = 0.0 V.
        // device 1889, IC IC294, analog/basic/level_down.hpp:31
        I(cpphdl_n2313, Vlogic) <+ 5e-15 * ddt(V(cpphdl_n2313, Vlogic)); // Bench initial voltage = 0.0 V.
        // device 1890, IC IC294, analog/basic/level_down.hpp:32
        I(cpphdl_n2313, CORE_DECISION2) <+ 2.0000000000000002e-15 * ddt(V(cpphdl_n2313, CORE_DECISION2)); // Bench initial voltage = 0.0 V.
        // device 1891, IC IC294, analog/basic/level_down.hpp:33
        I(CORE_DECISION2, Vss) <+ 1e-14 * ddt(V(CORE_DECISION2, Vss)); // Bench initial voltage = 0.0 V.
        // device 1892, IC IC295, analog/basic/level_down.hpp:23
        I(cpphdl_n2318, Vlogic) <+ cpphdl_channel(V(Vss, Vlogic), V(cpphdl_n2318, Vlogic), 0.00050000000000000001, 0.34999999999999998, -1.0);
        // device 1893, IC IC295, analog/basic/level_down.hpp:24
        I(cpphdl_n2318, Vss) <+ cpphdl_channel(V(cpphdl_n2316, Vss), V(cpphdl_n2318, Vss), 0.0040000000000000001, 0.69999999999999996, 1.0);
        // device 1894, IC IC295, analog/basic/level_down.hpp:25
        I(CORE_DECISION3, Vlogic) <+ cpphdl_channel(V(cpphdl_n2318, Vlogic), V(CORE_DECISION3, Vlogic), 0.0050000000000000001, 0.34999999999999998, -1.0);
        // device 1895, IC IC295, analog/basic/level_down.hpp:26
        I(CORE_DECISION3, Vss) <+ cpphdl_channel(V(cpphdl_n2318, Vss), V(CORE_DECISION3, Vss), 0.01, 0.34999999999999998, 1.0);
        // device 1896, IC IC295, analog/basic/level_down.hpp:27
        I(cpphdl_n2316, Vss) <+ 5e-15 * ddt(V(cpphdl_n2316, Vss)); // Bench initial voltage = 0.0 V.
        // device 1897, IC IC295, analog/basic/level_down.hpp:28
        I(cpphdl_n2316, Vlogic) <+ 5e-15 * ddt(V(cpphdl_n2316, Vlogic)); // Bench initial voltage = 0.0 V.
        // device 1898, IC IC295, analog/basic/level_down.hpp:29
        I(cpphdl_n2316, cpphdl_n2318) <+ 2.0000000000000002e-15 * ddt(V(cpphdl_n2316, cpphdl_n2318)); // Bench initial voltage = 0.0 V.
        // device 1899, IC IC295, analog/basic/level_down.hpp:30
        I(cpphdl_n2318, Vss) <+ 8e-14 * ddt(V(cpphdl_n2318, Vss)); // Bench initial voltage = 0.0 V.
        // device 1900, IC IC295, analog/basic/level_down.hpp:31
        I(cpphdl_n2318, Vlogic) <+ 5e-15 * ddt(V(cpphdl_n2318, Vlogic)); // Bench initial voltage = 0.0 V.
        // device 1901, IC IC295, analog/basic/level_down.hpp:32
        I(cpphdl_n2318, CORE_DECISION3) <+ 2.0000000000000002e-15 * ddt(V(cpphdl_n2318, CORE_DECISION3)); // Bench initial voltage = 0.0 V.
        // device 1902, IC IC295, analog/basic/level_down.hpp:33
        I(CORE_DECISION3, Vss) <+ 1e-14 * ddt(V(CORE_DECISION3, Vss)); // Bench initial voltage = 0.0 V.
        // device 1903, IC IC296, analog/basic/level_down.hpp:23
        I(cpphdl_n2323, Vlogic) <+ cpphdl_channel(V(Vss, Vlogic), V(cpphdl_n2323, Vlogic), 0.00050000000000000001, 0.34999999999999998, -1.0);
        // device 1904, IC IC296, analog/basic/level_down.hpp:24
        I(cpphdl_n2323, Vss) <+ cpphdl_channel(V(cpphdl_n2321, Vss), V(cpphdl_n2323, Vss), 0.0040000000000000001, 0.69999999999999996, 1.0);
        // device 1905, IC IC296, analog/basic/level_down.hpp:25
        I(CORE_DECISION4, Vlogic) <+ cpphdl_channel(V(cpphdl_n2323, Vlogic), V(CORE_DECISION4, Vlogic), 0.0050000000000000001, 0.34999999999999998, -1.0);
        // device 1906, IC IC296, analog/basic/level_down.hpp:26
        I(CORE_DECISION4, Vss) <+ cpphdl_channel(V(cpphdl_n2323, Vss), V(CORE_DECISION4, Vss), 0.01, 0.34999999999999998, 1.0);
        // device 1907, IC IC296, analog/basic/level_down.hpp:27
        I(cpphdl_n2321, Vss) <+ 5e-15 * ddt(V(cpphdl_n2321, Vss)); // Bench initial voltage = 0.0 V.
        // device 1908, IC IC296, analog/basic/level_down.hpp:28
        I(cpphdl_n2321, Vlogic) <+ 5e-15 * ddt(V(cpphdl_n2321, Vlogic)); // Bench initial voltage = 0.0 V.
        // device 1909, IC IC296, analog/basic/level_down.hpp:29
        I(cpphdl_n2321, cpphdl_n2323) <+ 2.0000000000000002e-15 * ddt(V(cpphdl_n2321, cpphdl_n2323)); // Bench initial voltage = 0.0 V.
        // device 1910, IC IC296, analog/basic/level_down.hpp:30
        I(cpphdl_n2323, Vss) <+ 8e-14 * ddt(V(cpphdl_n2323, Vss)); // Bench initial voltage = 0.0 V.
        // device 1911, IC IC296, analog/basic/level_down.hpp:31
        I(cpphdl_n2323, Vlogic) <+ 5e-15 * ddt(V(cpphdl_n2323, Vlogic)); // Bench initial voltage = 0.0 V.
        // device 1912, IC IC296, analog/basic/level_down.hpp:32
        I(cpphdl_n2323, CORE_DECISION4) <+ 2.0000000000000002e-15 * ddt(V(cpphdl_n2323, CORE_DECISION4)); // Bench initial voltage = 0.0 V.
        // device 1913, IC IC296, analog/basic/level_down.hpp:33
        I(CORE_DECISION4, Vss) <+ 1e-14 * ddt(V(CORE_DECISION4, Vss)); // Bench initial voltage = 0.0 V.
        // device 1914, IC IC297, analog/basic/level_down.hpp:23
        I(cpphdl_n2328, Vlogic) <+ cpphdl_channel(V(Vss, Vlogic), V(cpphdl_n2328, Vlogic), 0.00050000000000000001, 0.34999999999999998, -1.0);
        // device 1915, IC IC297, analog/basic/level_down.hpp:24
        I(cpphdl_n2328, Vss) <+ cpphdl_channel(V(cpphdl_n2326, Vss), V(cpphdl_n2328, Vss), 0.0040000000000000001, 0.69999999999999996, 1.0);
        // device 1916, IC IC297, analog/basic/level_down.hpp:25
        I(CORE_DECISION5, Vlogic) <+ cpphdl_channel(V(cpphdl_n2328, Vlogic), V(CORE_DECISION5, Vlogic), 0.0050000000000000001, 0.34999999999999998, -1.0);
        // device 1917, IC IC297, analog/basic/level_down.hpp:26
        I(CORE_DECISION5, Vss) <+ cpphdl_channel(V(cpphdl_n2328, Vss), V(CORE_DECISION5, Vss), 0.01, 0.34999999999999998, 1.0);
        // device 1918, IC IC297, analog/basic/level_down.hpp:27
        I(cpphdl_n2326, Vss) <+ 5e-15 * ddt(V(cpphdl_n2326, Vss)); // Bench initial voltage = 0.0 V.
        // device 1919, IC IC297, analog/basic/level_down.hpp:28
        I(cpphdl_n2326, Vlogic) <+ 5e-15 * ddt(V(cpphdl_n2326, Vlogic)); // Bench initial voltage = 0.0 V.
        // device 1920, IC IC297, analog/basic/level_down.hpp:29
        I(cpphdl_n2326, cpphdl_n2328) <+ 2.0000000000000002e-15 * ddt(V(cpphdl_n2326, cpphdl_n2328)); // Bench initial voltage = 0.0 V.
        // device 1921, IC IC297, analog/basic/level_down.hpp:30
        I(cpphdl_n2328, Vss) <+ 8e-14 * ddt(V(cpphdl_n2328, Vss)); // Bench initial voltage = 0.0 V.
        // device 1922, IC IC297, analog/basic/level_down.hpp:31
        I(cpphdl_n2328, Vlogic) <+ 5e-15 * ddt(V(cpphdl_n2328, Vlogic)); // Bench initial voltage = 0.0 V.
        // device 1923, IC IC297, analog/basic/level_down.hpp:32
        I(cpphdl_n2328, CORE_DECISION5) <+ 2.0000000000000002e-15 * ddt(V(cpphdl_n2328, CORE_DECISION5)); // Bench initial voltage = 0.0 V.
        // device 1924, IC IC297, analog/basic/level_down.hpp:33
        I(CORE_DECISION5, Vss) <+ 1e-14 * ddt(V(CORE_DECISION5, Vss)); // Bench initial voltage = 0.0 V.
        // device 1925, IC IC298, analog/basic/level_down.hpp:23
        I(cpphdl_n2333, Vlogic) <+ cpphdl_channel(V(Vss, Vlogic), V(cpphdl_n2333, Vlogic), 0.00050000000000000001, 0.34999999999999998, -1.0);
        // device 1926, IC IC298, analog/basic/level_down.hpp:24
        I(cpphdl_n2333, Vss) <+ cpphdl_channel(V(cpphdl_n2331, Vss), V(cpphdl_n2333, Vss), 0.0040000000000000001, 0.69999999999999996, 1.0);
        // device 1927, IC IC298, analog/basic/level_down.hpp:25
        I(CORE_DECISION6, Vlogic) <+ cpphdl_channel(V(cpphdl_n2333, Vlogic), V(CORE_DECISION6, Vlogic), 0.0050000000000000001, 0.34999999999999998, -1.0);
        // device 1928, IC IC298, analog/basic/level_down.hpp:26
        I(CORE_DECISION6, Vss) <+ cpphdl_channel(V(cpphdl_n2333, Vss), V(CORE_DECISION6, Vss), 0.01, 0.34999999999999998, 1.0);
        // device 1929, IC IC298, analog/basic/level_down.hpp:27
        I(cpphdl_n2331, Vss) <+ 5e-15 * ddt(V(cpphdl_n2331, Vss)); // Bench initial voltage = 0.0 V.
        // device 1930, IC IC298, analog/basic/level_down.hpp:28
        I(cpphdl_n2331, Vlogic) <+ 5e-15 * ddt(V(cpphdl_n2331, Vlogic)); // Bench initial voltage = 0.0 V.
        // device 1931, IC IC298, analog/basic/level_down.hpp:29
        I(cpphdl_n2331, cpphdl_n2333) <+ 2.0000000000000002e-15 * ddt(V(cpphdl_n2331, cpphdl_n2333)); // Bench initial voltage = 0.0 V.
        // device 1932, IC IC298, analog/basic/level_down.hpp:30
        I(cpphdl_n2333, Vss) <+ 8e-14 * ddt(V(cpphdl_n2333, Vss)); // Bench initial voltage = 0.0 V.
        // device 1933, IC IC298, analog/basic/level_down.hpp:31
        I(cpphdl_n2333, Vlogic) <+ 5e-15 * ddt(V(cpphdl_n2333, Vlogic)); // Bench initial voltage = 0.0 V.
        // device 1934, IC IC298, analog/basic/level_down.hpp:32
        I(cpphdl_n2333, CORE_DECISION6) <+ 2.0000000000000002e-15 * ddt(V(cpphdl_n2333, CORE_DECISION6)); // Bench initial voltage = 0.0 V.
        // device 1935, IC IC298, analog/basic/level_down.hpp:33
        I(CORE_DECISION6, Vss) <+ 1e-14 * ddt(V(CORE_DECISION6, Vss)); // Bench initial voltage = 0.0 V.
        // device 1936, IC IC299, analog/basic/level_down.hpp:23
        I(cpphdl_n2338, Vlogic) <+ cpphdl_channel(V(Vss, Vlogic), V(cpphdl_n2338, Vlogic), 0.00050000000000000001, 0.34999999999999998, -1.0);
        // device 1937, IC IC299, analog/basic/level_down.hpp:24
        I(cpphdl_n2338, Vss) <+ cpphdl_channel(V(cpphdl_n2336, Vss), V(cpphdl_n2338, Vss), 0.0040000000000000001, 0.69999999999999996, 1.0);
        // device 1938, IC IC299, analog/basic/level_down.hpp:25
        I(CORE_DECISION7, Vlogic) <+ cpphdl_channel(V(cpphdl_n2338, Vlogic), V(CORE_DECISION7, Vlogic), 0.0050000000000000001, 0.34999999999999998, -1.0);
        // device 1939, IC IC299, analog/basic/level_down.hpp:26
        I(CORE_DECISION7, Vss) <+ cpphdl_channel(V(cpphdl_n2338, Vss), V(CORE_DECISION7, Vss), 0.01, 0.34999999999999998, 1.0);
        // device 1940, IC IC299, analog/basic/level_down.hpp:27
        I(cpphdl_n2336, Vss) <+ 5e-15 * ddt(V(cpphdl_n2336, Vss)); // Bench initial voltage = 0.0 V.
        // device 1941, IC IC299, analog/basic/level_down.hpp:28
        I(cpphdl_n2336, Vlogic) <+ 5e-15 * ddt(V(cpphdl_n2336, Vlogic)); // Bench initial voltage = 0.0 V.
        // device 1942, IC IC299, analog/basic/level_down.hpp:29
        I(cpphdl_n2336, cpphdl_n2338) <+ 2.0000000000000002e-15 * ddt(V(cpphdl_n2336, cpphdl_n2338)); // Bench initial voltage = 0.0 V.
        // device 1943, IC IC299, analog/basic/level_down.hpp:30
        I(cpphdl_n2338, Vss) <+ 8e-14 * ddt(V(cpphdl_n2338, Vss)); // Bench initial voltage = 0.0 V.
        // device 1944, IC IC299, analog/basic/level_down.hpp:31
        I(cpphdl_n2338, Vlogic) <+ 5e-15 * ddt(V(cpphdl_n2338, Vlogic)); // Bench initial voltage = 0.0 V.
        // device 1945, IC IC299, analog/basic/level_down.hpp:32
        I(cpphdl_n2338, CORE_DECISION7) <+ 2.0000000000000002e-15 * ddt(V(cpphdl_n2338, CORE_DECISION7)); // Bench initial voltage = 0.0 V.
        // device 1946, IC IC299, analog/basic/level_down.hpp:33
        I(CORE_DECISION7, Vss) <+ 1e-14 * ddt(V(CORE_DECISION7, Vss)); // Bench initial voltage = 0.0 V.
        // device 1947, IC IC300, analog/basic/level_down.hpp:23
        I(cpphdl_n2343, Vlogic) <+ cpphdl_channel(V(Vss, Vlogic), V(cpphdl_n2343, Vlogic), 0.00050000000000000001, 0.34999999999999998, -1.0);
        // device 1948, IC IC300, analog/basic/level_down.hpp:24
        I(cpphdl_n2343, Vss) <+ cpphdl_channel(V(cpphdl_n2341, Vss), V(cpphdl_n2343, Vss), 0.0040000000000000001, 0.69999999999999996, 1.0);
        // device 1949, IC IC300, analog/basic/level_down.hpp:25
        I(CORE_DECISION8, Vlogic) <+ cpphdl_channel(V(cpphdl_n2343, Vlogic), V(CORE_DECISION8, Vlogic), 0.0050000000000000001, 0.34999999999999998, -1.0);
        // device 1950, IC IC300, analog/basic/level_down.hpp:26
        I(CORE_DECISION8, Vss) <+ cpphdl_channel(V(cpphdl_n2343, Vss), V(CORE_DECISION8, Vss), 0.01, 0.34999999999999998, 1.0);
        // device 1951, IC IC300, analog/basic/level_down.hpp:27
        I(cpphdl_n2341, Vss) <+ 5e-15 * ddt(V(cpphdl_n2341, Vss)); // Bench initial voltage = 0.0 V.
        // device 1952, IC IC300, analog/basic/level_down.hpp:28
        I(cpphdl_n2341, Vlogic) <+ 5e-15 * ddt(V(cpphdl_n2341, Vlogic)); // Bench initial voltage = 0.0 V.
        // device 1953, IC IC300, analog/basic/level_down.hpp:29
        I(cpphdl_n2341, cpphdl_n2343) <+ 2.0000000000000002e-15 * ddt(V(cpphdl_n2341, cpphdl_n2343)); // Bench initial voltage = 0.0 V.
        // device 1954, IC IC300, analog/basic/level_down.hpp:30
        I(cpphdl_n2343, Vss) <+ 8e-14 * ddt(V(cpphdl_n2343, Vss)); // Bench initial voltage = 0.0 V.
        // device 1955, IC IC300, analog/basic/level_down.hpp:31
        I(cpphdl_n2343, Vlogic) <+ 5e-15 * ddt(V(cpphdl_n2343, Vlogic)); // Bench initial voltage = 0.0 V.
        // device 1956, IC IC300, analog/basic/level_down.hpp:32
        I(cpphdl_n2343, CORE_DECISION8) <+ 2.0000000000000002e-15 * ddt(V(cpphdl_n2343, CORE_DECISION8)); // Bench initial voltage = 0.0 V.
        // device 1957, IC IC300, analog/basic/level_down.hpp:33
        I(CORE_DECISION8, Vss) <+ 1e-14 * ddt(V(CORE_DECISION8, Vss)); // Bench initial voltage = 0.0 V.
        // device 1958, IC IC301, analog/basic/level_down.hpp:23
        I(cpphdl_n2348, Vlogic) <+ cpphdl_channel(V(Vss, Vlogic), V(cpphdl_n2348, Vlogic), 0.00050000000000000001, 0.34999999999999998, -1.0);
        // device 1959, IC IC301, analog/basic/level_down.hpp:24
        I(cpphdl_n2348, Vss) <+ cpphdl_channel(V(cpphdl_n2346, Vss), V(cpphdl_n2348, Vss), 0.0040000000000000001, 0.69999999999999996, 1.0);
        // device 1960, IC IC301, analog/basic/level_down.hpp:25
        I(CORE_DECISION9, Vlogic) <+ cpphdl_channel(V(cpphdl_n2348, Vlogic), V(CORE_DECISION9, Vlogic), 0.0050000000000000001, 0.34999999999999998, -1.0);
        // device 1961, IC IC301, analog/basic/level_down.hpp:26
        I(CORE_DECISION9, Vss) <+ cpphdl_channel(V(cpphdl_n2348, Vss), V(CORE_DECISION9, Vss), 0.01, 0.34999999999999998, 1.0);
        // device 1962, IC IC301, analog/basic/level_down.hpp:27
        I(cpphdl_n2346, Vss) <+ 5e-15 * ddt(V(cpphdl_n2346, Vss)); // Bench initial voltage = 0.0 V.
        // device 1963, IC IC301, analog/basic/level_down.hpp:28
        I(cpphdl_n2346, Vlogic) <+ 5e-15 * ddt(V(cpphdl_n2346, Vlogic)); // Bench initial voltage = 0.0 V.
        // device 1964, IC IC301, analog/basic/level_down.hpp:29
        I(cpphdl_n2346, cpphdl_n2348) <+ 2.0000000000000002e-15 * ddt(V(cpphdl_n2346, cpphdl_n2348)); // Bench initial voltage = 0.0 V.
        // device 1965, IC IC301, analog/basic/level_down.hpp:30
        I(cpphdl_n2348, Vss) <+ 8e-14 * ddt(V(cpphdl_n2348, Vss)); // Bench initial voltage = 0.0 V.
        // device 1966, IC IC301, analog/basic/level_down.hpp:31
        I(cpphdl_n2348, Vlogic) <+ 5e-15 * ddt(V(cpphdl_n2348, Vlogic)); // Bench initial voltage = 0.0 V.
        // device 1967, IC IC301, analog/basic/level_down.hpp:32
        I(cpphdl_n2348, CORE_DECISION9) <+ 2.0000000000000002e-15 * ddt(V(cpphdl_n2348, CORE_DECISION9)); // Bench initial voltage = 0.0 V.
        // device 1968, IC IC301, analog/basic/level_down.hpp:33
        I(CORE_DECISION9, Vss) <+ 1e-14 * ddt(V(CORE_DECISION9, Vss)); // Bench initial voltage = 0.0 V.
        // device 1969, IC IC302, analog/basic/level_down.hpp:23
        I(cpphdl_n2353, Vlogic) <+ cpphdl_channel(V(Vss, Vlogic), V(cpphdl_n2353, Vlogic), 0.00050000000000000001, 0.34999999999999998, -1.0);
        // device 1970, IC IC302, analog/basic/level_down.hpp:24
        I(cpphdl_n2353, Vss) <+ cpphdl_channel(V(cpphdl_n2351, Vss), V(cpphdl_n2353, Vss), 0.0040000000000000001, 0.69999999999999996, 1.0);
        // device 1971, IC IC302, analog/basic/level_down.hpp:25
        I(CORE_DECISION10, Vlogic) <+ cpphdl_channel(V(cpphdl_n2353, Vlogic), V(CORE_DECISION10, Vlogic), 0.0050000000000000001, 0.34999999999999998, -1.0);
        // device 1972, IC IC302, analog/basic/level_down.hpp:26
        I(CORE_DECISION10, Vss) <+ cpphdl_channel(V(cpphdl_n2353, Vss), V(CORE_DECISION10, Vss), 0.01, 0.34999999999999998, 1.0);
        // device 1973, IC IC302, analog/basic/level_down.hpp:27
        I(cpphdl_n2351, Vss) <+ 5e-15 * ddt(V(cpphdl_n2351, Vss)); // Bench initial voltage = 0.0 V.
        // device 1974, IC IC302, analog/basic/level_down.hpp:28
        I(cpphdl_n2351, Vlogic) <+ 5e-15 * ddt(V(cpphdl_n2351, Vlogic)); // Bench initial voltage = 0.0 V.
        // device 1975, IC IC302, analog/basic/level_down.hpp:29
        I(cpphdl_n2351, cpphdl_n2353) <+ 2.0000000000000002e-15 * ddt(V(cpphdl_n2351, cpphdl_n2353)); // Bench initial voltage = 0.0 V.
        // device 1976, IC IC302, analog/basic/level_down.hpp:30
        I(cpphdl_n2353, Vss) <+ 8e-14 * ddt(V(cpphdl_n2353, Vss)); // Bench initial voltage = 0.0 V.
        // device 1977, IC IC302, analog/basic/level_down.hpp:31
        I(cpphdl_n2353, Vlogic) <+ 5e-15 * ddt(V(cpphdl_n2353, Vlogic)); // Bench initial voltage = 0.0 V.
        // device 1978, IC IC302, analog/basic/level_down.hpp:32
        I(cpphdl_n2353, CORE_DECISION10) <+ 2.0000000000000002e-15 * ddt(V(cpphdl_n2353, CORE_DECISION10)); // Bench initial voltage = 0.0 V.
        // device 1979, IC IC302, analog/basic/level_down.hpp:33
        I(CORE_DECISION10, Vss) <+ 1e-14 * ddt(V(CORE_DECISION10, Vss)); // Bench initial voltage = 0.0 V.
        // device 1980, IC IC303, analog/basic/level_down.hpp:23
        I(cpphdl_n2358, Vlogic) <+ cpphdl_channel(V(Vss, Vlogic), V(cpphdl_n2358, Vlogic), 0.00050000000000000001, 0.34999999999999998, -1.0);
        // device 1981, IC IC303, analog/basic/level_down.hpp:24
        I(cpphdl_n2358, Vss) <+ cpphdl_channel(V(cpphdl_n2356, Vss), V(cpphdl_n2358, Vss), 0.0040000000000000001, 0.69999999999999996, 1.0);
        // device 1982, IC IC303, analog/basic/level_down.hpp:25
        I(CORE_DECISION11, Vlogic) <+ cpphdl_channel(V(cpphdl_n2358, Vlogic), V(CORE_DECISION11, Vlogic), 0.0050000000000000001, 0.34999999999999998, -1.0);
        // device 1983, IC IC303, analog/basic/level_down.hpp:26
        I(CORE_DECISION11, Vss) <+ cpphdl_channel(V(cpphdl_n2358, Vss), V(CORE_DECISION11, Vss), 0.01, 0.34999999999999998, 1.0);
        // device 1984, IC IC303, analog/basic/level_down.hpp:27
        I(cpphdl_n2356, Vss) <+ 5e-15 * ddt(V(cpphdl_n2356, Vss)); // Bench initial voltage = 0.0 V.
        // device 1985, IC IC303, analog/basic/level_down.hpp:28
        I(cpphdl_n2356, Vlogic) <+ 5e-15 * ddt(V(cpphdl_n2356, Vlogic)); // Bench initial voltage = 0.0 V.
        // device 1986, IC IC303, analog/basic/level_down.hpp:29
        I(cpphdl_n2356, cpphdl_n2358) <+ 2.0000000000000002e-15 * ddt(V(cpphdl_n2356, cpphdl_n2358)); // Bench initial voltage = 0.0 V.
        // device 1987, IC IC303, analog/basic/level_down.hpp:30
        I(cpphdl_n2358, Vss) <+ 8e-14 * ddt(V(cpphdl_n2358, Vss)); // Bench initial voltage = 0.0 V.
        // device 1988, IC IC303, analog/basic/level_down.hpp:31
        I(cpphdl_n2358, Vlogic) <+ 5e-15 * ddt(V(cpphdl_n2358, Vlogic)); // Bench initial voltage = 0.0 V.
        // device 1989, IC IC303, analog/basic/level_down.hpp:32
        I(cpphdl_n2358, CORE_DECISION11) <+ 2.0000000000000002e-15 * ddt(V(cpphdl_n2358, CORE_DECISION11)); // Bench initial voltage = 0.0 V.
        // device 1990, IC IC303, analog/basic/level_down.hpp:33
        I(CORE_DECISION11, Vss) <+ 1e-14 * ddt(V(CORE_DECISION11, Vss)); // Bench initial voltage = 0.0 V.
        // device 1991, IC IC304, analog/basic/level_down.hpp:23
        I(cpphdl_n2363, Vlogic) <+ cpphdl_channel(V(Vss, Vlogic), V(cpphdl_n2363, Vlogic), 0.00050000000000000001, 0.34999999999999998, -1.0);
        // device 1992, IC IC304, analog/basic/level_down.hpp:24
        I(cpphdl_n2363, Vss) <+ cpphdl_channel(V(cpphdl_n2361, Vss), V(cpphdl_n2363, Vss), 0.0040000000000000001, 0.69999999999999996, 1.0);
        // device 1993, IC IC304, analog/basic/level_down.hpp:25
        I(CORE_DECISION12, Vlogic) <+ cpphdl_channel(V(cpphdl_n2363, Vlogic), V(CORE_DECISION12, Vlogic), 0.0050000000000000001, 0.34999999999999998, -1.0);
        // device 1994, IC IC304, analog/basic/level_down.hpp:26
        I(CORE_DECISION12, Vss) <+ cpphdl_channel(V(cpphdl_n2363, Vss), V(CORE_DECISION12, Vss), 0.01, 0.34999999999999998, 1.0);
        // device 1995, IC IC304, analog/basic/level_down.hpp:27
        I(cpphdl_n2361, Vss) <+ 5e-15 * ddt(V(cpphdl_n2361, Vss)); // Bench initial voltage = 0.0 V.
        // device 1996, IC IC304, analog/basic/level_down.hpp:28
        I(cpphdl_n2361, Vlogic) <+ 5e-15 * ddt(V(cpphdl_n2361, Vlogic)); // Bench initial voltage = 0.0 V.
        // device 1997, IC IC304, analog/basic/level_down.hpp:29
        I(cpphdl_n2361, cpphdl_n2363) <+ 2.0000000000000002e-15 * ddt(V(cpphdl_n2361, cpphdl_n2363)); // Bench initial voltage = 0.0 V.
        // device 1998, IC IC304, analog/basic/level_down.hpp:30
        I(cpphdl_n2363, Vss) <+ 8e-14 * ddt(V(cpphdl_n2363, Vss)); // Bench initial voltage = 0.0 V.
        // device 1999, IC IC304, analog/basic/level_down.hpp:31
        I(cpphdl_n2363, Vlogic) <+ 5e-15 * ddt(V(cpphdl_n2363, Vlogic)); // Bench initial voltage = 0.0 V.
        // device 2000, IC IC304, analog/basic/level_down.hpp:32
        I(cpphdl_n2363, CORE_DECISION12) <+ 2.0000000000000002e-15 * ddt(V(cpphdl_n2363, CORE_DECISION12)); // Bench initial voltage = 0.0 V.
        // device 2001, IC IC304, analog/basic/level_down.hpp:33
        I(CORE_DECISION12, Vss) <+ 1e-14 * ddt(V(CORE_DECISION12, Vss)); // Bench initial voltage = 0.0 V.
        // device 2002, IC IC305, analog/basic/level_down.hpp:23
        I(cpphdl_n2368, Vlogic) <+ cpphdl_channel(V(Vss, Vlogic), V(cpphdl_n2368, Vlogic), 0.00050000000000000001, 0.34999999999999998, -1.0);
        // device 2003, IC IC305, analog/basic/level_down.hpp:24
        I(cpphdl_n2368, Vss) <+ cpphdl_channel(V(cpphdl_n2366, Vss), V(cpphdl_n2368, Vss), 0.0040000000000000001, 0.69999999999999996, 1.0);
        // device 2004, IC IC305, analog/basic/level_down.hpp:25
        I(CORE_DECISION13, Vlogic) <+ cpphdl_channel(V(cpphdl_n2368, Vlogic), V(CORE_DECISION13, Vlogic), 0.0050000000000000001, 0.34999999999999998, -1.0);
        // device 2005, IC IC305, analog/basic/level_down.hpp:26
        I(CORE_DECISION13, Vss) <+ cpphdl_channel(V(cpphdl_n2368, Vss), V(CORE_DECISION13, Vss), 0.01, 0.34999999999999998, 1.0);
        // device 2006, IC IC305, analog/basic/level_down.hpp:27
        I(cpphdl_n2366, Vss) <+ 5e-15 * ddt(V(cpphdl_n2366, Vss)); // Bench initial voltage = 0.0 V.
        // device 2007, IC IC305, analog/basic/level_down.hpp:28
        I(cpphdl_n2366, Vlogic) <+ 5e-15 * ddt(V(cpphdl_n2366, Vlogic)); // Bench initial voltage = 0.0 V.
        // device 2008, IC IC305, analog/basic/level_down.hpp:29
        I(cpphdl_n2366, cpphdl_n2368) <+ 2.0000000000000002e-15 * ddt(V(cpphdl_n2366, cpphdl_n2368)); // Bench initial voltage = 0.0 V.
        // device 2009, IC IC305, analog/basic/level_down.hpp:30
        I(cpphdl_n2368, Vss) <+ 8e-14 * ddt(V(cpphdl_n2368, Vss)); // Bench initial voltage = 0.0 V.
        // device 2010, IC IC305, analog/basic/level_down.hpp:31
        I(cpphdl_n2368, Vlogic) <+ 5e-15 * ddt(V(cpphdl_n2368, Vlogic)); // Bench initial voltage = 0.0 V.
        // device 2011, IC IC305, analog/basic/level_down.hpp:32
        I(cpphdl_n2368, CORE_DECISION13) <+ 2.0000000000000002e-15 * ddt(V(cpphdl_n2368, CORE_DECISION13)); // Bench initial voltage = 0.0 V.
        // device 2012, IC IC305, analog/basic/level_down.hpp:33
        I(CORE_DECISION13, Vss) <+ 1e-14 * ddt(V(CORE_DECISION13, Vss)); // Bench initial voltage = 0.0 V.
        // device 2013, IC IC306, analog/basic/level_down.hpp:23
        I(cpphdl_n2373, Vlogic) <+ cpphdl_channel(V(Vss, Vlogic), V(cpphdl_n2373, Vlogic), 0.00050000000000000001, 0.34999999999999998, -1.0);
        // device 2014, IC IC306, analog/basic/level_down.hpp:24
        I(cpphdl_n2373, Vss) <+ cpphdl_channel(V(cpphdl_n2371, Vss), V(cpphdl_n2373, Vss), 0.0040000000000000001, 0.69999999999999996, 1.0);
        // device 2015, IC IC306, analog/basic/level_down.hpp:25
        I(CORE_DECISION14, Vlogic) <+ cpphdl_channel(V(cpphdl_n2373, Vlogic), V(CORE_DECISION14, Vlogic), 0.0050000000000000001, 0.34999999999999998, -1.0);
        // device 2016, IC IC306, analog/basic/level_down.hpp:26
        I(CORE_DECISION14, Vss) <+ cpphdl_channel(V(cpphdl_n2373, Vss), V(CORE_DECISION14, Vss), 0.01, 0.34999999999999998, 1.0);
        // device 2017, IC IC306, analog/basic/level_down.hpp:27
        I(cpphdl_n2371, Vss) <+ 5e-15 * ddt(V(cpphdl_n2371, Vss)); // Bench initial voltage = 0.0 V.
        // device 2018, IC IC306, analog/basic/level_down.hpp:28
        I(cpphdl_n2371, Vlogic) <+ 5e-15 * ddt(V(cpphdl_n2371, Vlogic)); // Bench initial voltage = 0.0 V.
        // device 2019, IC IC306, analog/basic/level_down.hpp:29
        I(cpphdl_n2371, cpphdl_n2373) <+ 2.0000000000000002e-15 * ddt(V(cpphdl_n2371, cpphdl_n2373)); // Bench initial voltage = 0.0 V.
        // device 2020, IC IC306, analog/basic/level_down.hpp:30
        I(cpphdl_n2373, Vss) <+ 8e-14 * ddt(V(cpphdl_n2373, Vss)); // Bench initial voltage = 0.0 V.
        // device 2021, IC IC306, analog/basic/level_down.hpp:31
        I(cpphdl_n2373, Vlogic) <+ 5e-15 * ddt(V(cpphdl_n2373, Vlogic)); // Bench initial voltage = 0.0 V.
        // device 2022, IC IC306, analog/basic/level_down.hpp:32
        I(cpphdl_n2373, CORE_DECISION14) <+ 2.0000000000000002e-15 * ddt(V(cpphdl_n2373, CORE_DECISION14)); // Bench initial voltage = 0.0 V.
        // device 2023, IC IC306, analog/basic/level_down.hpp:33
        I(CORE_DECISION14, Vss) <+ 1e-14 * ddt(V(CORE_DECISION14, Vss)); // Bench initial voltage = 0.0 V.
        // device 2024, IC IC307, analog/basic/level_down.hpp:23
        I(cpphdl_n2378, Vlogic) <+ cpphdl_channel(V(Vss, Vlogic), V(cpphdl_n2378, Vlogic), 0.00050000000000000001, 0.34999999999999998, -1.0);
        // device 2025, IC IC307, analog/basic/level_down.hpp:24
        I(cpphdl_n2378, Vss) <+ cpphdl_channel(V(cpphdl_n2376, Vss), V(cpphdl_n2378, Vss), 0.0040000000000000001, 0.69999999999999996, 1.0);
        // device 2026, IC IC307, analog/basic/level_down.hpp:25
        I(CORE_DECISION15, Vlogic) <+ cpphdl_channel(V(cpphdl_n2378, Vlogic), V(CORE_DECISION15, Vlogic), 0.0050000000000000001, 0.34999999999999998, -1.0);
        // device 2027, IC IC307, analog/basic/level_down.hpp:26
        I(CORE_DECISION15, Vss) <+ cpphdl_channel(V(cpphdl_n2378, Vss), V(CORE_DECISION15, Vss), 0.01, 0.34999999999999998, 1.0);
        // device 2028, IC IC307, analog/basic/level_down.hpp:27
        I(cpphdl_n2376, Vss) <+ 5e-15 * ddt(V(cpphdl_n2376, Vss)); // Bench initial voltage = 0.0 V.
        // device 2029, IC IC307, analog/basic/level_down.hpp:28
        I(cpphdl_n2376, Vlogic) <+ 5e-15 * ddt(V(cpphdl_n2376, Vlogic)); // Bench initial voltage = 0.0 V.
        // device 2030, IC IC307, analog/basic/level_down.hpp:29
        I(cpphdl_n2376, cpphdl_n2378) <+ 2.0000000000000002e-15 * ddt(V(cpphdl_n2376, cpphdl_n2378)); // Bench initial voltage = 0.0 V.
        // device 2031, IC IC307, analog/basic/level_down.hpp:30
        I(cpphdl_n2378, Vss) <+ 8e-14 * ddt(V(cpphdl_n2378, Vss)); // Bench initial voltage = 0.0 V.
        // device 2032, IC IC307, analog/basic/level_down.hpp:31
        I(cpphdl_n2378, Vlogic) <+ 5e-15 * ddt(V(cpphdl_n2378, Vlogic)); // Bench initial voltage = 0.0 V.
        // device 2033, IC IC307, analog/basic/level_down.hpp:32
        I(cpphdl_n2378, CORE_DECISION15) <+ 2.0000000000000002e-15 * ddt(V(cpphdl_n2378, CORE_DECISION15)); // Bench initial voltage = 0.0 V.
        // device 2034, IC IC307, analog/basic/level_down.hpp:33
        I(CORE_DECISION15, Vss) <+ 1e-14 * ddt(V(CORE_DECISION15, Vss)); // Bench initial voltage = 0.0 V.
    end
endmodule
