// SIMULATION APPROXIMATION: controlled conductances are not physical MOS devices.
// Generated from elaborated C++HDL IC purposes; all contributions coexist.
// Capacitor initialization belongs to the host analysis; declared initial voltages appear below.
`include "disciplines.vams"

module OneGReferenceClockDomain(Vdd, Vss, Vlogic, REF, CLEAR, OUT, OUT_N);
    inout Vdd, Vss, Vlogic, REF, CLEAR, OUT, OUT_N;
    electrical Vdd, Vss, Vlogic, REF, CLEAR, OUT, OUT_N;
    electrical cpphdl_n17;
    electrical cpphdl_n18;
    electrical cpphdl_n53;
    electrical cpphdl_n57;
    electrical cpphdl_n58;
    electrical cpphdl_n60;
    electrical cpphdl_n66;
    electrical cpphdl_n69;
    electrical cpphdl_n70;
    electrical cpphdl_n72;
    electrical cpphdl_n81;
    electrical cpphdl_n84;
    electrical cpphdl_n87;
    electrical cpphdl_n89;
    electrical cpphdl_n90;
    electrical cpphdl_n95;
    electrical cpphdl_n113;
    electrical cpphdl_n118;
    electrical cpphdl_n120;
    electrical cpphdl_n123;
    electrical cpphdl_n126;
    electrical cpphdl_n129;
    electrical cpphdl_n130;
    electrical cpphdl_n132;
    electrical cpphdl_n141;
    electrical cpphdl_n144;
    electrical cpphdl_n147;
    electrical cpphdl_n149;
    electrical cpphdl_n150;
    electrical cpphdl_n155;
    electrical cpphdl_n193;
    electrical cpphdl_n197;
    electrical cpphdl_n198;
    electrical cpphdl_n200;
    electrical cpphdl_n206;
    electrical cpphdl_n209;
    electrical cpphdl_n210;
    electrical cpphdl_n212;
    electrical cpphdl_n221;
    electrical cpphdl_n224;
    electrical cpphdl_n227;
    electrical cpphdl_n229;
    electrical cpphdl_n230;
    electrical cpphdl_n235;
    electrical cpphdl_n253;
    electrical cpphdl_n258;
    electrical cpphdl_n260;
    electrical cpphdl_n263;
    electrical cpphdl_n266;
    electrical cpphdl_n269;
    electrical cpphdl_n270;
    electrical cpphdl_n272;
    electrical cpphdl_n281;
    electrical cpphdl_n284;
    electrical cpphdl_n287;
    electrical cpphdl_n288;
    electrical cpphdl_n289;
    electrical cpphdl_n290;
    electrical cpphdl_n295;
    electrical cpphdl_n324;
    electrical cpphdl_n328;
    electrical cpphdl_n329;
    electrical cpphdl_n331;
    electrical cpphdl_n337;
    electrical cpphdl_n340;
    electrical cpphdl_n341;
    electrical cpphdl_n343;
    electrical cpphdl_n352;
    electrical cpphdl_n355;
    electrical cpphdl_n358;
    electrical cpphdl_n360;
    electrical cpphdl_n361;
    electrical cpphdl_n366;
    electrical cpphdl_n384;
    electrical cpphdl_n388;
    electrical cpphdl_n389;
    electrical cpphdl_n391;
    electrical cpphdl_n394;
    electrical cpphdl_n397;
    electrical cpphdl_n400;
    electrical cpphdl_n401;
    electrical cpphdl_n403;
    electrical cpphdl_n412;
    electrical cpphdl_n415;
    electrical cpphdl_n418;
    electrical cpphdl_n419;
    electrical cpphdl_n420;
    electrical cpphdl_n421;
    electrical cpphdl_n425;
    electrical cpphdl_n426;
    electrical cpphdl_n432;
    electrical cpphdl_n435;
    electrical cpphdl_n436;
    electrical cpphdl_n437;
    electrical cpphdl_n438;
    electrical cpphdl_n446;
    electrical cpphdl_n447;
    electrical cpphdl_n448;
    electrical cpphdl_n458;
    electrical cpphdl_n461;
    electrical cpphdl_n464;
    electrical cpphdl_n467;
    electrical cpphdl_n469;
    electrical cpphdl_n470;
    electrical cpphdl_n473;
    electrical cpphdl_n477;
    electrical cpphdl_n482;
    electrical cpphdl_n483;
    electrical cpphdl_n494;
    electrical cpphdl_n495;
    electrical cpphdl_n498;
    electrical cpphdl_n499;
    electrical cpphdl_n502;
    electrical cpphdl_n506;

    // Square-law channel, including reverse conduction. This is not a BSIM model.
    analog function real cpphdl_channel;
        input vgs, vds, beta, threshold, polarity;
        real vgs, vds, beta, threshold, polarity;
        real gate, drain, direction, overdrive, current;
        begin
            gate = polarity * vgs;
            drain = polarity * vds;
            direction = 1.0;
            if (drain < 0.0) begin
                gate = gate - drain;
                drain = -drain;
                direction = -1.0;
            end
            overdrive = gate - threshold;
            current = 0.0;
            if (overdrive > 0.0) begin
                if (drain < overdrive)
                    current = beta * (overdrive * drain - drain * drain / 2.0);
                else
                    current = beta * overdrive * overdrive / 2.0;
            end
            cpphdl_channel = polarity * direction * current;
        end
    endfunction

    analog begin
        // device 0, IC IC4, analog/basic/inverter.hpp:11
        I(cpphdl_n57, Vlogic) <+ cpphdl_channel(V(cpphdl_n473, Vlogic), V(cpphdl_n57, Vlogic), 0.01, 0.34999999999999998, -1.0);
        // device 1, IC IC4, analog/basic/inverter.hpp:12
        I(cpphdl_n57, Vss) <+ cpphdl_channel(V(cpphdl_n473, Vss), V(cpphdl_n57, Vss), 0.01, 0.34999999999999998, 1.0);
        // device 2, IC IC3, analog/basic/cmos_storage.hpp:83
        I(cpphdl_n57, Vss) <+ 5e-15 * ddt(V(cpphdl_n57, Vss)); // Bench initial voltage = 0.0 V.
        // device 3, IC IC6, analog/basic/inverter.hpp:11
        I(cpphdl_n69, Vlogic) <+ cpphdl_channel(V(cpphdl_n149, Vlogic), V(cpphdl_n69, Vlogic), 0.01, 0.34999999999999998, -1.0);
        // device 4, IC IC6, analog/basic/inverter.hpp:12
        I(cpphdl_n69, Vss) <+ cpphdl_channel(V(cpphdl_n149, Vss), V(cpphdl_n69, Vss), 0.01, 0.34999999999999998, 1.0);
        // device 5, IC IC5, analog/basic/cmos_storage.hpp:41
        I(cpphdl_n69, Vss) <+ 5e-15 * ddt(V(cpphdl_n69, Vss)); // Bench initial voltage = 0.0 V.
        // device 6, IC IC7, analog/basic/inverter.hpp:11
        I(cpphdl_n58, Vlogic) <+ cpphdl_channel(V(CLEAR, Vlogic), V(cpphdl_n58, Vlogic), 0.01, 0.34999999999999998, -1.0);
        // device 7, IC IC7, analog/basic/inverter.hpp:12
        I(cpphdl_n58, Vss) <+ cpphdl_channel(V(CLEAR, Vss), V(cpphdl_n58, Vss), 0.01, 0.34999999999999998, 1.0);
        // device 8, IC IC5, analog/basic/cmos_storage.hpp:41
        I(cpphdl_n58, Vss) <+ 5e-15 * ddt(V(cpphdl_n58, Vss)); // Bench initial voltage = 0.0 V.
        // device 9, IC IC8, analog/basic/inverter.hpp:11
        I(cpphdl_n70, Vlogic) <+ cpphdl_channel(V(cpphdl_n53, Vlogic), V(cpphdl_n70, Vlogic), 0.01, 0.34999999999999998, -1.0);
        // device 10, IC IC8, analog/basic/inverter.hpp:12
        I(cpphdl_n70, Vss) <+ cpphdl_channel(V(cpphdl_n53, Vss), V(cpphdl_n70, Vss), 0.01, 0.34999999999999998, 1.0);
        // device 11, IC IC5, analog/basic/cmos_storage.hpp:41
        I(cpphdl_n70, Vss) <+ 5e-15 * ddt(V(cpphdl_n70, Vss)); // Bench initial voltage = 0.0 V.
        // device 12, IC IC9, analog/basic/cmos_logic.hpp:15
        I(cpphdl_n53, Vss) <+ 5e-15 * ddt(V(cpphdl_n53, Vss)); // Bench initial voltage = 0.0 V.
        // device 13, IC IC9, analog/basic/cmos_logic.hpp:16
        I(cpphdl_n53, Vlogic) <+ cpphdl_channel(V(cpphdl_n57, Vlogic), V(cpphdl_n53, Vlogic), 0.01, 0.34999999999999998, -1.0);
        // device 14, IC IC9, analog/basic/cmos_logic.hpp:17
        I(cpphdl_n53, Vlogic) <+ cpphdl_channel(V(cpphdl_n58, Vlogic), V(cpphdl_n53, Vlogic), 0.01, 0.34999999999999998, -1.0);
        // device 15, IC IC9, analog/basic/cmos_logic.hpp:18
        I(cpphdl_n53, cpphdl_n60) <+ cpphdl_channel(V(cpphdl_n57, cpphdl_n60), V(cpphdl_n53, cpphdl_n60), 0.01, 0.34999999999999998, 1.0);
        // device 16, IC IC9, analog/basic/cmos_logic.hpp:19
        I(cpphdl_n60, Vss) <+ cpphdl_channel(V(cpphdl_n58, Vss), V(cpphdl_n60, Vss), 0.01, 0.34999999999999998, 1.0);
        // device 17, IC IC9, analog/basic/cmos_logic.hpp:20
        I(cpphdl_n53, Vss) <+ V(cpphdl_n53, Vss) / 1000000000.0;
        // device 18, IC IC9, analog/basic/cmos_logic.hpp:21
        I(cpphdl_n60, Vss) <+ V(cpphdl_n60, Vss) / 1000000000.0;
        // device 19, IC IC10, analog/basic/cmos_logic.hpp:15
        I(cpphdl_n81, Vss) <+ 5e-15 * ddt(V(cpphdl_n81, Vss)); // Bench initial voltage = 0.0 V.
        // device 20, IC IC10, analog/basic/cmos_logic.hpp:16
        I(cpphdl_n81, Vlogic) <+ cpphdl_channel(V(cpphdl_n149, Vlogic), V(cpphdl_n81, Vlogic), 0.01, 0.34999999999999998, -1.0);
        // device 21, IC IC10, analog/basic/cmos_logic.hpp:17
        I(cpphdl_n81, Vlogic) <+ cpphdl_channel(V(cpphdl_n70, Vlogic), V(cpphdl_n81, Vlogic), 0.01, 0.34999999999999998, -1.0);
        // device 22, IC IC10, analog/basic/cmos_logic.hpp:18
        I(cpphdl_n81, cpphdl_n66) <+ cpphdl_channel(V(cpphdl_n149, cpphdl_n66), V(cpphdl_n81, cpphdl_n66), 0.01, 0.34999999999999998, 1.0);
        // device 23, IC IC10, analog/basic/cmos_logic.hpp:19
        I(cpphdl_n66, Vss) <+ cpphdl_channel(V(cpphdl_n70, Vss), V(cpphdl_n66, Vss), 0.01, 0.34999999999999998, 1.0);
        // device 24, IC IC10, analog/basic/cmos_logic.hpp:20
        I(cpphdl_n81, Vss) <+ V(cpphdl_n81, Vss) / 1000000000.0;
        // device 25, IC IC10, analog/basic/cmos_logic.hpp:21
        I(cpphdl_n66, Vss) <+ V(cpphdl_n66, Vss) / 1000000000.0;
        // device 26, IC IC11, analog/basic/cmos_logic.hpp:15
        I(cpphdl_n87, Vss) <+ 5e-15 * ddt(V(cpphdl_n87, Vss)); // Bench initial voltage = 0.0 V.
        // device 27, IC IC11, analog/basic/cmos_logic.hpp:16
        I(cpphdl_n87, Vlogic) <+ cpphdl_channel(V(cpphdl_n69, Vlogic), V(cpphdl_n87, Vlogic), 0.01, 0.34999999999999998, -1.0);
        // device 28, IC IC11, analog/basic/cmos_logic.hpp:17
        I(cpphdl_n87, Vlogic) <+ cpphdl_channel(V(cpphdl_n70, Vlogic), V(cpphdl_n87, Vlogic), 0.01, 0.34999999999999998, -1.0);
        // device 29, IC IC11, analog/basic/cmos_logic.hpp:18
        I(cpphdl_n87, cpphdl_n72) <+ cpphdl_channel(V(cpphdl_n69, cpphdl_n72), V(cpphdl_n87, cpphdl_n72), 0.01, 0.34999999999999998, 1.0);
        // device 30, IC IC11, analog/basic/cmos_logic.hpp:19
        I(cpphdl_n72, Vss) <+ cpphdl_channel(V(cpphdl_n70, Vss), V(cpphdl_n72, Vss), 0.01, 0.34999999999999998, 1.0);
        // device 31, IC IC11, analog/basic/cmos_logic.hpp:20
        I(cpphdl_n87, Vss) <+ V(cpphdl_n87, Vss) / 1000000000.0;
        // device 32, IC IC11, analog/basic/cmos_logic.hpp:21
        I(cpphdl_n72, Vss) <+ V(cpphdl_n72, Vss) / 1000000000.0;
        // device 33, IC IC13, analog/basic/cmos_logic.hpp:15
        I(cpphdl_n123, Vss) <+ 5e-15 * ddt(V(cpphdl_n123, Vss)); // Bench initial voltage = 0.0 V.
        // device 34, IC IC13, analog/basic/cmos_logic.hpp:16
        I(cpphdl_n123, Vlogic) <+ cpphdl_channel(V(cpphdl_n81, Vlogic), V(cpphdl_n123, Vlogic), 0.01, 0.34999999999999998, -1.0);
        // device 35, IC IC13, analog/basic/cmos_logic.hpp:17
        I(cpphdl_n123, Vlogic) <+ cpphdl_channel(V(cpphdl_n89, Vlogic), V(cpphdl_n123, Vlogic), 0.01, 0.34999999999999998, -1.0);
        // device 36, IC IC13, analog/basic/cmos_logic.hpp:18
        I(cpphdl_n123, cpphdl_n84) <+ cpphdl_channel(V(cpphdl_n81, cpphdl_n84), V(cpphdl_n123, cpphdl_n84), 0.01, 0.34999999999999998, 1.0);
        // device 37, IC IC13, analog/basic/cmos_logic.hpp:19
        I(cpphdl_n84, Vss) <+ cpphdl_channel(V(cpphdl_n89, Vss), V(cpphdl_n84, Vss), 0.01, 0.34999999999999998, 1.0);
        // device 38, IC IC13, analog/basic/cmos_logic.hpp:20
        I(cpphdl_n123, Vss) <+ V(cpphdl_n123, Vss) / 1000000000.0;
        // device 39, IC IC13, analog/basic/cmos_logic.hpp:21
        I(cpphdl_n84, Vss) <+ V(cpphdl_n84, Vss) / 1000000000.0;
        // device 40, IC IC14, analog/basic/cmos_logic.hpp:15
        I(cpphdl_n89, Vss) <+ 5e-15 * ddt(V(cpphdl_n89, Vss)); // Bench initial voltage = 0.0 V.
        // device 41, IC IC14, analog/basic/cmos_logic.hpp:16
        I(cpphdl_n89, Vlogic) <+ cpphdl_channel(V(cpphdl_n87, Vlogic), V(cpphdl_n89, Vlogic), 0.01, 0.34999999999999998, -1.0);
        // device 42, IC IC14, analog/basic/cmos_logic.hpp:17
        I(cpphdl_n89, Vlogic) <+ cpphdl_channel(V(cpphdl_n123, Vlogic), V(cpphdl_n89, Vlogic), 0.01, 0.34999999999999998, -1.0);
        // device 43, IC IC14, analog/basic/cmos_logic.hpp:18
        I(cpphdl_n89, cpphdl_n90) <+ cpphdl_channel(V(cpphdl_n87, cpphdl_n90), V(cpphdl_n89, cpphdl_n90), 0.01, 0.34999999999999998, 1.0);
        // device 44, IC IC14, analog/basic/cmos_logic.hpp:19
        I(cpphdl_n90, Vss) <+ cpphdl_channel(V(cpphdl_n123, Vss), V(cpphdl_n90, Vss), 0.01, 0.34999999999999998, 1.0);
        // device 45, IC IC14, analog/basic/cmos_logic.hpp:20
        I(cpphdl_n89, Vss) <+ V(cpphdl_n89, Vss) / 1000000000.0;
        // device 46, IC IC14, analog/basic/cmos_logic.hpp:21
        I(cpphdl_n90, Vss) <+ V(cpphdl_n90, Vss) / 1000000000.0;
        // device 47, IC IC12, analog/basic/nand_latch.hpp:34
        I(cpphdl_n81, Vss) <+ 2.0000000000000002e-15 * ddt(V(cpphdl_n81, Vss)); // Bench initial voltage = 0.0 V.
        // device 48, IC IC12, analog/basic/nand_latch.hpp:35
        I(cpphdl_n87, Vss) <+ 2.0000000000000002e-15 * ddt(V(cpphdl_n87, Vss)); // Bench initial voltage = 0.0 V.
        // device 49, IC IC15, analog/basic/inverter.hpp:11
        I(cpphdl_n95, Vlogic) <+ cpphdl_channel(V(CLEAR, Vlogic), V(cpphdl_n95, Vlogic), 0.01, 0.34999999999999998, -1.0);
        // device 50, IC IC15, analog/basic/inverter.hpp:12
        I(cpphdl_n95, Vss) <+ cpphdl_channel(V(CLEAR, Vss), V(cpphdl_n95, Vss), 0.01, 0.34999999999999998, 1.0);
        // device 51, IC IC12, analog/basic/nand_latch.hpp:56
        I(cpphdl_n95, Vss) <+ 2.0000000000000002e-15 * ddt(V(cpphdl_n95, Vss)); // Bench initial voltage = 0.0 V.
        // device 52, IC IC12, analog/basic/nand_latch.hpp:57
        I(cpphdl_n123, Vss) <+ cpphdl_channel(V(CLEAR, Vss), V(cpphdl_n123, Vss), 0.050000000000000003, 0.34999999999999998, 1.0);
        // device 53, IC IC12, analog/basic/nand_latch.hpp:58
        I(cpphdl_n89, Vlogic) <+ cpphdl_channel(V(cpphdl_n95, Vlogic), V(cpphdl_n89, Vlogic), 0.050000000000000003, 0.34999999999999998, -1.0);
        // device 54, IC IC5, analog/basic/cmos_storage.hpp:57
        I(cpphdl_n149, Vss) <+ 2.0000000000000002e-15 * ddt(V(cpphdl_n149, Vss)); // Bench initial voltage = 0.0 V.
        // device 55, IC IC5, analog/basic/cmos_storage.hpp:58
        I(cpphdl_n57, Vss) <+ 2.0000000000000002e-15 * ddt(V(cpphdl_n57, Vss)); // Bench initial voltage = 0.0 V.
        // device 56, IC IC5, analog/basic/cmos_storage.hpp:59
        I(CLEAR, Vss) <+ 2.0000000000000002e-15 * ddt(V(CLEAR, Vss)); // Bench initial voltage = 0.0 V.
        // device 57, IC IC17, analog/basic/inverter.hpp:11
        I(cpphdl_n129, Vlogic) <+ cpphdl_channel(V(cpphdl_n123, Vlogic), V(cpphdl_n129, Vlogic), 0.01, 0.34999999999999998, -1.0);
        // device 58, IC IC17, analog/basic/inverter.hpp:12
        I(cpphdl_n129, Vss) <+ cpphdl_channel(V(cpphdl_n123, Vss), V(cpphdl_n129, Vss), 0.01, 0.34999999999999998, 1.0);
        // device 59, IC IC16, analog/basic/cmos_storage.hpp:41
        I(cpphdl_n129, Vss) <+ 5e-15 * ddt(V(cpphdl_n129, Vss)); // Bench initial voltage = 0.0 V.
        // device 60, IC IC18, analog/basic/inverter.hpp:11
        I(cpphdl_n118, Vlogic) <+ cpphdl_channel(V(CLEAR, Vlogic), V(cpphdl_n118, Vlogic), 0.01, 0.34999999999999998, -1.0);
        // device 61, IC IC18, analog/basic/inverter.hpp:12
        I(cpphdl_n118, Vss) <+ cpphdl_channel(V(CLEAR, Vss), V(cpphdl_n118, Vss), 0.01, 0.34999999999999998, 1.0);
        // device 62, IC IC16, analog/basic/cmos_storage.hpp:41
        I(cpphdl_n118, Vss) <+ 5e-15 * ddt(V(cpphdl_n118, Vss)); // Bench initial voltage = 0.0 V.
        // device 63, IC IC19, analog/basic/inverter.hpp:11
        I(cpphdl_n130, Vlogic) <+ cpphdl_channel(V(cpphdl_n113, Vlogic), V(cpphdl_n130, Vlogic), 0.01, 0.34999999999999998, -1.0);
        // device 64, IC IC19, analog/basic/inverter.hpp:12
        I(cpphdl_n130, Vss) <+ cpphdl_channel(V(cpphdl_n113, Vss), V(cpphdl_n130, Vss), 0.01, 0.34999999999999998, 1.0);
        // device 65, IC IC16, analog/basic/cmos_storage.hpp:41
        I(cpphdl_n130, Vss) <+ 5e-15 * ddt(V(cpphdl_n130, Vss)); // Bench initial voltage = 0.0 V.
        // device 66, IC IC20, analog/basic/cmos_logic.hpp:15
        I(cpphdl_n113, Vss) <+ 5e-15 * ddt(V(cpphdl_n113, Vss)); // Bench initial voltage = 0.0 V.
        // device 67, IC IC20, analog/basic/cmos_logic.hpp:16
        I(cpphdl_n113, Vlogic) <+ cpphdl_channel(V(cpphdl_n473, Vlogic), V(cpphdl_n113, Vlogic), 0.01, 0.34999999999999998, -1.0);
        // device 68, IC IC20, analog/basic/cmos_logic.hpp:17
        I(cpphdl_n113, Vlogic) <+ cpphdl_channel(V(cpphdl_n118, Vlogic), V(cpphdl_n113, Vlogic), 0.01, 0.34999999999999998, -1.0);
        // device 69, IC IC20, analog/basic/cmos_logic.hpp:18
        I(cpphdl_n113, cpphdl_n120) <+ cpphdl_channel(V(cpphdl_n473, cpphdl_n120), V(cpphdl_n113, cpphdl_n120), 0.01, 0.34999999999999998, 1.0);
        // device 70, IC IC20, analog/basic/cmos_logic.hpp:19
        I(cpphdl_n120, Vss) <+ cpphdl_channel(V(cpphdl_n118, Vss), V(cpphdl_n120, Vss), 0.01, 0.34999999999999998, 1.0);
        // device 71, IC IC20, analog/basic/cmos_logic.hpp:20
        I(cpphdl_n113, Vss) <+ V(cpphdl_n113, Vss) / 1000000000.0;
        // device 72, IC IC20, analog/basic/cmos_logic.hpp:21
        I(cpphdl_n120, Vss) <+ V(cpphdl_n120, Vss) / 1000000000.0;
        // device 73, IC IC21, analog/basic/cmos_logic.hpp:15
        I(cpphdl_n141, Vss) <+ 5e-15 * ddt(V(cpphdl_n141, Vss)); // Bench initial voltage = 0.0 V.
        // device 74, IC IC21, analog/basic/cmos_logic.hpp:16
        I(cpphdl_n141, Vlogic) <+ cpphdl_channel(V(cpphdl_n123, Vlogic), V(cpphdl_n141, Vlogic), 0.01, 0.34999999999999998, -1.0);
        // device 75, IC IC21, analog/basic/cmos_logic.hpp:17
        I(cpphdl_n141, Vlogic) <+ cpphdl_channel(V(cpphdl_n130, Vlogic), V(cpphdl_n141, Vlogic), 0.01, 0.34999999999999998, -1.0);
        // device 76, IC IC21, analog/basic/cmos_logic.hpp:18
        I(cpphdl_n141, cpphdl_n126) <+ cpphdl_channel(V(cpphdl_n123, cpphdl_n126), V(cpphdl_n141, cpphdl_n126), 0.01, 0.34999999999999998, 1.0);
        // device 77, IC IC21, analog/basic/cmos_logic.hpp:19
        I(cpphdl_n126, Vss) <+ cpphdl_channel(V(cpphdl_n130, Vss), V(cpphdl_n126, Vss), 0.01, 0.34999999999999998, 1.0);
        // device 78, IC IC21, analog/basic/cmos_logic.hpp:20
        I(cpphdl_n141, Vss) <+ V(cpphdl_n141, Vss) / 1000000000.0;
        // device 79, IC IC21, analog/basic/cmos_logic.hpp:21
        I(cpphdl_n126, Vss) <+ V(cpphdl_n126, Vss) / 1000000000.0;
        // device 80, IC IC22, analog/basic/cmos_logic.hpp:15
        I(cpphdl_n147, Vss) <+ 5e-15 * ddt(V(cpphdl_n147, Vss)); // Bench initial voltage = 0.0 V.
        // device 81, IC IC22, analog/basic/cmos_logic.hpp:16
        I(cpphdl_n147, Vlogic) <+ cpphdl_channel(V(cpphdl_n129, Vlogic), V(cpphdl_n147, Vlogic), 0.01, 0.34999999999999998, -1.0);
        // device 82, IC IC22, analog/basic/cmos_logic.hpp:17
        I(cpphdl_n147, Vlogic) <+ cpphdl_channel(V(cpphdl_n130, Vlogic), V(cpphdl_n147, Vlogic), 0.01, 0.34999999999999998, -1.0);
        // device 83, IC IC22, analog/basic/cmos_logic.hpp:18
        I(cpphdl_n147, cpphdl_n132) <+ cpphdl_channel(V(cpphdl_n129, cpphdl_n132), V(cpphdl_n147, cpphdl_n132), 0.01, 0.34999999999999998, 1.0);
        // device 84, IC IC22, analog/basic/cmos_logic.hpp:19
        I(cpphdl_n132, Vss) <+ cpphdl_channel(V(cpphdl_n130, Vss), V(cpphdl_n132, Vss), 0.01, 0.34999999999999998, 1.0);
        // device 85, IC IC22, analog/basic/cmos_logic.hpp:20
        I(cpphdl_n147, Vss) <+ V(cpphdl_n147, Vss) / 1000000000.0;
        // device 86, IC IC22, analog/basic/cmos_logic.hpp:21
        I(cpphdl_n132, Vss) <+ V(cpphdl_n132, Vss) / 1000000000.0;
        // device 87, IC IC24, analog/basic/cmos_logic.hpp:15
        I(cpphdl_n388, Vss) <+ 5e-15 * ddt(V(cpphdl_n388, Vss)); // Bench initial voltage = 0.0 V.
        // device 88, IC IC24, analog/basic/cmos_logic.hpp:16
        I(cpphdl_n388, Vlogic) <+ cpphdl_channel(V(cpphdl_n141, Vlogic), V(cpphdl_n388, Vlogic), 0.01, 0.34999999999999998, -1.0);
        // device 89, IC IC24, analog/basic/cmos_logic.hpp:17
        I(cpphdl_n388, Vlogic) <+ cpphdl_channel(V(cpphdl_n149, Vlogic), V(cpphdl_n388, Vlogic), 0.01, 0.34999999999999998, -1.0);
        // device 90, IC IC24, analog/basic/cmos_logic.hpp:18
        I(cpphdl_n388, cpphdl_n144) <+ cpphdl_channel(V(cpphdl_n141, cpphdl_n144), V(cpphdl_n388, cpphdl_n144), 0.01, 0.34999999999999998, 1.0);
        // device 91, IC IC24, analog/basic/cmos_logic.hpp:19
        I(cpphdl_n144, Vss) <+ cpphdl_channel(V(cpphdl_n149, Vss), V(cpphdl_n144, Vss), 0.01, 0.34999999999999998, 1.0);
        // device 92, IC IC24, analog/basic/cmos_logic.hpp:20
        I(cpphdl_n388, Vss) <+ V(cpphdl_n388, Vss) / 1000000000.0;
        // device 93, IC IC24, analog/basic/cmos_logic.hpp:21
        I(cpphdl_n144, Vss) <+ V(cpphdl_n144, Vss) / 1000000000.0;
        // device 94, IC IC25, analog/basic/cmos_logic.hpp:15
        I(cpphdl_n149, Vss) <+ 5e-15 * ddt(V(cpphdl_n149, Vss)); // Bench initial voltage = 0.0 V.
        // device 95, IC IC25, analog/basic/cmos_logic.hpp:16
        I(cpphdl_n149, Vlogic) <+ cpphdl_channel(V(cpphdl_n147, Vlogic), V(cpphdl_n149, Vlogic), 0.01, 0.34999999999999998, -1.0);
        // device 96, IC IC25, analog/basic/cmos_logic.hpp:17
        I(cpphdl_n149, Vlogic) <+ cpphdl_channel(V(cpphdl_n388, Vlogic), V(cpphdl_n149, Vlogic), 0.01, 0.34999999999999998, -1.0);
        // device 97, IC IC25, analog/basic/cmos_logic.hpp:18
        I(cpphdl_n149, cpphdl_n150) <+ cpphdl_channel(V(cpphdl_n147, cpphdl_n150), V(cpphdl_n149, cpphdl_n150), 0.01, 0.34999999999999998, 1.0);
        // device 98, IC IC25, analog/basic/cmos_logic.hpp:19
        I(cpphdl_n150, Vss) <+ cpphdl_channel(V(cpphdl_n388, Vss), V(cpphdl_n150, Vss), 0.01, 0.34999999999999998, 1.0);
        // device 99, IC IC25, analog/basic/cmos_logic.hpp:20
        I(cpphdl_n149, Vss) <+ V(cpphdl_n149, Vss) / 1000000000.0;
        // device 100, IC IC25, analog/basic/cmos_logic.hpp:21
        I(cpphdl_n150, Vss) <+ V(cpphdl_n150, Vss) / 1000000000.0;
        // device 101, IC IC23, analog/basic/nand_latch.hpp:34
        I(cpphdl_n141, Vss) <+ 2.0000000000000002e-15 * ddt(V(cpphdl_n141, Vss)); // Bench initial voltage = 0.0 V.
        // device 102, IC IC23, analog/basic/nand_latch.hpp:35
        I(cpphdl_n147, Vss) <+ 2.0000000000000002e-15 * ddt(V(cpphdl_n147, Vss)); // Bench initial voltage = 0.0 V.
        // device 103, IC IC26, analog/basic/inverter.hpp:11
        I(cpphdl_n155, Vlogic) <+ cpphdl_channel(V(CLEAR, Vlogic), V(cpphdl_n155, Vlogic), 0.01, 0.34999999999999998, -1.0);
        // device 104, IC IC26, analog/basic/inverter.hpp:12
        I(cpphdl_n155, Vss) <+ cpphdl_channel(V(CLEAR, Vss), V(cpphdl_n155, Vss), 0.01, 0.34999999999999998, 1.0);
        // device 105, IC IC23, analog/basic/nand_latch.hpp:56
        I(cpphdl_n155, Vss) <+ 2.0000000000000002e-15 * ddt(V(cpphdl_n155, Vss)); // Bench initial voltage = 0.0 V.
        // device 106, IC IC23, analog/basic/nand_latch.hpp:57
        I(cpphdl_n388, Vss) <+ cpphdl_channel(V(CLEAR, Vss), V(cpphdl_n388, Vss), 0.050000000000000003, 0.34999999999999998, 1.0);
        // device 107, IC IC23, analog/basic/nand_latch.hpp:58
        I(cpphdl_n149, Vlogic) <+ cpphdl_channel(V(cpphdl_n155, Vlogic), V(cpphdl_n149, Vlogic), 0.050000000000000003, 0.34999999999999998, -1.0);
        // device 108, IC IC16, analog/basic/cmos_storage.hpp:57
        I(cpphdl_n123, Vss) <+ 2.0000000000000002e-15 * ddt(V(cpphdl_n123, Vss)); // Bench initial voltage = 0.0 V.
        // device 109, IC IC16, analog/basic/cmos_storage.hpp:58
        I(cpphdl_n473, Vss) <+ 2.0000000000000002e-15 * ddt(V(cpphdl_n473, Vss)); // Bench initial voltage = 0.0 V.
        // device 110, IC IC16, analog/basic/cmos_storage.hpp:59
        I(CLEAR, Vss) <+ 2.0000000000000002e-15 * ddt(V(CLEAR, Vss)); // Bench initial voltage = 0.0 V.
        // device 111, IC IC78, analog/basic/inverter.hpp:11
        I(cpphdl_n436, Vlogic) <+ cpphdl_channel(V(CLEAR, Vlogic), V(cpphdl_n436, Vlogic), 0.01, 0.34999999999999998, -1.0);
        // device 112, IC IC78, analog/basic/inverter.hpp:12
        I(cpphdl_n436, Vss) <+ cpphdl_channel(V(CLEAR, Vss), V(cpphdl_n436, Vss), 0.01, 0.34999999999999998, 1.0);
        // device 113, IC IC27, analog/basic/phase_frequency_detector.hpp:43
        I(cpphdl_n436, Vss) <+ 5e-15 * ddt(V(cpphdl_n436, Vss)); // Bench initial voltage = 0.0 V.
        // device 114, IC IC76, analog/basic/cmos_logic.hpp:15
        I(cpphdl_n435, Vss) <+ 5e-15 * ddt(V(cpphdl_n435, Vss)); // Bench initial voltage = 0.0 V.
        // device 115, IC IC76, analog/basic/cmos_logic.hpp:16
        I(cpphdl_n435, Vlogic) <+ cpphdl_channel(V(cpphdl_n288, Vlogic), V(cpphdl_n435, Vlogic), 0.01, 0.34999999999999998, -1.0);
        // device 116, IC IC76, analog/basic/cmos_logic.hpp:17
        I(cpphdl_n435, Vlogic) <+ cpphdl_channel(V(cpphdl_n419, Vlogic), V(cpphdl_n435, Vlogic), 0.01, 0.34999999999999998, -1.0);
        // device 117, IC IC76, analog/basic/cmos_logic.hpp:18
        I(cpphdl_n435, cpphdl_n432) <+ cpphdl_channel(V(cpphdl_n288, cpphdl_n432), V(cpphdl_n435, cpphdl_n432), 0.01, 0.34999999999999998, 1.0);
        // device 118, IC IC76, analog/basic/cmos_logic.hpp:19
        I(cpphdl_n432, Vss) <+ cpphdl_channel(V(cpphdl_n419, Vss), V(cpphdl_n432, Vss), 0.01, 0.34999999999999998, 1.0);
        // device 119, IC IC76, analog/basic/cmos_logic.hpp:20
        I(cpphdl_n435, Vss) <+ V(cpphdl_n435, Vss) / 1000000000.0;
        // device 120, IC IC76, analog/basic/cmos_logic.hpp:21
        I(cpphdl_n432, Vss) <+ V(cpphdl_n432, Vss) / 1000000000.0;
        // device 121, IC IC77, analog/basic/cmos_logic.hpp:15
        I(cpphdl_n437, Vss) <+ 5e-15 * ddt(V(cpphdl_n437, Vss)); // Bench initial voltage = 0.0 V.
        // device 122, IC IC77, analog/basic/cmos_logic.hpp:16
        I(cpphdl_n437, Vlogic) <+ cpphdl_channel(V(cpphdl_n435, Vlogic), V(cpphdl_n437, Vlogic), 0.01, 0.34999999999999998, -1.0);
        // device 123, IC IC77, analog/basic/cmos_logic.hpp:17
        I(cpphdl_n437, Vlogic) <+ cpphdl_channel(V(cpphdl_n436, Vlogic), V(cpphdl_n437, Vlogic), 0.01, 0.34999999999999998, -1.0);
        // device 124, IC IC77, analog/basic/cmos_logic.hpp:18
        I(cpphdl_n437, cpphdl_n438) <+ cpphdl_channel(V(cpphdl_n435, cpphdl_n438), V(cpphdl_n437, cpphdl_n438), 0.01, 0.34999999999999998, 1.0);
        // device 125, IC IC77, analog/basic/cmos_logic.hpp:19
        I(cpphdl_n438, Vss) <+ cpphdl_channel(V(cpphdl_n436, Vss), V(cpphdl_n438, Vss), 0.01, 0.34999999999999998, 1.0);
        // device 126, IC IC77, analog/basic/cmos_logic.hpp:20
        I(cpphdl_n437, Vss) <+ V(cpphdl_n437, Vss) / 1000000000.0;
        // device 127, IC IC77, analog/basic/cmos_logic.hpp:21
        I(cpphdl_n438, Vss) <+ V(cpphdl_n438, Vss) / 1000000000.0;
        // device 128, IC IC29, analog/basic/inverter.hpp:11
        I(cpphdl_n197, Vlogic) <+ cpphdl_channel(V(REF, Vlogic), V(cpphdl_n197, Vlogic), 0.01, 0.34999999999999998, -1.0);
        // device 129, IC IC29, analog/basic/inverter.hpp:12
        I(cpphdl_n197, Vss) <+ cpphdl_channel(V(REF, Vss), V(cpphdl_n197, Vss), 0.01, 0.34999999999999998, 1.0);
        // device 130, IC IC28, analog/basic/cmos_storage.hpp:83
        I(cpphdl_n197, Vss) <+ 5e-15 * ddt(V(cpphdl_n197, Vss)); // Bench initial voltage = 0.0 V.
        // device 131, IC IC31, analog/basic/inverter.hpp:11
        I(cpphdl_n209, Vlogic) <+ cpphdl_channel(V(Vlogic, Vlogic), V(cpphdl_n209, Vlogic), 0.01, 0.34999999999999998, -1.0);
        // device 132, IC IC31, analog/basic/inverter.hpp:12
        I(cpphdl_n209, Vss) <+ cpphdl_channel(V(Vlogic, Vss), V(cpphdl_n209, Vss), 0.01, 0.34999999999999998, 1.0);
        // device 133, IC IC30, analog/basic/cmos_storage.hpp:41
        I(cpphdl_n209, Vss) <+ 5e-15 * ddt(V(cpphdl_n209, Vss)); // Bench initial voltage = 0.0 V.
        // device 134, IC IC32, analog/basic/inverter.hpp:11
        I(cpphdl_n198, Vlogic) <+ cpphdl_channel(V(cpphdl_n425, Vlogic), V(cpphdl_n198, Vlogic), 0.01, 0.34999999999999998, -1.0);
        // device 135, IC IC32, analog/basic/inverter.hpp:12
        I(cpphdl_n198, Vss) <+ cpphdl_channel(V(cpphdl_n425, Vss), V(cpphdl_n198, Vss), 0.01, 0.34999999999999998, 1.0);
        // device 136, IC IC30, analog/basic/cmos_storage.hpp:41
        I(cpphdl_n198, Vss) <+ 5e-15 * ddt(V(cpphdl_n198, Vss)); // Bench initial voltage = 0.0 V.
        // device 137, IC IC33, analog/basic/inverter.hpp:11
        I(cpphdl_n210, Vlogic) <+ cpphdl_channel(V(cpphdl_n193, Vlogic), V(cpphdl_n210, Vlogic), 0.01, 0.34999999999999998, -1.0);
        // device 138, IC IC33, analog/basic/inverter.hpp:12
        I(cpphdl_n210, Vss) <+ cpphdl_channel(V(cpphdl_n193, Vss), V(cpphdl_n210, Vss), 0.01, 0.34999999999999998, 1.0);
        // device 139, IC IC30, analog/basic/cmos_storage.hpp:41
        I(cpphdl_n210, Vss) <+ 5e-15 * ddt(V(cpphdl_n210, Vss)); // Bench initial voltage = 0.0 V.
        // device 140, IC IC34, analog/basic/cmos_logic.hpp:15
        I(cpphdl_n193, Vss) <+ 5e-15 * ddt(V(cpphdl_n193, Vss)); // Bench initial voltage = 0.0 V.
        // device 141, IC IC34, analog/basic/cmos_logic.hpp:16
        I(cpphdl_n193, Vlogic) <+ cpphdl_channel(V(cpphdl_n197, Vlogic), V(cpphdl_n193, Vlogic), 0.01, 0.34999999999999998, -1.0);
        // device 142, IC IC34, analog/basic/cmos_logic.hpp:17
        I(cpphdl_n193, Vlogic) <+ cpphdl_channel(V(cpphdl_n198, Vlogic), V(cpphdl_n193, Vlogic), 0.01, 0.34999999999999998, -1.0);
        // device 143, IC IC34, analog/basic/cmos_logic.hpp:18
        I(cpphdl_n193, cpphdl_n200) <+ cpphdl_channel(V(cpphdl_n197, cpphdl_n200), V(cpphdl_n193, cpphdl_n200), 0.01, 0.34999999999999998, 1.0);
        // device 144, IC IC34, analog/basic/cmos_logic.hpp:19
        I(cpphdl_n200, Vss) <+ cpphdl_channel(V(cpphdl_n198, Vss), V(cpphdl_n200, Vss), 0.01, 0.34999999999999998, 1.0);
        // device 145, IC IC34, analog/basic/cmos_logic.hpp:20
        I(cpphdl_n193, Vss) <+ V(cpphdl_n193, Vss) / 1000000000.0;
        // device 146, IC IC34, analog/basic/cmos_logic.hpp:21
        I(cpphdl_n200, Vss) <+ V(cpphdl_n200, Vss) / 1000000000.0;
        // device 147, IC IC35, analog/basic/cmos_logic.hpp:15
        I(cpphdl_n221, Vss) <+ 5e-15 * ddt(V(cpphdl_n221, Vss)); // Bench initial voltage = 0.0 V.
        // device 148, IC IC35, analog/basic/cmos_logic.hpp:16
        I(cpphdl_n221, Vlogic) <+ cpphdl_channel(V(Vlogic, Vlogic), V(cpphdl_n221, Vlogic), 0.01, 0.34999999999999998, -1.0);
        // device 149, IC IC35, analog/basic/cmos_logic.hpp:17
        I(cpphdl_n221, Vlogic) <+ cpphdl_channel(V(cpphdl_n210, Vlogic), V(cpphdl_n221, Vlogic), 0.01, 0.34999999999999998, -1.0);
        // device 150, IC IC35, analog/basic/cmos_logic.hpp:18
        I(cpphdl_n221, cpphdl_n206) <+ cpphdl_channel(V(Vlogic, cpphdl_n206), V(cpphdl_n221, cpphdl_n206), 0.01, 0.34999999999999998, 1.0);
        // device 151, IC IC35, analog/basic/cmos_logic.hpp:19
        I(cpphdl_n206, Vss) <+ cpphdl_channel(V(cpphdl_n210, Vss), V(cpphdl_n206, Vss), 0.01, 0.34999999999999998, 1.0);
        // device 152, IC IC35, analog/basic/cmos_logic.hpp:20
        I(cpphdl_n221, Vss) <+ V(cpphdl_n221, Vss) / 1000000000.0;
        // device 153, IC IC35, analog/basic/cmos_logic.hpp:21
        I(cpphdl_n206, Vss) <+ V(cpphdl_n206, Vss) / 1000000000.0;
        // device 154, IC IC36, analog/basic/cmos_logic.hpp:15
        I(cpphdl_n227, Vss) <+ 5e-15 * ddt(V(cpphdl_n227, Vss)); // Bench initial voltage = 0.0 V.
        // device 155, IC IC36, analog/basic/cmos_logic.hpp:16
        I(cpphdl_n227, Vlogic) <+ cpphdl_channel(V(cpphdl_n209, Vlogic), V(cpphdl_n227, Vlogic), 0.01, 0.34999999999999998, -1.0);
        // device 156, IC IC36, analog/basic/cmos_logic.hpp:17
        I(cpphdl_n227, Vlogic) <+ cpphdl_channel(V(cpphdl_n210, Vlogic), V(cpphdl_n227, Vlogic), 0.01, 0.34999999999999998, -1.0);
        // device 157, IC IC36, analog/basic/cmos_logic.hpp:18
        I(cpphdl_n227, cpphdl_n212) <+ cpphdl_channel(V(cpphdl_n209, cpphdl_n212), V(cpphdl_n227, cpphdl_n212), 0.01, 0.34999999999999998, 1.0);
        // device 158, IC IC36, analog/basic/cmos_logic.hpp:19
        I(cpphdl_n212, Vss) <+ cpphdl_channel(V(cpphdl_n210, Vss), V(cpphdl_n212, Vss), 0.01, 0.34999999999999998, 1.0);
        // device 159, IC IC36, analog/basic/cmos_logic.hpp:20
        I(cpphdl_n227, Vss) <+ V(cpphdl_n227, Vss) / 1000000000.0;
        // device 160, IC IC36, analog/basic/cmos_logic.hpp:21
        I(cpphdl_n212, Vss) <+ V(cpphdl_n212, Vss) / 1000000000.0;
        // device 161, IC IC38, analog/basic/cmos_logic.hpp:15
        I(cpphdl_n263, Vss) <+ 5e-15 * ddt(V(cpphdl_n263, Vss)); // Bench initial voltage = 0.0 V.
        // device 162, IC IC38, analog/basic/cmos_logic.hpp:16
        I(cpphdl_n263, Vlogic) <+ cpphdl_channel(V(cpphdl_n221, Vlogic), V(cpphdl_n263, Vlogic), 0.01, 0.34999999999999998, -1.0);
        // device 163, IC IC38, analog/basic/cmos_logic.hpp:17
        I(cpphdl_n263, Vlogic) <+ cpphdl_channel(V(cpphdl_n229, Vlogic), V(cpphdl_n263, Vlogic), 0.01, 0.34999999999999998, -1.0);
        // device 164, IC IC38, analog/basic/cmos_logic.hpp:18
        I(cpphdl_n263, cpphdl_n224) <+ cpphdl_channel(V(cpphdl_n221, cpphdl_n224), V(cpphdl_n263, cpphdl_n224), 0.01, 0.34999999999999998, 1.0);
        // device 165, IC IC38, analog/basic/cmos_logic.hpp:19
        I(cpphdl_n224, Vss) <+ cpphdl_channel(V(cpphdl_n229, Vss), V(cpphdl_n224, Vss), 0.01, 0.34999999999999998, 1.0);
        // device 166, IC IC38, analog/basic/cmos_logic.hpp:20
        I(cpphdl_n263, Vss) <+ V(cpphdl_n263, Vss) / 1000000000.0;
        // device 167, IC IC38, analog/basic/cmos_logic.hpp:21
        I(cpphdl_n224, Vss) <+ V(cpphdl_n224, Vss) / 1000000000.0;
        // device 168, IC IC39, analog/basic/cmos_logic.hpp:15
        I(cpphdl_n229, Vss) <+ 5e-15 * ddt(V(cpphdl_n229, Vss)); // Bench initial voltage = 0.0 V.
        // device 169, IC IC39, analog/basic/cmos_logic.hpp:16
        I(cpphdl_n229, Vlogic) <+ cpphdl_channel(V(cpphdl_n227, Vlogic), V(cpphdl_n229, Vlogic), 0.01, 0.34999999999999998, -1.0);
        // device 170, IC IC39, analog/basic/cmos_logic.hpp:17
        I(cpphdl_n229, Vlogic) <+ cpphdl_channel(V(cpphdl_n263, Vlogic), V(cpphdl_n229, Vlogic), 0.01, 0.34999999999999998, -1.0);
        // device 171, IC IC39, analog/basic/cmos_logic.hpp:18
        I(cpphdl_n229, cpphdl_n230) <+ cpphdl_channel(V(cpphdl_n227, cpphdl_n230), V(cpphdl_n229, cpphdl_n230), 0.01, 0.34999999999999998, 1.0);
        // device 172, IC IC39, analog/basic/cmos_logic.hpp:19
        I(cpphdl_n230, Vss) <+ cpphdl_channel(V(cpphdl_n263, Vss), V(cpphdl_n230, Vss), 0.01, 0.34999999999999998, 1.0);
        // device 173, IC IC39, analog/basic/cmos_logic.hpp:20
        I(cpphdl_n229, Vss) <+ V(cpphdl_n229, Vss) / 1000000000.0;
        // device 174, IC IC39, analog/basic/cmos_logic.hpp:21
        I(cpphdl_n230, Vss) <+ V(cpphdl_n230, Vss) / 1000000000.0;
        // device 175, IC IC37, analog/basic/nand_latch.hpp:34
        I(cpphdl_n221, Vss) <+ 2.0000000000000002e-15 * ddt(V(cpphdl_n221, Vss)); // Bench initial voltage = 0.0 V.
        // device 176, IC IC37, analog/basic/nand_latch.hpp:35
        I(cpphdl_n227, Vss) <+ 2.0000000000000002e-15 * ddt(V(cpphdl_n227, Vss)); // Bench initial voltage = 0.0 V.
        // device 177, IC IC40, analog/basic/inverter.hpp:11
        I(cpphdl_n235, Vlogic) <+ cpphdl_channel(V(cpphdl_n425, Vlogic), V(cpphdl_n235, Vlogic), 0.01, 0.34999999999999998, -1.0);
        // device 178, IC IC40, analog/basic/inverter.hpp:12
        I(cpphdl_n235, Vss) <+ cpphdl_channel(V(cpphdl_n425, Vss), V(cpphdl_n235, Vss), 0.01, 0.34999999999999998, 1.0);
        // device 179, IC IC37, analog/basic/nand_latch.hpp:56
        I(cpphdl_n235, Vss) <+ 2.0000000000000002e-15 * ddt(V(cpphdl_n235, Vss)); // Bench initial voltage = 0.0 V.
        // device 180, IC IC37, analog/basic/nand_latch.hpp:57
        I(cpphdl_n263, Vss) <+ cpphdl_channel(V(cpphdl_n425, Vss), V(cpphdl_n263, Vss), 0.050000000000000003, 0.34999999999999998, 1.0);
        // device 181, IC IC37, analog/basic/nand_latch.hpp:58
        I(cpphdl_n229, Vlogic) <+ cpphdl_channel(V(cpphdl_n235, Vlogic), V(cpphdl_n229, Vlogic), 0.050000000000000003, 0.34999999999999998, -1.0);
        // device 182, IC IC30, analog/basic/cmos_storage.hpp:57
        I(Vlogic, Vss) <+ 2.0000000000000002e-15 * ddt(V(Vlogic, Vss)); // Bench initial voltage = 0.0 V.
        // device 183, IC IC30, analog/basic/cmos_storage.hpp:58
        I(cpphdl_n197, Vss) <+ 2.0000000000000002e-15 * ddt(V(cpphdl_n197, Vss)); // Bench initial voltage = 0.0 V.
        // device 184, IC IC30, analog/basic/cmos_storage.hpp:59
        I(cpphdl_n425, Vss) <+ 2.0000000000000002e-15 * ddt(V(cpphdl_n425, Vss)); // Bench initial voltage = 0.0 V.
        // device 185, IC IC42, analog/basic/inverter.hpp:11
        I(cpphdl_n269, Vlogic) <+ cpphdl_channel(V(cpphdl_n263, Vlogic), V(cpphdl_n269, Vlogic), 0.01, 0.34999999999999998, -1.0);
        // device 186, IC IC42, analog/basic/inverter.hpp:12
        I(cpphdl_n269, Vss) <+ cpphdl_channel(V(cpphdl_n263, Vss), V(cpphdl_n269, Vss), 0.01, 0.34999999999999998, 1.0);
        // device 187, IC IC41, analog/basic/cmos_storage.hpp:41
        I(cpphdl_n269, Vss) <+ 5e-15 * ddt(V(cpphdl_n269, Vss)); // Bench initial voltage = 0.0 V.
        // device 188, IC IC43, analog/basic/inverter.hpp:11
        I(cpphdl_n258, Vlogic) <+ cpphdl_channel(V(cpphdl_n425, Vlogic), V(cpphdl_n258, Vlogic), 0.01, 0.34999999999999998, -1.0);
        // device 189, IC IC43, analog/basic/inverter.hpp:12
        I(cpphdl_n258, Vss) <+ cpphdl_channel(V(cpphdl_n425, Vss), V(cpphdl_n258, Vss), 0.01, 0.34999999999999998, 1.0);
        // device 190, IC IC41, analog/basic/cmos_storage.hpp:41
        I(cpphdl_n258, Vss) <+ 5e-15 * ddt(V(cpphdl_n258, Vss)); // Bench initial voltage = 0.0 V.
        // device 191, IC IC44, analog/basic/inverter.hpp:11
        I(cpphdl_n270, Vlogic) <+ cpphdl_channel(V(cpphdl_n253, Vlogic), V(cpphdl_n270, Vlogic), 0.01, 0.34999999999999998, -1.0);
        // device 192, IC IC44, analog/basic/inverter.hpp:12
        I(cpphdl_n270, Vss) <+ cpphdl_channel(V(cpphdl_n253, Vss), V(cpphdl_n270, Vss), 0.01, 0.34999999999999998, 1.0);
        // device 193, IC IC41, analog/basic/cmos_storage.hpp:41
        I(cpphdl_n270, Vss) <+ 5e-15 * ddt(V(cpphdl_n270, Vss)); // Bench initial voltage = 0.0 V.
        // device 194, IC IC45, analog/basic/cmos_logic.hpp:15
        I(cpphdl_n253, Vss) <+ 5e-15 * ddt(V(cpphdl_n253, Vss)); // Bench initial voltage = 0.0 V.
        // device 195, IC IC45, analog/basic/cmos_logic.hpp:16
        I(cpphdl_n253, Vlogic) <+ cpphdl_channel(V(REF, Vlogic), V(cpphdl_n253, Vlogic), 0.01, 0.34999999999999998, -1.0);
        // device 196, IC IC45, analog/basic/cmos_logic.hpp:17
        I(cpphdl_n253, Vlogic) <+ cpphdl_channel(V(cpphdl_n258, Vlogic), V(cpphdl_n253, Vlogic), 0.01, 0.34999999999999998, -1.0);
        // device 197, IC IC45, analog/basic/cmos_logic.hpp:18
        I(cpphdl_n253, cpphdl_n260) <+ cpphdl_channel(V(REF, cpphdl_n260), V(cpphdl_n253, cpphdl_n260), 0.01, 0.34999999999999998, 1.0);
        // device 198, IC IC45, analog/basic/cmos_logic.hpp:19
        I(cpphdl_n260, Vss) <+ cpphdl_channel(V(cpphdl_n258, Vss), V(cpphdl_n260, Vss), 0.01, 0.34999999999999998, 1.0);
        // device 199, IC IC45, analog/basic/cmos_logic.hpp:20
        I(cpphdl_n253, Vss) <+ V(cpphdl_n253, Vss) / 1000000000.0;
        // device 200, IC IC45, analog/basic/cmos_logic.hpp:21
        I(cpphdl_n260, Vss) <+ V(cpphdl_n260, Vss) / 1000000000.0;
        // device 201, IC IC46, analog/basic/cmos_logic.hpp:15
        I(cpphdl_n281, Vss) <+ 5e-15 * ddt(V(cpphdl_n281, Vss)); // Bench initial voltage = 0.0 V.
        // device 202, IC IC46, analog/basic/cmos_logic.hpp:16
        I(cpphdl_n281, Vlogic) <+ cpphdl_channel(V(cpphdl_n263, Vlogic), V(cpphdl_n281, Vlogic), 0.01, 0.34999999999999998, -1.0);
        // device 203, IC IC46, analog/basic/cmos_logic.hpp:17
        I(cpphdl_n281, Vlogic) <+ cpphdl_channel(V(cpphdl_n270, Vlogic), V(cpphdl_n281, Vlogic), 0.01, 0.34999999999999998, -1.0);
        // device 204, IC IC46, analog/basic/cmos_logic.hpp:18
        I(cpphdl_n281, cpphdl_n266) <+ cpphdl_channel(V(cpphdl_n263, cpphdl_n266), V(cpphdl_n281, cpphdl_n266), 0.01, 0.34999999999999998, 1.0);
        // device 205, IC IC46, analog/basic/cmos_logic.hpp:19
        I(cpphdl_n266, Vss) <+ cpphdl_channel(V(cpphdl_n270, Vss), V(cpphdl_n266, Vss), 0.01, 0.34999999999999998, 1.0);
        // device 206, IC IC46, analog/basic/cmos_logic.hpp:20
        I(cpphdl_n281, Vss) <+ V(cpphdl_n281, Vss) / 1000000000.0;
        // device 207, IC IC46, analog/basic/cmos_logic.hpp:21
        I(cpphdl_n266, Vss) <+ V(cpphdl_n266, Vss) / 1000000000.0;
        // device 208, IC IC47, analog/basic/cmos_logic.hpp:15
        I(cpphdl_n287, Vss) <+ 5e-15 * ddt(V(cpphdl_n287, Vss)); // Bench initial voltage = 0.0 V.
        // device 209, IC IC47, analog/basic/cmos_logic.hpp:16
        I(cpphdl_n287, Vlogic) <+ cpphdl_channel(V(cpphdl_n269, Vlogic), V(cpphdl_n287, Vlogic), 0.01, 0.34999999999999998, -1.0);
        // device 210, IC IC47, analog/basic/cmos_logic.hpp:17
        I(cpphdl_n287, Vlogic) <+ cpphdl_channel(V(cpphdl_n270, Vlogic), V(cpphdl_n287, Vlogic), 0.01, 0.34999999999999998, -1.0);
        // device 211, IC IC47, analog/basic/cmos_logic.hpp:18
        I(cpphdl_n287, cpphdl_n272) <+ cpphdl_channel(V(cpphdl_n269, cpphdl_n272), V(cpphdl_n287, cpphdl_n272), 0.01, 0.34999999999999998, 1.0);
        // device 212, IC IC47, analog/basic/cmos_logic.hpp:19
        I(cpphdl_n272, Vss) <+ cpphdl_channel(V(cpphdl_n270, Vss), V(cpphdl_n272, Vss), 0.01, 0.34999999999999998, 1.0);
        // device 213, IC IC47, analog/basic/cmos_logic.hpp:20
        I(cpphdl_n287, Vss) <+ V(cpphdl_n287, Vss) / 1000000000.0;
        // device 214, IC IC47, analog/basic/cmos_logic.hpp:21
        I(cpphdl_n272, Vss) <+ V(cpphdl_n272, Vss) / 1000000000.0;
        // device 215, IC IC49, analog/basic/cmos_logic.hpp:15
        I(cpphdl_n288, Vss) <+ 5e-15 * ddt(V(cpphdl_n288, Vss)); // Bench initial voltage = 0.0 V.
        // device 216, IC IC49, analog/basic/cmos_logic.hpp:16
        I(cpphdl_n288, Vlogic) <+ cpphdl_channel(V(cpphdl_n281, Vlogic), V(cpphdl_n288, Vlogic), 0.01, 0.34999999999999998, -1.0);
        // device 217, IC IC49, analog/basic/cmos_logic.hpp:17
        I(cpphdl_n288, Vlogic) <+ cpphdl_channel(V(cpphdl_n289, Vlogic), V(cpphdl_n288, Vlogic), 0.01, 0.34999999999999998, -1.0);
        // device 218, IC IC49, analog/basic/cmos_logic.hpp:18
        I(cpphdl_n288, cpphdl_n284) <+ cpphdl_channel(V(cpphdl_n281, cpphdl_n284), V(cpphdl_n288, cpphdl_n284), 0.01, 0.34999999999999998, 1.0);
        // device 219, IC IC49, analog/basic/cmos_logic.hpp:19
        I(cpphdl_n284, Vss) <+ cpphdl_channel(V(cpphdl_n289, Vss), V(cpphdl_n284, Vss), 0.01, 0.34999999999999998, 1.0);
        // device 220, IC IC49, analog/basic/cmos_logic.hpp:20
        I(cpphdl_n288, Vss) <+ V(cpphdl_n288, Vss) / 1000000000.0;
        // device 221, IC IC49, analog/basic/cmos_logic.hpp:21
        I(cpphdl_n284, Vss) <+ V(cpphdl_n284, Vss) / 1000000000.0;
        // device 222, IC IC50, analog/basic/cmos_logic.hpp:15
        I(cpphdl_n289, Vss) <+ 5e-15 * ddt(V(cpphdl_n289, Vss)); // Bench initial voltage = 0.0 V.
        // device 223, IC IC50, analog/basic/cmos_logic.hpp:16
        I(cpphdl_n289, Vlogic) <+ cpphdl_channel(V(cpphdl_n287, Vlogic), V(cpphdl_n289, Vlogic), 0.01, 0.34999999999999998, -1.0);
        // device 224, IC IC50, analog/basic/cmos_logic.hpp:17
        I(cpphdl_n289, Vlogic) <+ cpphdl_channel(V(cpphdl_n288, Vlogic), V(cpphdl_n289, Vlogic), 0.01, 0.34999999999999998, -1.0);
        // device 225, IC IC50, analog/basic/cmos_logic.hpp:18
        I(cpphdl_n289, cpphdl_n290) <+ cpphdl_channel(V(cpphdl_n287, cpphdl_n290), V(cpphdl_n289, cpphdl_n290), 0.01, 0.34999999999999998, 1.0);
        // device 226, IC IC50, analog/basic/cmos_logic.hpp:19
        I(cpphdl_n290, Vss) <+ cpphdl_channel(V(cpphdl_n288, Vss), V(cpphdl_n290, Vss), 0.01, 0.34999999999999998, 1.0);
        // device 227, IC IC50, analog/basic/cmos_logic.hpp:20
        I(cpphdl_n289, Vss) <+ V(cpphdl_n289, Vss) / 1000000000.0;
        // device 228, IC IC50, analog/basic/cmos_logic.hpp:21
        I(cpphdl_n290, Vss) <+ V(cpphdl_n290, Vss) / 1000000000.0;
        // device 229, IC IC48, analog/basic/nand_latch.hpp:34
        I(cpphdl_n281, Vss) <+ 2.0000000000000002e-15 * ddt(V(cpphdl_n281, Vss)); // Bench initial voltage = 0.0 V.
        // device 230, IC IC48, analog/basic/nand_latch.hpp:35
        I(cpphdl_n287, Vss) <+ 2.0000000000000002e-15 * ddt(V(cpphdl_n287, Vss)); // Bench initial voltage = 0.0 V.
        // device 231, IC IC51, analog/basic/inverter.hpp:11
        I(cpphdl_n295, Vlogic) <+ cpphdl_channel(V(cpphdl_n425, Vlogic), V(cpphdl_n295, Vlogic), 0.01, 0.34999999999999998, -1.0);
        // device 232, IC IC51, analog/basic/inverter.hpp:12
        I(cpphdl_n295, Vss) <+ cpphdl_channel(V(cpphdl_n425, Vss), V(cpphdl_n295, Vss), 0.01, 0.34999999999999998, 1.0);
        // device 233, IC IC48, analog/basic/nand_latch.hpp:56
        I(cpphdl_n295, Vss) <+ 2.0000000000000002e-15 * ddt(V(cpphdl_n295, Vss)); // Bench initial voltage = 0.0 V.
        // device 234, IC IC48, analog/basic/nand_latch.hpp:57
        I(cpphdl_n288, Vss) <+ cpphdl_channel(V(cpphdl_n425, Vss), V(cpphdl_n288, Vss), 0.050000000000000003, 0.34999999999999998, 1.0);
        // device 235, IC IC48, analog/basic/nand_latch.hpp:58
        I(cpphdl_n289, Vlogic) <+ cpphdl_channel(V(cpphdl_n295, Vlogic), V(cpphdl_n289, Vlogic), 0.050000000000000003, 0.34999999999999998, -1.0);
        // device 236, IC IC41, analog/basic/cmos_storage.hpp:57
        I(cpphdl_n263, Vss) <+ 2.0000000000000002e-15 * ddt(V(cpphdl_n263, Vss)); // Bench initial voltage = 0.0 V.
        // device 237, IC IC41, analog/basic/cmos_storage.hpp:58
        I(REF, Vss) <+ 2.0000000000000002e-15 * ddt(V(REF, Vss)); // Bench initial voltage = 0.0 V.
        // device 238, IC IC41, analog/basic/cmos_storage.hpp:59
        I(cpphdl_n425, Vss) <+ 2.0000000000000002e-15 * ddt(V(cpphdl_n425, Vss)); // Bench initial voltage = 0.0 V.
        // device 239, IC IC53, analog/basic/inverter.hpp:11
        I(cpphdl_n328, Vlogic) <+ cpphdl_channel(V(cpphdl_n388, Vlogic), V(cpphdl_n328, Vlogic), 0.01, 0.34999999999999998, -1.0);
        // device 240, IC IC53, analog/basic/inverter.hpp:12
        I(cpphdl_n328, Vss) <+ cpphdl_channel(V(cpphdl_n388, Vss), V(cpphdl_n328, Vss), 0.01, 0.34999999999999998, 1.0);
        // device 241, IC IC52, analog/basic/cmos_storage.hpp:83
        I(cpphdl_n328, Vss) <+ 5e-15 * ddt(V(cpphdl_n328, Vss)); // Bench initial voltage = 0.0 V.
        // device 242, IC IC55, analog/basic/inverter.hpp:11
        I(cpphdl_n340, Vlogic) <+ cpphdl_channel(V(Vlogic, Vlogic), V(cpphdl_n340, Vlogic), 0.01, 0.34999999999999998, -1.0);
        // device 243, IC IC55, analog/basic/inverter.hpp:12
        I(cpphdl_n340, Vss) <+ cpphdl_channel(V(Vlogic, Vss), V(cpphdl_n340, Vss), 0.01, 0.34999999999999998, 1.0);
        // device 244, IC IC54, analog/basic/cmos_storage.hpp:41
        I(cpphdl_n340, Vss) <+ 5e-15 * ddt(V(cpphdl_n340, Vss)); // Bench initial voltage = 0.0 V.
        // device 245, IC IC56, analog/basic/inverter.hpp:11
        I(cpphdl_n329, Vlogic) <+ cpphdl_channel(V(cpphdl_n425, Vlogic), V(cpphdl_n329, Vlogic), 0.01, 0.34999999999999998, -1.0);
        // device 246, IC IC56, analog/basic/inverter.hpp:12
        I(cpphdl_n329, Vss) <+ cpphdl_channel(V(cpphdl_n425, Vss), V(cpphdl_n329, Vss), 0.01, 0.34999999999999998, 1.0);
        // device 247, IC IC54, analog/basic/cmos_storage.hpp:41
        I(cpphdl_n329, Vss) <+ 5e-15 * ddt(V(cpphdl_n329, Vss)); // Bench initial voltage = 0.0 V.
        // device 248, IC IC57, analog/basic/inverter.hpp:11
        I(cpphdl_n341, Vlogic) <+ cpphdl_channel(V(cpphdl_n324, Vlogic), V(cpphdl_n341, Vlogic), 0.01, 0.34999999999999998, -1.0);
        // device 249, IC IC57, analog/basic/inverter.hpp:12
        I(cpphdl_n341, Vss) <+ cpphdl_channel(V(cpphdl_n324, Vss), V(cpphdl_n341, Vss), 0.01, 0.34999999999999998, 1.0);
        // device 250, IC IC54, analog/basic/cmos_storage.hpp:41
        I(cpphdl_n341, Vss) <+ 5e-15 * ddt(V(cpphdl_n341, Vss)); // Bench initial voltage = 0.0 V.
        // device 251, IC IC58, analog/basic/cmos_logic.hpp:15
        I(cpphdl_n324, Vss) <+ 5e-15 * ddt(V(cpphdl_n324, Vss)); // Bench initial voltage = 0.0 V.
        // device 252, IC IC58, analog/basic/cmos_logic.hpp:16
        I(cpphdl_n324, Vlogic) <+ cpphdl_channel(V(cpphdl_n328, Vlogic), V(cpphdl_n324, Vlogic), 0.01, 0.34999999999999998, -1.0);
        // device 253, IC IC58, analog/basic/cmos_logic.hpp:17
        I(cpphdl_n324, Vlogic) <+ cpphdl_channel(V(cpphdl_n329, Vlogic), V(cpphdl_n324, Vlogic), 0.01, 0.34999999999999998, -1.0);
        // device 254, IC IC58, analog/basic/cmos_logic.hpp:18
        I(cpphdl_n324, cpphdl_n331) <+ cpphdl_channel(V(cpphdl_n328, cpphdl_n331), V(cpphdl_n324, cpphdl_n331), 0.01, 0.34999999999999998, 1.0);
        // device 255, IC IC58, analog/basic/cmos_logic.hpp:19
        I(cpphdl_n331, Vss) <+ cpphdl_channel(V(cpphdl_n329, Vss), V(cpphdl_n331, Vss), 0.01, 0.34999999999999998, 1.0);
        // device 256, IC IC58, analog/basic/cmos_logic.hpp:20
        I(cpphdl_n324, Vss) <+ V(cpphdl_n324, Vss) / 1000000000.0;
        // device 257, IC IC58, analog/basic/cmos_logic.hpp:21
        I(cpphdl_n331, Vss) <+ V(cpphdl_n331, Vss) / 1000000000.0;
        // device 258, IC IC59, analog/basic/cmos_logic.hpp:15
        I(cpphdl_n352, Vss) <+ 5e-15 * ddt(V(cpphdl_n352, Vss)); // Bench initial voltage = 0.0 V.
        // device 259, IC IC59, analog/basic/cmos_logic.hpp:16
        I(cpphdl_n352, Vlogic) <+ cpphdl_channel(V(Vlogic, Vlogic), V(cpphdl_n352, Vlogic), 0.01, 0.34999999999999998, -1.0);
        // device 260, IC IC59, analog/basic/cmos_logic.hpp:17
        I(cpphdl_n352, Vlogic) <+ cpphdl_channel(V(cpphdl_n341, Vlogic), V(cpphdl_n352, Vlogic), 0.01, 0.34999999999999998, -1.0);
        // device 261, IC IC59, analog/basic/cmos_logic.hpp:18
        I(cpphdl_n352, cpphdl_n337) <+ cpphdl_channel(V(Vlogic, cpphdl_n337), V(cpphdl_n352, cpphdl_n337), 0.01, 0.34999999999999998, 1.0);
        // device 262, IC IC59, analog/basic/cmos_logic.hpp:19
        I(cpphdl_n337, Vss) <+ cpphdl_channel(V(cpphdl_n341, Vss), V(cpphdl_n337, Vss), 0.01, 0.34999999999999998, 1.0);
        // device 263, IC IC59, analog/basic/cmos_logic.hpp:20
        I(cpphdl_n352, Vss) <+ V(cpphdl_n352, Vss) / 1000000000.0;
        // device 264, IC IC59, analog/basic/cmos_logic.hpp:21
        I(cpphdl_n337, Vss) <+ V(cpphdl_n337, Vss) / 1000000000.0;
        // device 265, IC IC60, analog/basic/cmos_logic.hpp:15
        I(cpphdl_n358, Vss) <+ 5e-15 * ddt(V(cpphdl_n358, Vss)); // Bench initial voltage = 0.0 V.
        // device 266, IC IC60, analog/basic/cmos_logic.hpp:16
        I(cpphdl_n358, Vlogic) <+ cpphdl_channel(V(cpphdl_n340, Vlogic), V(cpphdl_n358, Vlogic), 0.01, 0.34999999999999998, -1.0);
        // device 267, IC IC60, analog/basic/cmos_logic.hpp:17
        I(cpphdl_n358, Vlogic) <+ cpphdl_channel(V(cpphdl_n341, Vlogic), V(cpphdl_n358, Vlogic), 0.01, 0.34999999999999998, -1.0);
        // device 268, IC IC60, analog/basic/cmos_logic.hpp:18
        I(cpphdl_n358, cpphdl_n343) <+ cpphdl_channel(V(cpphdl_n340, cpphdl_n343), V(cpphdl_n358, cpphdl_n343), 0.01, 0.34999999999999998, 1.0);
        // device 269, IC IC60, analog/basic/cmos_logic.hpp:19
        I(cpphdl_n343, Vss) <+ cpphdl_channel(V(cpphdl_n341, Vss), V(cpphdl_n343, Vss), 0.01, 0.34999999999999998, 1.0);
        // device 270, IC IC60, analog/basic/cmos_logic.hpp:20
        I(cpphdl_n358, Vss) <+ V(cpphdl_n358, Vss) / 1000000000.0;
        // device 271, IC IC60, analog/basic/cmos_logic.hpp:21
        I(cpphdl_n343, Vss) <+ V(cpphdl_n343, Vss) / 1000000000.0;
        // device 272, IC IC62, analog/basic/cmos_logic.hpp:15
        I(cpphdl_n394, Vss) <+ 5e-15 * ddt(V(cpphdl_n394, Vss)); // Bench initial voltage = 0.0 V.
        // device 273, IC IC62, analog/basic/cmos_logic.hpp:16
        I(cpphdl_n394, Vlogic) <+ cpphdl_channel(V(cpphdl_n352, Vlogic), V(cpphdl_n394, Vlogic), 0.01, 0.34999999999999998, -1.0);
        // device 274, IC IC62, analog/basic/cmos_logic.hpp:17
        I(cpphdl_n394, Vlogic) <+ cpphdl_channel(V(cpphdl_n360, Vlogic), V(cpphdl_n394, Vlogic), 0.01, 0.34999999999999998, -1.0);
        // device 275, IC IC62, analog/basic/cmos_logic.hpp:18
        I(cpphdl_n394, cpphdl_n355) <+ cpphdl_channel(V(cpphdl_n352, cpphdl_n355), V(cpphdl_n394, cpphdl_n355), 0.01, 0.34999999999999998, 1.0);
        // device 276, IC IC62, analog/basic/cmos_logic.hpp:19
        I(cpphdl_n355, Vss) <+ cpphdl_channel(V(cpphdl_n360, Vss), V(cpphdl_n355, Vss), 0.01, 0.34999999999999998, 1.0);
        // device 277, IC IC62, analog/basic/cmos_logic.hpp:20
        I(cpphdl_n394, Vss) <+ V(cpphdl_n394, Vss) / 1000000000.0;
        // device 278, IC IC62, analog/basic/cmos_logic.hpp:21
        I(cpphdl_n355, Vss) <+ V(cpphdl_n355, Vss) / 1000000000.0;
        // device 279, IC IC63, analog/basic/cmos_logic.hpp:15
        I(cpphdl_n360, Vss) <+ 5e-15 * ddt(V(cpphdl_n360, Vss)); // Bench initial voltage = 0.0 V.
        // device 280, IC IC63, analog/basic/cmos_logic.hpp:16
        I(cpphdl_n360, Vlogic) <+ cpphdl_channel(V(cpphdl_n358, Vlogic), V(cpphdl_n360, Vlogic), 0.01, 0.34999999999999998, -1.0);
        // device 281, IC IC63, analog/basic/cmos_logic.hpp:17
        I(cpphdl_n360, Vlogic) <+ cpphdl_channel(V(cpphdl_n394, Vlogic), V(cpphdl_n360, Vlogic), 0.01, 0.34999999999999998, -1.0);
        // device 282, IC IC63, analog/basic/cmos_logic.hpp:18
        I(cpphdl_n360, cpphdl_n361) <+ cpphdl_channel(V(cpphdl_n358, cpphdl_n361), V(cpphdl_n360, cpphdl_n361), 0.01, 0.34999999999999998, 1.0);
        // device 283, IC IC63, analog/basic/cmos_logic.hpp:19
        I(cpphdl_n361, Vss) <+ cpphdl_channel(V(cpphdl_n394, Vss), V(cpphdl_n361, Vss), 0.01, 0.34999999999999998, 1.0);
        // device 284, IC IC63, analog/basic/cmos_logic.hpp:20
        I(cpphdl_n360, Vss) <+ V(cpphdl_n360, Vss) / 1000000000.0;
        // device 285, IC IC63, analog/basic/cmos_logic.hpp:21
        I(cpphdl_n361, Vss) <+ V(cpphdl_n361, Vss) / 1000000000.0;
        // device 286, IC IC61, analog/basic/nand_latch.hpp:34
        I(cpphdl_n352, Vss) <+ 2.0000000000000002e-15 * ddt(V(cpphdl_n352, Vss)); // Bench initial voltage = 0.0 V.
        // device 287, IC IC61, analog/basic/nand_latch.hpp:35
        I(cpphdl_n358, Vss) <+ 2.0000000000000002e-15 * ddt(V(cpphdl_n358, Vss)); // Bench initial voltage = 0.0 V.
        // device 288, IC IC64, analog/basic/inverter.hpp:11
        I(cpphdl_n366, Vlogic) <+ cpphdl_channel(V(cpphdl_n425, Vlogic), V(cpphdl_n366, Vlogic), 0.01, 0.34999999999999998, -1.0);
        // device 289, IC IC64, analog/basic/inverter.hpp:12
        I(cpphdl_n366, Vss) <+ cpphdl_channel(V(cpphdl_n425, Vss), V(cpphdl_n366, Vss), 0.01, 0.34999999999999998, 1.0);
        // device 290, IC IC61, analog/basic/nand_latch.hpp:56
        I(cpphdl_n366, Vss) <+ 2.0000000000000002e-15 * ddt(V(cpphdl_n366, Vss)); // Bench initial voltage = 0.0 V.
        // device 291, IC IC61, analog/basic/nand_latch.hpp:57
        I(cpphdl_n394, Vss) <+ cpphdl_channel(V(cpphdl_n425, Vss), V(cpphdl_n394, Vss), 0.050000000000000003, 0.34999999999999998, 1.0);
        // device 292, IC IC61, analog/basic/nand_latch.hpp:58
        I(cpphdl_n360, Vlogic) <+ cpphdl_channel(V(cpphdl_n366, Vlogic), V(cpphdl_n360, Vlogic), 0.050000000000000003, 0.34999999999999998, -1.0);
        // device 293, IC IC54, analog/basic/cmos_storage.hpp:57
        I(Vlogic, Vss) <+ 2.0000000000000002e-15 * ddt(V(Vlogic, Vss)); // Bench initial voltage = 0.0 V.
        // device 294, IC IC54, analog/basic/cmos_storage.hpp:58
        I(cpphdl_n328, Vss) <+ 2.0000000000000002e-15 * ddt(V(cpphdl_n328, Vss)); // Bench initial voltage = 0.0 V.
        // device 295, IC IC54, analog/basic/cmos_storage.hpp:59
        I(cpphdl_n425, Vss) <+ 2.0000000000000002e-15 * ddt(V(cpphdl_n425, Vss)); // Bench initial voltage = 0.0 V.
        // device 296, IC IC66, analog/basic/inverter.hpp:11
        I(cpphdl_n400, Vlogic) <+ cpphdl_channel(V(cpphdl_n394, Vlogic), V(cpphdl_n400, Vlogic), 0.01, 0.34999999999999998, -1.0);
        // device 297, IC IC66, analog/basic/inverter.hpp:12
        I(cpphdl_n400, Vss) <+ cpphdl_channel(V(cpphdl_n394, Vss), V(cpphdl_n400, Vss), 0.01, 0.34999999999999998, 1.0);
        // device 298, IC IC65, analog/basic/cmos_storage.hpp:41
        I(cpphdl_n400, Vss) <+ 5e-15 * ddt(V(cpphdl_n400, Vss)); // Bench initial voltage = 0.0 V.
        // device 299, IC IC67, analog/basic/inverter.hpp:11
        I(cpphdl_n389, Vlogic) <+ cpphdl_channel(V(cpphdl_n425, Vlogic), V(cpphdl_n389, Vlogic), 0.01, 0.34999999999999998, -1.0);
        // device 300, IC IC67, analog/basic/inverter.hpp:12
        I(cpphdl_n389, Vss) <+ cpphdl_channel(V(cpphdl_n425, Vss), V(cpphdl_n389, Vss), 0.01, 0.34999999999999998, 1.0);
        // device 301, IC IC65, analog/basic/cmos_storage.hpp:41
        I(cpphdl_n389, Vss) <+ 5e-15 * ddt(V(cpphdl_n389, Vss)); // Bench initial voltage = 0.0 V.
        // device 302, IC IC68, analog/basic/inverter.hpp:11
        I(cpphdl_n401, Vlogic) <+ cpphdl_channel(V(cpphdl_n384, Vlogic), V(cpphdl_n401, Vlogic), 0.01, 0.34999999999999998, -1.0);
        // device 303, IC IC68, analog/basic/inverter.hpp:12
        I(cpphdl_n401, Vss) <+ cpphdl_channel(V(cpphdl_n384, Vss), V(cpphdl_n401, Vss), 0.01, 0.34999999999999998, 1.0);
        // device 304, IC IC65, analog/basic/cmos_storage.hpp:41
        I(cpphdl_n401, Vss) <+ 5e-15 * ddt(V(cpphdl_n401, Vss)); // Bench initial voltage = 0.0 V.
        // device 305, IC IC69, analog/basic/cmos_logic.hpp:15
        I(cpphdl_n384, Vss) <+ 5e-15 * ddt(V(cpphdl_n384, Vss)); // Bench initial voltage = 0.0 V.
        // device 306, IC IC69, analog/basic/cmos_logic.hpp:16
        I(cpphdl_n384, Vlogic) <+ cpphdl_channel(V(cpphdl_n388, Vlogic), V(cpphdl_n384, Vlogic), 0.01, 0.34999999999999998, -1.0);
        // device 307, IC IC69, analog/basic/cmos_logic.hpp:17
        I(cpphdl_n384, Vlogic) <+ cpphdl_channel(V(cpphdl_n389, Vlogic), V(cpphdl_n384, Vlogic), 0.01, 0.34999999999999998, -1.0);
        // device 308, IC IC69, analog/basic/cmos_logic.hpp:18
        I(cpphdl_n384, cpphdl_n391) <+ cpphdl_channel(V(cpphdl_n388, cpphdl_n391), V(cpphdl_n384, cpphdl_n391), 0.01, 0.34999999999999998, 1.0);
        // device 309, IC IC69, analog/basic/cmos_logic.hpp:19
        I(cpphdl_n391, Vss) <+ cpphdl_channel(V(cpphdl_n389, Vss), V(cpphdl_n391, Vss), 0.01, 0.34999999999999998, 1.0);
        // device 310, IC IC69, analog/basic/cmos_logic.hpp:20
        I(cpphdl_n384, Vss) <+ V(cpphdl_n384, Vss) / 1000000000.0;
        // device 311, IC IC69, analog/basic/cmos_logic.hpp:21
        I(cpphdl_n391, Vss) <+ V(cpphdl_n391, Vss) / 1000000000.0;
        // device 312, IC IC70, analog/basic/cmos_logic.hpp:15
        I(cpphdl_n412, Vss) <+ 5e-15 * ddt(V(cpphdl_n412, Vss)); // Bench initial voltage = 0.0 V.
        // device 313, IC IC70, analog/basic/cmos_logic.hpp:16
        I(cpphdl_n412, Vlogic) <+ cpphdl_channel(V(cpphdl_n394, Vlogic), V(cpphdl_n412, Vlogic), 0.01, 0.34999999999999998, -1.0);
        // device 314, IC IC70, analog/basic/cmos_logic.hpp:17
        I(cpphdl_n412, Vlogic) <+ cpphdl_channel(V(cpphdl_n401, Vlogic), V(cpphdl_n412, Vlogic), 0.01, 0.34999999999999998, -1.0);
        // device 315, IC IC70, analog/basic/cmos_logic.hpp:18
        I(cpphdl_n412, cpphdl_n397) <+ cpphdl_channel(V(cpphdl_n394, cpphdl_n397), V(cpphdl_n412, cpphdl_n397), 0.01, 0.34999999999999998, 1.0);
        // device 316, IC IC70, analog/basic/cmos_logic.hpp:19
        I(cpphdl_n397, Vss) <+ cpphdl_channel(V(cpphdl_n401, Vss), V(cpphdl_n397, Vss), 0.01, 0.34999999999999998, 1.0);
        // device 317, IC IC70, analog/basic/cmos_logic.hpp:20
        I(cpphdl_n412, Vss) <+ V(cpphdl_n412, Vss) / 1000000000.0;
        // device 318, IC IC70, analog/basic/cmos_logic.hpp:21
        I(cpphdl_n397, Vss) <+ V(cpphdl_n397, Vss) / 1000000000.0;
        // device 319, IC IC71, analog/basic/cmos_logic.hpp:15
        I(cpphdl_n418, Vss) <+ 5e-15 * ddt(V(cpphdl_n418, Vss)); // Bench initial voltage = 0.0 V.
        // device 320, IC IC71, analog/basic/cmos_logic.hpp:16
        I(cpphdl_n418, Vlogic) <+ cpphdl_channel(V(cpphdl_n400, Vlogic), V(cpphdl_n418, Vlogic), 0.01, 0.34999999999999998, -1.0);
        // device 321, IC IC71, analog/basic/cmos_logic.hpp:17
        I(cpphdl_n418, Vlogic) <+ cpphdl_channel(V(cpphdl_n401, Vlogic), V(cpphdl_n418, Vlogic), 0.01, 0.34999999999999998, -1.0);
        // device 322, IC IC71, analog/basic/cmos_logic.hpp:18
        I(cpphdl_n418, cpphdl_n403) <+ cpphdl_channel(V(cpphdl_n400, cpphdl_n403), V(cpphdl_n418, cpphdl_n403), 0.01, 0.34999999999999998, 1.0);
        // device 323, IC IC71, analog/basic/cmos_logic.hpp:19
        I(cpphdl_n403, Vss) <+ cpphdl_channel(V(cpphdl_n401, Vss), V(cpphdl_n403, Vss), 0.01, 0.34999999999999998, 1.0);
        // device 324, IC IC71, analog/basic/cmos_logic.hpp:20
        I(cpphdl_n418, Vss) <+ V(cpphdl_n418, Vss) / 1000000000.0;
        // device 325, IC IC71, analog/basic/cmos_logic.hpp:21
        I(cpphdl_n403, Vss) <+ V(cpphdl_n403, Vss) / 1000000000.0;
        // device 326, IC IC73, analog/basic/cmos_logic.hpp:15
        I(cpphdl_n419, Vss) <+ 5e-15 * ddt(V(cpphdl_n419, Vss)); // Bench initial voltage = 0.0 V.
        // device 327, IC IC73, analog/basic/cmos_logic.hpp:16
        I(cpphdl_n419, Vlogic) <+ cpphdl_channel(V(cpphdl_n412, Vlogic), V(cpphdl_n419, Vlogic), 0.01, 0.34999999999999998, -1.0);
        // device 328, IC IC73, analog/basic/cmos_logic.hpp:17
        I(cpphdl_n419, Vlogic) <+ cpphdl_channel(V(cpphdl_n420, Vlogic), V(cpphdl_n419, Vlogic), 0.01, 0.34999999999999998, -1.0);
        // device 329, IC IC73, analog/basic/cmos_logic.hpp:18
        I(cpphdl_n419, cpphdl_n415) <+ cpphdl_channel(V(cpphdl_n412, cpphdl_n415), V(cpphdl_n419, cpphdl_n415), 0.01, 0.34999999999999998, 1.0);
        // device 330, IC IC73, analog/basic/cmos_logic.hpp:19
        I(cpphdl_n415, Vss) <+ cpphdl_channel(V(cpphdl_n420, Vss), V(cpphdl_n415, Vss), 0.01, 0.34999999999999998, 1.0);
        // device 331, IC IC73, analog/basic/cmos_logic.hpp:20
        I(cpphdl_n419, Vss) <+ V(cpphdl_n419, Vss) / 1000000000.0;
        // device 332, IC IC73, analog/basic/cmos_logic.hpp:21
        I(cpphdl_n415, Vss) <+ V(cpphdl_n415, Vss) / 1000000000.0;
        // device 333, IC IC74, analog/basic/cmos_logic.hpp:15
        I(cpphdl_n420, Vss) <+ 5e-15 * ddt(V(cpphdl_n420, Vss)); // Bench initial voltage = 0.0 V.
        // device 334, IC IC74, analog/basic/cmos_logic.hpp:16
        I(cpphdl_n420, Vlogic) <+ cpphdl_channel(V(cpphdl_n418, Vlogic), V(cpphdl_n420, Vlogic), 0.01, 0.34999999999999998, -1.0);
        // device 335, IC IC74, analog/basic/cmos_logic.hpp:17
        I(cpphdl_n420, Vlogic) <+ cpphdl_channel(V(cpphdl_n419, Vlogic), V(cpphdl_n420, Vlogic), 0.01, 0.34999999999999998, -1.0);
        // device 336, IC IC74, analog/basic/cmos_logic.hpp:18
        I(cpphdl_n420, cpphdl_n421) <+ cpphdl_channel(V(cpphdl_n418, cpphdl_n421), V(cpphdl_n420, cpphdl_n421), 0.01, 0.34999999999999998, 1.0);
        // device 337, IC IC74, analog/basic/cmos_logic.hpp:19
        I(cpphdl_n421, Vss) <+ cpphdl_channel(V(cpphdl_n419, Vss), V(cpphdl_n421, Vss), 0.01, 0.34999999999999998, 1.0);
        // device 338, IC IC74, analog/basic/cmos_logic.hpp:20
        I(cpphdl_n420, Vss) <+ V(cpphdl_n420, Vss) / 1000000000.0;
        // device 339, IC IC74, analog/basic/cmos_logic.hpp:21
        I(cpphdl_n421, Vss) <+ V(cpphdl_n421, Vss) / 1000000000.0;
        // device 340, IC IC72, analog/basic/nand_latch.hpp:34
        I(cpphdl_n412, Vss) <+ 2.0000000000000002e-15 * ddt(V(cpphdl_n412, Vss)); // Bench initial voltage = 0.0 V.
        // device 341, IC IC72, analog/basic/nand_latch.hpp:35
        I(cpphdl_n418, Vss) <+ 2.0000000000000002e-15 * ddt(V(cpphdl_n418, Vss)); // Bench initial voltage = 0.0 V.
        // device 342, IC IC75, analog/basic/inverter.hpp:11
        I(cpphdl_n426, Vlogic) <+ cpphdl_channel(V(cpphdl_n425, Vlogic), V(cpphdl_n426, Vlogic), 0.01, 0.34999999999999998, -1.0);
        // device 343, IC IC75, analog/basic/inverter.hpp:12
        I(cpphdl_n426, Vss) <+ cpphdl_channel(V(cpphdl_n425, Vss), V(cpphdl_n426, Vss), 0.01, 0.34999999999999998, 1.0);
        // device 344, IC IC72, analog/basic/nand_latch.hpp:56
        I(cpphdl_n426, Vss) <+ 2.0000000000000002e-15 * ddt(V(cpphdl_n426, Vss)); // Bench initial voltage = 0.0 V.
        // device 345, IC IC72, analog/basic/nand_latch.hpp:57
        I(cpphdl_n419, Vss) <+ cpphdl_channel(V(cpphdl_n425, Vss), V(cpphdl_n419, Vss), 0.050000000000000003, 0.34999999999999998, 1.0);
        // device 346, IC IC72, analog/basic/nand_latch.hpp:58
        I(cpphdl_n420, Vlogic) <+ cpphdl_channel(V(cpphdl_n426, Vlogic), V(cpphdl_n420, Vlogic), 0.050000000000000003, 0.34999999999999998, -1.0);
        // device 347, IC IC65, analog/basic/cmos_storage.hpp:57
        I(cpphdl_n394, Vss) <+ 2.0000000000000002e-15 * ddt(V(cpphdl_n394, Vss)); // Bench initial voltage = 0.0 V.
        // device 348, IC IC65, analog/basic/cmos_storage.hpp:58
        I(cpphdl_n388, Vss) <+ 2.0000000000000002e-15 * ddt(V(cpphdl_n388, Vss)); // Bench initial voltage = 0.0 V.
        // device 349, IC IC65, analog/basic/cmos_storage.hpp:59
        I(cpphdl_n425, Vss) <+ 2.0000000000000002e-15 * ddt(V(cpphdl_n425, Vss)); // Bench initial voltage = 0.0 V.
        // device 350, IC IC27, analog/basic/phase_frequency_detector.hpp:63
        I(cpphdl_n437, cpphdl_n425) <+ V(cpphdl_n437, cpphdl_n425) / 1000.0;
        // device 351, IC IC27, analog/basic/phase_frequency_detector.hpp:64
        I(cpphdl_n425, Vss) <+ 1e-13 * ddt(V(cpphdl_n425, Vss)); // Bench initial voltage = 0.0 V.
        // device 352, IC IC1, analog/1G/reference_clock.hpp:45
        I(cpphdl_n17, Vlogic) <+ cpphdl_channel(V(cpphdl_n289, Vlogic), V(cpphdl_n17, Vlogic), 0.01, 0.34999999999999998, -1.0);
        // device 353, IC IC1, analog/1G/reference_clock.hpp:46
        I(cpphdl_n17, cpphdl_n446) <+ V(cpphdl_n17, cpphdl_n446) / 10000.0;
        // device 354, IC IC1, analog/1G/reference_clock.hpp:47
        I(cpphdl_n446, cpphdl_n18) <+ cpphdl_channel(V(cpphdl_n419, cpphdl_n18), V(cpphdl_n446, cpphdl_n18), 0.01, 0.34999999999999998, 1.0);
        // device 355, IC IC1, analog/1G/reference_clock.hpp:48
        I(Vss, cpphdl_n18) <+ V(Vss, cpphdl_n18) / 10000.0;
        // device 356, IC IC1, analog/1G/reference_clock.hpp:49
        I(Vss, cpphdl_n17) <+ V(Vss, cpphdl_n17) / 1000000000.0;
        // device 357, IC IC1, analog/1G/reference_clock.hpp:50
        I(cpphdl_n446, Vss) <+ 5e-15 * ddt(V(cpphdl_n446, Vss)); // Bench initial voltage = 0.0 V.
        // device 358, IC IC79, analog/basic/pll.hpp:16
        I(cpphdl_n446, cpphdl_n447) <+ V(cpphdl_n446, cpphdl_n447) / 10000.0;
        // device 359, IC IC79, analog/basic/pll.hpp:17
        I(cpphdl_n447, cpphdl_n448) <+ 1.9999999999999999e-11 * ddt(V(cpphdl_n447, cpphdl_n448)); // Bench initial voltage = 0.0 V.
        // device 360, IC IC79, analog/basic/pll.hpp:18
        I(cpphdl_n448, Vss) <+ V(cpphdl_n448, Vss) / 2000.0;
        // device 361, IC IC1, analog/1G/reference_clock.hpp:60
        I(cpphdl_n447, cpphdl_n469) <+ V(cpphdl_n447, cpphdl_n469) / 1000.0;
        // device 362, IC IC1, analog/1G/reference_clock.hpp:61
        I(cpphdl_n469, Vss) <+ 3.0000000000000001e-12 * ddt(V(cpphdl_n469, Vss)); // Bench initial voltage = 0.0 V.
        // device 363, IC IC81, analog/basic/ring_vco.hpp:18
        I(cpphdl_n461, Vlogic) <+ cpphdl_channel(V(cpphdl_n473, Vlogic), V(cpphdl_n461, Vlogic), 0.001, 0.34999999999999998, -1.0);
        // device 364, IC IC81, analog/basic/ring_vco.hpp:19
        I(cpphdl_n461, cpphdl_n458) <+ cpphdl_channel(V(cpphdl_n473, cpphdl_n458), V(cpphdl_n461, cpphdl_n458), 0.001, 0.34999999999999998, 1.0);
        // device 365, IC IC81, analog/basic/ring_vco.hpp:20
        I(cpphdl_n458, Vss) <+ cpphdl_channel(V(cpphdl_n469, Vss), V(cpphdl_n458, Vss), 0.001, 0.34999999999999998, 1.0);
        // device 366, IC IC81, analog/basic/ring_vco.hpp:21
        I(cpphdl_n458, Vss) <+ V(cpphdl_n458, Vss) / 1000000000.0;
        // device 367, IC IC81, analog/basic/ring_vco.hpp:22
        I(cpphdl_n461, Vss) <+ 5.0000000000000002e-14 * ddt(V(cpphdl_n461, Vss)); // Bench initial voltage = 0.0 V.
        // device 368, IC IC82, analog/basic/ring_vco.hpp:18
        I(cpphdl_n467, Vlogic) <+ cpphdl_channel(V(cpphdl_n461, Vlogic), V(cpphdl_n467, Vlogic), 0.001, 0.34999999999999998, -1.0);
        // device 369, IC IC82, analog/basic/ring_vco.hpp:19
        I(cpphdl_n467, cpphdl_n464) <+ cpphdl_channel(V(cpphdl_n461, cpphdl_n464), V(cpphdl_n467, cpphdl_n464), 0.001, 0.34999999999999998, 1.0);
        // device 370, IC IC82, analog/basic/ring_vco.hpp:20
        I(cpphdl_n464, Vss) <+ cpphdl_channel(V(cpphdl_n469, Vss), V(cpphdl_n464, Vss), 0.001, 0.34999999999999998, 1.0);
        // device 371, IC IC82, analog/basic/ring_vco.hpp:21
        I(cpphdl_n464, Vss) <+ V(cpphdl_n464, Vss) / 1000000000.0;
        // device 372, IC IC82, analog/basic/ring_vco.hpp:22
        I(cpphdl_n467, Vss) <+ 5.0000000000000002e-14 * ddt(V(cpphdl_n467, Vss)); // Bench initial voltage = 0.0 V.
        // device 373, IC IC83, analog/basic/ring_vco.hpp:18
        I(cpphdl_n473, Vlogic) <+ cpphdl_channel(V(cpphdl_n467, Vlogic), V(cpphdl_n473, Vlogic), 0.001, 0.34999999999999998, -1.0);
        // device 374, IC IC83, analog/basic/ring_vco.hpp:19
        I(cpphdl_n473, cpphdl_n470) <+ cpphdl_channel(V(cpphdl_n467, cpphdl_n470), V(cpphdl_n473, cpphdl_n470), 0.001, 0.34999999999999998, 1.0);
        // device 375, IC IC83, analog/basic/ring_vco.hpp:20
        I(cpphdl_n470, Vss) <+ cpphdl_channel(V(cpphdl_n469, Vss), V(cpphdl_n470, Vss), 0.001, 0.34999999999999998, 1.0);
        // device 376, IC IC83, analog/basic/ring_vco.hpp:21
        I(cpphdl_n470, Vss) <+ V(cpphdl_n470, Vss) / 1000000000.0;
        // device 377, IC IC83, analog/basic/ring_vco.hpp:22
        I(cpphdl_n473, Vss) <+ 5.0000000000000002e-14 * ddt(V(cpphdl_n473, Vss)); // Bench initial voltage = 0.0 V.
        // device 378, IC IC1, analog/1G/reference_clock.hpp:70
        I(cpphdl_n469, cpphdl_n458) <+ 1.0000000000000001e-15 * ddt(V(cpphdl_n469, cpphdl_n458)); // Bench initial voltage = 0.0 V.
        // device 379, IC IC1, analog/1G/reference_clock.hpp:70
        I(cpphdl_n469, cpphdl_n464) <+ 1.0000000000000001e-15 * ddt(V(cpphdl_n469, cpphdl_n464)); // Bench initial voltage = 0.0 V.
        // device 380, IC IC1, analog/1G/reference_clock.hpp:70
        I(cpphdl_n469, cpphdl_n470) <+ 1.0000000000000001e-15 * ddt(V(cpphdl_n469, cpphdl_n470)); // Bench initial voltage = 0.0 V.
        // device 381, IC IC1, analog/1G/reference_clock.hpp:72
        I(cpphdl_n467, Vss) <+ cpphdl_channel(V(CLEAR, Vss), V(cpphdl_n467, Vss), 0.01, 0.34999999999999998, 1.0);
        // device 382, IC IC1, analog/1G/reference_clock.hpp:73
        I(REF, Vss) <+ 2.0000000000000002e-15 * ddt(V(REF, Vss)); // Bench initial voltage = 0.0 V.
        // device 383, IC IC84, analog/basic/inverter.hpp:11
        I(cpphdl_n477, Vlogic) <+ cpphdl_channel(V(cpphdl_n473, Vlogic), V(cpphdl_n477, Vlogic), 0.0040000000000000001, 0.34999999999999998, -1.0);
        // device 384, IC IC84, analog/basic/inverter.hpp:12
        I(cpphdl_n477, Vss) <+ cpphdl_channel(V(cpphdl_n473, Vss), V(cpphdl_n477, Vss), 0.0040000000000000001, 0.34999999999999998, 1.0);
        // device 385, IC IC85, analog/basic/inverter.hpp:11
        I(cpphdl_n498, Vlogic) <+ cpphdl_channel(V(cpphdl_n477, Vlogic), V(cpphdl_n498, Vlogic), 0.02, 0.34999999999999998, -1.0);
        // device 386, IC IC85, analog/basic/inverter.hpp:12
        I(cpphdl_n498, Vss) <+ cpphdl_channel(V(cpphdl_n477, Vss), V(cpphdl_n498, Vss), 0.02, 0.34999999999999998, 1.0);
        // device 387, IC OneGReferenceClockDomain, analog/1G/reference_clock_domain.hpp:41
        I(cpphdl_n473, Vss) <+ 2.0000000000000002e-15 * ddt(V(cpphdl_n473, Vss)); // Bench initial voltage = 0.0 V.
        // device 388, IC OneGReferenceClockDomain, analog/1G/reference_clock_domain.hpp:42
        I(cpphdl_n473, Vlogic) <+ 2.0000000000000002e-15 * ddt(V(cpphdl_n473, Vlogic)); // Bench initial voltage = 0.0 V.
        // device 389, IC OneGReferenceClockDomain, analog/1G/reference_clock_domain.hpp:43
        I(cpphdl_n473, cpphdl_n477) <+ 1.0000000000000001e-15 * ddt(V(cpphdl_n473, cpphdl_n477)); // Bench initial voltage = 0.0 V.
        // device 390, IC OneGReferenceClockDomain, analog/1G/reference_clock_domain.hpp:44
        I(cpphdl_n477, Vss) <+ 1.4999999999999999e-14 * ddt(V(cpphdl_n477, Vss)); // Bench initial voltage = 0.0 V.
        // device 391, IC OneGReferenceClockDomain, analog/1G/reference_clock_domain.hpp:45
        I(cpphdl_n477, Vlogic) <+ 1e-14 * ddt(V(cpphdl_n477, Vlogic)); // Bench initial voltage = 0.0 V.
        // device 392, IC OneGReferenceClockDomain, analog/1G/reference_clock_domain.hpp:46
        I(cpphdl_n477, cpphdl_n498) <+ 5e-15 * ddt(V(cpphdl_n477, cpphdl_n498)); // Bench initial voltage = 0.0 V.
        // device 393, IC OneGReferenceClockDomain, analog/1G/reference_clock_domain.hpp:47
        I(cpphdl_n498, Vss) <+ 1e-14 * ddt(V(cpphdl_n498, Vss)); // Bench initial voltage = 0.0 V.
        // device 394, IC OneGReferenceClockDomain, analog/1G/reference_clock_domain.hpp:48
        I(Vlogic, Vss) <+ 4.9999999999999997e-12 * ddt(V(Vlogic, Vss)); // Bench initial voltage = 0.0 V.
        // device 395, IC IC86, analog/basic/cascoded_level_shifter.hpp:18
        I(Vlogic, cpphdl_n483) <+ V(Vlogic, cpphdl_n483) / 200.0;
        // device 396, IC IC86, analog/basic/cascoded_level_shifter.hpp:19
        I(Vss, cpphdl_n483) <+ V(Vss, cpphdl_n483) / 800.0;
        // device 397, IC IC86, analog/basic/cascoded_level_shifter.hpp:20
        I(Vdd, cpphdl_n482) <+ V(Vdd, cpphdl_n482) / 10000.0;
        // device 398, IC IC86, analog/basic/cascoded_level_shifter.hpp:21
        I(cpphdl_n482, cpphdl_n483) <+ cpphdl_channel(V(cpphdl_n482, cpphdl_n483), V(cpphdl_n482, cpphdl_n483), 0.018749999999999999, 0.69999999999999996, 1.0);
        // device 399, IC IC86, analog/basic/cascoded_level_shifter.hpp:22
        I(cpphdl_n482, Vss) <+ 9.9999999999999998e-13 * ddt(V(cpphdl_n482, Vss)); // Bench initial voltage = 0.0 V.
        // device 400, IC IC88, analog/basic/inverter.hpp:11
        I(cpphdl_n499, Vlogic) <+ cpphdl_channel(V(cpphdl_n498, Vlogic), V(cpphdl_n499, Vlogic), 0.02, 0.5, -1.0);
        // device 401, IC IC88, analog/basic/inverter.hpp:12
        I(cpphdl_n499, Vss) <+ cpphdl_channel(V(cpphdl_n498, Vss), V(cpphdl_n499, Vss), 0.02, 0.5, 1.0);
        // device 402, IC IC87, analog/basic/cascoded_level_shifter.hpp:58
        I(cpphdl_n499, Vss) <+ 1e-14 * ddt(V(cpphdl_n499, Vss)); // Bench initial voltage = 0.0 V.
        // device 403, IC IC87, analog/basic/cascoded_level_shifter.hpp:59
        I(cpphdl_n506, Vdd) <+ cpphdl_channel(V(cpphdl_n502, Vdd), V(cpphdl_n506, Vdd), 0.0014, 0.69999999999999996, -1.0);
        // device 404, IC IC87, analog/basic/cascoded_level_shifter.hpp:60
        I(cpphdl_n502, Vdd) <+ cpphdl_channel(V(cpphdl_n506, Vdd), V(cpphdl_n502, Vdd), 0.0014, 0.69999999999999996, -1.0);
        // device 405, IC IC87, analog/basic/cascoded_level_shifter.hpp:61
        I(cpphdl_n506, cpphdl_n494) <+ cpphdl_channel(V(cpphdl_n482, cpphdl_n494), V(cpphdl_n506, cpphdl_n494), 0.014999999999999999, 0.69999999999999996, 1.0);
        // device 406, IC IC87, analog/basic/cascoded_level_shifter.hpp:62
        I(cpphdl_n502, cpphdl_n495) <+ cpphdl_channel(V(cpphdl_n482, cpphdl_n495), V(cpphdl_n502, cpphdl_n495), 0.014999999999999999, 0.69999999999999996, 1.0);
        // device 407, IC IC87, analog/basic/cascoded_level_shifter.hpp:63
        I(cpphdl_n494, Vss) <+ cpphdl_channel(V(cpphdl_n499, Vss), V(cpphdl_n494, Vss), 0.059999999999999998, 0.5, 1.0);
        // device 408, IC IC87, analog/basic/cascoded_level_shifter.hpp:64
        I(cpphdl_n495, Vss) <+ cpphdl_channel(V(cpphdl_n498, Vss), V(cpphdl_n495, Vss), 0.059999999999999998, 0.5, 1.0);
        // device 409, IC IC87, analog/basic/cascoded_level_shifter.hpp:65
        I(cpphdl_n506, Vss) <+ 1e-14 * ddt(V(cpphdl_n506, Vss)); // Bench initial voltage = 0.0 V.
        // device 410, IC IC87, analog/basic/cascoded_level_shifter.hpp:66
        I(cpphdl_n502, Vss) <+ 1e-14 * ddt(V(cpphdl_n502, Vss)); // Bench initial voltage = 0.0 V.
        // device 411, IC IC87, analog/basic/cascoded_level_shifter.hpp:67
        I(cpphdl_n494, Vss) <+ 1e-14 * ddt(V(cpphdl_n494, Vss)); // Bench initial voltage = 0.0 V.
        // device 412, IC IC87, analog/basic/cascoded_level_shifter.hpp:68
        I(cpphdl_n495, Vss) <+ 1e-14 * ddt(V(cpphdl_n495, Vss)); // Bench initial voltage = 0.0 V.
        // device 413, IC IC87, analog/basic/cascoded_level_shifter.hpp:72
        I(cpphdl_n482, cpphdl_n494) <+ 5.9999999999999997e-14 * ddt(V(cpphdl_n482, cpphdl_n494)); // Bench initial voltage = 0.0 V.
        // device 414, IC IC87, analog/basic/cascoded_level_shifter.hpp:73
        I(cpphdl_n482, cpphdl_n495) <+ 5.9999999999999997e-14 * ddt(V(cpphdl_n482, cpphdl_n495)); // Bench initial voltage = 0.0 V.
        // device 415, IC IC87, analog/basic/cascoded_level_shifter.hpp:74
        I(cpphdl_n482, cpphdl_n506) <+ 3.5999999999999998e-14 * ddt(V(cpphdl_n482, cpphdl_n506)); // Bench initial voltage = 0.0 V.
        // device 416, IC IC87, analog/basic/cascoded_level_shifter.hpp:75
        I(cpphdl_n482, cpphdl_n502) <+ 3.5999999999999998e-14 * ddt(V(cpphdl_n482, cpphdl_n502)); // Bench initial voltage = 0.0 V.
        // device 417, IC IC87, analog/basic/cascoded_level_shifter.hpp:76
        I(cpphdl_n498, Vss) <+ 4e-14 * ddt(V(cpphdl_n498, Vss)); // Bench initial voltage = 0.0 V.
        // device 418, IC IC87, analog/basic/cascoded_level_shifter.hpp:77
        I(cpphdl_n499, Vss) <+ 4e-14 * ddt(V(cpphdl_n499, Vss)); // Bench initial voltage = 0.0 V.
        // device 419, IC IC87, analog/basic/cascoded_level_shifter.hpp:78
        I(cpphdl_n506, Vdd) <+ 4e-14 * ddt(V(cpphdl_n506, Vdd)); // Bench initial voltage = 0.0 V.
        // device 420, IC IC87, analog/basic/cascoded_level_shifter.hpp:79
        I(cpphdl_n502, Vdd) <+ 4e-14 * ddt(V(cpphdl_n502, Vdd)); // Bench initial voltage = 0.0 V.
        // device 421, IC IC87, analog/basic/cascoded_level_shifter.hpp:80
        I(cpphdl_n506, cpphdl_n502) <+ 1.4e-14 * ddt(V(cpphdl_n506, cpphdl_n502)); // Bench initial voltage = 0.0 V.
        // device 422, IC IC87, analog/basic/cascoded_level_shifter.hpp:81
        I(cpphdl_n506, Vss) <+ 7.0000000000000005e-14 * ddt(V(cpphdl_n506, Vss)); // Bench initial voltage = 0.0 V.
        // device 423, IC IC87, analog/basic/cascoded_level_shifter.hpp:82
        I(cpphdl_n502, Vss) <+ 7.0000000000000005e-14 * ddt(V(cpphdl_n502, Vss)); // Bench initial voltage = 0.0 V.
        // device 424, IC IC87, analog/basic/cascoded_level_shifter.hpp:83
        I(cpphdl_n506, OUT_N) <+ 2.3e-14 * ddt(V(cpphdl_n506, OUT_N)); // Bench initial voltage = 0.0 V.
        // device 425, IC IC87, analog/basic/cascoded_level_shifter.hpp:84
        I(cpphdl_n502, OUT) <+ 2.3e-14 * ddt(V(cpphdl_n502, OUT)); // Bench initial voltage = 0.0 V.
        // device 426, IC IC89, analog/basic/inverter.hpp:11
        I(OUT, Vdd) <+ cpphdl_channel(V(cpphdl_n502, Vdd), V(OUT, Vdd), 0.0030000000000000001, 0.69999999999999996, -1.0);
        // device 427, IC IC89, analog/basic/inverter.hpp:12
        I(OUT, Vss) <+ cpphdl_channel(V(cpphdl_n502, Vss), V(OUT, Vss), 0.0030000000000000001, 0.69999999999999996, 1.0);
        // device 428, IC IC90, analog/basic/inverter.hpp:11
        I(OUT_N, Vdd) <+ cpphdl_channel(V(cpphdl_n506, Vdd), V(OUT_N, Vdd), 0.0030000000000000001, 0.69999999999999996, -1.0);
        // device 429, IC IC90, analog/basic/inverter.hpp:12
        I(OUT_N, Vss) <+ cpphdl_channel(V(cpphdl_n506, Vss), V(OUT_N, Vss), 0.0030000000000000001, 0.69999999999999996, 1.0);
        // device 430, IC IC87, analog/basic/cascoded_level_shifter.hpp:95
        I(OUT, Vss) <+ 5.0000000000000002e-14 * ddt(V(OUT, Vss)); // Bench initial voltage = 0.0 V.
        // device 431, IC IC87, analog/basic/cascoded_level_shifter.hpp:96
        I(OUT_N, Vss) <+ 5.0000000000000002e-14 * ddt(V(OUT_N, Vss)); // Bench initial voltage = 0.0 V.
        // device 432, IC IC87, analog/basic/cascoded_level_shifter.hpp:97
        I(cpphdl_n498, cpphdl_n495) <+ 1.6000000000000001e-14 * ddt(V(cpphdl_n498, cpphdl_n495)); // Bench initial voltage = 0.0 V.
        // device 433, IC IC87, analog/basic/cascoded_level_shifter.hpp:98
        I(cpphdl_n499, cpphdl_n494) <+ 1.6000000000000001e-14 * ddt(V(cpphdl_n499, cpphdl_n494)); // Bench initial voltage = 0.0 V.
        // device 434, IC IC87, analog/1G/clock_level_shifter.hpp:14
        I(OUT, Vss) <+ 2.0000000000000001e-13 * ddt(V(OUT, Vss)); // Bench initial voltage = 0.0 V.
        // device 435, IC IC87, analog/1G/clock_level_shifter.hpp:15
        I(OUT_N, Vss) <+ 2.0000000000000001e-13 * ddt(V(OUT_N, Vss)); // Bench initial voltage = 0.0 V.
    end
endmodule
