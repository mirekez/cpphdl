// SIMULATION APPROXIMATION: controlled conductances are not physical MOS devices.
// Generated from elaborated C++HDL IC purposes; all contributions coexist.
// Capacitor initialization belongs to the host analysis; declared initial voltages appear below.
`include "disciplines.vams"

module OneGSARADCCoreArray(Vdd, Vss, Vlogic, IN, EVALUATE, CLEAR, TRACK0, DECISION0, DECISION_N0, CORE_DECISION0, BIT_N0_0, BIT_N0_1, BIT_N0_2, BIT_N0_3, BIT_N0_4, BIT_N0_5, BIT_N0_6, BIT_N0_7, TRACK1, DECISION1, DECISION_N1, CORE_DECISION1, BIT_N1_0, BIT_N1_1, BIT_N1_2, BIT_N1_3, BIT_N1_4, BIT_N1_5, BIT_N1_6, BIT_N1_7, TRACK2, DECISION2, DECISION_N2, CORE_DECISION2, BIT_N2_0, BIT_N2_1, BIT_N2_2, BIT_N2_3, BIT_N2_4, BIT_N2_5, BIT_N2_6, BIT_N2_7, TRACK3, DECISION3, DECISION_N3, CORE_DECISION3, BIT_N3_0, BIT_N3_1, BIT_N3_2, BIT_N3_3, BIT_N3_4, BIT_N3_5, BIT_N3_6, BIT_N3_7, TRACK4, DECISION4, DECISION_N4, CORE_DECISION4, BIT_N4_0, BIT_N4_1, BIT_N4_2, BIT_N4_3, BIT_N4_4, BIT_N4_5, BIT_N4_6, BIT_N4_7, TRACK5, DECISION5, DECISION_N5, CORE_DECISION5, BIT_N5_0, BIT_N5_1, BIT_N5_2, BIT_N5_3, BIT_N5_4, BIT_N5_5, BIT_N5_6, BIT_N5_7, TRACK6, DECISION6, DECISION_N6, CORE_DECISION6, BIT_N6_0, BIT_N6_1, BIT_N6_2, BIT_N6_3, BIT_N6_4, BIT_N6_5, BIT_N6_6, BIT_N6_7, TRACK7, DECISION7, DECISION_N7, CORE_DECISION7, BIT_N7_0, BIT_N7_1, BIT_N7_2, BIT_N7_3, BIT_N7_4, BIT_N7_5, BIT_N7_6, BIT_N7_7, TRACK8, DECISION8, DECISION_N8, CORE_DECISION8, BIT_N8_0, BIT_N8_1, BIT_N8_2, BIT_N8_3, BIT_N8_4, BIT_N8_5, BIT_N8_6, BIT_N8_7, TRACK9, DECISION9, DECISION_N9, CORE_DECISION9, BIT_N9_0, BIT_N9_1, BIT_N9_2, BIT_N9_3, BIT_N9_4, BIT_N9_5, BIT_N9_6, BIT_N9_7, TRACK10, DECISION10, DECISION_N10, CORE_DECISION10, BIT_N10_0, BIT_N10_1, BIT_N10_2, BIT_N10_3, BIT_N10_4, BIT_N10_5, BIT_N10_6, BIT_N10_7, TRACK11, DECISION11, DECISION_N11, CORE_DECISION11, BIT_N11_0, BIT_N11_1, BIT_N11_2, BIT_N11_3, BIT_N11_4, BIT_N11_5, BIT_N11_6, BIT_N11_7, TRACK12, DECISION12, DECISION_N12, CORE_DECISION12, BIT_N12_0, BIT_N12_1, BIT_N12_2, BIT_N12_3, BIT_N12_4, BIT_N12_5, BIT_N12_6, BIT_N12_7, TRACK13, DECISION13, DECISION_N13, CORE_DECISION13, BIT_N13_0, BIT_N13_1, BIT_N13_2, BIT_N13_3, BIT_N13_4, BIT_N13_5, BIT_N13_6, BIT_N13_7, TRACK14, DECISION14, DECISION_N14, CORE_DECISION14, BIT_N14_0, BIT_N14_1, BIT_N14_2, BIT_N14_3, BIT_N14_4, BIT_N14_5, BIT_N14_6, BIT_N14_7, TRACK15, DECISION15, DECISION_N15, CORE_DECISION15, BIT_N15_0, BIT_N15_1, BIT_N15_2, BIT_N15_3, BIT_N15_4, BIT_N15_5, BIT_N15_6, BIT_N15_7);
    inout Vdd, Vss, Vlogic, IN, EVALUATE, CLEAR, TRACK0, DECISION0, DECISION_N0, CORE_DECISION0, BIT_N0_0, BIT_N0_1, BIT_N0_2, BIT_N0_3, BIT_N0_4, BIT_N0_5, BIT_N0_6, BIT_N0_7, TRACK1, DECISION1, DECISION_N1, CORE_DECISION1, BIT_N1_0, BIT_N1_1, BIT_N1_2, BIT_N1_3, BIT_N1_4, BIT_N1_5, BIT_N1_6, BIT_N1_7, TRACK2, DECISION2, DECISION_N2, CORE_DECISION2, BIT_N2_0, BIT_N2_1, BIT_N2_2, BIT_N2_3, BIT_N2_4, BIT_N2_5, BIT_N2_6, BIT_N2_7, TRACK3, DECISION3, DECISION_N3, CORE_DECISION3, BIT_N3_0, BIT_N3_1, BIT_N3_2, BIT_N3_3, BIT_N3_4, BIT_N3_5, BIT_N3_6, BIT_N3_7, TRACK4, DECISION4, DECISION_N4, CORE_DECISION4, BIT_N4_0, BIT_N4_1, BIT_N4_2, BIT_N4_3, BIT_N4_4, BIT_N4_5, BIT_N4_6, BIT_N4_7, TRACK5, DECISION5, DECISION_N5, CORE_DECISION5, BIT_N5_0, BIT_N5_1, BIT_N5_2, BIT_N5_3, BIT_N5_4, BIT_N5_5, BIT_N5_6, BIT_N5_7, TRACK6, DECISION6, DECISION_N6, CORE_DECISION6, BIT_N6_0, BIT_N6_1, BIT_N6_2, BIT_N6_3, BIT_N6_4, BIT_N6_5, BIT_N6_6, BIT_N6_7, TRACK7, DECISION7, DECISION_N7, CORE_DECISION7, BIT_N7_0, BIT_N7_1, BIT_N7_2, BIT_N7_3, BIT_N7_4, BIT_N7_5, BIT_N7_6, BIT_N7_7, TRACK8, DECISION8, DECISION_N8, CORE_DECISION8, BIT_N8_0, BIT_N8_1, BIT_N8_2, BIT_N8_3, BIT_N8_4, BIT_N8_5, BIT_N8_6, BIT_N8_7, TRACK9, DECISION9, DECISION_N9, CORE_DECISION9, BIT_N9_0, BIT_N9_1, BIT_N9_2, BIT_N9_3, BIT_N9_4, BIT_N9_5, BIT_N9_6, BIT_N9_7, TRACK10, DECISION10, DECISION_N10, CORE_DECISION10, BIT_N10_0, BIT_N10_1, BIT_N10_2, BIT_N10_3, BIT_N10_4, BIT_N10_5, BIT_N10_6, BIT_N10_7, TRACK11, DECISION11, DECISION_N11, CORE_DECISION11, BIT_N11_0, BIT_N11_1, BIT_N11_2, BIT_N11_3, BIT_N11_4, BIT_N11_5, BIT_N11_6, BIT_N11_7, TRACK12, DECISION12, DECISION_N12, CORE_DECISION12, BIT_N12_0, BIT_N12_1, BIT_N12_2, BIT_N12_3, BIT_N12_4, BIT_N12_5, BIT_N12_6, BIT_N12_7, TRACK13, DECISION13, DECISION_N13, CORE_DECISION13, BIT_N13_0, BIT_N13_1, BIT_N13_2, BIT_N13_3, BIT_N13_4, BIT_N13_5, BIT_N13_6, BIT_N13_7, TRACK14, DECISION14, DECISION_N14, CORE_DECISION14, BIT_N14_0, BIT_N14_1, BIT_N14_2, BIT_N14_3, BIT_N14_4, BIT_N14_5, BIT_N14_6, BIT_N14_7, TRACK15, DECISION15, DECISION_N15, CORE_DECISION15, BIT_N15_0, BIT_N15_1, BIT_N15_2, BIT_N15_3, BIT_N15_4, BIT_N15_5, BIT_N15_6, BIT_N15_7;
    electrical Vdd, Vss, Vlogic, IN, EVALUATE, CLEAR, TRACK0, DECISION0, DECISION_N0, CORE_DECISION0, BIT_N0_0, BIT_N0_1, BIT_N0_2, BIT_N0_3, BIT_N0_4, BIT_N0_5, BIT_N0_6, BIT_N0_7, TRACK1, DECISION1, DECISION_N1, CORE_DECISION1, BIT_N1_0, BIT_N1_1, BIT_N1_2, BIT_N1_3, BIT_N1_4, BIT_N1_5, BIT_N1_6, BIT_N1_7, TRACK2, DECISION2, DECISION_N2, CORE_DECISION2, BIT_N2_0, BIT_N2_1, BIT_N2_2, BIT_N2_3, BIT_N2_4, BIT_N2_5, BIT_N2_6, BIT_N2_7, TRACK3, DECISION3, DECISION_N3, CORE_DECISION3, BIT_N3_0, BIT_N3_1, BIT_N3_2, BIT_N3_3, BIT_N3_4, BIT_N3_5, BIT_N3_6, BIT_N3_7, TRACK4, DECISION4, DECISION_N4, CORE_DECISION4, BIT_N4_0, BIT_N4_1, BIT_N4_2, BIT_N4_3, BIT_N4_4, BIT_N4_5, BIT_N4_6, BIT_N4_7, TRACK5, DECISION5, DECISION_N5, CORE_DECISION5, BIT_N5_0, BIT_N5_1, BIT_N5_2, BIT_N5_3, BIT_N5_4, BIT_N5_5, BIT_N5_6, BIT_N5_7, TRACK6, DECISION6, DECISION_N6, CORE_DECISION6, BIT_N6_0, BIT_N6_1, BIT_N6_2, BIT_N6_3, BIT_N6_4, BIT_N6_5, BIT_N6_6, BIT_N6_7, TRACK7, DECISION7, DECISION_N7, CORE_DECISION7, BIT_N7_0, BIT_N7_1, BIT_N7_2, BIT_N7_3, BIT_N7_4, BIT_N7_5, BIT_N7_6, BIT_N7_7, TRACK8, DECISION8, DECISION_N8, CORE_DECISION8, BIT_N8_0, BIT_N8_1, BIT_N8_2, BIT_N8_3, BIT_N8_4, BIT_N8_5, BIT_N8_6, BIT_N8_7, TRACK9, DECISION9, DECISION_N9, CORE_DECISION9, BIT_N9_0, BIT_N9_1, BIT_N9_2, BIT_N9_3, BIT_N9_4, BIT_N9_5, BIT_N9_6, BIT_N9_7, TRACK10, DECISION10, DECISION_N10, CORE_DECISION10, BIT_N10_0, BIT_N10_1, BIT_N10_2, BIT_N10_3, BIT_N10_4, BIT_N10_5, BIT_N10_6, BIT_N10_7, TRACK11, DECISION11, DECISION_N11, CORE_DECISION11, BIT_N11_0, BIT_N11_1, BIT_N11_2, BIT_N11_3, BIT_N11_4, BIT_N11_5, BIT_N11_6, BIT_N11_7, TRACK12, DECISION12, DECISION_N12, CORE_DECISION12, BIT_N12_0, BIT_N12_1, BIT_N12_2, BIT_N12_3, BIT_N12_4, BIT_N12_5, BIT_N12_6, BIT_N12_7, TRACK13, DECISION13, DECISION_N13, CORE_DECISION13, BIT_N13_0, BIT_N13_1, BIT_N13_2, BIT_N13_3, BIT_N13_4, BIT_N13_5, BIT_N13_6, BIT_N13_7, TRACK14, DECISION14, DECISION_N14, CORE_DECISION14, BIT_N14_0, BIT_N14_1, BIT_N14_2, BIT_N14_3, BIT_N14_4, BIT_N14_5, BIT_N14_6, BIT_N14_7, TRACK15, DECISION15, DECISION_N15, CORE_DECISION15, BIT_N15_0, BIT_N15_1, BIT_N15_2, BIT_N15_3, BIT_N15_4, BIT_N15_5, BIT_N15_6, BIT_N15_7;
    electrical cpphdl_n205;
    electrical cpphdl_n220;
    electrical cpphdl_n224;
    electrical cpphdl_n228;
    electrical cpphdl_n232;
    electrical cpphdl_n236;
    electrical cpphdl_n240;
    electrical cpphdl_n244;
    electrical cpphdl_n248;
    electrical cpphdl_n249;
    electrical cpphdl_n250;
    electrical cpphdl_n251;
    electrical cpphdl_n252;
    electrical cpphdl_n253;
    electrical cpphdl_n254;
    electrical cpphdl_n255;
    electrical cpphdl_n259;
    electrical cpphdl_n260;
    electrical cpphdl_n263;
    electrical cpphdl_n264;
    electrical cpphdl_n265;
    electrical cpphdl_n268;
    electrical cpphdl_n269;
    electrical cpphdl_n273;
    electrical cpphdl_n274;
    electrical cpphdl_n275;
    electrical cpphdl_n287;
    electrical cpphdl_n290;
    electrical cpphdl_n293;
    electrical cpphdl_n296;
    electrical cpphdl_n301;
    electrical cpphdl_n325;
    electrical cpphdl_n340;
    electrical cpphdl_n344;
    electrical cpphdl_n348;
    electrical cpphdl_n352;
    electrical cpphdl_n356;
    electrical cpphdl_n360;
    electrical cpphdl_n364;
    electrical cpphdl_n368;
    electrical cpphdl_n369;
    electrical cpphdl_n370;
    electrical cpphdl_n371;
    electrical cpphdl_n372;
    electrical cpphdl_n373;
    electrical cpphdl_n374;
    electrical cpphdl_n375;
    electrical cpphdl_n379;
    electrical cpphdl_n380;
    electrical cpphdl_n383;
    electrical cpphdl_n384;
    electrical cpphdl_n385;
    electrical cpphdl_n388;
    electrical cpphdl_n389;
    electrical cpphdl_n393;
    electrical cpphdl_n394;
    electrical cpphdl_n395;
    electrical cpphdl_n407;
    electrical cpphdl_n410;
    electrical cpphdl_n413;
    electrical cpphdl_n416;
    electrical cpphdl_n421;
    electrical cpphdl_n445;
    electrical cpphdl_n460;
    electrical cpphdl_n464;
    electrical cpphdl_n468;
    electrical cpphdl_n472;
    electrical cpphdl_n476;
    electrical cpphdl_n480;
    electrical cpphdl_n484;
    electrical cpphdl_n488;
    electrical cpphdl_n489;
    electrical cpphdl_n490;
    electrical cpphdl_n491;
    electrical cpphdl_n492;
    electrical cpphdl_n493;
    electrical cpphdl_n494;
    electrical cpphdl_n495;
    electrical cpphdl_n499;
    electrical cpphdl_n500;
    electrical cpphdl_n503;
    electrical cpphdl_n504;
    electrical cpphdl_n505;
    electrical cpphdl_n508;
    electrical cpphdl_n509;
    electrical cpphdl_n513;
    electrical cpphdl_n514;
    electrical cpphdl_n515;
    electrical cpphdl_n527;
    electrical cpphdl_n530;
    electrical cpphdl_n533;
    electrical cpphdl_n536;
    electrical cpphdl_n541;
    electrical cpphdl_n565;
    electrical cpphdl_n580;
    electrical cpphdl_n584;
    electrical cpphdl_n588;
    electrical cpphdl_n592;
    electrical cpphdl_n596;
    electrical cpphdl_n600;
    electrical cpphdl_n604;
    electrical cpphdl_n608;
    electrical cpphdl_n609;
    electrical cpphdl_n610;
    electrical cpphdl_n611;
    electrical cpphdl_n612;
    electrical cpphdl_n613;
    electrical cpphdl_n614;
    electrical cpphdl_n615;
    electrical cpphdl_n619;
    electrical cpphdl_n620;
    electrical cpphdl_n623;
    electrical cpphdl_n624;
    electrical cpphdl_n625;
    electrical cpphdl_n628;
    electrical cpphdl_n629;
    electrical cpphdl_n633;
    electrical cpphdl_n634;
    electrical cpphdl_n635;
    electrical cpphdl_n647;
    electrical cpphdl_n650;
    electrical cpphdl_n653;
    electrical cpphdl_n656;
    electrical cpphdl_n661;
    electrical cpphdl_n685;
    electrical cpphdl_n700;
    electrical cpphdl_n704;
    electrical cpphdl_n708;
    electrical cpphdl_n712;
    electrical cpphdl_n716;
    electrical cpphdl_n720;
    electrical cpphdl_n724;
    electrical cpphdl_n728;
    electrical cpphdl_n729;
    electrical cpphdl_n730;
    electrical cpphdl_n731;
    electrical cpphdl_n732;
    electrical cpphdl_n733;
    electrical cpphdl_n734;
    electrical cpphdl_n735;
    electrical cpphdl_n739;
    electrical cpphdl_n740;
    electrical cpphdl_n743;
    electrical cpphdl_n744;
    electrical cpphdl_n745;
    electrical cpphdl_n748;
    electrical cpphdl_n749;
    electrical cpphdl_n753;
    electrical cpphdl_n754;
    electrical cpphdl_n755;
    electrical cpphdl_n767;
    electrical cpphdl_n770;
    electrical cpphdl_n773;
    electrical cpphdl_n776;
    electrical cpphdl_n781;
    electrical cpphdl_n805;
    electrical cpphdl_n820;
    electrical cpphdl_n824;
    electrical cpphdl_n828;
    electrical cpphdl_n832;
    electrical cpphdl_n836;
    electrical cpphdl_n840;
    electrical cpphdl_n844;
    electrical cpphdl_n848;
    electrical cpphdl_n849;
    electrical cpphdl_n850;
    electrical cpphdl_n851;
    electrical cpphdl_n852;
    electrical cpphdl_n853;
    electrical cpphdl_n854;
    electrical cpphdl_n855;
    electrical cpphdl_n859;
    electrical cpphdl_n860;
    electrical cpphdl_n863;
    electrical cpphdl_n864;
    electrical cpphdl_n865;
    electrical cpphdl_n868;
    electrical cpphdl_n869;
    electrical cpphdl_n873;
    electrical cpphdl_n874;
    electrical cpphdl_n875;
    electrical cpphdl_n887;
    electrical cpphdl_n890;
    electrical cpphdl_n893;
    electrical cpphdl_n896;
    electrical cpphdl_n901;
    electrical cpphdl_n925;
    electrical cpphdl_n940;
    electrical cpphdl_n944;
    electrical cpphdl_n948;
    electrical cpphdl_n952;
    electrical cpphdl_n956;
    electrical cpphdl_n960;
    electrical cpphdl_n964;
    electrical cpphdl_n968;
    electrical cpphdl_n969;
    electrical cpphdl_n970;
    electrical cpphdl_n971;
    electrical cpphdl_n972;
    electrical cpphdl_n973;
    electrical cpphdl_n974;
    electrical cpphdl_n975;
    electrical cpphdl_n979;
    electrical cpphdl_n980;
    electrical cpphdl_n983;
    electrical cpphdl_n984;
    electrical cpphdl_n985;
    electrical cpphdl_n988;
    electrical cpphdl_n989;
    electrical cpphdl_n993;
    electrical cpphdl_n994;
    electrical cpphdl_n995;
    electrical cpphdl_n1007;
    electrical cpphdl_n1010;
    electrical cpphdl_n1013;
    electrical cpphdl_n1016;
    electrical cpphdl_n1021;
    electrical cpphdl_n1045;
    electrical cpphdl_n1060;
    electrical cpphdl_n1064;
    electrical cpphdl_n1068;
    electrical cpphdl_n1072;
    electrical cpphdl_n1076;
    electrical cpphdl_n1080;
    electrical cpphdl_n1084;
    electrical cpphdl_n1088;
    electrical cpphdl_n1089;
    electrical cpphdl_n1090;
    electrical cpphdl_n1091;
    electrical cpphdl_n1092;
    electrical cpphdl_n1093;
    electrical cpphdl_n1094;
    electrical cpphdl_n1095;
    electrical cpphdl_n1099;
    electrical cpphdl_n1100;
    electrical cpphdl_n1103;
    electrical cpphdl_n1104;
    electrical cpphdl_n1105;
    electrical cpphdl_n1108;
    electrical cpphdl_n1109;
    electrical cpphdl_n1113;
    electrical cpphdl_n1114;
    electrical cpphdl_n1115;
    electrical cpphdl_n1127;
    electrical cpphdl_n1130;
    electrical cpphdl_n1133;
    electrical cpphdl_n1136;
    electrical cpphdl_n1141;
    electrical cpphdl_n1165;
    electrical cpphdl_n1180;
    electrical cpphdl_n1184;
    electrical cpphdl_n1188;
    electrical cpphdl_n1192;
    electrical cpphdl_n1196;
    electrical cpphdl_n1200;
    electrical cpphdl_n1204;
    electrical cpphdl_n1208;
    electrical cpphdl_n1209;
    electrical cpphdl_n1210;
    electrical cpphdl_n1211;
    electrical cpphdl_n1212;
    electrical cpphdl_n1213;
    electrical cpphdl_n1214;
    electrical cpphdl_n1215;
    electrical cpphdl_n1219;
    electrical cpphdl_n1220;
    electrical cpphdl_n1223;
    electrical cpphdl_n1224;
    electrical cpphdl_n1225;
    electrical cpphdl_n1228;
    electrical cpphdl_n1229;
    electrical cpphdl_n1233;
    electrical cpphdl_n1234;
    electrical cpphdl_n1235;
    electrical cpphdl_n1247;
    electrical cpphdl_n1250;
    electrical cpphdl_n1253;
    electrical cpphdl_n1256;
    electrical cpphdl_n1261;
    electrical cpphdl_n1285;
    electrical cpphdl_n1300;
    electrical cpphdl_n1304;
    electrical cpphdl_n1308;
    electrical cpphdl_n1312;
    electrical cpphdl_n1316;
    electrical cpphdl_n1320;
    electrical cpphdl_n1324;
    electrical cpphdl_n1328;
    electrical cpphdl_n1329;
    electrical cpphdl_n1330;
    electrical cpphdl_n1331;
    electrical cpphdl_n1332;
    electrical cpphdl_n1333;
    electrical cpphdl_n1334;
    electrical cpphdl_n1335;
    electrical cpphdl_n1339;
    electrical cpphdl_n1340;
    electrical cpphdl_n1343;
    electrical cpphdl_n1344;
    electrical cpphdl_n1345;
    electrical cpphdl_n1348;
    electrical cpphdl_n1349;
    electrical cpphdl_n1353;
    electrical cpphdl_n1354;
    electrical cpphdl_n1355;
    electrical cpphdl_n1367;
    electrical cpphdl_n1370;
    electrical cpphdl_n1373;
    electrical cpphdl_n1376;
    electrical cpphdl_n1381;
    electrical cpphdl_n1405;
    electrical cpphdl_n1420;
    electrical cpphdl_n1424;
    electrical cpphdl_n1428;
    electrical cpphdl_n1432;
    electrical cpphdl_n1436;
    electrical cpphdl_n1440;
    electrical cpphdl_n1444;
    electrical cpphdl_n1448;
    electrical cpphdl_n1449;
    electrical cpphdl_n1450;
    electrical cpphdl_n1451;
    electrical cpphdl_n1452;
    electrical cpphdl_n1453;
    electrical cpphdl_n1454;
    electrical cpphdl_n1455;
    electrical cpphdl_n1459;
    electrical cpphdl_n1460;
    electrical cpphdl_n1463;
    electrical cpphdl_n1464;
    electrical cpphdl_n1465;
    electrical cpphdl_n1468;
    electrical cpphdl_n1469;
    electrical cpphdl_n1473;
    electrical cpphdl_n1474;
    electrical cpphdl_n1475;
    electrical cpphdl_n1487;
    electrical cpphdl_n1490;
    electrical cpphdl_n1493;
    electrical cpphdl_n1496;
    electrical cpphdl_n1501;
    electrical cpphdl_n1525;
    electrical cpphdl_n1540;
    electrical cpphdl_n1544;
    electrical cpphdl_n1548;
    electrical cpphdl_n1552;
    electrical cpphdl_n1556;
    electrical cpphdl_n1560;
    electrical cpphdl_n1564;
    electrical cpphdl_n1568;
    electrical cpphdl_n1569;
    electrical cpphdl_n1570;
    electrical cpphdl_n1571;
    electrical cpphdl_n1572;
    electrical cpphdl_n1573;
    electrical cpphdl_n1574;
    electrical cpphdl_n1575;
    electrical cpphdl_n1579;
    electrical cpphdl_n1580;
    electrical cpphdl_n1583;
    electrical cpphdl_n1584;
    electrical cpphdl_n1585;
    electrical cpphdl_n1588;
    electrical cpphdl_n1589;
    electrical cpphdl_n1593;
    electrical cpphdl_n1594;
    electrical cpphdl_n1595;
    electrical cpphdl_n1607;
    electrical cpphdl_n1610;
    electrical cpphdl_n1613;
    electrical cpphdl_n1616;
    electrical cpphdl_n1621;
    electrical cpphdl_n1645;
    electrical cpphdl_n1660;
    electrical cpphdl_n1664;
    electrical cpphdl_n1668;
    electrical cpphdl_n1672;
    electrical cpphdl_n1676;
    electrical cpphdl_n1680;
    electrical cpphdl_n1684;
    electrical cpphdl_n1688;
    electrical cpphdl_n1689;
    electrical cpphdl_n1690;
    electrical cpphdl_n1691;
    electrical cpphdl_n1692;
    electrical cpphdl_n1693;
    electrical cpphdl_n1694;
    electrical cpphdl_n1695;
    electrical cpphdl_n1699;
    electrical cpphdl_n1700;
    electrical cpphdl_n1703;
    electrical cpphdl_n1704;
    electrical cpphdl_n1705;
    electrical cpphdl_n1708;
    electrical cpphdl_n1709;
    electrical cpphdl_n1713;
    electrical cpphdl_n1714;
    electrical cpphdl_n1715;
    electrical cpphdl_n1727;
    electrical cpphdl_n1730;
    electrical cpphdl_n1733;
    electrical cpphdl_n1736;
    electrical cpphdl_n1741;
    electrical cpphdl_n1765;
    electrical cpphdl_n1780;
    electrical cpphdl_n1784;
    electrical cpphdl_n1788;
    electrical cpphdl_n1792;
    electrical cpphdl_n1796;
    electrical cpphdl_n1800;
    electrical cpphdl_n1804;
    electrical cpphdl_n1808;
    electrical cpphdl_n1809;
    electrical cpphdl_n1810;
    electrical cpphdl_n1811;
    electrical cpphdl_n1812;
    electrical cpphdl_n1813;
    electrical cpphdl_n1814;
    electrical cpphdl_n1815;
    electrical cpphdl_n1819;
    electrical cpphdl_n1820;
    electrical cpphdl_n1823;
    electrical cpphdl_n1824;
    electrical cpphdl_n1825;
    electrical cpphdl_n1828;
    electrical cpphdl_n1829;
    electrical cpphdl_n1833;
    electrical cpphdl_n1834;
    electrical cpphdl_n1835;
    electrical cpphdl_n1847;
    electrical cpphdl_n1850;
    electrical cpphdl_n1853;
    electrical cpphdl_n1856;
    electrical cpphdl_n1861;
    electrical cpphdl_n1885;
    electrical cpphdl_n1900;
    electrical cpphdl_n1904;
    electrical cpphdl_n1908;
    electrical cpphdl_n1912;
    electrical cpphdl_n1916;
    electrical cpphdl_n1920;
    electrical cpphdl_n1924;
    electrical cpphdl_n1928;
    electrical cpphdl_n1929;
    electrical cpphdl_n1930;
    electrical cpphdl_n1931;
    electrical cpphdl_n1932;
    electrical cpphdl_n1933;
    electrical cpphdl_n1934;
    electrical cpphdl_n1935;
    electrical cpphdl_n1939;
    electrical cpphdl_n1940;
    electrical cpphdl_n1943;
    electrical cpphdl_n1944;
    electrical cpphdl_n1945;
    electrical cpphdl_n1948;
    electrical cpphdl_n1949;
    electrical cpphdl_n1953;
    electrical cpphdl_n1954;
    electrical cpphdl_n1955;
    electrical cpphdl_n1967;
    electrical cpphdl_n1970;
    electrical cpphdl_n1973;
    electrical cpphdl_n1976;
    electrical cpphdl_n1981;
    electrical cpphdl_n2005;
    electrical cpphdl_n2020;
    electrical cpphdl_n2024;
    electrical cpphdl_n2028;
    electrical cpphdl_n2032;
    electrical cpphdl_n2036;
    electrical cpphdl_n2040;
    electrical cpphdl_n2044;
    electrical cpphdl_n2048;
    electrical cpphdl_n2049;
    electrical cpphdl_n2050;
    electrical cpphdl_n2051;
    electrical cpphdl_n2052;
    electrical cpphdl_n2053;
    electrical cpphdl_n2054;
    electrical cpphdl_n2055;
    electrical cpphdl_n2059;
    electrical cpphdl_n2060;
    electrical cpphdl_n2063;
    electrical cpphdl_n2064;
    electrical cpphdl_n2065;
    electrical cpphdl_n2068;
    electrical cpphdl_n2069;
    electrical cpphdl_n2073;
    electrical cpphdl_n2074;
    electrical cpphdl_n2075;
    electrical cpphdl_n2087;
    electrical cpphdl_n2090;
    electrical cpphdl_n2093;
    electrical cpphdl_n2096;
    electrical cpphdl_n2101;
    electrical cpphdl_n2123;
    electrical cpphdl_n2128;
    electrical cpphdl_n2133;
    electrical cpphdl_n2138;
    electrical cpphdl_n2143;
    electrical cpphdl_n2148;
    electrical cpphdl_n2153;
    electrical cpphdl_n2158;
    electrical cpphdl_n2163;
    electrical cpphdl_n2168;
    electrical cpphdl_n2173;
    electrical cpphdl_n2178;
    electrical cpphdl_n2183;
    electrical cpphdl_n2188;
    electrical cpphdl_n2193;
    electrical cpphdl_n2198;

    // Square-law channel, including reverse conduction. This is not a BSIM model.
    analog function real cpphdl_channel;
        input vgs, vds, beta, threshold, polarity;
        real vgs, vds, beta, threshold, polarity;
        real gate, drain, direction, overdrive, current;
        begin
            gate = polarity * vgs;
            drain = polarity * vds;
            direction = 1.0;
            if (drain < 0.0) begin
                gate = gate - drain;
                drain = -drain;
                direction = -1.0;
            end
            overdrive = gate - threshold;
            current = 0.0;
            if (overdrive > 0.0) begin
                if (drain < overdrive)
                    current = beta * (overdrive * drain - drain * drain / 2.0);
                else
                    current = beta * overdrive * overdrive / 2.0;
            end
            cpphdl_channel = polarity * direction * current;
        end
    endfunction

    analog begin
        // device 0, IC IC3, analog/basic/inverter.hpp:11
        I(cpphdl_n205, Vdd) <+ cpphdl_channel(V(TRACK0, Vdd), V(cpphdl_n205, Vdd), 0.0040000000000000001, 0.69999999999999996, -1.0);
        // device 1, IC IC3, analog/basic/inverter.hpp:12
        I(cpphdl_n205, Vss) <+ cpphdl_channel(V(TRACK0, Vss), V(cpphdl_n205, Vss), 0.0040000000000000001, 0.69999999999999996, 1.0);
        // device 2, IC IC2, analog/basic/mos_track_hold.hpp:31
        I(cpphdl_n205, Vss) <+ 2e-14 * ddt(V(cpphdl_n205, Vss)); // Bench initial voltage = 3.2999999999999998 V.
        // device 3, IC IC2, analog/basic/mos_track_hold.hpp:32
        I(IN, cpphdl_n259) <+ cpphdl_channel(V(TRACK0, cpphdl_n259), V(IN, cpphdl_n259), 0.080000000000000002, 0.69999999999999996, 1.0);
        // device 4, IC IC2, analog/basic/mos_track_hold.hpp:33
        I(cpphdl_n259, IN) <+ cpphdl_channel(V(cpphdl_n205, IN), V(cpphdl_n259, IN), 0.040000000000000001, 0.69999999999999996, -1.0);
        // device 5, IC IC2, analog/basic/mos_track_hold.hpp:37
        I(cpphdl_n259, cpphdl_n259) <+ cpphdl_channel(V(cpphdl_n205, cpphdl_n259), V(cpphdl_n259, cpphdl_n259), 0.040000000000000001, 0.69999999999999996, 1.0);
        // device 6, IC IC2, analog/basic/mos_track_hold.hpp:38
        I(cpphdl_n259, cpphdl_n259) <+ cpphdl_channel(V(TRACK0, cpphdl_n259), V(cpphdl_n259, cpphdl_n259), 0.02, 0.69999999999999996, -1.0);
        // device 7, IC IC2, analog/basic/mos_track_hold.hpp:39
        I(cpphdl_n259, Vss) <+ 2e-12 * ddt(V(cpphdl_n259, Vss)); // Bench initial voltage = 1.6499999999999999 V.
        // device 8, IC IC2, analog/basic/mos_track_hold.hpp:41
        I(Vss, cpphdl_n259) <+ V(Vss, cpphdl_n259) / 1000000000.0;
        // device 9, IC IC2, analog/basic/mos_track_hold.hpp:42
        I(TRACK0, cpphdl_n259) <+ 8.0000000000000006e-15 * ddt(V(TRACK0, cpphdl_n259)); // Bench initial voltage = -1.6499999999999999 V.
        // device 10, IC IC2, analog/basic/mos_track_hold.hpp:43
        I(cpphdl_n205, cpphdl_n259) <+ 8.0000000000000006e-15 * ddt(V(cpphdl_n205, cpphdl_n259)); // Bench initial voltage = 1.6499999999999999 V.
        // device 11, IC IC2, analog/basic/mos_track_hold.hpp:44
        I(IN, cpphdl_n259) <+ 4.0000000000000003e-15 * ddt(V(IN, cpphdl_n259)); // Bench initial voltage = 0.0 V.
        // device 12, IC IC5, analog/basic/inverter.hpp:11
        I(cpphdl_n220, Vdd) <+ cpphdl_channel(V(BIT_N0_0, Vdd), V(cpphdl_n220, Vdd), 0.080000000000000002, 0.69999999999999996, -1.0);
        // device 13, IC IC5, analog/basic/inverter.hpp:12
        I(cpphdl_n220, Vss) <+ cpphdl_channel(V(BIT_N0_0, Vss), V(cpphdl_n220, Vss), 0.080000000000000002, 0.69999999999999996, 1.0);
        // device 14, IC IC4, analog/basic/mos_r2r_dac.hpp:27
        I(cpphdl_n220, Vss) <+ 2.9999999999999998e-15 * ddt(V(cpphdl_n220, Vss)); // Bench initial voltage = 0.0 V.
        // device 15, IC IC4, analog/basic/mos_r2r_dac.hpp:28
        I(cpphdl_n220, cpphdl_n249) <+ V(cpphdl_n220, cpphdl_n249) / 20000.0;
        // device 16, IC IC4, analog/basic/mos_r2r_dac.hpp:29
        I(cpphdl_n249, Vss) <+ 2.9999999999999998e-15 * ddt(V(cpphdl_n249, Vss)); // Bench initial voltage = 0.0 V.
        // device 17, IC IC6, analog/basic/inverter.hpp:11
        I(cpphdl_n224, Vdd) <+ cpphdl_channel(V(BIT_N0_1, Vdd), V(cpphdl_n224, Vdd), 0.080000000000000002, 0.69999999999999996, -1.0);
        // device 18, IC IC6, analog/basic/inverter.hpp:12
        I(cpphdl_n224, Vss) <+ cpphdl_channel(V(BIT_N0_1, Vss), V(cpphdl_n224, Vss), 0.080000000000000002, 0.69999999999999996, 1.0);
        // device 19, IC IC4, analog/basic/mos_r2r_dac.hpp:27
        I(cpphdl_n224, Vss) <+ 2.9999999999999998e-15 * ddt(V(cpphdl_n224, Vss)); // Bench initial voltage = 0.0 V.
        // device 20, IC IC4, analog/basic/mos_r2r_dac.hpp:28
        I(cpphdl_n224, cpphdl_n250) <+ V(cpphdl_n224, cpphdl_n250) / 20000.0;
        // device 21, IC IC4, analog/basic/mos_r2r_dac.hpp:29
        I(cpphdl_n250, Vss) <+ 2.9999999999999998e-15 * ddt(V(cpphdl_n250, Vss)); // Bench initial voltage = 0.0 V.
        // device 22, IC IC4, analog/basic/mos_r2r_dac.hpp:31
        I(cpphdl_n249, cpphdl_n250) <+ V(cpphdl_n249, cpphdl_n250) / 10000.0;
        // device 23, IC IC7, analog/basic/inverter.hpp:11
        I(cpphdl_n228, Vdd) <+ cpphdl_channel(V(BIT_N0_2, Vdd), V(cpphdl_n228, Vdd), 0.080000000000000002, 0.69999999999999996, -1.0);
        // device 24, IC IC7, analog/basic/inverter.hpp:12
        I(cpphdl_n228, Vss) <+ cpphdl_channel(V(BIT_N0_2, Vss), V(cpphdl_n228, Vss), 0.080000000000000002, 0.69999999999999996, 1.0);
        // device 25, IC IC4, analog/basic/mos_r2r_dac.hpp:27
        I(cpphdl_n228, Vss) <+ 2.9999999999999998e-15 * ddt(V(cpphdl_n228, Vss)); // Bench initial voltage = 0.0 V.
        // device 26, IC IC4, analog/basic/mos_r2r_dac.hpp:28
        I(cpphdl_n228, cpphdl_n251) <+ V(cpphdl_n228, cpphdl_n251) / 20000.0;
        // device 27, IC IC4, analog/basic/mos_r2r_dac.hpp:29
        I(cpphdl_n251, Vss) <+ 2.9999999999999998e-15 * ddt(V(cpphdl_n251, Vss)); // Bench initial voltage = 0.0 V.
        // device 28, IC IC4, analog/basic/mos_r2r_dac.hpp:31
        I(cpphdl_n250, cpphdl_n251) <+ V(cpphdl_n250, cpphdl_n251) / 10000.0;
        // device 29, IC IC8, analog/basic/inverter.hpp:11
        I(cpphdl_n232, Vdd) <+ cpphdl_channel(V(BIT_N0_3, Vdd), V(cpphdl_n232, Vdd), 0.080000000000000002, 0.69999999999999996, -1.0);
        // device 30, IC IC8, analog/basic/inverter.hpp:12
        I(cpphdl_n232, Vss) <+ cpphdl_channel(V(BIT_N0_3, Vss), V(cpphdl_n232, Vss), 0.080000000000000002, 0.69999999999999996, 1.0);
        // device 31, IC IC4, analog/basic/mos_r2r_dac.hpp:27
        I(cpphdl_n232, Vss) <+ 2.9999999999999998e-15 * ddt(V(cpphdl_n232, Vss)); // Bench initial voltage = 0.0 V.
        // device 32, IC IC4, analog/basic/mos_r2r_dac.hpp:28
        I(cpphdl_n232, cpphdl_n252) <+ V(cpphdl_n232, cpphdl_n252) / 20000.0;
        // device 33, IC IC4, analog/basic/mos_r2r_dac.hpp:29
        I(cpphdl_n252, Vss) <+ 2.9999999999999998e-15 * ddt(V(cpphdl_n252, Vss)); // Bench initial voltage = 0.0 V.
        // device 34, IC IC4, analog/basic/mos_r2r_dac.hpp:31
        I(cpphdl_n251, cpphdl_n252) <+ V(cpphdl_n251, cpphdl_n252) / 10000.0;
        // device 35, IC IC9, analog/basic/inverter.hpp:11
        I(cpphdl_n236, Vdd) <+ cpphdl_channel(V(BIT_N0_4, Vdd), V(cpphdl_n236, Vdd), 0.080000000000000002, 0.69999999999999996, -1.0);
        // device 36, IC IC9, analog/basic/inverter.hpp:12
        I(cpphdl_n236, Vss) <+ cpphdl_channel(V(BIT_N0_4, Vss), V(cpphdl_n236, Vss), 0.080000000000000002, 0.69999999999999996, 1.0);
        // device 37, IC IC4, analog/basic/mos_r2r_dac.hpp:27
        I(cpphdl_n236, Vss) <+ 2.9999999999999998e-15 * ddt(V(cpphdl_n236, Vss)); // Bench initial voltage = 0.0 V.
        // device 38, IC IC4, analog/basic/mos_r2r_dac.hpp:28
        I(cpphdl_n236, cpphdl_n253) <+ V(cpphdl_n236, cpphdl_n253) / 20000.0;
        // device 39, IC IC4, analog/basic/mos_r2r_dac.hpp:29
        I(cpphdl_n253, Vss) <+ 2.9999999999999998e-15 * ddt(V(cpphdl_n253, Vss)); // Bench initial voltage = 0.0 V.
        // device 40, IC IC4, analog/basic/mos_r2r_dac.hpp:31
        I(cpphdl_n252, cpphdl_n253) <+ V(cpphdl_n252, cpphdl_n253) / 10000.0;
        // device 41, IC IC10, analog/basic/inverter.hpp:11
        I(cpphdl_n240, Vdd) <+ cpphdl_channel(V(BIT_N0_5, Vdd), V(cpphdl_n240, Vdd), 0.080000000000000002, 0.69999999999999996, -1.0);
        // device 42, IC IC10, analog/basic/inverter.hpp:12
        I(cpphdl_n240, Vss) <+ cpphdl_channel(V(BIT_N0_5, Vss), V(cpphdl_n240, Vss), 0.080000000000000002, 0.69999999999999996, 1.0);
        // device 43, IC IC4, analog/basic/mos_r2r_dac.hpp:27
        I(cpphdl_n240, Vss) <+ 2.9999999999999998e-15 * ddt(V(cpphdl_n240, Vss)); // Bench initial voltage = 0.0 V.
        // device 44, IC IC4, analog/basic/mos_r2r_dac.hpp:28
        I(cpphdl_n240, cpphdl_n254) <+ V(cpphdl_n240, cpphdl_n254) / 20000.0;
        // device 45, IC IC4, analog/basic/mos_r2r_dac.hpp:29
        I(cpphdl_n254, Vss) <+ 2.9999999999999998e-15 * ddt(V(cpphdl_n254, Vss)); // Bench initial voltage = 0.0 V.
        // device 46, IC IC4, analog/basic/mos_r2r_dac.hpp:31
        I(cpphdl_n253, cpphdl_n254) <+ V(cpphdl_n253, cpphdl_n254) / 10000.0;
        // device 47, IC IC11, analog/basic/inverter.hpp:11
        I(cpphdl_n244, Vdd) <+ cpphdl_channel(V(BIT_N0_6, Vdd), V(cpphdl_n244, Vdd), 0.080000000000000002, 0.69999999999999996, -1.0);
        // device 48, IC IC11, analog/basic/inverter.hpp:12
        I(cpphdl_n244, Vss) <+ cpphdl_channel(V(BIT_N0_6, Vss), V(cpphdl_n244, Vss), 0.080000000000000002, 0.69999999999999996, 1.0);
        // device 49, IC IC4, analog/basic/mos_r2r_dac.hpp:27
        I(cpphdl_n244, Vss) <+ 2.9999999999999998e-15 * ddt(V(cpphdl_n244, Vss)); // Bench initial voltage = 0.0 V.
        // device 50, IC IC4, analog/basic/mos_r2r_dac.hpp:28
        I(cpphdl_n244, cpphdl_n255) <+ V(cpphdl_n244, cpphdl_n255) / 20000.0;
        // device 51, IC IC4, analog/basic/mos_r2r_dac.hpp:29
        I(cpphdl_n255, Vss) <+ 2.9999999999999998e-15 * ddt(V(cpphdl_n255, Vss)); // Bench initial voltage = 0.0 V.
        // device 52, IC IC4, analog/basic/mos_r2r_dac.hpp:31
        I(cpphdl_n254, cpphdl_n255) <+ V(cpphdl_n254, cpphdl_n255) / 10000.0;
        // device 53, IC IC12, analog/basic/inverter.hpp:11
        I(cpphdl_n248, Vdd) <+ cpphdl_channel(V(BIT_N0_7, Vdd), V(cpphdl_n248, Vdd), 0.080000000000000002, 0.69999999999999996, -1.0);
        // device 54, IC IC12, analog/basic/inverter.hpp:12
        I(cpphdl_n248, Vss) <+ cpphdl_channel(V(BIT_N0_7, Vss), V(cpphdl_n248, Vss), 0.080000000000000002, 0.69999999999999996, 1.0);
        // device 55, IC IC4, analog/basic/mos_r2r_dac.hpp:27
        I(cpphdl_n248, Vss) <+ 2.9999999999999998e-15 * ddt(V(cpphdl_n248, Vss)); // Bench initial voltage = 0.0 V.
        // device 56, IC IC4, analog/basic/mos_r2r_dac.hpp:28
        I(cpphdl_n248, cpphdl_n260) <+ V(cpphdl_n248, cpphdl_n260) / 20000.0;
        // device 57, IC IC4, analog/basic/mos_r2r_dac.hpp:29
        I(cpphdl_n260, Vss) <+ 2.9999999999999998e-15 * ddt(V(cpphdl_n260, Vss)); // Bench initial voltage = 0.0 V.
        // device 58, IC IC4, analog/basic/mos_r2r_dac.hpp:31
        I(cpphdl_n255, cpphdl_n260) <+ V(cpphdl_n255, cpphdl_n260) / 10000.0;
        // device 59, IC IC4, analog/basic/mos_r2r_dac.hpp:33
        I(Vss, cpphdl_n249) <+ V(Vss, cpphdl_n249) / 20000.0;
        // device 60, IC IC13, analog/basic/nmos_resistor_amplifier.hpp:23
        I(Vdd, cpphdl_n269) <+ V(Vdd, cpphdl_n269) / 1000.0;
        // device 61, IC IC13, analog/basic/nmos_resistor_amplifier.hpp:24
        I(Vdd, cpphdl_n268) <+ V(Vdd, cpphdl_n268) / 1000.0;
        // device 62, IC IC13, analog/basic/nmos_resistor_amplifier.hpp:25
        I(cpphdl_n269, cpphdl_n263) <+ cpphdl_channel(V(cpphdl_n259, cpphdl_n263), V(cpphdl_n269, cpphdl_n263), 0.014999999999999999, 0.69999999999999996, 1.0);
        // device 63, IC IC13, analog/basic/nmos_resistor_amplifier.hpp:26
        I(cpphdl_n268, cpphdl_n264) <+ cpphdl_channel(V(cpphdl_n260, cpphdl_n264), V(cpphdl_n268, cpphdl_n264), 0.014999999999999999, 0.69999999999999996, 1.0);
        // device 64, IC IC13, analog/basic/nmos_resistor_amplifier.hpp:27
        I(cpphdl_n265, cpphdl_n263) <+ V(cpphdl_n265, cpphdl_n263) / 50.0;
        // device 65, IC IC13, analog/basic/nmos_resistor_amplifier.hpp:28
        I(cpphdl_n265, cpphdl_n264) <+ V(cpphdl_n265, cpphdl_n264) / 50.0;
        // device 66, IC IC13, analog/basic/nmos_resistor_amplifier.hpp:29
        I(Vss, cpphdl_n265) <+ V(Vss, cpphdl_n265) / 150.0;
        // device 67, IC IC13, analog/basic/nmos_resistor_amplifier.hpp:30
        I(cpphdl_n269, Vdd) <+ 2.9999999999999998e-13 * ddt(V(cpphdl_n269, Vdd)); // Bench initial voltage = 0.0 V.
        // device 68, IC IC13, analog/basic/nmos_resistor_amplifier.hpp:31
        I(cpphdl_n268, Vdd) <+ 2.9999999999999998e-13 * ddt(V(cpphdl_n268, Vdd)); // Bench initial voltage = 0.0 V.
        // device 69, IC IC13, analog/basic/nmos_resistor_amplifier.hpp:32
        I(cpphdl_n265, Vss) <+ 4e-14 * ddt(V(cpphdl_n265, Vss)); // Bench initial voltage = 0.0 V.
        // device 70, IC IC13, analog/basic/nmos_resistor_amplifier.hpp:34
        I(cpphdl_n259, cpphdl_n263) <+ 2e-14 * ddt(V(cpphdl_n259, cpphdl_n263)); // Bench initial voltage = 1.6499999999999999 V.
        // device 71, IC IC13, analog/basic/nmos_resistor_amplifier.hpp:35
        I(cpphdl_n260, cpphdl_n264) <+ 2e-14 * ddt(V(cpphdl_n260, cpphdl_n264)); // Bench initial voltage = 0.0 V.
        // device 72, IC IC13, analog/basic/nmos_resistor_amplifier.hpp:36
        I(cpphdl_n259, cpphdl_n269) <+ 2.9999999999999998e-15 * ddt(V(cpphdl_n259, cpphdl_n269)); // Bench initial voltage = -1.6499999999999999 V.
        // device 73, IC IC13, analog/basic/nmos_resistor_amplifier.hpp:37
        I(cpphdl_n260, cpphdl_n268) <+ 2.9999999999999998e-15 * ddt(V(cpphdl_n260, cpphdl_n268)); // Bench initial voltage = -3.2999999999999998 V.
        // device 74, IC IC14, analog/basic/strongarm_comparator.hpp:28
        I(cpphdl_n273, cpphdl_n275) <+ cpphdl_channel(V(cpphdl_n268, cpphdl_n275), V(cpphdl_n273, cpphdl_n275), 0.0080000000000000002, 0.69999999999999996, 1.0);
        // device 75, IC IC14, analog/basic/strongarm_comparator.hpp:29
        I(cpphdl_n274, cpphdl_n275) <+ cpphdl_channel(V(cpphdl_n269, cpphdl_n275), V(cpphdl_n274, cpphdl_n275), 0.0080000000000000002, 0.69999999999999996, 1.0);
        // device 76, IC IC14, analog/basic/strongarm_comparator.hpp:30
        I(cpphdl_n275, Vss) <+ cpphdl_channel(V(EVALUATE, Vss), V(cpphdl_n275, Vss), 0.0080000000000000002, 0.69999999999999996, 1.0);
        // device 77, IC IC14, analog/basic/strongarm_comparator.hpp:33
        I(cpphdl_n287, cpphdl_n273) <+ cpphdl_channel(V(cpphdl_n293, cpphdl_n273), V(cpphdl_n287, cpphdl_n273), 0.0040000000000000001, 0.69999999999999996, 1.0);
        // device 78, IC IC14, analog/basic/strongarm_comparator.hpp:34
        I(cpphdl_n293, cpphdl_n274) <+ cpphdl_channel(V(cpphdl_n287, cpphdl_n274), V(cpphdl_n293, cpphdl_n274), 0.0040000000000000001, 0.69999999999999996, 1.0);
        // device 79, IC IC14, analog/basic/strongarm_comparator.hpp:35
        I(cpphdl_n293, Vdd) <+ cpphdl_channel(V(cpphdl_n287, Vdd), V(cpphdl_n293, Vdd), 0.002, 0.69999999999999996, -1.0);
        // device 80, IC IC14, analog/basic/strongarm_comparator.hpp:36
        I(cpphdl_n287, Vdd) <+ cpphdl_channel(V(cpphdl_n293, Vdd), V(cpphdl_n287, Vdd), 0.002, 0.69999999999999996, -1.0);
        // device 81, IC IC14, analog/basic/strongarm_comparator.hpp:38
        I(cpphdl_n273, Vdd) <+ cpphdl_channel(V(EVALUATE, Vdd), V(cpphdl_n273, Vdd), 0.002, 0.69999999999999996, -1.0);
        // device 82, IC IC14, analog/basic/strongarm_comparator.hpp:39
        I(cpphdl_n274, Vdd) <+ cpphdl_channel(V(EVALUATE, Vdd), V(cpphdl_n274, Vdd), 0.002, 0.69999999999999996, -1.0);
        // device 83, IC IC14, analog/basic/strongarm_comparator.hpp:40
        I(cpphdl_n293, Vdd) <+ cpphdl_channel(V(EVALUATE, Vdd), V(cpphdl_n293, Vdd), 0.002, 0.69999999999999996, -1.0);
        // device 84, IC IC14, analog/basic/strongarm_comparator.hpp:41
        I(cpphdl_n287, Vdd) <+ cpphdl_channel(V(EVALUATE, Vdd), V(cpphdl_n287, Vdd), 0.002, 0.69999999999999996, -1.0);
        // device 85, IC IC14, analog/basic/strongarm_comparator.hpp:42
        I(cpphdl_n273, Vss) <+ 2.9999999999999998e-14 * ddt(V(cpphdl_n273, Vss)); // Bench initial voltage = 0.0 V.
        // device 86, IC IC14, analog/basic/strongarm_comparator.hpp:43
        I(cpphdl_n274, Vss) <+ 2.9999999999999998e-14 * ddt(V(cpphdl_n274, Vss)); // Bench initial voltage = 0.0 V.
        // device 87, IC IC14, analog/basic/strongarm_comparator.hpp:44
        I(cpphdl_n275, Vss) <+ 2.9999999999999998e-14 * ddt(V(cpphdl_n275, Vss)); // Bench initial voltage = 0.0 V.
        // device 88, IC IC14, analog/basic/strongarm_comparator.hpp:45
        I(cpphdl_n293, Vss) <+ 5.0000000000000002e-14 * ddt(V(cpphdl_n293, Vss)); // Bench initial voltage = 0.0 V.
        // device 89, IC IC14, analog/basic/strongarm_comparator.hpp:46
        I(cpphdl_n287, Vss) <+ 5.0000000000000002e-14 * ddt(V(cpphdl_n287, Vss)); // Bench initial voltage = 0.0 V.
        // device 90, IC IC14, analog/basic/strongarm_comparator.hpp:47
        I(cpphdl_n268, cpphdl_n275) <+ 2e-14 * ddt(V(cpphdl_n268, cpphdl_n275)); // Bench initial voltage = 3.2999999999999998 V.
        // device 91, IC IC14, analog/basic/strongarm_comparator.hpp:48
        I(cpphdl_n269, cpphdl_n275) <+ 2e-14 * ddt(V(cpphdl_n269, cpphdl_n275)); // Bench initial voltage = 3.2999999999999998 V.
        // device 92, IC IC14, analog/basic/strongarm_comparator.hpp:49
        I(cpphdl_n268, cpphdl_n273) <+ 2.9999999999999998e-15 * ddt(V(cpphdl_n268, cpphdl_n273)); // Bench initial voltage = 3.2999999999999998 V.
        // device 93, IC IC14, analog/basic/strongarm_comparator.hpp:50
        I(cpphdl_n269, cpphdl_n274) <+ 2.9999999999999998e-15 * ddt(V(cpphdl_n269, cpphdl_n274)); // Bench initial voltage = 3.2999999999999998 V.
        // device 94, IC IC16, analog/basic/cmos_logic.hpp:17
        I(DECISION0, Vss) <+ 5.0000000000000002e-14 * ddt(V(DECISION0, Vss)); // Bench initial voltage = 0.0 V.
        // device 95, IC IC16, analog/basic/cmos_logic.hpp:18
        I(DECISION0, Vdd) <+ cpphdl_channel(V(cpphdl_n287, Vdd), V(DECISION0, Vdd), 0.01, 0.69999999999999996, -1.0);
        // device 96, IC IC16, analog/basic/cmos_logic.hpp:19
        I(DECISION0, Vdd) <+ cpphdl_channel(V(DECISION_N0, Vdd), V(DECISION0, Vdd), 0.01, 0.69999999999999996, -1.0);
        // device 97, IC IC16, analog/basic/cmos_logic.hpp:20
        I(DECISION0, cpphdl_n290) <+ cpphdl_channel(V(cpphdl_n287, cpphdl_n290), V(DECISION0, cpphdl_n290), 0.01, 0.69999999999999996, 1.0);
        // device 98, IC IC16, analog/basic/cmos_logic.hpp:21
        I(cpphdl_n290, Vss) <+ cpphdl_channel(V(DECISION_N0, Vss), V(cpphdl_n290, Vss), 0.01, 0.69999999999999996, 1.0);
        // device 99, IC IC16, analog/basic/cmos_logic.hpp:23
        I(DECISION0, Vss) <+ V(DECISION0, Vss) / 1000000000.0;
        // device 100, IC IC16, analog/basic/cmos_logic.hpp:24
        I(cpphdl_n290, Vss) <+ V(cpphdl_n290, Vss) / 1000000000.0;
        // device 101, IC IC17, analog/basic/cmos_logic.hpp:17
        I(DECISION_N0, Vss) <+ 5.0000000000000002e-14 * ddt(V(DECISION_N0, Vss)); // Bench initial voltage = 0.0 V.
        // device 102, IC IC17, analog/basic/cmos_logic.hpp:18
        I(DECISION_N0, Vdd) <+ cpphdl_channel(V(cpphdl_n293, Vdd), V(DECISION_N0, Vdd), 0.01, 0.69999999999999996, -1.0);
        // device 103, IC IC17, analog/basic/cmos_logic.hpp:19
        I(DECISION_N0, Vdd) <+ cpphdl_channel(V(DECISION0, Vdd), V(DECISION_N0, Vdd), 0.01, 0.69999999999999996, -1.0);
        // device 104, IC IC17, analog/basic/cmos_logic.hpp:20
        I(DECISION_N0, cpphdl_n296) <+ cpphdl_channel(V(cpphdl_n293, cpphdl_n296), V(DECISION_N0, cpphdl_n296), 0.01, 0.69999999999999996, 1.0);
        // device 105, IC IC17, analog/basic/cmos_logic.hpp:21
        I(cpphdl_n296, Vss) <+ cpphdl_channel(V(DECISION0, Vss), V(cpphdl_n296, Vss), 0.01, 0.69999999999999996, 1.0);
        // device 106, IC IC17, analog/basic/cmos_logic.hpp:23
        I(DECISION_N0, Vss) <+ V(DECISION_N0, Vss) / 1000000000.0;
        // device 107, IC IC17, analog/basic/cmos_logic.hpp:24
        I(cpphdl_n296, Vss) <+ V(cpphdl_n296, Vss) / 1000000000.0;
        // device 108, IC IC15, analog/basic/nand_latch.hpp:36
        I(cpphdl_n287, Vss) <+ 2.9999999999999998e-15 * ddt(V(cpphdl_n287, Vss)); // Bench initial voltage = 0.0 V.
        // device 109, IC IC15, analog/basic/nand_latch.hpp:37
        I(cpphdl_n293, Vss) <+ 2.9999999999999998e-15 * ddt(V(cpphdl_n293, Vss)); // Bench initial voltage = 0.0 V.
        // device 110, IC IC18, analog/basic/inverter.hpp:11
        I(cpphdl_n301, Vdd) <+ cpphdl_channel(V(CLEAR, Vdd), V(cpphdl_n301, Vdd), 0.01, 0.69999999999999996, -1.0);
        // device 111, IC IC18, analog/basic/inverter.hpp:12
        I(cpphdl_n301, Vss) <+ cpphdl_channel(V(CLEAR, Vss), V(cpphdl_n301, Vss), 0.01, 0.69999999999999996, 1.0);
        // device 112, IC IC15, analog/basic/nand_latch.hpp:58
        I(cpphdl_n301, Vss) <+ 2.9999999999999998e-15 * ddt(V(cpphdl_n301, Vss)); // Bench initial voltage = 0.0 V.
        // device 113, IC IC15, analog/basic/nand_latch.hpp:59
        I(DECISION0, Vss) <+ cpphdl_channel(V(CLEAR, Vss), V(DECISION0, Vss), 0.050000000000000003, 0.69999999999999996, 1.0);
        // device 114, IC IC15, analog/basic/nand_latch.hpp:60
        I(DECISION_N0, Vdd) <+ cpphdl_channel(V(cpphdl_n301, Vdd), V(DECISION_N0, Vdd), 0.050000000000000003, 0.69999999999999996, -1.0);
        // device 115, IC IC21, analog/basic/inverter.hpp:11
        I(cpphdl_n325, Vdd) <+ cpphdl_channel(V(TRACK1, Vdd), V(cpphdl_n325, Vdd), 0.0040000000000000001, 0.69999999999999996, -1.0);
        // device 116, IC IC21, analog/basic/inverter.hpp:12
        I(cpphdl_n325, Vss) <+ cpphdl_channel(V(TRACK1, Vss), V(cpphdl_n325, Vss), 0.0040000000000000001, 0.69999999999999996, 1.0);
        // device 117, IC IC20, analog/basic/mos_track_hold.hpp:31
        I(cpphdl_n325, Vss) <+ 2e-14 * ddt(V(cpphdl_n325, Vss)); // Bench initial voltage = 3.2999999999999998 V.
        // device 118, IC IC20, analog/basic/mos_track_hold.hpp:32
        I(IN, cpphdl_n379) <+ cpphdl_channel(V(TRACK1, cpphdl_n379), V(IN, cpphdl_n379), 0.080000000000000002, 0.69999999999999996, 1.0);
        // device 119, IC IC20, analog/basic/mos_track_hold.hpp:33
        I(cpphdl_n379, IN) <+ cpphdl_channel(V(cpphdl_n325, IN), V(cpphdl_n379, IN), 0.040000000000000001, 0.69999999999999996, -1.0);
        // device 120, IC IC20, analog/basic/mos_track_hold.hpp:37
        I(cpphdl_n379, cpphdl_n379) <+ cpphdl_channel(V(cpphdl_n325, cpphdl_n379), V(cpphdl_n379, cpphdl_n379), 0.040000000000000001, 0.69999999999999996, 1.0);
        // device 121, IC IC20, analog/basic/mos_track_hold.hpp:38
        I(cpphdl_n379, cpphdl_n379) <+ cpphdl_channel(V(TRACK1, cpphdl_n379), V(cpphdl_n379, cpphdl_n379), 0.02, 0.69999999999999996, -1.0);
        // device 122, IC IC20, analog/basic/mos_track_hold.hpp:39
        I(cpphdl_n379, Vss) <+ 2e-12 * ddt(V(cpphdl_n379, Vss)); // Bench initial voltage = 1.6499999999999999 V.
        // device 123, IC IC20, analog/basic/mos_track_hold.hpp:41
        I(Vss, cpphdl_n379) <+ V(Vss, cpphdl_n379) / 1000000000.0;
        // device 124, IC IC20, analog/basic/mos_track_hold.hpp:42
        I(TRACK1, cpphdl_n379) <+ 8.0000000000000006e-15 * ddt(V(TRACK1, cpphdl_n379)); // Bench initial voltage = -1.6499999999999999 V.
        // device 125, IC IC20, analog/basic/mos_track_hold.hpp:43
        I(cpphdl_n325, cpphdl_n379) <+ 8.0000000000000006e-15 * ddt(V(cpphdl_n325, cpphdl_n379)); // Bench initial voltage = 1.6499999999999999 V.
        // device 126, IC IC20, analog/basic/mos_track_hold.hpp:44
        I(IN, cpphdl_n379) <+ 4.0000000000000003e-15 * ddt(V(IN, cpphdl_n379)); // Bench initial voltage = 0.0 V.
        // device 127, IC IC23, analog/basic/inverter.hpp:11
        I(cpphdl_n340, Vdd) <+ cpphdl_channel(V(BIT_N1_0, Vdd), V(cpphdl_n340, Vdd), 0.080000000000000002, 0.69999999999999996, -1.0);
        // device 128, IC IC23, analog/basic/inverter.hpp:12
        I(cpphdl_n340, Vss) <+ cpphdl_channel(V(BIT_N1_0, Vss), V(cpphdl_n340, Vss), 0.080000000000000002, 0.69999999999999996, 1.0);
        // device 129, IC IC22, analog/basic/mos_r2r_dac.hpp:27
        I(cpphdl_n340, Vss) <+ 2.9999999999999998e-15 * ddt(V(cpphdl_n340, Vss)); // Bench initial voltage = 0.0 V.
        // device 130, IC IC22, analog/basic/mos_r2r_dac.hpp:28
        I(cpphdl_n340, cpphdl_n369) <+ V(cpphdl_n340, cpphdl_n369) / 20000.0;
        // device 131, IC IC22, analog/basic/mos_r2r_dac.hpp:29
        I(cpphdl_n369, Vss) <+ 2.9999999999999998e-15 * ddt(V(cpphdl_n369, Vss)); // Bench initial voltage = 0.0 V.
        // device 132, IC IC24, analog/basic/inverter.hpp:11
        I(cpphdl_n344, Vdd) <+ cpphdl_channel(V(BIT_N1_1, Vdd), V(cpphdl_n344, Vdd), 0.080000000000000002, 0.69999999999999996, -1.0);
        // device 133, IC IC24, analog/basic/inverter.hpp:12
        I(cpphdl_n344, Vss) <+ cpphdl_channel(V(BIT_N1_1, Vss), V(cpphdl_n344, Vss), 0.080000000000000002, 0.69999999999999996, 1.0);
        // device 134, IC IC22, analog/basic/mos_r2r_dac.hpp:27
        I(cpphdl_n344, Vss) <+ 2.9999999999999998e-15 * ddt(V(cpphdl_n344, Vss)); // Bench initial voltage = 0.0 V.
        // device 135, IC IC22, analog/basic/mos_r2r_dac.hpp:28
        I(cpphdl_n344, cpphdl_n370) <+ V(cpphdl_n344, cpphdl_n370) / 20000.0;
        // device 136, IC IC22, analog/basic/mos_r2r_dac.hpp:29
        I(cpphdl_n370, Vss) <+ 2.9999999999999998e-15 * ddt(V(cpphdl_n370, Vss)); // Bench initial voltage = 0.0 V.
        // device 137, IC IC22, analog/basic/mos_r2r_dac.hpp:31
        I(cpphdl_n369, cpphdl_n370) <+ V(cpphdl_n369, cpphdl_n370) / 10000.0;
        // device 138, IC IC25, analog/basic/inverter.hpp:11
        I(cpphdl_n348, Vdd) <+ cpphdl_channel(V(BIT_N1_2, Vdd), V(cpphdl_n348, Vdd), 0.080000000000000002, 0.69999999999999996, -1.0);
        // device 139, IC IC25, analog/basic/inverter.hpp:12
        I(cpphdl_n348, Vss) <+ cpphdl_channel(V(BIT_N1_2, Vss), V(cpphdl_n348, Vss), 0.080000000000000002, 0.69999999999999996, 1.0);
        // device 140, IC IC22, analog/basic/mos_r2r_dac.hpp:27
        I(cpphdl_n348, Vss) <+ 2.9999999999999998e-15 * ddt(V(cpphdl_n348, Vss)); // Bench initial voltage = 0.0 V.
        // device 141, IC IC22, analog/basic/mos_r2r_dac.hpp:28
        I(cpphdl_n348, cpphdl_n371) <+ V(cpphdl_n348, cpphdl_n371) / 20000.0;
        // device 142, IC IC22, analog/basic/mos_r2r_dac.hpp:29
        I(cpphdl_n371, Vss) <+ 2.9999999999999998e-15 * ddt(V(cpphdl_n371, Vss)); // Bench initial voltage = 0.0 V.
        // device 143, IC IC22, analog/basic/mos_r2r_dac.hpp:31
        I(cpphdl_n370, cpphdl_n371) <+ V(cpphdl_n370, cpphdl_n371) / 10000.0;
        // device 144, IC IC26, analog/basic/inverter.hpp:11
        I(cpphdl_n352, Vdd) <+ cpphdl_channel(V(BIT_N1_3, Vdd), V(cpphdl_n352, Vdd), 0.080000000000000002, 0.69999999999999996, -1.0);
        // device 145, IC IC26, analog/basic/inverter.hpp:12
        I(cpphdl_n352, Vss) <+ cpphdl_channel(V(BIT_N1_3, Vss), V(cpphdl_n352, Vss), 0.080000000000000002, 0.69999999999999996, 1.0);
        // device 146, IC IC22, analog/basic/mos_r2r_dac.hpp:27
        I(cpphdl_n352, Vss) <+ 2.9999999999999998e-15 * ddt(V(cpphdl_n352, Vss)); // Bench initial voltage = 0.0 V.
        // device 147, IC IC22, analog/basic/mos_r2r_dac.hpp:28
        I(cpphdl_n352, cpphdl_n372) <+ V(cpphdl_n352, cpphdl_n372) / 20000.0;
        // device 148, IC IC22, analog/basic/mos_r2r_dac.hpp:29
        I(cpphdl_n372, Vss) <+ 2.9999999999999998e-15 * ddt(V(cpphdl_n372, Vss)); // Bench initial voltage = 0.0 V.
        // device 149, IC IC22, analog/basic/mos_r2r_dac.hpp:31
        I(cpphdl_n371, cpphdl_n372) <+ V(cpphdl_n371, cpphdl_n372) / 10000.0;
        // device 150, IC IC27, analog/basic/inverter.hpp:11
        I(cpphdl_n356, Vdd) <+ cpphdl_channel(V(BIT_N1_4, Vdd), V(cpphdl_n356, Vdd), 0.080000000000000002, 0.69999999999999996, -1.0);
        // device 151, IC IC27, analog/basic/inverter.hpp:12
        I(cpphdl_n356, Vss) <+ cpphdl_channel(V(BIT_N1_4, Vss), V(cpphdl_n356, Vss), 0.080000000000000002, 0.69999999999999996, 1.0);
        // device 152, IC IC22, analog/basic/mos_r2r_dac.hpp:27
        I(cpphdl_n356, Vss) <+ 2.9999999999999998e-15 * ddt(V(cpphdl_n356, Vss)); // Bench initial voltage = 0.0 V.
        // device 153, IC IC22, analog/basic/mos_r2r_dac.hpp:28
        I(cpphdl_n356, cpphdl_n373) <+ V(cpphdl_n356, cpphdl_n373) / 20000.0;
        // device 154, IC IC22, analog/basic/mos_r2r_dac.hpp:29
        I(cpphdl_n373, Vss) <+ 2.9999999999999998e-15 * ddt(V(cpphdl_n373, Vss)); // Bench initial voltage = 0.0 V.
        // device 155, IC IC22, analog/basic/mos_r2r_dac.hpp:31
        I(cpphdl_n372, cpphdl_n373) <+ V(cpphdl_n372, cpphdl_n373) / 10000.0;
        // device 156, IC IC28, analog/basic/inverter.hpp:11
        I(cpphdl_n360, Vdd) <+ cpphdl_channel(V(BIT_N1_5, Vdd), V(cpphdl_n360, Vdd), 0.080000000000000002, 0.69999999999999996, -1.0);
        // device 157, IC IC28, analog/basic/inverter.hpp:12
        I(cpphdl_n360, Vss) <+ cpphdl_channel(V(BIT_N1_5, Vss), V(cpphdl_n360, Vss), 0.080000000000000002, 0.69999999999999996, 1.0);
        // device 158, IC IC22, analog/basic/mos_r2r_dac.hpp:27
        I(cpphdl_n360, Vss) <+ 2.9999999999999998e-15 * ddt(V(cpphdl_n360, Vss)); // Bench initial voltage = 0.0 V.
        // device 159, IC IC22, analog/basic/mos_r2r_dac.hpp:28
        I(cpphdl_n360, cpphdl_n374) <+ V(cpphdl_n360, cpphdl_n374) / 20000.0;
        // device 160, IC IC22, analog/basic/mos_r2r_dac.hpp:29
        I(cpphdl_n374, Vss) <+ 2.9999999999999998e-15 * ddt(V(cpphdl_n374, Vss)); // Bench initial voltage = 0.0 V.
        // device 161, IC IC22, analog/basic/mos_r2r_dac.hpp:31
        I(cpphdl_n373, cpphdl_n374) <+ V(cpphdl_n373, cpphdl_n374) / 10000.0;
        // device 162, IC IC29, analog/basic/inverter.hpp:11
        I(cpphdl_n364, Vdd) <+ cpphdl_channel(V(BIT_N1_6, Vdd), V(cpphdl_n364, Vdd), 0.080000000000000002, 0.69999999999999996, -1.0);
        // device 163, IC IC29, analog/basic/inverter.hpp:12
        I(cpphdl_n364, Vss) <+ cpphdl_channel(V(BIT_N1_6, Vss), V(cpphdl_n364, Vss), 0.080000000000000002, 0.69999999999999996, 1.0);
        // device 164, IC IC22, analog/basic/mos_r2r_dac.hpp:27
        I(cpphdl_n364, Vss) <+ 2.9999999999999998e-15 * ddt(V(cpphdl_n364, Vss)); // Bench initial voltage = 0.0 V.
        // device 165, IC IC22, analog/basic/mos_r2r_dac.hpp:28
        I(cpphdl_n364, cpphdl_n375) <+ V(cpphdl_n364, cpphdl_n375) / 20000.0;
        // device 166, IC IC22, analog/basic/mos_r2r_dac.hpp:29
        I(cpphdl_n375, Vss) <+ 2.9999999999999998e-15 * ddt(V(cpphdl_n375, Vss)); // Bench initial voltage = 0.0 V.
        // device 167, IC IC22, analog/basic/mos_r2r_dac.hpp:31
        I(cpphdl_n374, cpphdl_n375) <+ V(cpphdl_n374, cpphdl_n375) / 10000.0;
        // device 168, IC IC30, analog/basic/inverter.hpp:11
        I(cpphdl_n368, Vdd) <+ cpphdl_channel(V(BIT_N1_7, Vdd), V(cpphdl_n368, Vdd), 0.080000000000000002, 0.69999999999999996, -1.0);
        // device 169, IC IC30, analog/basic/inverter.hpp:12
        I(cpphdl_n368, Vss) <+ cpphdl_channel(V(BIT_N1_7, Vss), V(cpphdl_n368, Vss), 0.080000000000000002, 0.69999999999999996, 1.0);
        // device 170, IC IC22, analog/basic/mos_r2r_dac.hpp:27
        I(cpphdl_n368, Vss) <+ 2.9999999999999998e-15 * ddt(V(cpphdl_n368, Vss)); // Bench initial voltage = 0.0 V.
        // device 171, IC IC22, analog/basic/mos_r2r_dac.hpp:28
        I(cpphdl_n368, cpphdl_n380) <+ V(cpphdl_n368, cpphdl_n380) / 20000.0;
        // device 172, IC IC22, analog/basic/mos_r2r_dac.hpp:29
        I(cpphdl_n380, Vss) <+ 2.9999999999999998e-15 * ddt(V(cpphdl_n380, Vss)); // Bench initial voltage = 0.0 V.
        // device 173, IC IC22, analog/basic/mos_r2r_dac.hpp:31
        I(cpphdl_n375, cpphdl_n380) <+ V(cpphdl_n375, cpphdl_n380) / 10000.0;
        // device 174, IC IC22, analog/basic/mos_r2r_dac.hpp:33
        I(Vss, cpphdl_n369) <+ V(Vss, cpphdl_n369) / 20000.0;
        // device 175, IC IC31, analog/basic/nmos_resistor_amplifier.hpp:23
        I(Vdd, cpphdl_n389) <+ V(Vdd, cpphdl_n389) / 1000.0;
        // device 176, IC IC31, analog/basic/nmos_resistor_amplifier.hpp:24
        I(Vdd, cpphdl_n388) <+ V(Vdd, cpphdl_n388) / 1000.0;
        // device 177, IC IC31, analog/basic/nmos_resistor_amplifier.hpp:25
        I(cpphdl_n389, cpphdl_n383) <+ cpphdl_channel(V(cpphdl_n379, cpphdl_n383), V(cpphdl_n389, cpphdl_n383), 0.014999999999999999, 0.69999999999999996, 1.0);
        // device 178, IC IC31, analog/basic/nmos_resistor_amplifier.hpp:26
        I(cpphdl_n388, cpphdl_n384) <+ cpphdl_channel(V(cpphdl_n380, cpphdl_n384), V(cpphdl_n388, cpphdl_n384), 0.014999999999999999, 0.69999999999999996, 1.0);
        // device 179, IC IC31, analog/basic/nmos_resistor_amplifier.hpp:27
        I(cpphdl_n385, cpphdl_n383) <+ V(cpphdl_n385, cpphdl_n383) / 50.0;
        // device 180, IC IC31, analog/basic/nmos_resistor_amplifier.hpp:28
        I(cpphdl_n385, cpphdl_n384) <+ V(cpphdl_n385, cpphdl_n384) / 50.0;
        // device 181, IC IC31, analog/basic/nmos_resistor_amplifier.hpp:29
        I(Vss, cpphdl_n385) <+ V(Vss, cpphdl_n385) / 150.0;
        // device 182, IC IC31, analog/basic/nmos_resistor_amplifier.hpp:30
        I(cpphdl_n389, Vdd) <+ 2.9999999999999998e-13 * ddt(V(cpphdl_n389, Vdd)); // Bench initial voltage = 0.0 V.
        // device 183, IC IC31, analog/basic/nmos_resistor_amplifier.hpp:31
        I(cpphdl_n388, Vdd) <+ 2.9999999999999998e-13 * ddt(V(cpphdl_n388, Vdd)); // Bench initial voltage = 0.0 V.
        // device 184, IC IC31, analog/basic/nmos_resistor_amplifier.hpp:32
        I(cpphdl_n385, Vss) <+ 4e-14 * ddt(V(cpphdl_n385, Vss)); // Bench initial voltage = 0.0 V.
        // device 185, IC IC31, analog/basic/nmos_resistor_amplifier.hpp:34
        I(cpphdl_n379, cpphdl_n383) <+ 2e-14 * ddt(V(cpphdl_n379, cpphdl_n383)); // Bench initial voltage = 1.6499999999999999 V.
        // device 186, IC IC31, analog/basic/nmos_resistor_amplifier.hpp:35
        I(cpphdl_n380, cpphdl_n384) <+ 2e-14 * ddt(V(cpphdl_n380, cpphdl_n384)); // Bench initial voltage = 0.0 V.
        // device 187, IC IC31, analog/basic/nmos_resistor_amplifier.hpp:36
        I(cpphdl_n379, cpphdl_n389) <+ 2.9999999999999998e-15 * ddt(V(cpphdl_n379, cpphdl_n389)); // Bench initial voltage = -1.6499999999999999 V.
        // device 188, IC IC31, analog/basic/nmos_resistor_amplifier.hpp:37
        I(cpphdl_n380, cpphdl_n388) <+ 2.9999999999999998e-15 * ddt(V(cpphdl_n380, cpphdl_n388)); // Bench initial voltage = -3.2999999999999998 V.
        // device 189, IC IC32, analog/basic/strongarm_comparator.hpp:28
        I(cpphdl_n393, cpphdl_n395) <+ cpphdl_channel(V(cpphdl_n388, cpphdl_n395), V(cpphdl_n393, cpphdl_n395), 0.0080000000000000002, 0.69999999999999996, 1.0);
        // device 190, IC IC32, analog/basic/strongarm_comparator.hpp:29
        I(cpphdl_n394, cpphdl_n395) <+ cpphdl_channel(V(cpphdl_n389, cpphdl_n395), V(cpphdl_n394, cpphdl_n395), 0.0080000000000000002, 0.69999999999999996, 1.0);
        // device 191, IC IC32, analog/basic/strongarm_comparator.hpp:30
        I(cpphdl_n395, Vss) <+ cpphdl_channel(V(EVALUATE, Vss), V(cpphdl_n395, Vss), 0.0080000000000000002, 0.69999999999999996, 1.0);
        // device 192, IC IC32, analog/basic/strongarm_comparator.hpp:33
        I(cpphdl_n407, cpphdl_n393) <+ cpphdl_channel(V(cpphdl_n413, cpphdl_n393), V(cpphdl_n407, cpphdl_n393), 0.0040000000000000001, 0.69999999999999996, 1.0);
        // device 193, IC IC32, analog/basic/strongarm_comparator.hpp:34
        I(cpphdl_n413, cpphdl_n394) <+ cpphdl_channel(V(cpphdl_n407, cpphdl_n394), V(cpphdl_n413, cpphdl_n394), 0.0040000000000000001, 0.69999999999999996, 1.0);
        // device 194, IC IC32, analog/basic/strongarm_comparator.hpp:35
        I(cpphdl_n413, Vdd) <+ cpphdl_channel(V(cpphdl_n407, Vdd), V(cpphdl_n413, Vdd), 0.002, 0.69999999999999996, -1.0);
        // device 195, IC IC32, analog/basic/strongarm_comparator.hpp:36
        I(cpphdl_n407, Vdd) <+ cpphdl_channel(V(cpphdl_n413, Vdd), V(cpphdl_n407, Vdd), 0.002, 0.69999999999999996, -1.0);
        // device 196, IC IC32, analog/basic/strongarm_comparator.hpp:38
        I(cpphdl_n393, Vdd) <+ cpphdl_channel(V(EVALUATE, Vdd), V(cpphdl_n393, Vdd), 0.002, 0.69999999999999996, -1.0);
        // device 197, IC IC32, analog/basic/strongarm_comparator.hpp:39
        I(cpphdl_n394, Vdd) <+ cpphdl_channel(V(EVALUATE, Vdd), V(cpphdl_n394, Vdd), 0.002, 0.69999999999999996, -1.0);
        // device 198, IC IC32, analog/basic/strongarm_comparator.hpp:40
        I(cpphdl_n413, Vdd) <+ cpphdl_channel(V(EVALUATE, Vdd), V(cpphdl_n413, Vdd), 0.002, 0.69999999999999996, -1.0);
        // device 199, IC IC32, analog/basic/strongarm_comparator.hpp:41
        I(cpphdl_n407, Vdd) <+ cpphdl_channel(V(EVALUATE, Vdd), V(cpphdl_n407, Vdd), 0.002, 0.69999999999999996, -1.0);
        // device 200, IC IC32, analog/basic/strongarm_comparator.hpp:42
        I(cpphdl_n393, Vss) <+ 2.9999999999999998e-14 * ddt(V(cpphdl_n393, Vss)); // Bench initial voltage = 0.0 V.
        // device 201, IC IC32, analog/basic/strongarm_comparator.hpp:43
        I(cpphdl_n394, Vss) <+ 2.9999999999999998e-14 * ddt(V(cpphdl_n394, Vss)); // Bench initial voltage = 0.0 V.
        // device 202, IC IC32, analog/basic/strongarm_comparator.hpp:44
        I(cpphdl_n395, Vss) <+ 2.9999999999999998e-14 * ddt(V(cpphdl_n395, Vss)); // Bench initial voltage = 0.0 V.
        // device 203, IC IC32, analog/basic/strongarm_comparator.hpp:45
        I(cpphdl_n413, Vss) <+ 5.0000000000000002e-14 * ddt(V(cpphdl_n413, Vss)); // Bench initial voltage = 0.0 V.
        // device 204, IC IC32, analog/basic/strongarm_comparator.hpp:46
        I(cpphdl_n407, Vss) <+ 5.0000000000000002e-14 * ddt(V(cpphdl_n407, Vss)); // Bench initial voltage = 0.0 V.
        // device 205, IC IC32, analog/basic/strongarm_comparator.hpp:47
        I(cpphdl_n388, cpphdl_n395) <+ 2e-14 * ddt(V(cpphdl_n388, cpphdl_n395)); // Bench initial voltage = 3.2999999999999998 V.
        // device 206, IC IC32, analog/basic/strongarm_comparator.hpp:48
        I(cpphdl_n389, cpphdl_n395) <+ 2e-14 * ddt(V(cpphdl_n389, cpphdl_n395)); // Bench initial voltage = 3.2999999999999998 V.
        // device 207, IC IC32, analog/basic/strongarm_comparator.hpp:49
        I(cpphdl_n388, cpphdl_n393) <+ 2.9999999999999998e-15 * ddt(V(cpphdl_n388, cpphdl_n393)); // Bench initial voltage = 3.2999999999999998 V.
        // device 208, IC IC32, analog/basic/strongarm_comparator.hpp:50
        I(cpphdl_n389, cpphdl_n394) <+ 2.9999999999999998e-15 * ddt(V(cpphdl_n389, cpphdl_n394)); // Bench initial voltage = 3.2999999999999998 V.
        // device 209, IC IC34, analog/basic/cmos_logic.hpp:17
        I(DECISION1, Vss) <+ 5.0000000000000002e-14 * ddt(V(DECISION1, Vss)); // Bench initial voltage = 0.0 V.
        // device 210, IC IC34, analog/basic/cmos_logic.hpp:18
        I(DECISION1, Vdd) <+ cpphdl_channel(V(cpphdl_n407, Vdd), V(DECISION1, Vdd), 0.01, 0.69999999999999996, -1.0);
        // device 211, IC IC34, analog/basic/cmos_logic.hpp:19
        I(DECISION1, Vdd) <+ cpphdl_channel(V(DECISION_N1, Vdd), V(DECISION1, Vdd), 0.01, 0.69999999999999996, -1.0);
        // device 212, IC IC34, analog/basic/cmos_logic.hpp:20
        I(DECISION1, cpphdl_n410) <+ cpphdl_channel(V(cpphdl_n407, cpphdl_n410), V(DECISION1, cpphdl_n410), 0.01, 0.69999999999999996, 1.0);
        // device 213, IC IC34, analog/basic/cmos_logic.hpp:21
        I(cpphdl_n410, Vss) <+ cpphdl_channel(V(DECISION_N1, Vss), V(cpphdl_n410, Vss), 0.01, 0.69999999999999996, 1.0);
        // device 214, IC IC34, analog/basic/cmos_logic.hpp:23
        I(DECISION1, Vss) <+ V(DECISION1, Vss) / 1000000000.0;
        // device 215, IC IC34, analog/basic/cmos_logic.hpp:24
        I(cpphdl_n410, Vss) <+ V(cpphdl_n410, Vss) / 1000000000.0;
        // device 216, IC IC35, analog/basic/cmos_logic.hpp:17
        I(DECISION_N1, Vss) <+ 5.0000000000000002e-14 * ddt(V(DECISION_N1, Vss)); // Bench initial voltage = 0.0 V.
        // device 217, IC IC35, analog/basic/cmos_logic.hpp:18
        I(DECISION_N1, Vdd) <+ cpphdl_channel(V(cpphdl_n413, Vdd), V(DECISION_N1, Vdd), 0.01, 0.69999999999999996, -1.0);
        // device 218, IC IC35, analog/basic/cmos_logic.hpp:19
        I(DECISION_N1, Vdd) <+ cpphdl_channel(V(DECISION1, Vdd), V(DECISION_N1, Vdd), 0.01, 0.69999999999999996, -1.0);
        // device 219, IC IC35, analog/basic/cmos_logic.hpp:20
        I(DECISION_N1, cpphdl_n416) <+ cpphdl_channel(V(cpphdl_n413, cpphdl_n416), V(DECISION_N1, cpphdl_n416), 0.01, 0.69999999999999996, 1.0);
        // device 220, IC IC35, analog/basic/cmos_logic.hpp:21
        I(cpphdl_n416, Vss) <+ cpphdl_channel(V(DECISION1, Vss), V(cpphdl_n416, Vss), 0.01, 0.69999999999999996, 1.0);
        // device 221, IC IC35, analog/basic/cmos_logic.hpp:23
        I(DECISION_N1, Vss) <+ V(DECISION_N1, Vss) / 1000000000.0;
        // device 222, IC IC35, analog/basic/cmos_logic.hpp:24
        I(cpphdl_n416, Vss) <+ V(cpphdl_n416, Vss) / 1000000000.0;
        // device 223, IC IC33, analog/basic/nand_latch.hpp:36
        I(cpphdl_n407, Vss) <+ 2.9999999999999998e-15 * ddt(V(cpphdl_n407, Vss)); // Bench initial voltage = 0.0 V.
        // device 224, IC IC33, analog/basic/nand_latch.hpp:37
        I(cpphdl_n413, Vss) <+ 2.9999999999999998e-15 * ddt(V(cpphdl_n413, Vss)); // Bench initial voltage = 0.0 V.
        // device 225, IC IC36, analog/basic/inverter.hpp:11
        I(cpphdl_n421, Vdd) <+ cpphdl_channel(V(CLEAR, Vdd), V(cpphdl_n421, Vdd), 0.01, 0.69999999999999996, -1.0);
        // device 226, IC IC36, analog/basic/inverter.hpp:12
        I(cpphdl_n421, Vss) <+ cpphdl_channel(V(CLEAR, Vss), V(cpphdl_n421, Vss), 0.01, 0.69999999999999996, 1.0);
        // device 227, IC IC33, analog/basic/nand_latch.hpp:58
        I(cpphdl_n421, Vss) <+ 2.9999999999999998e-15 * ddt(V(cpphdl_n421, Vss)); // Bench initial voltage = 0.0 V.
        // device 228, IC IC33, analog/basic/nand_latch.hpp:59
        I(DECISION1, Vss) <+ cpphdl_channel(V(CLEAR, Vss), V(DECISION1, Vss), 0.050000000000000003, 0.69999999999999996, 1.0);
        // device 229, IC IC33, analog/basic/nand_latch.hpp:60
        I(DECISION_N1, Vdd) <+ cpphdl_channel(V(cpphdl_n421, Vdd), V(DECISION_N1, Vdd), 0.050000000000000003, 0.69999999999999996, -1.0);
        // device 230, IC IC39, analog/basic/inverter.hpp:11
        I(cpphdl_n445, Vdd) <+ cpphdl_channel(V(TRACK2, Vdd), V(cpphdl_n445, Vdd), 0.0040000000000000001, 0.69999999999999996, -1.0);
        // device 231, IC IC39, analog/basic/inverter.hpp:12
        I(cpphdl_n445, Vss) <+ cpphdl_channel(V(TRACK2, Vss), V(cpphdl_n445, Vss), 0.0040000000000000001, 0.69999999999999996, 1.0);
        // device 232, IC IC38, analog/basic/mos_track_hold.hpp:31
        I(cpphdl_n445, Vss) <+ 2e-14 * ddt(V(cpphdl_n445, Vss)); // Bench initial voltage = 3.2999999999999998 V.
        // device 233, IC IC38, analog/basic/mos_track_hold.hpp:32
        I(IN, cpphdl_n499) <+ cpphdl_channel(V(TRACK2, cpphdl_n499), V(IN, cpphdl_n499), 0.080000000000000002, 0.69999999999999996, 1.0);
        // device 234, IC IC38, analog/basic/mos_track_hold.hpp:33
        I(cpphdl_n499, IN) <+ cpphdl_channel(V(cpphdl_n445, IN), V(cpphdl_n499, IN), 0.040000000000000001, 0.69999999999999996, -1.0);
        // device 235, IC IC38, analog/basic/mos_track_hold.hpp:37
        I(cpphdl_n499, cpphdl_n499) <+ cpphdl_channel(V(cpphdl_n445, cpphdl_n499), V(cpphdl_n499, cpphdl_n499), 0.040000000000000001, 0.69999999999999996, 1.0);
        // device 236, IC IC38, analog/basic/mos_track_hold.hpp:38
        I(cpphdl_n499, cpphdl_n499) <+ cpphdl_channel(V(TRACK2, cpphdl_n499), V(cpphdl_n499, cpphdl_n499), 0.02, 0.69999999999999996, -1.0);
        // device 237, IC IC38, analog/basic/mos_track_hold.hpp:39
        I(cpphdl_n499, Vss) <+ 2e-12 * ddt(V(cpphdl_n499, Vss)); // Bench initial voltage = 1.6499999999999999 V.
        // device 238, IC IC38, analog/basic/mos_track_hold.hpp:41
        I(Vss, cpphdl_n499) <+ V(Vss, cpphdl_n499) / 1000000000.0;
        // device 239, IC IC38, analog/basic/mos_track_hold.hpp:42
        I(TRACK2, cpphdl_n499) <+ 8.0000000000000006e-15 * ddt(V(TRACK2, cpphdl_n499)); // Bench initial voltage = -1.6499999999999999 V.
        // device 240, IC IC38, analog/basic/mos_track_hold.hpp:43
        I(cpphdl_n445, cpphdl_n499) <+ 8.0000000000000006e-15 * ddt(V(cpphdl_n445, cpphdl_n499)); // Bench initial voltage = 1.6499999999999999 V.
        // device 241, IC IC38, analog/basic/mos_track_hold.hpp:44
        I(IN, cpphdl_n499) <+ 4.0000000000000003e-15 * ddt(V(IN, cpphdl_n499)); // Bench initial voltage = 0.0 V.
        // device 242, IC IC41, analog/basic/inverter.hpp:11
        I(cpphdl_n460, Vdd) <+ cpphdl_channel(V(BIT_N2_0, Vdd), V(cpphdl_n460, Vdd), 0.080000000000000002, 0.69999999999999996, -1.0);
        // device 243, IC IC41, analog/basic/inverter.hpp:12
        I(cpphdl_n460, Vss) <+ cpphdl_channel(V(BIT_N2_0, Vss), V(cpphdl_n460, Vss), 0.080000000000000002, 0.69999999999999996, 1.0);
        // device 244, IC IC40, analog/basic/mos_r2r_dac.hpp:27
        I(cpphdl_n460, Vss) <+ 2.9999999999999998e-15 * ddt(V(cpphdl_n460, Vss)); // Bench initial voltage = 0.0 V.
        // device 245, IC IC40, analog/basic/mos_r2r_dac.hpp:28
        I(cpphdl_n460, cpphdl_n489) <+ V(cpphdl_n460, cpphdl_n489) / 20000.0;
        // device 246, IC IC40, analog/basic/mos_r2r_dac.hpp:29
        I(cpphdl_n489, Vss) <+ 2.9999999999999998e-15 * ddt(V(cpphdl_n489, Vss)); // Bench initial voltage = 0.0 V.
        // device 247, IC IC42, analog/basic/inverter.hpp:11
        I(cpphdl_n464, Vdd) <+ cpphdl_channel(V(BIT_N2_1, Vdd), V(cpphdl_n464, Vdd), 0.080000000000000002, 0.69999999999999996, -1.0);
        // device 248, IC IC42, analog/basic/inverter.hpp:12
        I(cpphdl_n464, Vss) <+ cpphdl_channel(V(BIT_N2_1, Vss), V(cpphdl_n464, Vss), 0.080000000000000002, 0.69999999999999996, 1.0);
        // device 249, IC IC40, analog/basic/mos_r2r_dac.hpp:27
        I(cpphdl_n464, Vss) <+ 2.9999999999999998e-15 * ddt(V(cpphdl_n464, Vss)); // Bench initial voltage = 0.0 V.
        // device 250, IC IC40, analog/basic/mos_r2r_dac.hpp:28
        I(cpphdl_n464, cpphdl_n490) <+ V(cpphdl_n464, cpphdl_n490) / 20000.0;
        // device 251, IC IC40, analog/basic/mos_r2r_dac.hpp:29
        I(cpphdl_n490, Vss) <+ 2.9999999999999998e-15 * ddt(V(cpphdl_n490, Vss)); // Bench initial voltage = 0.0 V.
        // device 252, IC IC40, analog/basic/mos_r2r_dac.hpp:31
        I(cpphdl_n489, cpphdl_n490) <+ V(cpphdl_n489, cpphdl_n490) / 10000.0;
        // device 253, IC IC43, analog/basic/inverter.hpp:11
        I(cpphdl_n468, Vdd) <+ cpphdl_channel(V(BIT_N2_2, Vdd), V(cpphdl_n468, Vdd), 0.080000000000000002, 0.69999999999999996, -1.0);
        // device 254, IC IC43, analog/basic/inverter.hpp:12
        I(cpphdl_n468, Vss) <+ cpphdl_channel(V(BIT_N2_2, Vss), V(cpphdl_n468, Vss), 0.080000000000000002, 0.69999999999999996, 1.0);
        // device 255, IC IC40, analog/basic/mos_r2r_dac.hpp:27
        I(cpphdl_n468, Vss) <+ 2.9999999999999998e-15 * ddt(V(cpphdl_n468, Vss)); // Bench initial voltage = 0.0 V.
        // device 256, IC IC40, analog/basic/mos_r2r_dac.hpp:28
        I(cpphdl_n468, cpphdl_n491) <+ V(cpphdl_n468, cpphdl_n491) / 20000.0;
        // device 257, IC IC40, analog/basic/mos_r2r_dac.hpp:29
        I(cpphdl_n491, Vss) <+ 2.9999999999999998e-15 * ddt(V(cpphdl_n491, Vss)); // Bench initial voltage = 0.0 V.
        // device 258, IC IC40, analog/basic/mos_r2r_dac.hpp:31
        I(cpphdl_n490, cpphdl_n491) <+ V(cpphdl_n490, cpphdl_n491) / 10000.0;
        // device 259, IC IC44, analog/basic/inverter.hpp:11
        I(cpphdl_n472, Vdd) <+ cpphdl_channel(V(BIT_N2_3, Vdd), V(cpphdl_n472, Vdd), 0.080000000000000002, 0.69999999999999996, -1.0);
        // device 260, IC IC44, analog/basic/inverter.hpp:12
        I(cpphdl_n472, Vss) <+ cpphdl_channel(V(BIT_N2_3, Vss), V(cpphdl_n472, Vss), 0.080000000000000002, 0.69999999999999996, 1.0);
        // device 261, IC IC40, analog/basic/mos_r2r_dac.hpp:27
        I(cpphdl_n472, Vss) <+ 2.9999999999999998e-15 * ddt(V(cpphdl_n472, Vss)); // Bench initial voltage = 0.0 V.
        // device 262, IC IC40, analog/basic/mos_r2r_dac.hpp:28
        I(cpphdl_n472, cpphdl_n492) <+ V(cpphdl_n472, cpphdl_n492) / 20000.0;
        // device 263, IC IC40, analog/basic/mos_r2r_dac.hpp:29
        I(cpphdl_n492, Vss) <+ 2.9999999999999998e-15 * ddt(V(cpphdl_n492, Vss)); // Bench initial voltage = 0.0 V.
        // device 264, IC IC40, analog/basic/mos_r2r_dac.hpp:31
        I(cpphdl_n491, cpphdl_n492) <+ V(cpphdl_n491, cpphdl_n492) / 10000.0;
        // device 265, IC IC45, analog/basic/inverter.hpp:11
        I(cpphdl_n476, Vdd) <+ cpphdl_channel(V(BIT_N2_4, Vdd), V(cpphdl_n476, Vdd), 0.080000000000000002, 0.69999999999999996, -1.0);
        // device 266, IC IC45, analog/basic/inverter.hpp:12
        I(cpphdl_n476, Vss) <+ cpphdl_channel(V(BIT_N2_4, Vss), V(cpphdl_n476, Vss), 0.080000000000000002, 0.69999999999999996, 1.0);
        // device 267, IC IC40, analog/basic/mos_r2r_dac.hpp:27
        I(cpphdl_n476, Vss) <+ 2.9999999999999998e-15 * ddt(V(cpphdl_n476, Vss)); // Bench initial voltage = 0.0 V.
        // device 268, IC IC40, analog/basic/mos_r2r_dac.hpp:28
        I(cpphdl_n476, cpphdl_n493) <+ V(cpphdl_n476, cpphdl_n493) / 20000.0;
        // device 269, IC IC40, analog/basic/mos_r2r_dac.hpp:29
        I(cpphdl_n493, Vss) <+ 2.9999999999999998e-15 * ddt(V(cpphdl_n493, Vss)); // Bench initial voltage = 0.0 V.
        // device 270, IC IC40, analog/basic/mos_r2r_dac.hpp:31
        I(cpphdl_n492, cpphdl_n493) <+ V(cpphdl_n492, cpphdl_n493) / 10000.0;
        // device 271, IC IC46, analog/basic/inverter.hpp:11
        I(cpphdl_n480, Vdd) <+ cpphdl_channel(V(BIT_N2_5, Vdd), V(cpphdl_n480, Vdd), 0.080000000000000002, 0.69999999999999996, -1.0);
        // device 272, IC IC46, analog/basic/inverter.hpp:12
        I(cpphdl_n480, Vss) <+ cpphdl_channel(V(BIT_N2_5, Vss), V(cpphdl_n480, Vss), 0.080000000000000002, 0.69999999999999996, 1.0);
        // device 273, IC IC40, analog/basic/mos_r2r_dac.hpp:27
        I(cpphdl_n480, Vss) <+ 2.9999999999999998e-15 * ddt(V(cpphdl_n480, Vss)); // Bench initial voltage = 0.0 V.
        // device 274, IC IC40, analog/basic/mos_r2r_dac.hpp:28
        I(cpphdl_n480, cpphdl_n494) <+ V(cpphdl_n480, cpphdl_n494) / 20000.0;
        // device 275, IC IC40, analog/basic/mos_r2r_dac.hpp:29
        I(cpphdl_n494, Vss) <+ 2.9999999999999998e-15 * ddt(V(cpphdl_n494, Vss)); // Bench initial voltage = 0.0 V.
        // device 276, IC IC40, analog/basic/mos_r2r_dac.hpp:31
        I(cpphdl_n493, cpphdl_n494) <+ V(cpphdl_n493, cpphdl_n494) / 10000.0;
        // device 277, IC IC47, analog/basic/inverter.hpp:11
        I(cpphdl_n484, Vdd) <+ cpphdl_channel(V(BIT_N2_6, Vdd), V(cpphdl_n484, Vdd), 0.080000000000000002, 0.69999999999999996, -1.0);
        // device 278, IC IC47, analog/basic/inverter.hpp:12
        I(cpphdl_n484, Vss) <+ cpphdl_channel(V(BIT_N2_6, Vss), V(cpphdl_n484, Vss), 0.080000000000000002, 0.69999999999999996, 1.0);
        // device 279, IC IC40, analog/basic/mos_r2r_dac.hpp:27
        I(cpphdl_n484, Vss) <+ 2.9999999999999998e-15 * ddt(V(cpphdl_n484, Vss)); // Bench initial voltage = 0.0 V.
        // device 280, IC IC40, analog/basic/mos_r2r_dac.hpp:28
        I(cpphdl_n484, cpphdl_n495) <+ V(cpphdl_n484, cpphdl_n495) / 20000.0;
        // device 281, IC IC40, analog/basic/mos_r2r_dac.hpp:29
        I(cpphdl_n495, Vss) <+ 2.9999999999999998e-15 * ddt(V(cpphdl_n495, Vss)); // Bench initial voltage = 0.0 V.
        // device 282, IC IC40, analog/basic/mos_r2r_dac.hpp:31
        I(cpphdl_n494, cpphdl_n495) <+ V(cpphdl_n494, cpphdl_n495) / 10000.0;
        // device 283, IC IC48, analog/basic/inverter.hpp:11
        I(cpphdl_n488, Vdd) <+ cpphdl_channel(V(BIT_N2_7, Vdd), V(cpphdl_n488, Vdd), 0.080000000000000002, 0.69999999999999996, -1.0);
        // device 284, IC IC48, analog/basic/inverter.hpp:12
        I(cpphdl_n488, Vss) <+ cpphdl_channel(V(BIT_N2_7, Vss), V(cpphdl_n488, Vss), 0.080000000000000002, 0.69999999999999996, 1.0);
        // device 285, IC IC40, analog/basic/mos_r2r_dac.hpp:27
        I(cpphdl_n488, Vss) <+ 2.9999999999999998e-15 * ddt(V(cpphdl_n488, Vss)); // Bench initial voltage = 0.0 V.
        // device 286, IC IC40, analog/basic/mos_r2r_dac.hpp:28
        I(cpphdl_n488, cpphdl_n500) <+ V(cpphdl_n488, cpphdl_n500) / 20000.0;
        // device 287, IC IC40, analog/basic/mos_r2r_dac.hpp:29
        I(cpphdl_n500, Vss) <+ 2.9999999999999998e-15 * ddt(V(cpphdl_n500, Vss)); // Bench initial voltage = 0.0 V.
        // device 288, IC IC40, analog/basic/mos_r2r_dac.hpp:31
        I(cpphdl_n495, cpphdl_n500) <+ V(cpphdl_n495, cpphdl_n500) / 10000.0;
        // device 289, IC IC40, analog/basic/mos_r2r_dac.hpp:33
        I(Vss, cpphdl_n489) <+ V(Vss, cpphdl_n489) / 20000.0;
        // device 290, IC IC49, analog/basic/nmos_resistor_amplifier.hpp:23
        I(Vdd, cpphdl_n509) <+ V(Vdd, cpphdl_n509) / 1000.0;
        // device 291, IC IC49, analog/basic/nmos_resistor_amplifier.hpp:24
        I(Vdd, cpphdl_n508) <+ V(Vdd, cpphdl_n508) / 1000.0;
        // device 292, IC IC49, analog/basic/nmos_resistor_amplifier.hpp:25
        I(cpphdl_n509, cpphdl_n503) <+ cpphdl_channel(V(cpphdl_n499, cpphdl_n503), V(cpphdl_n509, cpphdl_n503), 0.014999999999999999, 0.69999999999999996, 1.0);
        // device 293, IC IC49, analog/basic/nmos_resistor_amplifier.hpp:26
        I(cpphdl_n508, cpphdl_n504) <+ cpphdl_channel(V(cpphdl_n500, cpphdl_n504), V(cpphdl_n508, cpphdl_n504), 0.014999999999999999, 0.69999999999999996, 1.0);
        // device 294, IC IC49, analog/basic/nmos_resistor_amplifier.hpp:27
        I(cpphdl_n505, cpphdl_n503) <+ V(cpphdl_n505, cpphdl_n503) / 50.0;
        // device 295, IC IC49, analog/basic/nmos_resistor_amplifier.hpp:28
        I(cpphdl_n505, cpphdl_n504) <+ V(cpphdl_n505, cpphdl_n504) / 50.0;
        // device 296, IC IC49, analog/basic/nmos_resistor_amplifier.hpp:29
        I(Vss, cpphdl_n505) <+ V(Vss, cpphdl_n505) / 150.0;
        // device 297, IC IC49, analog/basic/nmos_resistor_amplifier.hpp:30
        I(cpphdl_n509, Vdd) <+ 2.9999999999999998e-13 * ddt(V(cpphdl_n509, Vdd)); // Bench initial voltage = 0.0 V.
        // device 298, IC IC49, analog/basic/nmos_resistor_amplifier.hpp:31
        I(cpphdl_n508, Vdd) <+ 2.9999999999999998e-13 * ddt(V(cpphdl_n508, Vdd)); // Bench initial voltage = 0.0 V.
        // device 299, IC IC49, analog/basic/nmos_resistor_amplifier.hpp:32
        I(cpphdl_n505, Vss) <+ 4e-14 * ddt(V(cpphdl_n505, Vss)); // Bench initial voltage = 0.0 V.
        // device 300, IC IC49, analog/basic/nmos_resistor_amplifier.hpp:34
        I(cpphdl_n499, cpphdl_n503) <+ 2e-14 * ddt(V(cpphdl_n499, cpphdl_n503)); // Bench initial voltage = 1.6499999999999999 V.
        // device 301, IC IC49, analog/basic/nmos_resistor_amplifier.hpp:35
        I(cpphdl_n500, cpphdl_n504) <+ 2e-14 * ddt(V(cpphdl_n500, cpphdl_n504)); // Bench initial voltage = 0.0 V.
        // device 302, IC IC49, analog/basic/nmos_resistor_amplifier.hpp:36
        I(cpphdl_n499, cpphdl_n509) <+ 2.9999999999999998e-15 * ddt(V(cpphdl_n499, cpphdl_n509)); // Bench initial voltage = -1.6499999999999999 V.
        // device 303, IC IC49, analog/basic/nmos_resistor_amplifier.hpp:37
        I(cpphdl_n500, cpphdl_n508) <+ 2.9999999999999998e-15 * ddt(V(cpphdl_n500, cpphdl_n508)); // Bench initial voltage = -3.2999999999999998 V.
        // device 304, IC IC50, analog/basic/strongarm_comparator.hpp:28
        I(cpphdl_n513, cpphdl_n515) <+ cpphdl_channel(V(cpphdl_n508, cpphdl_n515), V(cpphdl_n513, cpphdl_n515), 0.0080000000000000002, 0.69999999999999996, 1.0);
        // device 305, IC IC50, analog/basic/strongarm_comparator.hpp:29
        I(cpphdl_n514, cpphdl_n515) <+ cpphdl_channel(V(cpphdl_n509, cpphdl_n515), V(cpphdl_n514, cpphdl_n515), 0.0080000000000000002, 0.69999999999999996, 1.0);
        // device 306, IC IC50, analog/basic/strongarm_comparator.hpp:30
        I(cpphdl_n515, Vss) <+ cpphdl_channel(V(EVALUATE, Vss), V(cpphdl_n515, Vss), 0.0080000000000000002, 0.69999999999999996, 1.0);
        // device 307, IC IC50, analog/basic/strongarm_comparator.hpp:33
        I(cpphdl_n527, cpphdl_n513) <+ cpphdl_channel(V(cpphdl_n533, cpphdl_n513), V(cpphdl_n527, cpphdl_n513), 0.0040000000000000001, 0.69999999999999996, 1.0);
        // device 308, IC IC50, analog/basic/strongarm_comparator.hpp:34
        I(cpphdl_n533, cpphdl_n514) <+ cpphdl_channel(V(cpphdl_n527, cpphdl_n514), V(cpphdl_n533, cpphdl_n514), 0.0040000000000000001, 0.69999999999999996, 1.0);
        // device 309, IC IC50, analog/basic/strongarm_comparator.hpp:35
        I(cpphdl_n533, Vdd) <+ cpphdl_channel(V(cpphdl_n527, Vdd), V(cpphdl_n533, Vdd), 0.002, 0.69999999999999996, -1.0);
        // device 310, IC IC50, analog/basic/strongarm_comparator.hpp:36
        I(cpphdl_n527, Vdd) <+ cpphdl_channel(V(cpphdl_n533, Vdd), V(cpphdl_n527, Vdd), 0.002, 0.69999999999999996, -1.0);
        // device 311, IC IC50, analog/basic/strongarm_comparator.hpp:38
        I(cpphdl_n513, Vdd) <+ cpphdl_channel(V(EVALUATE, Vdd), V(cpphdl_n513, Vdd), 0.002, 0.69999999999999996, -1.0);
        // device 312, IC IC50, analog/basic/strongarm_comparator.hpp:39
        I(cpphdl_n514, Vdd) <+ cpphdl_channel(V(EVALUATE, Vdd), V(cpphdl_n514, Vdd), 0.002, 0.69999999999999996, -1.0);
        // device 313, IC IC50, analog/basic/strongarm_comparator.hpp:40
        I(cpphdl_n533, Vdd) <+ cpphdl_channel(V(EVALUATE, Vdd), V(cpphdl_n533, Vdd), 0.002, 0.69999999999999996, -1.0);
        // device 314, IC IC50, analog/basic/strongarm_comparator.hpp:41
        I(cpphdl_n527, Vdd) <+ cpphdl_channel(V(EVALUATE, Vdd), V(cpphdl_n527, Vdd), 0.002, 0.69999999999999996, -1.0);
        // device 315, IC IC50, analog/basic/strongarm_comparator.hpp:42
        I(cpphdl_n513, Vss) <+ 2.9999999999999998e-14 * ddt(V(cpphdl_n513, Vss)); // Bench initial voltage = 0.0 V.
        // device 316, IC IC50, analog/basic/strongarm_comparator.hpp:43
        I(cpphdl_n514, Vss) <+ 2.9999999999999998e-14 * ddt(V(cpphdl_n514, Vss)); // Bench initial voltage = 0.0 V.
        // device 317, IC IC50, analog/basic/strongarm_comparator.hpp:44
        I(cpphdl_n515, Vss) <+ 2.9999999999999998e-14 * ddt(V(cpphdl_n515, Vss)); // Bench initial voltage = 0.0 V.
        // device 318, IC IC50, analog/basic/strongarm_comparator.hpp:45
        I(cpphdl_n533, Vss) <+ 5.0000000000000002e-14 * ddt(V(cpphdl_n533, Vss)); // Bench initial voltage = 0.0 V.
        // device 319, IC IC50, analog/basic/strongarm_comparator.hpp:46
        I(cpphdl_n527, Vss) <+ 5.0000000000000002e-14 * ddt(V(cpphdl_n527, Vss)); // Bench initial voltage = 0.0 V.
        // device 320, IC IC50, analog/basic/strongarm_comparator.hpp:47
        I(cpphdl_n508, cpphdl_n515) <+ 2e-14 * ddt(V(cpphdl_n508, cpphdl_n515)); // Bench initial voltage = 3.2999999999999998 V.
        // device 321, IC IC50, analog/basic/strongarm_comparator.hpp:48
        I(cpphdl_n509, cpphdl_n515) <+ 2e-14 * ddt(V(cpphdl_n509, cpphdl_n515)); // Bench initial voltage = 3.2999999999999998 V.
        // device 322, IC IC50, analog/basic/strongarm_comparator.hpp:49
        I(cpphdl_n508, cpphdl_n513) <+ 2.9999999999999998e-15 * ddt(V(cpphdl_n508, cpphdl_n513)); // Bench initial voltage = 3.2999999999999998 V.
        // device 323, IC IC50, analog/basic/strongarm_comparator.hpp:50
        I(cpphdl_n509, cpphdl_n514) <+ 2.9999999999999998e-15 * ddt(V(cpphdl_n509, cpphdl_n514)); // Bench initial voltage = 3.2999999999999998 V.
        // device 324, IC IC52, analog/basic/cmos_logic.hpp:17
        I(DECISION2, Vss) <+ 5.0000000000000002e-14 * ddt(V(DECISION2, Vss)); // Bench initial voltage = 0.0 V.
        // device 325, IC IC52, analog/basic/cmos_logic.hpp:18
        I(DECISION2, Vdd) <+ cpphdl_channel(V(cpphdl_n527, Vdd), V(DECISION2, Vdd), 0.01, 0.69999999999999996, -1.0);
        // device 326, IC IC52, analog/basic/cmos_logic.hpp:19
        I(DECISION2, Vdd) <+ cpphdl_channel(V(DECISION_N2, Vdd), V(DECISION2, Vdd), 0.01, 0.69999999999999996, -1.0);
        // device 327, IC IC52, analog/basic/cmos_logic.hpp:20
        I(DECISION2, cpphdl_n530) <+ cpphdl_channel(V(cpphdl_n527, cpphdl_n530), V(DECISION2, cpphdl_n530), 0.01, 0.69999999999999996, 1.0);
        // device 328, IC IC52, analog/basic/cmos_logic.hpp:21
        I(cpphdl_n530, Vss) <+ cpphdl_channel(V(DECISION_N2, Vss), V(cpphdl_n530, Vss), 0.01, 0.69999999999999996, 1.0);
        // device 329, IC IC52, analog/basic/cmos_logic.hpp:23
        I(DECISION2, Vss) <+ V(DECISION2, Vss) / 1000000000.0;
        // device 330, IC IC52, analog/basic/cmos_logic.hpp:24
        I(cpphdl_n530, Vss) <+ V(cpphdl_n530, Vss) / 1000000000.0;
        // device 331, IC IC53, analog/basic/cmos_logic.hpp:17
        I(DECISION_N2, Vss) <+ 5.0000000000000002e-14 * ddt(V(DECISION_N2, Vss)); // Bench initial voltage = 0.0 V.
        // device 332, IC IC53, analog/basic/cmos_logic.hpp:18
        I(DECISION_N2, Vdd) <+ cpphdl_channel(V(cpphdl_n533, Vdd), V(DECISION_N2, Vdd), 0.01, 0.69999999999999996, -1.0);
        // device 333, IC IC53, analog/basic/cmos_logic.hpp:19
        I(DECISION_N2, Vdd) <+ cpphdl_channel(V(DECISION2, Vdd), V(DECISION_N2, Vdd), 0.01, 0.69999999999999996, -1.0);
        // device 334, IC IC53, analog/basic/cmos_logic.hpp:20
        I(DECISION_N2, cpphdl_n536) <+ cpphdl_channel(V(cpphdl_n533, cpphdl_n536), V(DECISION_N2, cpphdl_n536), 0.01, 0.69999999999999996, 1.0);
        // device 335, IC IC53, analog/basic/cmos_logic.hpp:21
        I(cpphdl_n536, Vss) <+ cpphdl_channel(V(DECISION2, Vss), V(cpphdl_n536, Vss), 0.01, 0.69999999999999996, 1.0);
        // device 336, IC IC53, analog/basic/cmos_logic.hpp:23
        I(DECISION_N2, Vss) <+ V(DECISION_N2, Vss) / 1000000000.0;
        // device 337, IC IC53, analog/basic/cmos_logic.hpp:24
        I(cpphdl_n536, Vss) <+ V(cpphdl_n536, Vss) / 1000000000.0;
        // device 338, IC IC51, analog/basic/nand_latch.hpp:36
        I(cpphdl_n527, Vss) <+ 2.9999999999999998e-15 * ddt(V(cpphdl_n527, Vss)); // Bench initial voltage = 0.0 V.
        // device 339, IC IC51, analog/basic/nand_latch.hpp:37
        I(cpphdl_n533, Vss) <+ 2.9999999999999998e-15 * ddt(V(cpphdl_n533, Vss)); // Bench initial voltage = 0.0 V.
        // device 340, IC IC54, analog/basic/inverter.hpp:11
        I(cpphdl_n541, Vdd) <+ cpphdl_channel(V(CLEAR, Vdd), V(cpphdl_n541, Vdd), 0.01, 0.69999999999999996, -1.0);
        // device 341, IC IC54, analog/basic/inverter.hpp:12
        I(cpphdl_n541, Vss) <+ cpphdl_channel(V(CLEAR, Vss), V(cpphdl_n541, Vss), 0.01, 0.69999999999999996, 1.0);
        // device 342, IC IC51, analog/basic/nand_latch.hpp:58
        I(cpphdl_n541, Vss) <+ 2.9999999999999998e-15 * ddt(V(cpphdl_n541, Vss)); // Bench initial voltage = 0.0 V.
        // device 343, IC IC51, analog/basic/nand_latch.hpp:59
        I(DECISION2, Vss) <+ cpphdl_channel(V(CLEAR, Vss), V(DECISION2, Vss), 0.050000000000000003, 0.69999999999999996, 1.0);
        // device 344, IC IC51, analog/basic/nand_latch.hpp:60
        I(DECISION_N2, Vdd) <+ cpphdl_channel(V(cpphdl_n541, Vdd), V(DECISION_N2, Vdd), 0.050000000000000003, 0.69999999999999996, -1.0);
        // device 345, IC IC57, analog/basic/inverter.hpp:11
        I(cpphdl_n565, Vdd) <+ cpphdl_channel(V(TRACK3, Vdd), V(cpphdl_n565, Vdd), 0.0040000000000000001, 0.69999999999999996, -1.0);
        // device 346, IC IC57, analog/basic/inverter.hpp:12
        I(cpphdl_n565, Vss) <+ cpphdl_channel(V(TRACK3, Vss), V(cpphdl_n565, Vss), 0.0040000000000000001, 0.69999999999999996, 1.0);
        // device 347, IC IC56, analog/basic/mos_track_hold.hpp:31
        I(cpphdl_n565, Vss) <+ 2e-14 * ddt(V(cpphdl_n565, Vss)); // Bench initial voltage = 3.2999999999999998 V.
        // device 348, IC IC56, analog/basic/mos_track_hold.hpp:32
        I(IN, cpphdl_n619) <+ cpphdl_channel(V(TRACK3, cpphdl_n619), V(IN, cpphdl_n619), 0.080000000000000002, 0.69999999999999996, 1.0);
        // device 349, IC IC56, analog/basic/mos_track_hold.hpp:33
        I(cpphdl_n619, IN) <+ cpphdl_channel(V(cpphdl_n565, IN), V(cpphdl_n619, IN), 0.040000000000000001, 0.69999999999999996, -1.0);
        // device 350, IC IC56, analog/basic/mos_track_hold.hpp:37
        I(cpphdl_n619, cpphdl_n619) <+ cpphdl_channel(V(cpphdl_n565, cpphdl_n619), V(cpphdl_n619, cpphdl_n619), 0.040000000000000001, 0.69999999999999996, 1.0);
        // device 351, IC IC56, analog/basic/mos_track_hold.hpp:38
        I(cpphdl_n619, cpphdl_n619) <+ cpphdl_channel(V(TRACK3, cpphdl_n619), V(cpphdl_n619, cpphdl_n619), 0.02, 0.69999999999999996, -1.0);
        // device 352, IC IC56, analog/basic/mos_track_hold.hpp:39
        I(cpphdl_n619, Vss) <+ 2e-12 * ddt(V(cpphdl_n619, Vss)); // Bench initial voltage = 1.6499999999999999 V.
        // device 353, IC IC56, analog/basic/mos_track_hold.hpp:41
        I(Vss, cpphdl_n619) <+ V(Vss, cpphdl_n619) / 1000000000.0;
        // device 354, IC IC56, analog/basic/mos_track_hold.hpp:42
        I(TRACK3, cpphdl_n619) <+ 8.0000000000000006e-15 * ddt(V(TRACK3, cpphdl_n619)); // Bench initial voltage = -1.6499999999999999 V.
        // device 355, IC IC56, analog/basic/mos_track_hold.hpp:43
        I(cpphdl_n565, cpphdl_n619) <+ 8.0000000000000006e-15 * ddt(V(cpphdl_n565, cpphdl_n619)); // Bench initial voltage = 1.6499999999999999 V.
        // device 356, IC IC56, analog/basic/mos_track_hold.hpp:44
        I(IN, cpphdl_n619) <+ 4.0000000000000003e-15 * ddt(V(IN, cpphdl_n619)); // Bench initial voltage = 0.0 V.
        // device 357, IC IC59, analog/basic/inverter.hpp:11
        I(cpphdl_n580, Vdd) <+ cpphdl_channel(V(BIT_N3_0, Vdd), V(cpphdl_n580, Vdd), 0.080000000000000002, 0.69999999999999996, -1.0);
        // device 358, IC IC59, analog/basic/inverter.hpp:12
        I(cpphdl_n580, Vss) <+ cpphdl_channel(V(BIT_N3_0, Vss), V(cpphdl_n580, Vss), 0.080000000000000002, 0.69999999999999996, 1.0);
        // device 359, IC IC58, analog/basic/mos_r2r_dac.hpp:27
        I(cpphdl_n580, Vss) <+ 2.9999999999999998e-15 * ddt(V(cpphdl_n580, Vss)); // Bench initial voltage = 0.0 V.
        // device 360, IC IC58, analog/basic/mos_r2r_dac.hpp:28
        I(cpphdl_n580, cpphdl_n609) <+ V(cpphdl_n580, cpphdl_n609) / 20000.0;
        // device 361, IC IC58, analog/basic/mos_r2r_dac.hpp:29
        I(cpphdl_n609, Vss) <+ 2.9999999999999998e-15 * ddt(V(cpphdl_n609, Vss)); // Bench initial voltage = 0.0 V.
        // device 362, IC IC60, analog/basic/inverter.hpp:11
        I(cpphdl_n584, Vdd) <+ cpphdl_channel(V(BIT_N3_1, Vdd), V(cpphdl_n584, Vdd), 0.080000000000000002, 0.69999999999999996, -1.0);
        // device 363, IC IC60, analog/basic/inverter.hpp:12
        I(cpphdl_n584, Vss) <+ cpphdl_channel(V(BIT_N3_1, Vss), V(cpphdl_n584, Vss), 0.080000000000000002, 0.69999999999999996, 1.0);
        // device 364, IC IC58, analog/basic/mos_r2r_dac.hpp:27
        I(cpphdl_n584, Vss) <+ 2.9999999999999998e-15 * ddt(V(cpphdl_n584, Vss)); // Bench initial voltage = 0.0 V.
        // device 365, IC IC58, analog/basic/mos_r2r_dac.hpp:28
        I(cpphdl_n584, cpphdl_n610) <+ V(cpphdl_n584, cpphdl_n610) / 20000.0;
        // device 366, IC IC58, analog/basic/mos_r2r_dac.hpp:29
        I(cpphdl_n610, Vss) <+ 2.9999999999999998e-15 * ddt(V(cpphdl_n610, Vss)); // Bench initial voltage = 0.0 V.
        // device 367, IC IC58, analog/basic/mos_r2r_dac.hpp:31
        I(cpphdl_n609, cpphdl_n610) <+ V(cpphdl_n609, cpphdl_n610) / 10000.0;
        // device 368, IC IC61, analog/basic/inverter.hpp:11
        I(cpphdl_n588, Vdd) <+ cpphdl_channel(V(BIT_N3_2, Vdd), V(cpphdl_n588, Vdd), 0.080000000000000002, 0.69999999999999996, -1.0);
        // device 369, IC IC61, analog/basic/inverter.hpp:12
        I(cpphdl_n588, Vss) <+ cpphdl_channel(V(BIT_N3_2, Vss), V(cpphdl_n588, Vss), 0.080000000000000002, 0.69999999999999996, 1.0);
        // device 370, IC IC58, analog/basic/mos_r2r_dac.hpp:27
        I(cpphdl_n588, Vss) <+ 2.9999999999999998e-15 * ddt(V(cpphdl_n588, Vss)); // Bench initial voltage = 0.0 V.
        // device 371, IC IC58, analog/basic/mos_r2r_dac.hpp:28
        I(cpphdl_n588, cpphdl_n611) <+ V(cpphdl_n588, cpphdl_n611) / 20000.0;
        // device 372, IC IC58, analog/basic/mos_r2r_dac.hpp:29
        I(cpphdl_n611, Vss) <+ 2.9999999999999998e-15 * ddt(V(cpphdl_n611, Vss)); // Bench initial voltage = 0.0 V.
        // device 373, IC IC58, analog/basic/mos_r2r_dac.hpp:31
        I(cpphdl_n610, cpphdl_n611) <+ V(cpphdl_n610, cpphdl_n611) / 10000.0;
        // device 374, IC IC62, analog/basic/inverter.hpp:11
        I(cpphdl_n592, Vdd) <+ cpphdl_channel(V(BIT_N3_3, Vdd), V(cpphdl_n592, Vdd), 0.080000000000000002, 0.69999999999999996, -1.0);
        // device 375, IC IC62, analog/basic/inverter.hpp:12
        I(cpphdl_n592, Vss) <+ cpphdl_channel(V(BIT_N3_3, Vss), V(cpphdl_n592, Vss), 0.080000000000000002, 0.69999999999999996, 1.0);
        // device 376, IC IC58, analog/basic/mos_r2r_dac.hpp:27
        I(cpphdl_n592, Vss) <+ 2.9999999999999998e-15 * ddt(V(cpphdl_n592, Vss)); // Bench initial voltage = 0.0 V.
        // device 377, IC IC58, analog/basic/mos_r2r_dac.hpp:28
        I(cpphdl_n592, cpphdl_n612) <+ V(cpphdl_n592, cpphdl_n612) / 20000.0;
        // device 378, IC IC58, analog/basic/mos_r2r_dac.hpp:29
        I(cpphdl_n612, Vss) <+ 2.9999999999999998e-15 * ddt(V(cpphdl_n612, Vss)); // Bench initial voltage = 0.0 V.
        // device 379, IC IC58, analog/basic/mos_r2r_dac.hpp:31
        I(cpphdl_n611, cpphdl_n612) <+ V(cpphdl_n611, cpphdl_n612) / 10000.0;
        // device 380, IC IC63, analog/basic/inverter.hpp:11
        I(cpphdl_n596, Vdd) <+ cpphdl_channel(V(BIT_N3_4, Vdd), V(cpphdl_n596, Vdd), 0.080000000000000002, 0.69999999999999996, -1.0);
        // device 381, IC IC63, analog/basic/inverter.hpp:12
        I(cpphdl_n596, Vss) <+ cpphdl_channel(V(BIT_N3_4, Vss), V(cpphdl_n596, Vss), 0.080000000000000002, 0.69999999999999996, 1.0);
        // device 382, IC IC58, analog/basic/mos_r2r_dac.hpp:27
        I(cpphdl_n596, Vss) <+ 2.9999999999999998e-15 * ddt(V(cpphdl_n596, Vss)); // Bench initial voltage = 0.0 V.
        // device 383, IC IC58, analog/basic/mos_r2r_dac.hpp:28
        I(cpphdl_n596, cpphdl_n613) <+ V(cpphdl_n596, cpphdl_n613) / 20000.0;
        // device 384, IC IC58, analog/basic/mos_r2r_dac.hpp:29
        I(cpphdl_n613, Vss) <+ 2.9999999999999998e-15 * ddt(V(cpphdl_n613, Vss)); // Bench initial voltage = 0.0 V.
        // device 385, IC IC58, analog/basic/mos_r2r_dac.hpp:31
        I(cpphdl_n612, cpphdl_n613) <+ V(cpphdl_n612, cpphdl_n613) / 10000.0;
        // device 386, IC IC64, analog/basic/inverter.hpp:11
        I(cpphdl_n600, Vdd) <+ cpphdl_channel(V(BIT_N3_5, Vdd), V(cpphdl_n600, Vdd), 0.080000000000000002, 0.69999999999999996, -1.0);
        // device 387, IC IC64, analog/basic/inverter.hpp:12
        I(cpphdl_n600, Vss) <+ cpphdl_channel(V(BIT_N3_5, Vss), V(cpphdl_n600, Vss), 0.080000000000000002, 0.69999999999999996, 1.0);
        // device 388, IC IC58, analog/basic/mos_r2r_dac.hpp:27
        I(cpphdl_n600, Vss) <+ 2.9999999999999998e-15 * ddt(V(cpphdl_n600, Vss)); // Bench initial voltage = 0.0 V.
        // device 389, IC IC58, analog/basic/mos_r2r_dac.hpp:28
        I(cpphdl_n600, cpphdl_n614) <+ V(cpphdl_n600, cpphdl_n614) / 20000.0;
        // device 390, IC IC58, analog/basic/mos_r2r_dac.hpp:29
        I(cpphdl_n614, Vss) <+ 2.9999999999999998e-15 * ddt(V(cpphdl_n614, Vss)); // Bench initial voltage = 0.0 V.
        // device 391, IC IC58, analog/basic/mos_r2r_dac.hpp:31
        I(cpphdl_n613, cpphdl_n614) <+ V(cpphdl_n613, cpphdl_n614) / 10000.0;
        // device 392, IC IC65, analog/basic/inverter.hpp:11
        I(cpphdl_n604, Vdd) <+ cpphdl_channel(V(BIT_N3_6, Vdd), V(cpphdl_n604, Vdd), 0.080000000000000002, 0.69999999999999996, -1.0);
        // device 393, IC IC65, analog/basic/inverter.hpp:12
        I(cpphdl_n604, Vss) <+ cpphdl_channel(V(BIT_N3_6, Vss), V(cpphdl_n604, Vss), 0.080000000000000002, 0.69999999999999996, 1.0);
        // device 394, IC IC58, analog/basic/mos_r2r_dac.hpp:27
        I(cpphdl_n604, Vss) <+ 2.9999999999999998e-15 * ddt(V(cpphdl_n604, Vss)); // Bench initial voltage = 0.0 V.
        // device 395, IC IC58, analog/basic/mos_r2r_dac.hpp:28
        I(cpphdl_n604, cpphdl_n615) <+ V(cpphdl_n604, cpphdl_n615) / 20000.0;
        // device 396, IC IC58, analog/basic/mos_r2r_dac.hpp:29
        I(cpphdl_n615, Vss) <+ 2.9999999999999998e-15 * ddt(V(cpphdl_n615, Vss)); // Bench initial voltage = 0.0 V.
        // device 397, IC IC58, analog/basic/mos_r2r_dac.hpp:31
        I(cpphdl_n614, cpphdl_n615) <+ V(cpphdl_n614, cpphdl_n615) / 10000.0;
        // device 398, IC IC66, analog/basic/inverter.hpp:11
        I(cpphdl_n608, Vdd) <+ cpphdl_channel(V(BIT_N3_7, Vdd), V(cpphdl_n608, Vdd), 0.080000000000000002, 0.69999999999999996, -1.0);
        // device 399, IC IC66, analog/basic/inverter.hpp:12
        I(cpphdl_n608, Vss) <+ cpphdl_channel(V(BIT_N3_7, Vss), V(cpphdl_n608, Vss), 0.080000000000000002, 0.69999999999999996, 1.0);
        // device 400, IC IC58, analog/basic/mos_r2r_dac.hpp:27
        I(cpphdl_n608, Vss) <+ 2.9999999999999998e-15 * ddt(V(cpphdl_n608, Vss)); // Bench initial voltage = 0.0 V.
        // device 401, IC IC58, analog/basic/mos_r2r_dac.hpp:28
        I(cpphdl_n608, cpphdl_n620) <+ V(cpphdl_n608, cpphdl_n620) / 20000.0;
        // device 402, IC IC58, analog/basic/mos_r2r_dac.hpp:29
        I(cpphdl_n620, Vss) <+ 2.9999999999999998e-15 * ddt(V(cpphdl_n620, Vss)); // Bench initial voltage = 0.0 V.
        // device 403, IC IC58, analog/basic/mos_r2r_dac.hpp:31
        I(cpphdl_n615, cpphdl_n620) <+ V(cpphdl_n615, cpphdl_n620) / 10000.0;
        // device 404, IC IC58, analog/basic/mos_r2r_dac.hpp:33
        I(Vss, cpphdl_n609) <+ V(Vss, cpphdl_n609) / 20000.0;
        // device 405, IC IC67, analog/basic/nmos_resistor_amplifier.hpp:23
        I(Vdd, cpphdl_n629) <+ V(Vdd, cpphdl_n629) / 1000.0;
        // device 406, IC IC67, analog/basic/nmos_resistor_amplifier.hpp:24
        I(Vdd, cpphdl_n628) <+ V(Vdd, cpphdl_n628) / 1000.0;
        // device 407, IC IC67, analog/basic/nmos_resistor_amplifier.hpp:25
        I(cpphdl_n629, cpphdl_n623) <+ cpphdl_channel(V(cpphdl_n619, cpphdl_n623), V(cpphdl_n629, cpphdl_n623), 0.014999999999999999, 0.69999999999999996, 1.0);
        // device 408, IC IC67, analog/basic/nmos_resistor_amplifier.hpp:26
        I(cpphdl_n628, cpphdl_n624) <+ cpphdl_channel(V(cpphdl_n620, cpphdl_n624), V(cpphdl_n628, cpphdl_n624), 0.014999999999999999, 0.69999999999999996, 1.0);
        // device 409, IC IC67, analog/basic/nmos_resistor_amplifier.hpp:27
        I(cpphdl_n625, cpphdl_n623) <+ V(cpphdl_n625, cpphdl_n623) / 50.0;
        // device 410, IC IC67, analog/basic/nmos_resistor_amplifier.hpp:28
        I(cpphdl_n625, cpphdl_n624) <+ V(cpphdl_n625, cpphdl_n624) / 50.0;
        // device 411, IC IC67, analog/basic/nmos_resistor_amplifier.hpp:29
        I(Vss, cpphdl_n625) <+ V(Vss, cpphdl_n625) / 150.0;
        // device 412, IC IC67, analog/basic/nmos_resistor_amplifier.hpp:30
        I(cpphdl_n629, Vdd) <+ 2.9999999999999998e-13 * ddt(V(cpphdl_n629, Vdd)); // Bench initial voltage = 0.0 V.
        // device 413, IC IC67, analog/basic/nmos_resistor_amplifier.hpp:31
        I(cpphdl_n628, Vdd) <+ 2.9999999999999998e-13 * ddt(V(cpphdl_n628, Vdd)); // Bench initial voltage = 0.0 V.
        // device 414, IC IC67, analog/basic/nmos_resistor_amplifier.hpp:32
        I(cpphdl_n625, Vss) <+ 4e-14 * ddt(V(cpphdl_n625, Vss)); // Bench initial voltage = 0.0 V.
        // device 415, IC IC67, analog/basic/nmos_resistor_amplifier.hpp:34
        I(cpphdl_n619, cpphdl_n623) <+ 2e-14 * ddt(V(cpphdl_n619, cpphdl_n623)); // Bench initial voltage = 1.6499999999999999 V.
        // device 416, IC IC67, analog/basic/nmos_resistor_amplifier.hpp:35
        I(cpphdl_n620, cpphdl_n624) <+ 2e-14 * ddt(V(cpphdl_n620, cpphdl_n624)); // Bench initial voltage = 0.0 V.
        // device 417, IC IC67, analog/basic/nmos_resistor_amplifier.hpp:36
        I(cpphdl_n619, cpphdl_n629) <+ 2.9999999999999998e-15 * ddt(V(cpphdl_n619, cpphdl_n629)); // Bench initial voltage = -1.6499999999999999 V.
        // device 418, IC IC67, analog/basic/nmos_resistor_amplifier.hpp:37
        I(cpphdl_n620, cpphdl_n628) <+ 2.9999999999999998e-15 * ddt(V(cpphdl_n620, cpphdl_n628)); // Bench initial voltage = -3.2999999999999998 V.
        // device 419, IC IC68, analog/basic/strongarm_comparator.hpp:28
        I(cpphdl_n633, cpphdl_n635) <+ cpphdl_channel(V(cpphdl_n628, cpphdl_n635), V(cpphdl_n633, cpphdl_n635), 0.0080000000000000002, 0.69999999999999996, 1.0);
        // device 420, IC IC68, analog/basic/strongarm_comparator.hpp:29
        I(cpphdl_n634, cpphdl_n635) <+ cpphdl_channel(V(cpphdl_n629, cpphdl_n635), V(cpphdl_n634, cpphdl_n635), 0.0080000000000000002, 0.69999999999999996, 1.0);
        // device 421, IC IC68, analog/basic/strongarm_comparator.hpp:30
        I(cpphdl_n635, Vss) <+ cpphdl_channel(V(EVALUATE, Vss), V(cpphdl_n635, Vss), 0.0080000000000000002, 0.69999999999999996, 1.0);
        // device 422, IC IC68, analog/basic/strongarm_comparator.hpp:33
        I(cpphdl_n647, cpphdl_n633) <+ cpphdl_channel(V(cpphdl_n653, cpphdl_n633), V(cpphdl_n647, cpphdl_n633), 0.0040000000000000001, 0.69999999999999996, 1.0);
        // device 423, IC IC68, analog/basic/strongarm_comparator.hpp:34
        I(cpphdl_n653, cpphdl_n634) <+ cpphdl_channel(V(cpphdl_n647, cpphdl_n634), V(cpphdl_n653, cpphdl_n634), 0.0040000000000000001, 0.69999999999999996, 1.0);
        // device 424, IC IC68, analog/basic/strongarm_comparator.hpp:35
        I(cpphdl_n653, Vdd) <+ cpphdl_channel(V(cpphdl_n647, Vdd), V(cpphdl_n653, Vdd), 0.002, 0.69999999999999996, -1.0);
        // device 425, IC IC68, analog/basic/strongarm_comparator.hpp:36
        I(cpphdl_n647, Vdd) <+ cpphdl_channel(V(cpphdl_n653, Vdd), V(cpphdl_n647, Vdd), 0.002, 0.69999999999999996, -1.0);
        // device 426, IC IC68, analog/basic/strongarm_comparator.hpp:38
        I(cpphdl_n633, Vdd) <+ cpphdl_channel(V(EVALUATE, Vdd), V(cpphdl_n633, Vdd), 0.002, 0.69999999999999996, -1.0);
        // device 427, IC IC68, analog/basic/strongarm_comparator.hpp:39
        I(cpphdl_n634, Vdd) <+ cpphdl_channel(V(EVALUATE, Vdd), V(cpphdl_n634, Vdd), 0.002, 0.69999999999999996, -1.0);
        // device 428, IC IC68, analog/basic/strongarm_comparator.hpp:40
        I(cpphdl_n653, Vdd) <+ cpphdl_channel(V(EVALUATE, Vdd), V(cpphdl_n653, Vdd), 0.002, 0.69999999999999996, -1.0);
        // device 429, IC IC68, analog/basic/strongarm_comparator.hpp:41
        I(cpphdl_n647, Vdd) <+ cpphdl_channel(V(EVALUATE, Vdd), V(cpphdl_n647, Vdd), 0.002, 0.69999999999999996, -1.0);
        // device 430, IC IC68, analog/basic/strongarm_comparator.hpp:42
        I(cpphdl_n633, Vss) <+ 2.9999999999999998e-14 * ddt(V(cpphdl_n633, Vss)); // Bench initial voltage = 0.0 V.
        // device 431, IC IC68, analog/basic/strongarm_comparator.hpp:43
        I(cpphdl_n634, Vss) <+ 2.9999999999999998e-14 * ddt(V(cpphdl_n634, Vss)); // Bench initial voltage = 0.0 V.
        // device 432, IC IC68, analog/basic/strongarm_comparator.hpp:44
        I(cpphdl_n635, Vss) <+ 2.9999999999999998e-14 * ddt(V(cpphdl_n635, Vss)); // Bench initial voltage = 0.0 V.
        // device 433, IC IC68, analog/basic/strongarm_comparator.hpp:45
        I(cpphdl_n653, Vss) <+ 5.0000000000000002e-14 * ddt(V(cpphdl_n653, Vss)); // Bench initial voltage = 0.0 V.
        // device 434, IC IC68, analog/basic/strongarm_comparator.hpp:46
        I(cpphdl_n647, Vss) <+ 5.0000000000000002e-14 * ddt(V(cpphdl_n647, Vss)); // Bench initial voltage = 0.0 V.
        // device 435, IC IC68, analog/basic/strongarm_comparator.hpp:47
        I(cpphdl_n628, cpphdl_n635) <+ 2e-14 * ddt(V(cpphdl_n628, cpphdl_n635)); // Bench initial voltage = 3.2999999999999998 V.
        // device 436, IC IC68, analog/basic/strongarm_comparator.hpp:48
        I(cpphdl_n629, cpphdl_n635) <+ 2e-14 * ddt(V(cpphdl_n629, cpphdl_n635)); // Bench initial voltage = 3.2999999999999998 V.
        // device 437, IC IC68, analog/basic/strongarm_comparator.hpp:49
        I(cpphdl_n628, cpphdl_n633) <+ 2.9999999999999998e-15 * ddt(V(cpphdl_n628, cpphdl_n633)); // Bench initial voltage = 3.2999999999999998 V.
        // device 438, IC IC68, analog/basic/strongarm_comparator.hpp:50
        I(cpphdl_n629, cpphdl_n634) <+ 2.9999999999999998e-15 * ddt(V(cpphdl_n629, cpphdl_n634)); // Bench initial voltage = 3.2999999999999998 V.
        // device 439, IC IC70, analog/basic/cmos_logic.hpp:17
        I(DECISION3, Vss) <+ 5.0000000000000002e-14 * ddt(V(DECISION3, Vss)); // Bench initial voltage = 0.0 V.
        // device 440, IC IC70, analog/basic/cmos_logic.hpp:18
        I(DECISION3, Vdd) <+ cpphdl_channel(V(cpphdl_n647, Vdd), V(DECISION3, Vdd), 0.01, 0.69999999999999996, -1.0);
        // device 441, IC IC70, analog/basic/cmos_logic.hpp:19
        I(DECISION3, Vdd) <+ cpphdl_channel(V(DECISION_N3, Vdd), V(DECISION3, Vdd), 0.01, 0.69999999999999996, -1.0);
        // device 442, IC IC70, analog/basic/cmos_logic.hpp:20
        I(DECISION3, cpphdl_n650) <+ cpphdl_channel(V(cpphdl_n647, cpphdl_n650), V(DECISION3, cpphdl_n650), 0.01, 0.69999999999999996, 1.0);
        // device 443, IC IC70, analog/basic/cmos_logic.hpp:21
        I(cpphdl_n650, Vss) <+ cpphdl_channel(V(DECISION_N3, Vss), V(cpphdl_n650, Vss), 0.01, 0.69999999999999996, 1.0);
        // device 444, IC IC70, analog/basic/cmos_logic.hpp:23
        I(DECISION3, Vss) <+ V(DECISION3, Vss) / 1000000000.0;
        // device 445, IC IC70, analog/basic/cmos_logic.hpp:24
        I(cpphdl_n650, Vss) <+ V(cpphdl_n650, Vss) / 1000000000.0;
        // device 446, IC IC71, analog/basic/cmos_logic.hpp:17
        I(DECISION_N3, Vss) <+ 5.0000000000000002e-14 * ddt(V(DECISION_N3, Vss)); // Bench initial voltage = 0.0 V.
        // device 447, IC IC71, analog/basic/cmos_logic.hpp:18
        I(DECISION_N3, Vdd) <+ cpphdl_channel(V(cpphdl_n653, Vdd), V(DECISION_N3, Vdd), 0.01, 0.69999999999999996, -1.0);
        // device 448, IC IC71, analog/basic/cmos_logic.hpp:19
        I(DECISION_N3, Vdd) <+ cpphdl_channel(V(DECISION3, Vdd), V(DECISION_N3, Vdd), 0.01, 0.69999999999999996, -1.0);
        // device 449, IC IC71, analog/basic/cmos_logic.hpp:20
        I(DECISION_N3, cpphdl_n656) <+ cpphdl_channel(V(cpphdl_n653, cpphdl_n656), V(DECISION_N3, cpphdl_n656), 0.01, 0.69999999999999996, 1.0);
        // device 450, IC IC71, analog/basic/cmos_logic.hpp:21
        I(cpphdl_n656, Vss) <+ cpphdl_channel(V(DECISION3, Vss), V(cpphdl_n656, Vss), 0.01, 0.69999999999999996, 1.0);
        // device 451, IC IC71, analog/basic/cmos_logic.hpp:23
        I(DECISION_N3, Vss) <+ V(DECISION_N3, Vss) / 1000000000.0;
        // device 452, IC IC71, analog/basic/cmos_logic.hpp:24
        I(cpphdl_n656, Vss) <+ V(cpphdl_n656, Vss) / 1000000000.0;
        // device 453, IC IC69, analog/basic/nand_latch.hpp:36
        I(cpphdl_n647, Vss) <+ 2.9999999999999998e-15 * ddt(V(cpphdl_n647, Vss)); // Bench initial voltage = 0.0 V.
        // device 454, IC IC69, analog/basic/nand_latch.hpp:37
        I(cpphdl_n653, Vss) <+ 2.9999999999999998e-15 * ddt(V(cpphdl_n653, Vss)); // Bench initial voltage = 0.0 V.
        // device 455, IC IC72, analog/basic/inverter.hpp:11
        I(cpphdl_n661, Vdd) <+ cpphdl_channel(V(CLEAR, Vdd), V(cpphdl_n661, Vdd), 0.01, 0.69999999999999996, -1.0);
        // device 456, IC IC72, analog/basic/inverter.hpp:12
        I(cpphdl_n661, Vss) <+ cpphdl_channel(V(CLEAR, Vss), V(cpphdl_n661, Vss), 0.01, 0.69999999999999996, 1.0);
        // device 457, IC IC69, analog/basic/nand_latch.hpp:58
        I(cpphdl_n661, Vss) <+ 2.9999999999999998e-15 * ddt(V(cpphdl_n661, Vss)); // Bench initial voltage = 0.0 V.
        // device 458, IC IC69, analog/basic/nand_latch.hpp:59
        I(DECISION3, Vss) <+ cpphdl_channel(V(CLEAR, Vss), V(DECISION3, Vss), 0.050000000000000003, 0.69999999999999996, 1.0);
        // device 459, IC IC69, analog/basic/nand_latch.hpp:60
        I(DECISION_N3, Vdd) <+ cpphdl_channel(V(cpphdl_n661, Vdd), V(DECISION_N3, Vdd), 0.050000000000000003, 0.69999999999999996, -1.0);
        // device 460, IC IC75, analog/basic/inverter.hpp:11
        I(cpphdl_n685, Vdd) <+ cpphdl_channel(V(TRACK4, Vdd), V(cpphdl_n685, Vdd), 0.0040000000000000001, 0.69999999999999996, -1.0);
        // device 461, IC IC75, analog/basic/inverter.hpp:12
        I(cpphdl_n685, Vss) <+ cpphdl_channel(V(TRACK4, Vss), V(cpphdl_n685, Vss), 0.0040000000000000001, 0.69999999999999996, 1.0);
        // device 462, IC IC74, analog/basic/mos_track_hold.hpp:31
        I(cpphdl_n685, Vss) <+ 2e-14 * ddt(V(cpphdl_n685, Vss)); // Bench initial voltage = 3.2999999999999998 V.
        // device 463, IC IC74, analog/basic/mos_track_hold.hpp:32
        I(IN, cpphdl_n739) <+ cpphdl_channel(V(TRACK4, cpphdl_n739), V(IN, cpphdl_n739), 0.080000000000000002, 0.69999999999999996, 1.0);
        // device 464, IC IC74, analog/basic/mos_track_hold.hpp:33
        I(cpphdl_n739, IN) <+ cpphdl_channel(V(cpphdl_n685, IN), V(cpphdl_n739, IN), 0.040000000000000001, 0.69999999999999996, -1.0);
        // device 465, IC IC74, analog/basic/mos_track_hold.hpp:37
        I(cpphdl_n739, cpphdl_n739) <+ cpphdl_channel(V(cpphdl_n685, cpphdl_n739), V(cpphdl_n739, cpphdl_n739), 0.040000000000000001, 0.69999999999999996, 1.0);
        // device 466, IC IC74, analog/basic/mos_track_hold.hpp:38
        I(cpphdl_n739, cpphdl_n739) <+ cpphdl_channel(V(TRACK4, cpphdl_n739), V(cpphdl_n739, cpphdl_n739), 0.02, 0.69999999999999996, -1.0);
        // device 467, IC IC74, analog/basic/mos_track_hold.hpp:39
        I(cpphdl_n739, Vss) <+ 2e-12 * ddt(V(cpphdl_n739, Vss)); // Bench initial voltage = 1.6499999999999999 V.
        // device 468, IC IC74, analog/basic/mos_track_hold.hpp:41
        I(Vss, cpphdl_n739) <+ V(Vss, cpphdl_n739) / 1000000000.0;
        // device 469, IC IC74, analog/basic/mos_track_hold.hpp:42
        I(TRACK4, cpphdl_n739) <+ 8.0000000000000006e-15 * ddt(V(TRACK4, cpphdl_n739)); // Bench initial voltage = -1.6499999999999999 V.
        // device 470, IC IC74, analog/basic/mos_track_hold.hpp:43
        I(cpphdl_n685, cpphdl_n739) <+ 8.0000000000000006e-15 * ddt(V(cpphdl_n685, cpphdl_n739)); // Bench initial voltage = 1.6499999999999999 V.
        // device 471, IC IC74, analog/basic/mos_track_hold.hpp:44
        I(IN, cpphdl_n739) <+ 4.0000000000000003e-15 * ddt(V(IN, cpphdl_n739)); // Bench initial voltage = 0.0 V.
        // device 472, IC IC77, analog/basic/inverter.hpp:11
        I(cpphdl_n700, Vdd) <+ cpphdl_channel(V(BIT_N4_0, Vdd), V(cpphdl_n700, Vdd), 0.080000000000000002, 0.69999999999999996, -1.0);
        // device 473, IC IC77, analog/basic/inverter.hpp:12
        I(cpphdl_n700, Vss) <+ cpphdl_channel(V(BIT_N4_0, Vss), V(cpphdl_n700, Vss), 0.080000000000000002, 0.69999999999999996, 1.0);
        // device 474, IC IC76, analog/basic/mos_r2r_dac.hpp:27
        I(cpphdl_n700, Vss) <+ 2.9999999999999998e-15 * ddt(V(cpphdl_n700, Vss)); // Bench initial voltage = 0.0 V.
        // device 475, IC IC76, analog/basic/mos_r2r_dac.hpp:28
        I(cpphdl_n700, cpphdl_n729) <+ V(cpphdl_n700, cpphdl_n729) / 20000.0;
        // device 476, IC IC76, analog/basic/mos_r2r_dac.hpp:29
        I(cpphdl_n729, Vss) <+ 2.9999999999999998e-15 * ddt(V(cpphdl_n729, Vss)); // Bench initial voltage = 0.0 V.
        // device 477, IC IC78, analog/basic/inverter.hpp:11
        I(cpphdl_n704, Vdd) <+ cpphdl_channel(V(BIT_N4_1, Vdd), V(cpphdl_n704, Vdd), 0.080000000000000002, 0.69999999999999996, -1.0);
        // device 478, IC IC78, analog/basic/inverter.hpp:12
        I(cpphdl_n704, Vss) <+ cpphdl_channel(V(BIT_N4_1, Vss), V(cpphdl_n704, Vss), 0.080000000000000002, 0.69999999999999996, 1.0);
        // device 479, IC IC76, analog/basic/mos_r2r_dac.hpp:27
        I(cpphdl_n704, Vss) <+ 2.9999999999999998e-15 * ddt(V(cpphdl_n704, Vss)); // Bench initial voltage = 0.0 V.
        // device 480, IC IC76, analog/basic/mos_r2r_dac.hpp:28
        I(cpphdl_n704, cpphdl_n730) <+ V(cpphdl_n704, cpphdl_n730) / 20000.0;
        // device 481, IC IC76, analog/basic/mos_r2r_dac.hpp:29
        I(cpphdl_n730, Vss) <+ 2.9999999999999998e-15 * ddt(V(cpphdl_n730, Vss)); // Bench initial voltage = 0.0 V.
        // device 482, IC IC76, analog/basic/mos_r2r_dac.hpp:31
        I(cpphdl_n729, cpphdl_n730) <+ V(cpphdl_n729, cpphdl_n730) / 10000.0;
        // device 483, IC IC79, analog/basic/inverter.hpp:11
        I(cpphdl_n708, Vdd) <+ cpphdl_channel(V(BIT_N4_2, Vdd), V(cpphdl_n708, Vdd), 0.080000000000000002, 0.69999999999999996, -1.0);
        // device 484, IC IC79, analog/basic/inverter.hpp:12
        I(cpphdl_n708, Vss) <+ cpphdl_channel(V(BIT_N4_2, Vss), V(cpphdl_n708, Vss), 0.080000000000000002, 0.69999999999999996, 1.0);
        // device 485, IC IC76, analog/basic/mos_r2r_dac.hpp:27
        I(cpphdl_n708, Vss) <+ 2.9999999999999998e-15 * ddt(V(cpphdl_n708, Vss)); // Bench initial voltage = 0.0 V.
        // device 486, IC IC76, analog/basic/mos_r2r_dac.hpp:28
        I(cpphdl_n708, cpphdl_n731) <+ V(cpphdl_n708, cpphdl_n731) / 20000.0;
        // device 487, IC IC76, analog/basic/mos_r2r_dac.hpp:29
        I(cpphdl_n731, Vss) <+ 2.9999999999999998e-15 * ddt(V(cpphdl_n731, Vss)); // Bench initial voltage = 0.0 V.
        // device 488, IC IC76, analog/basic/mos_r2r_dac.hpp:31
        I(cpphdl_n730, cpphdl_n731) <+ V(cpphdl_n730, cpphdl_n731) / 10000.0;
        // device 489, IC IC80, analog/basic/inverter.hpp:11
        I(cpphdl_n712, Vdd) <+ cpphdl_channel(V(BIT_N4_3, Vdd), V(cpphdl_n712, Vdd), 0.080000000000000002, 0.69999999999999996, -1.0);
        // device 490, IC IC80, analog/basic/inverter.hpp:12
        I(cpphdl_n712, Vss) <+ cpphdl_channel(V(BIT_N4_3, Vss), V(cpphdl_n712, Vss), 0.080000000000000002, 0.69999999999999996, 1.0);
        // device 491, IC IC76, analog/basic/mos_r2r_dac.hpp:27
        I(cpphdl_n712, Vss) <+ 2.9999999999999998e-15 * ddt(V(cpphdl_n712, Vss)); // Bench initial voltage = 0.0 V.
        // device 492, IC IC76, analog/basic/mos_r2r_dac.hpp:28
        I(cpphdl_n712, cpphdl_n732) <+ V(cpphdl_n712, cpphdl_n732) / 20000.0;
        // device 493, IC IC76, analog/basic/mos_r2r_dac.hpp:29
        I(cpphdl_n732, Vss) <+ 2.9999999999999998e-15 * ddt(V(cpphdl_n732, Vss)); // Bench initial voltage = 0.0 V.
        // device 494, IC IC76, analog/basic/mos_r2r_dac.hpp:31
        I(cpphdl_n731, cpphdl_n732) <+ V(cpphdl_n731, cpphdl_n732) / 10000.0;
        // device 495, IC IC81, analog/basic/inverter.hpp:11
        I(cpphdl_n716, Vdd) <+ cpphdl_channel(V(BIT_N4_4, Vdd), V(cpphdl_n716, Vdd), 0.080000000000000002, 0.69999999999999996, -1.0);
        // device 496, IC IC81, analog/basic/inverter.hpp:12
        I(cpphdl_n716, Vss) <+ cpphdl_channel(V(BIT_N4_4, Vss), V(cpphdl_n716, Vss), 0.080000000000000002, 0.69999999999999996, 1.0);
        // device 497, IC IC76, analog/basic/mos_r2r_dac.hpp:27
        I(cpphdl_n716, Vss) <+ 2.9999999999999998e-15 * ddt(V(cpphdl_n716, Vss)); // Bench initial voltage = 0.0 V.
        // device 498, IC IC76, analog/basic/mos_r2r_dac.hpp:28
        I(cpphdl_n716, cpphdl_n733) <+ V(cpphdl_n716, cpphdl_n733) / 20000.0;
        // device 499, IC IC76, analog/basic/mos_r2r_dac.hpp:29
        I(cpphdl_n733, Vss) <+ 2.9999999999999998e-15 * ddt(V(cpphdl_n733, Vss)); // Bench initial voltage = 0.0 V.
        // device 500, IC IC76, analog/basic/mos_r2r_dac.hpp:31
        I(cpphdl_n732, cpphdl_n733) <+ V(cpphdl_n732, cpphdl_n733) / 10000.0;
        // device 501, IC IC82, analog/basic/inverter.hpp:11
        I(cpphdl_n720, Vdd) <+ cpphdl_channel(V(BIT_N4_5, Vdd), V(cpphdl_n720, Vdd), 0.080000000000000002, 0.69999999999999996, -1.0);
        // device 502, IC IC82, analog/basic/inverter.hpp:12
        I(cpphdl_n720, Vss) <+ cpphdl_channel(V(BIT_N4_5, Vss), V(cpphdl_n720, Vss), 0.080000000000000002, 0.69999999999999996, 1.0);
        // device 503, IC IC76, analog/basic/mos_r2r_dac.hpp:27
        I(cpphdl_n720, Vss) <+ 2.9999999999999998e-15 * ddt(V(cpphdl_n720, Vss)); // Bench initial voltage = 0.0 V.
        // device 504, IC IC76, analog/basic/mos_r2r_dac.hpp:28
        I(cpphdl_n720, cpphdl_n734) <+ V(cpphdl_n720, cpphdl_n734) / 20000.0;
        // device 505, IC IC76, analog/basic/mos_r2r_dac.hpp:29
        I(cpphdl_n734, Vss) <+ 2.9999999999999998e-15 * ddt(V(cpphdl_n734, Vss)); // Bench initial voltage = 0.0 V.
        // device 506, IC IC76, analog/basic/mos_r2r_dac.hpp:31
        I(cpphdl_n733, cpphdl_n734) <+ V(cpphdl_n733, cpphdl_n734) / 10000.0;
        // device 507, IC IC83, analog/basic/inverter.hpp:11
        I(cpphdl_n724, Vdd) <+ cpphdl_channel(V(BIT_N4_6, Vdd), V(cpphdl_n724, Vdd), 0.080000000000000002, 0.69999999999999996, -1.0);
        // device 508, IC IC83, analog/basic/inverter.hpp:12
        I(cpphdl_n724, Vss) <+ cpphdl_channel(V(BIT_N4_6, Vss), V(cpphdl_n724, Vss), 0.080000000000000002, 0.69999999999999996, 1.0);
        // device 509, IC IC76, analog/basic/mos_r2r_dac.hpp:27
        I(cpphdl_n724, Vss) <+ 2.9999999999999998e-15 * ddt(V(cpphdl_n724, Vss)); // Bench initial voltage = 0.0 V.
        // device 510, IC IC76, analog/basic/mos_r2r_dac.hpp:28
        I(cpphdl_n724, cpphdl_n735) <+ V(cpphdl_n724, cpphdl_n735) / 20000.0;
        // device 511, IC IC76, analog/basic/mos_r2r_dac.hpp:29
        I(cpphdl_n735, Vss) <+ 2.9999999999999998e-15 * ddt(V(cpphdl_n735, Vss)); // Bench initial voltage = 0.0 V.
        // device 512, IC IC76, analog/basic/mos_r2r_dac.hpp:31
        I(cpphdl_n734, cpphdl_n735) <+ V(cpphdl_n734, cpphdl_n735) / 10000.0;
        // device 513, IC IC84, analog/basic/inverter.hpp:11
        I(cpphdl_n728, Vdd) <+ cpphdl_channel(V(BIT_N4_7, Vdd), V(cpphdl_n728, Vdd), 0.080000000000000002, 0.69999999999999996, -1.0);
        // device 514, IC IC84, analog/basic/inverter.hpp:12
        I(cpphdl_n728, Vss) <+ cpphdl_channel(V(BIT_N4_7, Vss), V(cpphdl_n728, Vss), 0.080000000000000002, 0.69999999999999996, 1.0);
        // device 515, IC IC76, analog/basic/mos_r2r_dac.hpp:27
        I(cpphdl_n728, Vss) <+ 2.9999999999999998e-15 * ddt(V(cpphdl_n728, Vss)); // Bench initial voltage = 0.0 V.
        // device 516, IC IC76, analog/basic/mos_r2r_dac.hpp:28
        I(cpphdl_n728, cpphdl_n740) <+ V(cpphdl_n728, cpphdl_n740) / 20000.0;
        // device 517, IC IC76, analog/basic/mos_r2r_dac.hpp:29
        I(cpphdl_n740, Vss) <+ 2.9999999999999998e-15 * ddt(V(cpphdl_n740, Vss)); // Bench initial voltage = 0.0 V.
        // device 518, IC IC76, analog/basic/mos_r2r_dac.hpp:31
        I(cpphdl_n735, cpphdl_n740) <+ V(cpphdl_n735, cpphdl_n740) / 10000.0;
        // device 519, IC IC76, analog/basic/mos_r2r_dac.hpp:33
        I(Vss, cpphdl_n729) <+ V(Vss, cpphdl_n729) / 20000.0;
        // device 520, IC IC85, analog/basic/nmos_resistor_amplifier.hpp:23
        I(Vdd, cpphdl_n749) <+ V(Vdd, cpphdl_n749) / 1000.0;
        // device 521, IC IC85, analog/basic/nmos_resistor_amplifier.hpp:24
        I(Vdd, cpphdl_n748) <+ V(Vdd, cpphdl_n748) / 1000.0;
        // device 522, IC IC85, analog/basic/nmos_resistor_amplifier.hpp:25
        I(cpphdl_n749, cpphdl_n743) <+ cpphdl_channel(V(cpphdl_n739, cpphdl_n743), V(cpphdl_n749, cpphdl_n743), 0.014999999999999999, 0.69999999999999996, 1.0);
        // device 523, IC IC85, analog/basic/nmos_resistor_amplifier.hpp:26
        I(cpphdl_n748, cpphdl_n744) <+ cpphdl_channel(V(cpphdl_n740, cpphdl_n744), V(cpphdl_n748, cpphdl_n744), 0.014999999999999999, 0.69999999999999996, 1.0);
        // device 524, IC IC85, analog/basic/nmos_resistor_amplifier.hpp:27
        I(cpphdl_n745, cpphdl_n743) <+ V(cpphdl_n745, cpphdl_n743) / 50.0;
        // device 525, IC IC85, analog/basic/nmos_resistor_amplifier.hpp:28
        I(cpphdl_n745, cpphdl_n744) <+ V(cpphdl_n745, cpphdl_n744) / 50.0;
        // device 526, IC IC85, analog/basic/nmos_resistor_amplifier.hpp:29
        I(Vss, cpphdl_n745) <+ V(Vss, cpphdl_n745) / 150.0;
        // device 527, IC IC85, analog/basic/nmos_resistor_amplifier.hpp:30
        I(cpphdl_n749, Vdd) <+ 2.9999999999999998e-13 * ddt(V(cpphdl_n749, Vdd)); // Bench initial voltage = 0.0 V.
        // device 528, IC IC85, analog/basic/nmos_resistor_amplifier.hpp:31
        I(cpphdl_n748, Vdd) <+ 2.9999999999999998e-13 * ddt(V(cpphdl_n748, Vdd)); // Bench initial voltage = 0.0 V.
        // device 529, IC IC85, analog/basic/nmos_resistor_amplifier.hpp:32
        I(cpphdl_n745, Vss) <+ 4e-14 * ddt(V(cpphdl_n745, Vss)); // Bench initial voltage = 0.0 V.
        // device 530, IC IC85, analog/basic/nmos_resistor_amplifier.hpp:34
        I(cpphdl_n739, cpphdl_n743) <+ 2e-14 * ddt(V(cpphdl_n739, cpphdl_n743)); // Bench initial voltage = 1.6499999999999999 V.
        // device 531, IC IC85, analog/basic/nmos_resistor_amplifier.hpp:35
        I(cpphdl_n740, cpphdl_n744) <+ 2e-14 * ddt(V(cpphdl_n740, cpphdl_n744)); // Bench initial voltage = 0.0 V.
        // device 532, IC IC85, analog/basic/nmos_resistor_amplifier.hpp:36
        I(cpphdl_n739, cpphdl_n749) <+ 2.9999999999999998e-15 * ddt(V(cpphdl_n739, cpphdl_n749)); // Bench initial voltage = -1.6499999999999999 V.
        // device 533, IC IC85, analog/basic/nmos_resistor_amplifier.hpp:37
        I(cpphdl_n740, cpphdl_n748) <+ 2.9999999999999998e-15 * ddt(V(cpphdl_n740, cpphdl_n748)); // Bench initial voltage = -3.2999999999999998 V.
        // device 534, IC IC86, analog/basic/strongarm_comparator.hpp:28
        I(cpphdl_n753, cpphdl_n755) <+ cpphdl_channel(V(cpphdl_n748, cpphdl_n755), V(cpphdl_n753, cpphdl_n755), 0.0080000000000000002, 0.69999999999999996, 1.0);
        // device 535, IC IC86, analog/basic/strongarm_comparator.hpp:29
        I(cpphdl_n754, cpphdl_n755) <+ cpphdl_channel(V(cpphdl_n749, cpphdl_n755), V(cpphdl_n754, cpphdl_n755), 0.0080000000000000002, 0.69999999999999996, 1.0);
        // device 536, IC IC86, analog/basic/strongarm_comparator.hpp:30
        I(cpphdl_n755, Vss) <+ cpphdl_channel(V(EVALUATE, Vss), V(cpphdl_n755, Vss), 0.0080000000000000002, 0.69999999999999996, 1.0);
        // device 537, IC IC86, analog/basic/strongarm_comparator.hpp:33
        I(cpphdl_n767, cpphdl_n753) <+ cpphdl_channel(V(cpphdl_n773, cpphdl_n753), V(cpphdl_n767, cpphdl_n753), 0.0040000000000000001, 0.69999999999999996, 1.0);
        // device 538, IC IC86, analog/basic/strongarm_comparator.hpp:34
        I(cpphdl_n773, cpphdl_n754) <+ cpphdl_channel(V(cpphdl_n767, cpphdl_n754), V(cpphdl_n773, cpphdl_n754), 0.0040000000000000001, 0.69999999999999996, 1.0);
        // device 539, IC IC86, analog/basic/strongarm_comparator.hpp:35
        I(cpphdl_n773, Vdd) <+ cpphdl_channel(V(cpphdl_n767, Vdd), V(cpphdl_n773, Vdd), 0.002, 0.69999999999999996, -1.0);
        // device 540, IC IC86, analog/basic/strongarm_comparator.hpp:36
        I(cpphdl_n767, Vdd) <+ cpphdl_channel(V(cpphdl_n773, Vdd), V(cpphdl_n767, Vdd), 0.002, 0.69999999999999996, -1.0);
        // device 541, IC IC86, analog/basic/strongarm_comparator.hpp:38
        I(cpphdl_n753, Vdd) <+ cpphdl_channel(V(EVALUATE, Vdd), V(cpphdl_n753, Vdd), 0.002, 0.69999999999999996, -1.0);
        // device 542, IC IC86, analog/basic/strongarm_comparator.hpp:39
        I(cpphdl_n754, Vdd) <+ cpphdl_channel(V(EVALUATE, Vdd), V(cpphdl_n754, Vdd), 0.002, 0.69999999999999996, -1.0);
        // device 543, IC IC86, analog/basic/strongarm_comparator.hpp:40
        I(cpphdl_n773, Vdd) <+ cpphdl_channel(V(EVALUATE, Vdd), V(cpphdl_n773, Vdd), 0.002, 0.69999999999999996, -1.0);
        // device 544, IC IC86, analog/basic/strongarm_comparator.hpp:41
        I(cpphdl_n767, Vdd) <+ cpphdl_channel(V(EVALUATE, Vdd), V(cpphdl_n767, Vdd), 0.002, 0.69999999999999996, -1.0);
        // device 545, IC IC86, analog/basic/strongarm_comparator.hpp:42
        I(cpphdl_n753, Vss) <+ 2.9999999999999998e-14 * ddt(V(cpphdl_n753, Vss)); // Bench initial voltage = 0.0 V.
        // device 546, IC IC86, analog/basic/strongarm_comparator.hpp:43
        I(cpphdl_n754, Vss) <+ 2.9999999999999998e-14 * ddt(V(cpphdl_n754, Vss)); // Bench initial voltage = 0.0 V.
        // device 547, IC IC86, analog/basic/strongarm_comparator.hpp:44
        I(cpphdl_n755, Vss) <+ 2.9999999999999998e-14 * ddt(V(cpphdl_n755, Vss)); // Bench initial voltage = 0.0 V.
        // device 548, IC IC86, analog/basic/strongarm_comparator.hpp:45
        I(cpphdl_n773, Vss) <+ 5.0000000000000002e-14 * ddt(V(cpphdl_n773, Vss)); // Bench initial voltage = 0.0 V.
        // device 549, IC IC86, analog/basic/strongarm_comparator.hpp:46
        I(cpphdl_n767, Vss) <+ 5.0000000000000002e-14 * ddt(V(cpphdl_n767, Vss)); // Bench initial voltage = 0.0 V.
        // device 550, IC IC86, analog/basic/strongarm_comparator.hpp:47
        I(cpphdl_n748, cpphdl_n755) <+ 2e-14 * ddt(V(cpphdl_n748, cpphdl_n755)); // Bench initial voltage = 3.2999999999999998 V.
        // device 551, IC IC86, analog/basic/strongarm_comparator.hpp:48
        I(cpphdl_n749, cpphdl_n755) <+ 2e-14 * ddt(V(cpphdl_n749, cpphdl_n755)); // Bench initial voltage = 3.2999999999999998 V.
        // device 552, IC IC86, analog/basic/strongarm_comparator.hpp:49
        I(cpphdl_n748, cpphdl_n753) <+ 2.9999999999999998e-15 * ddt(V(cpphdl_n748, cpphdl_n753)); // Bench initial voltage = 3.2999999999999998 V.
        // device 553, IC IC86, analog/basic/strongarm_comparator.hpp:50
        I(cpphdl_n749, cpphdl_n754) <+ 2.9999999999999998e-15 * ddt(V(cpphdl_n749, cpphdl_n754)); // Bench initial voltage = 3.2999999999999998 V.
        // device 554, IC IC88, analog/basic/cmos_logic.hpp:17
        I(DECISION4, Vss) <+ 5.0000000000000002e-14 * ddt(V(DECISION4, Vss)); // Bench initial voltage = 0.0 V.
        // device 555, IC IC88, analog/basic/cmos_logic.hpp:18
        I(DECISION4, Vdd) <+ cpphdl_channel(V(cpphdl_n767, Vdd), V(DECISION4, Vdd), 0.01, 0.69999999999999996, -1.0);
        // device 556, IC IC88, analog/basic/cmos_logic.hpp:19
        I(DECISION4, Vdd) <+ cpphdl_channel(V(DECISION_N4, Vdd), V(DECISION4, Vdd), 0.01, 0.69999999999999996, -1.0);
        // device 557, IC IC88, analog/basic/cmos_logic.hpp:20
        I(DECISION4, cpphdl_n770) <+ cpphdl_channel(V(cpphdl_n767, cpphdl_n770), V(DECISION4, cpphdl_n770), 0.01, 0.69999999999999996, 1.0);
        // device 558, IC IC88, analog/basic/cmos_logic.hpp:21
        I(cpphdl_n770, Vss) <+ cpphdl_channel(V(DECISION_N4, Vss), V(cpphdl_n770, Vss), 0.01, 0.69999999999999996, 1.0);
        // device 559, IC IC88, analog/basic/cmos_logic.hpp:23
        I(DECISION4, Vss) <+ V(DECISION4, Vss) / 1000000000.0;
        // device 560, IC IC88, analog/basic/cmos_logic.hpp:24
        I(cpphdl_n770, Vss) <+ V(cpphdl_n770, Vss) / 1000000000.0;
        // device 561, IC IC89, analog/basic/cmos_logic.hpp:17
        I(DECISION_N4, Vss) <+ 5.0000000000000002e-14 * ddt(V(DECISION_N4, Vss)); // Bench initial voltage = 0.0 V.
        // device 562, IC IC89, analog/basic/cmos_logic.hpp:18
        I(DECISION_N4, Vdd) <+ cpphdl_channel(V(cpphdl_n773, Vdd), V(DECISION_N4, Vdd), 0.01, 0.69999999999999996, -1.0);
        // device 563, IC IC89, analog/basic/cmos_logic.hpp:19
        I(DECISION_N4, Vdd) <+ cpphdl_channel(V(DECISION4, Vdd), V(DECISION_N4, Vdd), 0.01, 0.69999999999999996, -1.0);
        // device 564, IC IC89, analog/basic/cmos_logic.hpp:20
        I(DECISION_N4, cpphdl_n776) <+ cpphdl_channel(V(cpphdl_n773, cpphdl_n776), V(DECISION_N4, cpphdl_n776), 0.01, 0.69999999999999996, 1.0);
        // device 565, IC IC89, analog/basic/cmos_logic.hpp:21
        I(cpphdl_n776, Vss) <+ cpphdl_channel(V(DECISION4, Vss), V(cpphdl_n776, Vss), 0.01, 0.69999999999999996, 1.0);
        // device 566, IC IC89, analog/basic/cmos_logic.hpp:23
        I(DECISION_N4, Vss) <+ V(DECISION_N4, Vss) / 1000000000.0;
        // device 567, IC IC89, analog/basic/cmos_logic.hpp:24
        I(cpphdl_n776, Vss) <+ V(cpphdl_n776, Vss) / 1000000000.0;
        // device 568, IC IC87, analog/basic/nand_latch.hpp:36
        I(cpphdl_n767, Vss) <+ 2.9999999999999998e-15 * ddt(V(cpphdl_n767, Vss)); // Bench initial voltage = 0.0 V.
        // device 569, IC IC87, analog/basic/nand_latch.hpp:37
        I(cpphdl_n773, Vss) <+ 2.9999999999999998e-15 * ddt(V(cpphdl_n773, Vss)); // Bench initial voltage = 0.0 V.
        // device 570, IC IC90, analog/basic/inverter.hpp:11
        I(cpphdl_n781, Vdd) <+ cpphdl_channel(V(CLEAR, Vdd), V(cpphdl_n781, Vdd), 0.01, 0.69999999999999996, -1.0);
        // device 571, IC IC90, analog/basic/inverter.hpp:12
        I(cpphdl_n781, Vss) <+ cpphdl_channel(V(CLEAR, Vss), V(cpphdl_n781, Vss), 0.01, 0.69999999999999996, 1.0);
        // device 572, IC IC87, analog/basic/nand_latch.hpp:58
        I(cpphdl_n781, Vss) <+ 2.9999999999999998e-15 * ddt(V(cpphdl_n781, Vss)); // Bench initial voltage = 0.0 V.
        // device 573, IC IC87, analog/basic/nand_latch.hpp:59
        I(DECISION4, Vss) <+ cpphdl_channel(V(CLEAR, Vss), V(DECISION4, Vss), 0.050000000000000003, 0.69999999999999996, 1.0);
        // device 574, IC IC87, analog/basic/nand_latch.hpp:60
        I(DECISION_N4, Vdd) <+ cpphdl_channel(V(cpphdl_n781, Vdd), V(DECISION_N4, Vdd), 0.050000000000000003, 0.69999999999999996, -1.0);
        // device 575, IC IC93, analog/basic/inverter.hpp:11
        I(cpphdl_n805, Vdd) <+ cpphdl_channel(V(TRACK5, Vdd), V(cpphdl_n805, Vdd), 0.0040000000000000001, 0.69999999999999996, -1.0);
        // device 576, IC IC93, analog/basic/inverter.hpp:12
        I(cpphdl_n805, Vss) <+ cpphdl_channel(V(TRACK5, Vss), V(cpphdl_n805, Vss), 0.0040000000000000001, 0.69999999999999996, 1.0);
        // device 577, IC IC92, analog/basic/mos_track_hold.hpp:31
        I(cpphdl_n805, Vss) <+ 2e-14 * ddt(V(cpphdl_n805, Vss)); // Bench initial voltage = 3.2999999999999998 V.
        // device 578, IC IC92, analog/basic/mos_track_hold.hpp:32
        I(IN, cpphdl_n859) <+ cpphdl_channel(V(TRACK5, cpphdl_n859), V(IN, cpphdl_n859), 0.080000000000000002, 0.69999999999999996, 1.0);
        // device 579, IC IC92, analog/basic/mos_track_hold.hpp:33
        I(cpphdl_n859, IN) <+ cpphdl_channel(V(cpphdl_n805, IN), V(cpphdl_n859, IN), 0.040000000000000001, 0.69999999999999996, -1.0);
        // device 580, IC IC92, analog/basic/mos_track_hold.hpp:37
        I(cpphdl_n859, cpphdl_n859) <+ cpphdl_channel(V(cpphdl_n805, cpphdl_n859), V(cpphdl_n859, cpphdl_n859), 0.040000000000000001, 0.69999999999999996, 1.0);
        // device 581, IC IC92, analog/basic/mos_track_hold.hpp:38
        I(cpphdl_n859, cpphdl_n859) <+ cpphdl_channel(V(TRACK5, cpphdl_n859), V(cpphdl_n859, cpphdl_n859), 0.02, 0.69999999999999996, -1.0);
        // device 582, IC IC92, analog/basic/mos_track_hold.hpp:39
        I(cpphdl_n859, Vss) <+ 2e-12 * ddt(V(cpphdl_n859, Vss)); // Bench initial voltage = 1.6499999999999999 V.
        // device 583, IC IC92, analog/basic/mos_track_hold.hpp:41
        I(Vss, cpphdl_n859) <+ V(Vss, cpphdl_n859) / 1000000000.0;
        // device 584, IC IC92, analog/basic/mos_track_hold.hpp:42
        I(TRACK5, cpphdl_n859) <+ 8.0000000000000006e-15 * ddt(V(TRACK5, cpphdl_n859)); // Bench initial voltage = -1.6499999999999999 V.
        // device 585, IC IC92, analog/basic/mos_track_hold.hpp:43
        I(cpphdl_n805, cpphdl_n859) <+ 8.0000000000000006e-15 * ddt(V(cpphdl_n805, cpphdl_n859)); // Bench initial voltage = 1.6499999999999999 V.
        // device 586, IC IC92, analog/basic/mos_track_hold.hpp:44
        I(IN, cpphdl_n859) <+ 4.0000000000000003e-15 * ddt(V(IN, cpphdl_n859)); // Bench initial voltage = 0.0 V.
        // device 587, IC IC95, analog/basic/inverter.hpp:11
        I(cpphdl_n820, Vdd) <+ cpphdl_channel(V(BIT_N5_0, Vdd), V(cpphdl_n820, Vdd), 0.080000000000000002, 0.69999999999999996, -1.0);
        // device 588, IC IC95, analog/basic/inverter.hpp:12
        I(cpphdl_n820, Vss) <+ cpphdl_channel(V(BIT_N5_0, Vss), V(cpphdl_n820, Vss), 0.080000000000000002, 0.69999999999999996, 1.0);
        // device 589, IC IC94, analog/basic/mos_r2r_dac.hpp:27
        I(cpphdl_n820, Vss) <+ 2.9999999999999998e-15 * ddt(V(cpphdl_n820, Vss)); // Bench initial voltage = 0.0 V.
        // device 590, IC IC94, analog/basic/mos_r2r_dac.hpp:28
        I(cpphdl_n820, cpphdl_n849) <+ V(cpphdl_n820, cpphdl_n849) / 20000.0;
        // device 591, IC IC94, analog/basic/mos_r2r_dac.hpp:29
        I(cpphdl_n849, Vss) <+ 2.9999999999999998e-15 * ddt(V(cpphdl_n849, Vss)); // Bench initial voltage = 0.0 V.
        // device 592, IC IC96, analog/basic/inverter.hpp:11
        I(cpphdl_n824, Vdd) <+ cpphdl_channel(V(BIT_N5_1, Vdd), V(cpphdl_n824, Vdd), 0.080000000000000002, 0.69999999999999996, -1.0);
        // device 593, IC IC96, analog/basic/inverter.hpp:12
        I(cpphdl_n824, Vss) <+ cpphdl_channel(V(BIT_N5_1, Vss), V(cpphdl_n824, Vss), 0.080000000000000002, 0.69999999999999996, 1.0);
        // device 594, IC IC94, analog/basic/mos_r2r_dac.hpp:27
        I(cpphdl_n824, Vss) <+ 2.9999999999999998e-15 * ddt(V(cpphdl_n824, Vss)); // Bench initial voltage = 0.0 V.
        // device 595, IC IC94, analog/basic/mos_r2r_dac.hpp:28
        I(cpphdl_n824, cpphdl_n850) <+ V(cpphdl_n824, cpphdl_n850) / 20000.0;
        // device 596, IC IC94, analog/basic/mos_r2r_dac.hpp:29
        I(cpphdl_n850, Vss) <+ 2.9999999999999998e-15 * ddt(V(cpphdl_n850, Vss)); // Bench initial voltage = 0.0 V.
        // device 597, IC IC94, analog/basic/mos_r2r_dac.hpp:31
        I(cpphdl_n849, cpphdl_n850) <+ V(cpphdl_n849, cpphdl_n850) / 10000.0;
        // device 598, IC IC97, analog/basic/inverter.hpp:11
        I(cpphdl_n828, Vdd) <+ cpphdl_channel(V(BIT_N5_2, Vdd), V(cpphdl_n828, Vdd), 0.080000000000000002, 0.69999999999999996, -1.0);
        // device 599, IC IC97, analog/basic/inverter.hpp:12
        I(cpphdl_n828, Vss) <+ cpphdl_channel(V(BIT_N5_2, Vss), V(cpphdl_n828, Vss), 0.080000000000000002, 0.69999999999999996, 1.0);
        // device 600, IC IC94, analog/basic/mos_r2r_dac.hpp:27
        I(cpphdl_n828, Vss) <+ 2.9999999999999998e-15 * ddt(V(cpphdl_n828, Vss)); // Bench initial voltage = 0.0 V.
        // device 601, IC IC94, analog/basic/mos_r2r_dac.hpp:28
        I(cpphdl_n828, cpphdl_n851) <+ V(cpphdl_n828, cpphdl_n851) / 20000.0;
        // device 602, IC IC94, analog/basic/mos_r2r_dac.hpp:29
        I(cpphdl_n851, Vss) <+ 2.9999999999999998e-15 * ddt(V(cpphdl_n851, Vss)); // Bench initial voltage = 0.0 V.
        // device 603, IC IC94, analog/basic/mos_r2r_dac.hpp:31
        I(cpphdl_n850, cpphdl_n851) <+ V(cpphdl_n850, cpphdl_n851) / 10000.0;
        // device 604, IC IC98, analog/basic/inverter.hpp:11
        I(cpphdl_n832, Vdd) <+ cpphdl_channel(V(BIT_N5_3, Vdd), V(cpphdl_n832, Vdd), 0.080000000000000002, 0.69999999999999996, -1.0);
        // device 605, IC IC98, analog/basic/inverter.hpp:12
        I(cpphdl_n832, Vss) <+ cpphdl_channel(V(BIT_N5_3, Vss), V(cpphdl_n832, Vss), 0.080000000000000002, 0.69999999999999996, 1.0);
        // device 606, IC IC94, analog/basic/mos_r2r_dac.hpp:27
        I(cpphdl_n832, Vss) <+ 2.9999999999999998e-15 * ddt(V(cpphdl_n832, Vss)); // Bench initial voltage = 0.0 V.
        // device 607, IC IC94, analog/basic/mos_r2r_dac.hpp:28
        I(cpphdl_n832, cpphdl_n852) <+ V(cpphdl_n832, cpphdl_n852) / 20000.0;
        // device 608, IC IC94, analog/basic/mos_r2r_dac.hpp:29
        I(cpphdl_n852, Vss) <+ 2.9999999999999998e-15 * ddt(V(cpphdl_n852, Vss)); // Bench initial voltage = 0.0 V.
        // device 609, IC IC94, analog/basic/mos_r2r_dac.hpp:31
        I(cpphdl_n851, cpphdl_n852) <+ V(cpphdl_n851, cpphdl_n852) / 10000.0;
        // device 610, IC IC99, analog/basic/inverter.hpp:11
        I(cpphdl_n836, Vdd) <+ cpphdl_channel(V(BIT_N5_4, Vdd), V(cpphdl_n836, Vdd), 0.080000000000000002, 0.69999999999999996, -1.0);
        // device 611, IC IC99, analog/basic/inverter.hpp:12
        I(cpphdl_n836, Vss) <+ cpphdl_channel(V(BIT_N5_4, Vss), V(cpphdl_n836, Vss), 0.080000000000000002, 0.69999999999999996, 1.0);
        // device 612, IC IC94, analog/basic/mos_r2r_dac.hpp:27
        I(cpphdl_n836, Vss) <+ 2.9999999999999998e-15 * ddt(V(cpphdl_n836, Vss)); // Bench initial voltage = 0.0 V.
        // device 613, IC IC94, analog/basic/mos_r2r_dac.hpp:28
        I(cpphdl_n836, cpphdl_n853) <+ V(cpphdl_n836, cpphdl_n853) / 20000.0;
        // device 614, IC IC94, analog/basic/mos_r2r_dac.hpp:29
        I(cpphdl_n853, Vss) <+ 2.9999999999999998e-15 * ddt(V(cpphdl_n853, Vss)); // Bench initial voltage = 0.0 V.
        // device 615, IC IC94, analog/basic/mos_r2r_dac.hpp:31
        I(cpphdl_n852, cpphdl_n853) <+ V(cpphdl_n852, cpphdl_n853) / 10000.0;
        // device 616, IC IC100, analog/basic/inverter.hpp:11
        I(cpphdl_n840, Vdd) <+ cpphdl_channel(V(BIT_N5_5, Vdd), V(cpphdl_n840, Vdd), 0.080000000000000002, 0.69999999999999996, -1.0);
        // device 617, IC IC100, analog/basic/inverter.hpp:12
        I(cpphdl_n840, Vss) <+ cpphdl_channel(V(BIT_N5_5, Vss), V(cpphdl_n840, Vss), 0.080000000000000002, 0.69999999999999996, 1.0);
        // device 618, IC IC94, analog/basic/mos_r2r_dac.hpp:27
        I(cpphdl_n840, Vss) <+ 2.9999999999999998e-15 * ddt(V(cpphdl_n840, Vss)); // Bench initial voltage = 0.0 V.
        // device 619, IC IC94, analog/basic/mos_r2r_dac.hpp:28
        I(cpphdl_n840, cpphdl_n854) <+ V(cpphdl_n840, cpphdl_n854) / 20000.0;
        // device 620, IC IC94, analog/basic/mos_r2r_dac.hpp:29
        I(cpphdl_n854, Vss) <+ 2.9999999999999998e-15 * ddt(V(cpphdl_n854, Vss)); // Bench initial voltage = 0.0 V.
        // device 621, IC IC94, analog/basic/mos_r2r_dac.hpp:31
        I(cpphdl_n853, cpphdl_n854) <+ V(cpphdl_n853, cpphdl_n854) / 10000.0;
        // device 622, IC IC101, analog/basic/inverter.hpp:11
        I(cpphdl_n844, Vdd) <+ cpphdl_channel(V(BIT_N5_6, Vdd), V(cpphdl_n844, Vdd), 0.080000000000000002, 0.69999999999999996, -1.0);
        // device 623, IC IC101, analog/basic/inverter.hpp:12
        I(cpphdl_n844, Vss) <+ cpphdl_channel(V(BIT_N5_6, Vss), V(cpphdl_n844, Vss), 0.080000000000000002, 0.69999999999999996, 1.0);
        // device 624, IC IC94, analog/basic/mos_r2r_dac.hpp:27
        I(cpphdl_n844, Vss) <+ 2.9999999999999998e-15 * ddt(V(cpphdl_n844, Vss)); // Bench initial voltage = 0.0 V.
        // device 625, IC IC94, analog/basic/mos_r2r_dac.hpp:28
        I(cpphdl_n844, cpphdl_n855) <+ V(cpphdl_n844, cpphdl_n855) / 20000.0;
        // device 626, IC IC94, analog/basic/mos_r2r_dac.hpp:29
        I(cpphdl_n855, Vss) <+ 2.9999999999999998e-15 * ddt(V(cpphdl_n855, Vss)); // Bench initial voltage = 0.0 V.
        // device 627, IC IC94, analog/basic/mos_r2r_dac.hpp:31
        I(cpphdl_n854, cpphdl_n855) <+ V(cpphdl_n854, cpphdl_n855) / 10000.0;
        // device 628, IC IC102, analog/basic/inverter.hpp:11
        I(cpphdl_n848, Vdd) <+ cpphdl_channel(V(BIT_N5_7, Vdd), V(cpphdl_n848, Vdd), 0.080000000000000002, 0.69999999999999996, -1.0);
        // device 629, IC IC102, analog/basic/inverter.hpp:12
        I(cpphdl_n848, Vss) <+ cpphdl_channel(V(BIT_N5_7, Vss), V(cpphdl_n848, Vss), 0.080000000000000002, 0.69999999999999996, 1.0);
        // device 630, IC IC94, analog/basic/mos_r2r_dac.hpp:27
        I(cpphdl_n848, Vss) <+ 2.9999999999999998e-15 * ddt(V(cpphdl_n848, Vss)); // Bench initial voltage = 0.0 V.
        // device 631, IC IC94, analog/basic/mos_r2r_dac.hpp:28
        I(cpphdl_n848, cpphdl_n860) <+ V(cpphdl_n848, cpphdl_n860) / 20000.0;
        // device 632, IC IC94, analog/basic/mos_r2r_dac.hpp:29
        I(cpphdl_n860, Vss) <+ 2.9999999999999998e-15 * ddt(V(cpphdl_n860, Vss)); // Bench initial voltage = 0.0 V.
        // device 633, IC IC94, analog/basic/mos_r2r_dac.hpp:31
        I(cpphdl_n855, cpphdl_n860) <+ V(cpphdl_n855, cpphdl_n860) / 10000.0;
        // device 634, IC IC94, analog/basic/mos_r2r_dac.hpp:33
        I(Vss, cpphdl_n849) <+ V(Vss, cpphdl_n849) / 20000.0;
        // device 635, IC IC103, analog/basic/nmos_resistor_amplifier.hpp:23
        I(Vdd, cpphdl_n869) <+ V(Vdd, cpphdl_n869) / 1000.0;
        // device 636, IC IC103, analog/basic/nmos_resistor_amplifier.hpp:24
        I(Vdd, cpphdl_n868) <+ V(Vdd, cpphdl_n868) / 1000.0;
        // device 637, IC IC103, analog/basic/nmos_resistor_amplifier.hpp:25
        I(cpphdl_n869, cpphdl_n863) <+ cpphdl_channel(V(cpphdl_n859, cpphdl_n863), V(cpphdl_n869, cpphdl_n863), 0.014999999999999999, 0.69999999999999996, 1.0);
        // device 638, IC IC103, analog/basic/nmos_resistor_amplifier.hpp:26
        I(cpphdl_n868, cpphdl_n864) <+ cpphdl_channel(V(cpphdl_n860, cpphdl_n864), V(cpphdl_n868, cpphdl_n864), 0.014999999999999999, 0.69999999999999996, 1.0);
        // device 639, IC IC103, analog/basic/nmos_resistor_amplifier.hpp:27
        I(cpphdl_n865, cpphdl_n863) <+ V(cpphdl_n865, cpphdl_n863) / 50.0;
        // device 640, IC IC103, analog/basic/nmos_resistor_amplifier.hpp:28
        I(cpphdl_n865, cpphdl_n864) <+ V(cpphdl_n865, cpphdl_n864) / 50.0;
        // device 641, IC IC103, analog/basic/nmos_resistor_amplifier.hpp:29
        I(Vss, cpphdl_n865) <+ V(Vss, cpphdl_n865) / 150.0;
        // device 642, IC IC103, analog/basic/nmos_resistor_amplifier.hpp:30
        I(cpphdl_n869, Vdd) <+ 2.9999999999999998e-13 * ddt(V(cpphdl_n869, Vdd)); // Bench initial voltage = 0.0 V.
        // device 643, IC IC103, analog/basic/nmos_resistor_amplifier.hpp:31
        I(cpphdl_n868, Vdd) <+ 2.9999999999999998e-13 * ddt(V(cpphdl_n868, Vdd)); // Bench initial voltage = 0.0 V.
        // device 644, IC IC103, analog/basic/nmos_resistor_amplifier.hpp:32
        I(cpphdl_n865, Vss) <+ 4e-14 * ddt(V(cpphdl_n865, Vss)); // Bench initial voltage = 0.0 V.
        // device 645, IC IC103, analog/basic/nmos_resistor_amplifier.hpp:34
        I(cpphdl_n859, cpphdl_n863) <+ 2e-14 * ddt(V(cpphdl_n859, cpphdl_n863)); // Bench initial voltage = 1.6499999999999999 V.
        // device 646, IC IC103, analog/basic/nmos_resistor_amplifier.hpp:35
        I(cpphdl_n860, cpphdl_n864) <+ 2e-14 * ddt(V(cpphdl_n860, cpphdl_n864)); // Bench initial voltage = 0.0 V.
        // device 647, IC IC103, analog/basic/nmos_resistor_amplifier.hpp:36
        I(cpphdl_n859, cpphdl_n869) <+ 2.9999999999999998e-15 * ddt(V(cpphdl_n859, cpphdl_n869)); // Bench initial voltage = -1.6499999999999999 V.
        // device 648, IC IC103, analog/basic/nmos_resistor_amplifier.hpp:37
        I(cpphdl_n860, cpphdl_n868) <+ 2.9999999999999998e-15 * ddt(V(cpphdl_n860, cpphdl_n868)); // Bench initial voltage = -3.2999999999999998 V.
        // device 649, IC IC104, analog/basic/strongarm_comparator.hpp:28
        I(cpphdl_n873, cpphdl_n875) <+ cpphdl_channel(V(cpphdl_n868, cpphdl_n875), V(cpphdl_n873, cpphdl_n875), 0.0080000000000000002, 0.69999999999999996, 1.0);
        // device 650, IC IC104, analog/basic/strongarm_comparator.hpp:29
        I(cpphdl_n874, cpphdl_n875) <+ cpphdl_channel(V(cpphdl_n869, cpphdl_n875), V(cpphdl_n874, cpphdl_n875), 0.0080000000000000002, 0.69999999999999996, 1.0);
        // device 651, IC IC104, analog/basic/strongarm_comparator.hpp:30
        I(cpphdl_n875, Vss) <+ cpphdl_channel(V(EVALUATE, Vss), V(cpphdl_n875, Vss), 0.0080000000000000002, 0.69999999999999996, 1.0);
        // device 652, IC IC104, analog/basic/strongarm_comparator.hpp:33
        I(cpphdl_n887, cpphdl_n873) <+ cpphdl_channel(V(cpphdl_n893, cpphdl_n873), V(cpphdl_n887, cpphdl_n873), 0.0040000000000000001, 0.69999999999999996, 1.0);
        // device 653, IC IC104, analog/basic/strongarm_comparator.hpp:34
        I(cpphdl_n893, cpphdl_n874) <+ cpphdl_channel(V(cpphdl_n887, cpphdl_n874), V(cpphdl_n893, cpphdl_n874), 0.0040000000000000001, 0.69999999999999996, 1.0);
        // device 654, IC IC104, analog/basic/strongarm_comparator.hpp:35
        I(cpphdl_n893, Vdd) <+ cpphdl_channel(V(cpphdl_n887, Vdd), V(cpphdl_n893, Vdd), 0.002, 0.69999999999999996, -1.0);
        // device 655, IC IC104, analog/basic/strongarm_comparator.hpp:36
        I(cpphdl_n887, Vdd) <+ cpphdl_channel(V(cpphdl_n893, Vdd), V(cpphdl_n887, Vdd), 0.002, 0.69999999999999996, -1.0);
        // device 656, IC IC104, analog/basic/strongarm_comparator.hpp:38
        I(cpphdl_n873, Vdd) <+ cpphdl_channel(V(EVALUATE, Vdd), V(cpphdl_n873, Vdd), 0.002, 0.69999999999999996, -1.0);
        // device 657, IC IC104, analog/basic/strongarm_comparator.hpp:39
        I(cpphdl_n874, Vdd) <+ cpphdl_channel(V(EVALUATE, Vdd), V(cpphdl_n874, Vdd), 0.002, 0.69999999999999996, -1.0);
        // device 658, IC IC104, analog/basic/strongarm_comparator.hpp:40
        I(cpphdl_n893, Vdd) <+ cpphdl_channel(V(EVALUATE, Vdd), V(cpphdl_n893, Vdd), 0.002, 0.69999999999999996, -1.0);
        // device 659, IC IC104, analog/basic/strongarm_comparator.hpp:41
        I(cpphdl_n887, Vdd) <+ cpphdl_channel(V(EVALUATE, Vdd), V(cpphdl_n887, Vdd), 0.002, 0.69999999999999996, -1.0);
        // device 660, IC IC104, analog/basic/strongarm_comparator.hpp:42
        I(cpphdl_n873, Vss) <+ 2.9999999999999998e-14 * ddt(V(cpphdl_n873, Vss)); // Bench initial voltage = 0.0 V.
        // device 661, IC IC104, analog/basic/strongarm_comparator.hpp:43
        I(cpphdl_n874, Vss) <+ 2.9999999999999998e-14 * ddt(V(cpphdl_n874, Vss)); // Bench initial voltage = 0.0 V.
        // device 662, IC IC104, analog/basic/strongarm_comparator.hpp:44
        I(cpphdl_n875, Vss) <+ 2.9999999999999998e-14 * ddt(V(cpphdl_n875, Vss)); // Bench initial voltage = 0.0 V.
        // device 663, IC IC104, analog/basic/strongarm_comparator.hpp:45
        I(cpphdl_n893, Vss) <+ 5.0000000000000002e-14 * ddt(V(cpphdl_n893, Vss)); // Bench initial voltage = 0.0 V.
        // device 664, IC IC104, analog/basic/strongarm_comparator.hpp:46
        I(cpphdl_n887, Vss) <+ 5.0000000000000002e-14 * ddt(V(cpphdl_n887, Vss)); // Bench initial voltage = 0.0 V.
        // device 665, IC IC104, analog/basic/strongarm_comparator.hpp:47
        I(cpphdl_n868, cpphdl_n875) <+ 2e-14 * ddt(V(cpphdl_n868, cpphdl_n875)); // Bench initial voltage = 3.2999999999999998 V.
        // device 666, IC IC104, analog/basic/strongarm_comparator.hpp:48
        I(cpphdl_n869, cpphdl_n875) <+ 2e-14 * ddt(V(cpphdl_n869, cpphdl_n875)); // Bench initial voltage = 3.2999999999999998 V.
        // device 667, IC IC104, analog/basic/strongarm_comparator.hpp:49
        I(cpphdl_n868, cpphdl_n873) <+ 2.9999999999999998e-15 * ddt(V(cpphdl_n868, cpphdl_n873)); // Bench initial voltage = 3.2999999999999998 V.
        // device 668, IC IC104, analog/basic/strongarm_comparator.hpp:50
        I(cpphdl_n869, cpphdl_n874) <+ 2.9999999999999998e-15 * ddt(V(cpphdl_n869, cpphdl_n874)); // Bench initial voltage = 3.2999999999999998 V.
        // device 669, IC IC106, analog/basic/cmos_logic.hpp:17
        I(DECISION5, Vss) <+ 5.0000000000000002e-14 * ddt(V(DECISION5, Vss)); // Bench initial voltage = 0.0 V.
        // device 670, IC IC106, analog/basic/cmos_logic.hpp:18
        I(DECISION5, Vdd) <+ cpphdl_channel(V(cpphdl_n887, Vdd), V(DECISION5, Vdd), 0.01, 0.69999999999999996, -1.0);
        // device 671, IC IC106, analog/basic/cmos_logic.hpp:19
        I(DECISION5, Vdd) <+ cpphdl_channel(V(DECISION_N5, Vdd), V(DECISION5, Vdd), 0.01, 0.69999999999999996, -1.0);
        // device 672, IC IC106, analog/basic/cmos_logic.hpp:20
        I(DECISION5, cpphdl_n890) <+ cpphdl_channel(V(cpphdl_n887, cpphdl_n890), V(DECISION5, cpphdl_n890), 0.01, 0.69999999999999996, 1.0);
        // device 673, IC IC106, analog/basic/cmos_logic.hpp:21
        I(cpphdl_n890, Vss) <+ cpphdl_channel(V(DECISION_N5, Vss), V(cpphdl_n890, Vss), 0.01, 0.69999999999999996, 1.0);
        // device 674, IC IC106, analog/basic/cmos_logic.hpp:23
        I(DECISION5, Vss) <+ V(DECISION5, Vss) / 1000000000.0;
        // device 675, IC IC106, analog/basic/cmos_logic.hpp:24
        I(cpphdl_n890, Vss) <+ V(cpphdl_n890, Vss) / 1000000000.0;
        // device 676, IC IC107, analog/basic/cmos_logic.hpp:17
        I(DECISION_N5, Vss) <+ 5.0000000000000002e-14 * ddt(V(DECISION_N5, Vss)); // Bench initial voltage = 0.0 V.
        // device 677, IC IC107, analog/basic/cmos_logic.hpp:18
        I(DECISION_N5, Vdd) <+ cpphdl_channel(V(cpphdl_n893, Vdd), V(DECISION_N5, Vdd), 0.01, 0.69999999999999996, -1.0);
        // device 678, IC IC107, analog/basic/cmos_logic.hpp:19
        I(DECISION_N5, Vdd) <+ cpphdl_channel(V(DECISION5, Vdd), V(DECISION_N5, Vdd), 0.01, 0.69999999999999996, -1.0);
        // device 679, IC IC107, analog/basic/cmos_logic.hpp:20
        I(DECISION_N5, cpphdl_n896) <+ cpphdl_channel(V(cpphdl_n893, cpphdl_n896), V(DECISION_N5, cpphdl_n896), 0.01, 0.69999999999999996, 1.0);
        // device 680, IC IC107, analog/basic/cmos_logic.hpp:21
        I(cpphdl_n896, Vss) <+ cpphdl_channel(V(DECISION5, Vss), V(cpphdl_n896, Vss), 0.01, 0.69999999999999996, 1.0);
        // device 681, IC IC107, analog/basic/cmos_logic.hpp:23
        I(DECISION_N5, Vss) <+ V(DECISION_N5, Vss) / 1000000000.0;
        // device 682, IC IC107, analog/basic/cmos_logic.hpp:24
        I(cpphdl_n896, Vss) <+ V(cpphdl_n896, Vss) / 1000000000.0;
        // device 683, IC IC105, analog/basic/nand_latch.hpp:36
        I(cpphdl_n887, Vss) <+ 2.9999999999999998e-15 * ddt(V(cpphdl_n887, Vss)); // Bench initial voltage = 0.0 V.
        // device 684, IC IC105, analog/basic/nand_latch.hpp:37
        I(cpphdl_n893, Vss) <+ 2.9999999999999998e-15 * ddt(V(cpphdl_n893, Vss)); // Bench initial voltage = 0.0 V.
        // device 685, IC IC108, analog/basic/inverter.hpp:11
        I(cpphdl_n901, Vdd) <+ cpphdl_channel(V(CLEAR, Vdd), V(cpphdl_n901, Vdd), 0.01, 0.69999999999999996, -1.0);
        // device 686, IC IC108, analog/basic/inverter.hpp:12
        I(cpphdl_n901, Vss) <+ cpphdl_channel(V(CLEAR, Vss), V(cpphdl_n901, Vss), 0.01, 0.69999999999999996, 1.0);
        // device 687, IC IC105, analog/basic/nand_latch.hpp:58
        I(cpphdl_n901, Vss) <+ 2.9999999999999998e-15 * ddt(V(cpphdl_n901, Vss)); // Bench initial voltage = 0.0 V.
        // device 688, IC IC105, analog/basic/nand_latch.hpp:59
        I(DECISION5, Vss) <+ cpphdl_channel(V(CLEAR, Vss), V(DECISION5, Vss), 0.050000000000000003, 0.69999999999999996, 1.0);
        // device 689, IC IC105, analog/basic/nand_latch.hpp:60
        I(DECISION_N5, Vdd) <+ cpphdl_channel(V(cpphdl_n901, Vdd), V(DECISION_N5, Vdd), 0.050000000000000003, 0.69999999999999996, -1.0);
        // device 690, IC IC111, analog/basic/inverter.hpp:11
        I(cpphdl_n925, Vdd) <+ cpphdl_channel(V(TRACK6, Vdd), V(cpphdl_n925, Vdd), 0.0040000000000000001, 0.69999999999999996, -1.0);
        // device 691, IC IC111, analog/basic/inverter.hpp:12
        I(cpphdl_n925, Vss) <+ cpphdl_channel(V(TRACK6, Vss), V(cpphdl_n925, Vss), 0.0040000000000000001, 0.69999999999999996, 1.0);
        // device 692, IC IC110, analog/basic/mos_track_hold.hpp:31
        I(cpphdl_n925, Vss) <+ 2e-14 * ddt(V(cpphdl_n925, Vss)); // Bench initial voltage = 3.2999999999999998 V.
        // device 693, IC IC110, analog/basic/mos_track_hold.hpp:32
        I(IN, cpphdl_n979) <+ cpphdl_channel(V(TRACK6, cpphdl_n979), V(IN, cpphdl_n979), 0.080000000000000002, 0.69999999999999996, 1.0);
        // device 694, IC IC110, analog/basic/mos_track_hold.hpp:33
        I(cpphdl_n979, IN) <+ cpphdl_channel(V(cpphdl_n925, IN), V(cpphdl_n979, IN), 0.040000000000000001, 0.69999999999999996, -1.0);
        // device 695, IC IC110, analog/basic/mos_track_hold.hpp:37
        I(cpphdl_n979, cpphdl_n979) <+ cpphdl_channel(V(cpphdl_n925, cpphdl_n979), V(cpphdl_n979, cpphdl_n979), 0.040000000000000001, 0.69999999999999996, 1.0);
        // device 696, IC IC110, analog/basic/mos_track_hold.hpp:38
        I(cpphdl_n979, cpphdl_n979) <+ cpphdl_channel(V(TRACK6, cpphdl_n979), V(cpphdl_n979, cpphdl_n979), 0.02, 0.69999999999999996, -1.0);
        // device 697, IC IC110, analog/basic/mos_track_hold.hpp:39
        I(cpphdl_n979, Vss) <+ 2e-12 * ddt(V(cpphdl_n979, Vss)); // Bench initial voltage = 1.6499999999999999 V.
        // device 698, IC IC110, analog/basic/mos_track_hold.hpp:41
        I(Vss, cpphdl_n979) <+ V(Vss, cpphdl_n979) / 1000000000.0;
        // device 699, IC IC110, analog/basic/mos_track_hold.hpp:42
        I(TRACK6, cpphdl_n979) <+ 8.0000000000000006e-15 * ddt(V(TRACK6, cpphdl_n979)); // Bench initial voltage = -1.6499999999999999 V.
        // device 700, IC IC110, analog/basic/mos_track_hold.hpp:43
        I(cpphdl_n925, cpphdl_n979) <+ 8.0000000000000006e-15 * ddt(V(cpphdl_n925, cpphdl_n979)); // Bench initial voltage = 1.6499999999999999 V.
        // device 701, IC IC110, analog/basic/mos_track_hold.hpp:44
        I(IN, cpphdl_n979) <+ 4.0000000000000003e-15 * ddt(V(IN, cpphdl_n979)); // Bench initial voltage = 0.0 V.
        // device 702, IC IC113, analog/basic/inverter.hpp:11
        I(cpphdl_n940, Vdd) <+ cpphdl_channel(V(BIT_N6_0, Vdd), V(cpphdl_n940, Vdd), 0.080000000000000002, 0.69999999999999996, -1.0);
        // device 703, IC IC113, analog/basic/inverter.hpp:12
        I(cpphdl_n940, Vss) <+ cpphdl_channel(V(BIT_N6_0, Vss), V(cpphdl_n940, Vss), 0.080000000000000002, 0.69999999999999996, 1.0);
        // device 704, IC IC112, analog/basic/mos_r2r_dac.hpp:27
        I(cpphdl_n940, Vss) <+ 2.9999999999999998e-15 * ddt(V(cpphdl_n940, Vss)); // Bench initial voltage = 0.0 V.
        // device 705, IC IC112, analog/basic/mos_r2r_dac.hpp:28
        I(cpphdl_n940, cpphdl_n969) <+ V(cpphdl_n940, cpphdl_n969) / 20000.0;
        // device 706, IC IC112, analog/basic/mos_r2r_dac.hpp:29
        I(cpphdl_n969, Vss) <+ 2.9999999999999998e-15 * ddt(V(cpphdl_n969, Vss)); // Bench initial voltage = 0.0 V.
        // device 707, IC IC114, analog/basic/inverter.hpp:11
        I(cpphdl_n944, Vdd) <+ cpphdl_channel(V(BIT_N6_1, Vdd), V(cpphdl_n944, Vdd), 0.080000000000000002, 0.69999999999999996, -1.0);
        // device 708, IC IC114, analog/basic/inverter.hpp:12
        I(cpphdl_n944, Vss) <+ cpphdl_channel(V(BIT_N6_1, Vss), V(cpphdl_n944, Vss), 0.080000000000000002, 0.69999999999999996, 1.0);
        // device 709, IC IC112, analog/basic/mos_r2r_dac.hpp:27
        I(cpphdl_n944, Vss) <+ 2.9999999999999998e-15 * ddt(V(cpphdl_n944, Vss)); // Bench initial voltage = 0.0 V.
        // device 710, IC IC112, analog/basic/mos_r2r_dac.hpp:28
        I(cpphdl_n944, cpphdl_n970) <+ V(cpphdl_n944, cpphdl_n970) / 20000.0;
        // device 711, IC IC112, analog/basic/mos_r2r_dac.hpp:29
        I(cpphdl_n970, Vss) <+ 2.9999999999999998e-15 * ddt(V(cpphdl_n970, Vss)); // Bench initial voltage = 0.0 V.
        // device 712, IC IC112, analog/basic/mos_r2r_dac.hpp:31
        I(cpphdl_n969, cpphdl_n970) <+ V(cpphdl_n969, cpphdl_n970) / 10000.0;
        // device 713, IC IC115, analog/basic/inverter.hpp:11
        I(cpphdl_n948, Vdd) <+ cpphdl_channel(V(BIT_N6_2, Vdd), V(cpphdl_n948, Vdd), 0.080000000000000002, 0.69999999999999996, -1.0);
        // device 714, IC IC115, analog/basic/inverter.hpp:12
        I(cpphdl_n948, Vss) <+ cpphdl_channel(V(BIT_N6_2, Vss), V(cpphdl_n948, Vss), 0.080000000000000002, 0.69999999999999996, 1.0);
        // device 715, IC IC112, analog/basic/mos_r2r_dac.hpp:27
        I(cpphdl_n948, Vss) <+ 2.9999999999999998e-15 * ddt(V(cpphdl_n948, Vss)); // Bench initial voltage = 0.0 V.
        // device 716, IC IC112, analog/basic/mos_r2r_dac.hpp:28
        I(cpphdl_n948, cpphdl_n971) <+ V(cpphdl_n948, cpphdl_n971) / 20000.0;
        // device 717, IC IC112, analog/basic/mos_r2r_dac.hpp:29
        I(cpphdl_n971, Vss) <+ 2.9999999999999998e-15 * ddt(V(cpphdl_n971, Vss)); // Bench initial voltage = 0.0 V.
        // device 718, IC IC112, analog/basic/mos_r2r_dac.hpp:31
        I(cpphdl_n970, cpphdl_n971) <+ V(cpphdl_n970, cpphdl_n971) / 10000.0;
        // device 719, IC IC116, analog/basic/inverter.hpp:11
        I(cpphdl_n952, Vdd) <+ cpphdl_channel(V(BIT_N6_3, Vdd), V(cpphdl_n952, Vdd), 0.080000000000000002, 0.69999999999999996, -1.0);
        // device 720, IC IC116, analog/basic/inverter.hpp:12
        I(cpphdl_n952, Vss) <+ cpphdl_channel(V(BIT_N6_3, Vss), V(cpphdl_n952, Vss), 0.080000000000000002, 0.69999999999999996, 1.0);
        // device 721, IC IC112, analog/basic/mos_r2r_dac.hpp:27
        I(cpphdl_n952, Vss) <+ 2.9999999999999998e-15 * ddt(V(cpphdl_n952, Vss)); // Bench initial voltage = 0.0 V.
        // device 722, IC IC112, analog/basic/mos_r2r_dac.hpp:28
        I(cpphdl_n952, cpphdl_n972) <+ V(cpphdl_n952, cpphdl_n972) / 20000.0;
        // device 723, IC IC112, analog/basic/mos_r2r_dac.hpp:29
        I(cpphdl_n972, Vss) <+ 2.9999999999999998e-15 * ddt(V(cpphdl_n972, Vss)); // Bench initial voltage = 0.0 V.
        // device 724, IC IC112, analog/basic/mos_r2r_dac.hpp:31
        I(cpphdl_n971, cpphdl_n972) <+ V(cpphdl_n971, cpphdl_n972) / 10000.0;
        // device 725, IC IC117, analog/basic/inverter.hpp:11
        I(cpphdl_n956, Vdd) <+ cpphdl_channel(V(BIT_N6_4, Vdd), V(cpphdl_n956, Vdd), 0.080000000000000002, 0.69999999999999996, -1.0);
        // device 726, IC IC117, analog/basic/inverter.hpp:12
        I(cpphdl_n956, Vss) <+ cpphdl_channel(V(BIT_N6_4, Vss), V(cpphdl_n956, Vss), 0.080000000000000002, 0.69999999999999996, 1.0);
        // device 727, IC IC112, analog/basic/mos_r2r_dac.hpp:27
        I(cpphdl_n956, Vss) <+ 2.9999999999999998e-15 * ddt(V(cpphdl_n956, Vss)); // Bench initial voltage = 0.0 V.
        // device 728, IC IC112, analog/basic/mos_r2r_dac.hpp:28
        I(cpphdl_n956, cpphdl_n973) <+ V(cpphdl_n956, cpphdl_n973) / 20000.0;
        // device 729, IC IC112, analog/basic/mos_r2r_dac.hpp:29
        I(cpphdl_n973, Vss) <+ 2.9999999999999998e-15 * ddt(V(cpphdl_n973, Vss)); // Bench initial voltage = 0.0 V.
        // device 730, IC IC112, analog/basic/mos_r2r_dac.hpp:31
        I(cpphdl_n972, cpphdl_n973) <+ V(cpphdl_n972, cpphdl_n973) / 10000.0;
        // device 731, IC IC118, analog/basic/inverter.hpp:11
        I(cpphdl_n960, Vdd) <+ cpphdl_channel(V(BIT_N6_5, Vdd), V(cpphdl_n960, Vdd), 0.080000000000000002, 0.69999999999999996, -1.0);
        // device 732, IC IC118, analog/basic/inverter.hpp:12
        I(cpphdl_n960, Vss) <+ cpphdl_channel(V(BIT_N6_5, Vss), V(cpphdl_n960, Vss), 0.080000000000000002, 0.69999999999999996, 1.0);
        // device 733, IC IC112, analog/basic/mos_r2r_dac.hpp:27
        I(cpphdl_n960, Vss) <+ 2.9999999999999998e-15 * ddt(V(cpphdl_n960, Vss)); // Bench initial voltage = 0.0 V.
        // device 734, IC IC112, analog/basic/mos_r2r_dac.hpp:28
        I(cpphdl_n960, cpphdl_n974) <+ V(cpphdl_n960, cpphdl_n974) / 20000.0;
        // device 735, IC IC112, analog/basic/mos_r2r_dac.hpp:29
        I(cpphdl_n974, Vss) <+ 2.9999999999999998e-15 * ddt(V(cpphdl_n974, Vss)); // Bench initial voltage = 0.0 V.
        // device 736, IC IC112, analog/basic/mos_r2r_dac.hpp:31
        I(cpphdl_n973, cpphdl_n974) <+ V(cpphdl_n973, cpphdl_n974) / 10000.0;
        // device 737, IC IC119, analog/basic/inverter.hpp:11
        I(cpphdl_n964, Vdd) <+ cpphdl_channel(V(BIT_N6_6, Vdd), V(cpphdl_n964, Vdd), 0.080000000000000002, 0.69999999999999996, -1.0);
        // device 738, IC IC119, analog/basic/inverter.hpp:12
        I(cpphdl_n964, Vss) <+ cpphdl_channel(V(BIT_N6_6, Vss), V(cpphdl_n964, Vss), 0.080000000000000002, 0.69999999999999996, 1.0);
        // device 739, IC IC112, analog/basic/mos_r2r_dac.hpp:27
        I(cpphdl_n964, Vss) <+ 2.9999999999999998e-15 * ddt(V(cpphdl_n964, Vss)); // Bench initial voltage = 0.0 V.
        // device 740, IC IC112, analog/basic/mos_r2r_dac.hpp:28
        I(cpphdl_n964, cpphdl_n975) <+ V(cpphdl_n964, cpphdl_n975) / 20000.0;
        // device 741, IC IC112, analog/basic/mos_r2r_dac.hpp:29
        I(cpphdl_n975, Vss) <+ 2.9999999999999998e-15 * ddt(V(cpphdl_n975, Vss)); // Bench initial voltage = 0.0 V.
        // device 742, IC IC112, analog/basic/mos_r2r_dac.hpp:31
        I(cpphdl_n974, cpphdl_n975) <+ V(cpphdl_n974, cpphdl_n975) / 10000.0;
        // device 743, IC IC120, analog/basic/inverter.hpp:11
        I(cpphdl_n968, Vdd) <+ cpphdl_channel(V(BIT_N6_7, Vdd), V(cpphdl_n968, Vdd), 0.080000000000000002, 0.69999999999999996, -1.0);
        // device 744, IC IC120, analog/basic/inverter.hpp:12
        I(cpphdl_n968, Vss) <+ cpphdl_channel(V(BIT_N6_7, Vss), V(cpphdl_n968, Vss), 0.080000000000000002, 0.69999999999999996, 1.0);
        // device 745, IC IC112, analog/basic/mos_r2r_dac.hpp:27
        I(cpphdl_n968, Vss) <+ 2.9999999999999998e-15 * ddt(V(cpphdl_n968, Vss)); // Bench initial voltage = 0.0 V.
        // device 746, IC IC112, analog/basic/mos_r2r_dac.hpp:28
        I(cpphdl_n968, cpphdl_n980) <+ V(cpphdl_n968, cpphdl_n980) / 20000.0;
        // device 747, IC IC112, analog/basic/mos_r2r_dac.hpp:29
        I(cpphdl_n980, Vss) <+ 2.9999999999999998e-15 * ddt(V(cpphdl_n980, Vss)); // Bench initial voltage = 0.0 V.
        // device 748, IC IC112, analog/basic/mos_r2r_dac.hpp:31
        I(cpphdl_n975, cpphdl_n980) <+ V(cpphdl_n975, cpphdl_n980) / 10000.0;
        // device 749, IC IC112, analog/basic/mos_r2r_dac.hpp:33
        I(Vss, cpphdl_n969) <+ V(Vss, cpphdl_n969) / 20000.0;
        // device 750, IC IC121, analog/basic/nmos_resistor_amplifier.hpp:23
        I(Vdd, cpphdl_n989) <+ V(Vdd, cpphdl_n989) / 1000.0;
        // device 751, IC IC121, analog/basic/nmos_resistor_amplifier.hpp:24
        I(Vdd, cpphdl_n988) <+ V(Vdd, cpphdl_n988) / 1000.0;
        // device 752, IC IC121, analog/basic/nmos_resistor_amplifier.hpp:25
        I(cpphdl_n989, cpphdl_n983) <+ cpphdl_channel(V(cpphdl_n979, cpphdl_n983), V(cpphdl_n989, cpphdl_n983), 0.014999999999999999, 0.69999999999999996, 1.0);
        // device 753, IC IC121, analog/basic/nmos_resistor_amplifier.hpp:26
        I(cpphdl_n988, cpphdl_n984) <+ cpphdl_channel(V(cpphdl_n980, cpphdl_n984), V(cpphdl_n988, cpphdl_n984), 0.014999999999999999, 0.69999999999999996, 1.0);
        // device 754, IC IC121, analog/basic/nmos_resistor_amplifier.hpp:27
        I(cpphdl_n985, cpphdl_n983) <+ V(cpphdl_n985, cpphdl_n983) / 50.0;
        // device 755, IC IC121, analog/basic/nmos_resistor_amplifier.hpp:28
        I(cpphdl_n985, cpphdl_n984) <+ V(cpphdl_n985, cpphdl_n984) / 50.0;
        // device 756, IC IC121, analog/basic/nmos_resistor_amplifier.hpp:29
        I(Vss, cpphdl_n985) <+ V(Vss, cpphdl_n985) / 150.0;
        // device 757, IC IC121, analog/basic/nmos_resistor_amplifier.hpp:30
        I(cpphdl_n989, Vdd) <+ 2.9999999999999998e-13 * ddt(V(cpphdl_n989, Vdd)); // Bench initial voltage = 0.0 V.
        // device 758, IC IC121, analog/basic/nmos_resistor_amplifier.hpp:31
        I(cpphdl_n988, Vdd) <+ 2.9999999999999998e-13 * ddt(V(cpphdl_n988, Vdd)); // Bench initial voltage = 0.0 V.
        // device 759, IC IC121, analog/basic/nmos_resistor_amplifier.hpp:32
        I(cpphdl_n985, Vss) <+ 4e-14 * ddt(V(cpphdl_n985, Vss)); // Bench initial voltage = 0.0 V.
        // device 760, IC IC121, analog/basic/nmos_resistor_amplifier.hpp:34
        I(cpphdl_n979, cpphdl_n983) <+ 2e-14 * ddt(V(cpphdl_n979, cpphdl_n983)); // Bench initial voltage = 1.6499999999999999 V.
        // device 761, IC IC121, analog/basic/nmos_resistor_amplifier.hpp:35
        I(cpphdl_n980, cpphdl_n984) <+ 2e-14 * ddt(V(cpphdl_n980, cpphdl_n984)); // Bench initial voltage = 0.0 V.
        // device 762, IC IC121, analog/basic/nmos_resistor_amplifier.hpp:36
        I(cpphdl_n979, cpphdl_n989) <+ 2.9999999999999998e-15 * ddt(V(cpphdl_n979, cpphdl_n989)); // Bench initial voltage = -1.6499999999999999 V.
        // device 763, IC IC121, analog/basic/nmos_resistor_amplifier.hpp:37
        I(cpphdl_n980, cpphdl_n988) <+ 2.9999999999999998e-15 * ddt(V(cpphdl_n980, cpphdl_n988)); // Bench initial voltage = -3.2999999999999998 V.
        // device 764, IC IC122, analog/basic/strongarm_comparator.hpp:28
        I(cpphdl_n993, cpphdl_n995) <+ cpphdl_channel(V(cpphdl_n988, cpphdl_n995), V(cpphdl_n993, cpphdl_n995), 0.0080000000000000002, 0.69999999999999996, 1.0);
        // device 765, IC IC122, analog/basic/strongarm_comparator.hpp:29
        I(cpphdl_n994, cpphdl_n995) <+ cpphdl_channel(V(cpphdl_n989, cpphdl_n995), V(cpphdl_n994, cpphdl_n995), 0.0080000000000000002, 0.69999999999999996, 1.0);
        // device 766, IC IC122, analog/basic/strongarm_comparator.hpp:30
        I(cpphdl_n995, Vss) <+ cpphdl_channel(V(EVALUATE, Vss), V(cpphdl_n995, Vss), 0.0080000000000000002, 0.69999999999999996, 1.0);
        // device 767, IC IC122, analog/basic/strongarm_comparator.hpp:33
        I(cpphdl_n1007, cpphdl_n993) <+ cpphdl_channel(V(cpphdl_n1013, cpphdl_n993), V(cpphdl_n1007, cpphdl_n993), 0.0040000000000000001, 0.69999999999999996, 1.0);
        // device 768, IC IC122, analog/basic/strongarm_comparator.hpp:34
        I(cpphdl_n1013, cpphdl_n994) <+ cpphdl_channel(V(cpphdl_n1007, cpphdl_n994), V(cpphdl_n1013, cpphdl_n994), 0.0040000000000000001, 0.69999999999999996, 1.0);
        // device 769, IC IC122, analog/basic/strongarm_comparator.hpp:35
        I(cpphdl_n1013, Vdd) <+ cpphdl_channel(V(cpphdl_n1007, Vdd), V(cpphdl_n1013, Vdd), 0.002, 0.69999999999999996, -1.0);
        // device 770, IC IC122, analog/basic/strongarm_comparator.hpp:36
        I(cpphdl_n1007, Vdd) <+ cpphdl_channel(V(cpphdl_n1013, Vdd), V(cpphdl_n1007, Vdd), 0.002, 0.69999999999999996, -1.0);
        // device 771, IC IC122, analog/basic/strongarm_comparator.hpp:38
        I(cpphdl_n993, Vdd) <+ cpphdl_channel(V(EVALUATE, Vdd), V(cpphdl_n993, Vdd), 0.002, 0.69999999999999996, -1.0);
        // device 772, IC IC122, analog/basic/strongarm_comparator.hpp:39
        I(cpphdl_n994, Vdd) <+ cpphdl_channel(V(EVALUATE, Vdd), V(cpphdl_n994, Vdd), 0.002, 0.69999999999999996, -1.0);
        // device 773, IC IC122, analog/basic/strongarm_comparator.hpp:40
        I(cpphdl_n1013, Vdd) <+ cpphdl_channel(V(EVALUATE, Vdd), V(cpphdl_n1013, Vdd), 0.002, 0.69999999999999996, -1.0);
        // device 774, IC IC122, analog/basic/strongarm_comparator.hpp:41
        I(cpphdl_n1007, Vdd) <+ cpphdl_channel(V(EVALUATE, Vdd), V(cpphdl_n1007, Vdd), 0.002, 0.69999999999999996, -1.0);
        // device 775, IC IC122, analog/basic/strongarm_comparator.hpp:42
        I(cpphdl_n993, Vss) <+ 2.9999999999999998e-14 * ddt(V(cpphdl_n993, Vss)); // Bench initial voltage = 0.0 V.
        // device 776, IC IC122, analog/basic/strongarm_comparator.hpp:43
        I(cpphdl_n994, Vss) <+ 2.9999999999999998e-14 * ddt(V(cpphdl_n994, Vss)); // Bench initial voltage = 0.0 V.
        // device 777, IC IC122, analog/basic/strongarm_comparator.hpp:44
        I(cpphdl_n995, Vss) <+ 2.9999999999999998e-14 * ddt(V(cpphdl_n995, Vss)); // Bench initial voltage = 0.0 V.
        // device 778, IC IC122, analog/basic/strongarm_comparator.hpp:45
        I(cpphdl_n1013, Vss) <+ 5.0000000000000002e-14 * ddt(V(cpphdl_n1013, Vss)); // Bench initial voltage = 0.0 V.
        // device 779, IC IC122, analog/basic/strongarm_comparator.hpp:46
        I(cpphdl_n1007, Vss) <+ 5.0000000000000002e-14 * ddt(V(cpphdl_n1007, Vss)); // Bench initial voltage = 0.0 V.
        // device 780, IC IC122, analog/basic/strongarm_comparator.hpp:47
        I(cpphdl_n988, cpphdl_n995) <+ 2e-14 * ddt(V(cpphdl_n988, cpphdl_n995)); // Bench initial voltage = 3.2999999999999998 V.
        // device 781, IC IC122, analog/basic/strongarm_comparator.hpp:48
        I(cpphdl_n989, cpphdl_n995) <+ 2e-14 * ddt(V(cpphdl_n989, cpphdl_n995)); // Bench initial voltage = 3.2999999999999998 V.
        // device 782, IC IC122, analog/basic/strongarm_comparator.hpp:49
        I(cpphdl_n988, cpphdl_n993) <+ 2.9999999999999998e-15 * ddt(V(cpphdl_n988, cpphdl_n993)); // Bench initial voltage = 3.2999999999999998 V.
        // device 783, IC IC122, analog/basic/strongarm_comparator.hpp:50
        I(cpphdl_n989, cpphdl_n994) <+ 2.9999999999999998e-15 * ddt(V(cpphdl_n989, cpphdl_n994)); // Bench initial voltage = 3.2999999999999998 V.
        // device 784, IC IC124, analog/basic/cmos_logic.hpp:17
        I(DECISION6, Vss) <+ 5.0000000000000002e-14 * ddt(V(DECISION6, Vss)); // Bench initial voltage = 0.0 V.
        // device 785, IC IC124, analog/basic/cmos_logic.hpp:18
        I(DECISION6, Vdd) <+ cpphdl_channel(V(cpphdl_n1007, Vdd), V(DECISION6, Vdd), 0.01, 0.69999999999999996, -1.0);
        // device 786, IC IC124, analog/basic/cmos_logic.hpp:19
        I(DECISION6, Vdd) <+ cpphdl_channel(V(DECISION_N6, Vdd), V(DECISION6, Vdd), 0.01, 0.69999999999999996, -1.0);
        // device 787, IC IC124, analog/basic/cmos_logic.hpp:20
        I(DECISION6, cpphdl_n1010) <+ cpphdl_channel(V(cpphdl_n1007, cpphdl_n1010), V(DECISION6, cpphdl_n1010), 0.01, 0.69999999999999996, 1.0);
        // device 788, IC IC124, analog/basic/cmos_logic.hpp:21
        I(cpphdl_n1010, Vss) <+ cpphdl_channel(V(DECISION_N6, Vss), V(cpphdl_n1010, Vss), 0.01, 0.69999999999999996, 1.0);
        // device 789, IC IC124, analog/basic/cmos_logic.hpp:23
        I(DECISION6, Vss) <+ V(DECISION6, Vss) / 1000000000.0;
        // device 790, IC IC124, analog/basic/cmos_logic.hpp:24
        I(cpphdl_n1010, Vss) <+ V(cpphdl_n1010, Vss) / 1000000000.0;
        // device 791, IC IC125, analog/basic/cmos_logic.hpp:17
        I(DECISION_N6, Vss) <+ 5.0000000000000002e-14 * ddt(V(DECISION_N6, Vss)); // Bench initial voltage = 0.0 V.
        // device 792, IC IC125, analog/basic/cmos_logic.hpp:18
        I(DECISION_N6, Vdd) <+ cpphdl_channel(V(cpphdl_n1013, Vdd), V(DECISION_N6, Vdd), 0.01, 0.69999999999999996, -1.0);
        // device 793, IC IC125, analog/basic/cmos_logic.hpp:19
        I(DECISION_N6, Vdd) <+ cpphdl_channel(V(DECISION6, Vdd), V(DECISION_N6, Vdd), 0.01, 0.69999999999999996, -1.0);
        // device 794, IC IC125, analog/basic/cmos_logic.hpp:20
        I(DECISION_N6, cpphdl_n1016) <+ cpphdl_channel(V(cpphdl_n1013, cpphdl_n1016), V(DECISION_N6, cpphdl_n1016), 0.01, 0.69999999999999996, 1.0);
        // device 795, IC IC125, analog/basic/cmos_logic.hpp:21
        I(cpphdl_n1016, Vss) <+ cpphdl_channel(V(DECISION6, Vss), V(cpphdl_n1016, Vss), 0.01, 0.69999999999999996, 1.0);
        // device 796, IC IC125, analog/basic/cmos_logic.hpp:23
        I(DECISION_N6, Vss) <+ V(DECISION_N6, Vss) / 1000000000.0;
        // device 797, IC IC125, analog/basic/cmos_logic.hpp:24
        I(cpphdl_n1016, Vss) <+ V(cpphdl_n1016, Vss) / 1000000000.0;
        // device 798, IC IC123, analog/basic/nand_latch.hpp:36
        I(cpphdl_n1007, Vss) <+ 2.9999999999999998e-15 * ddt(V(cpphdl_n1007, Vss)); // Bench initial voltage = 0.0 V.
        // device 799, IC IC123, analog/basic/nand_latch.hpp:37
        I(cpphdl_n1013, Vss) <+ 2.9999999999999998e-15 * ddt(V(cpphdl_n1013, Vss)); // Bench initial voltage = 0.0 V.
        // device 800, IC IC126, analog/basic/inverter.hpp:11
        I(cpphdl_n1021, Vdd) <+ cpphdl_channel(V(CLEAR, Vdd), V(cpphdl_n1021, Vdd), 0.01, 0.69999999999999996, -1.0);
        // device 801, IC IC126, analog/basic/inverter.hpp:12
        I(cpphdl_n1021, Vss) <+ cpphdl_channel(V(CLEAR, Vss), V(cpphdl_n1021, Vss), 0.01, 0.69999999999999996, 1.0);
        // device 802, IC IC123, analog/basic/nand_latch.hpp:58
        I(cpphdl_n1021, Vss) <+ 2.9999999999999998e-15 * ddt(V(cpphdl_n1021, Vss)); // Bench initial voltage = 0.0 V.
        // device 803, IC IC123, analog/basic/nand_latch.hpp:59
        I(DECISION6, Vss) <+ cpphdl_channel(V(CLEAR, Vss), V(DECISION6, Vss), 0.050000000000000003, 0.69999999999999996, 1.0);
        // device 804, IC IC123, analog/basic/nand_latch.hpp:60
        I(DECISION_N6, Vdd) <+ cpphdl_channel(V(cpphdl_n1021, Vdd), V(DECISION_N6, Vdd), 0.050000000000000003, 0.69999999999999996, -1.0);
        // device 805, IC IC129, analog/basic/inverter.hpp:11
        I(cpphdl_n1045, Vdd) <+ cpphdl_channel(V(TRACK7, Vdd), V(cpphdl_n1045, Vdd), 0.0040000000000000001, 0.69999999999999996, -1.0);
        // device 806, IC IC129, analog/basic/inverter.hpp:12
        I(cpphdl_n1045, Vss) <+ cpphdl_channel(V(TRACK7, Vss), V(cpphdl_n1045, Vss), 0.0040000000000000001, 0.69999999999999996, 1.0);
        // device 807, IC IC128, analog/basic/mos_track_hold.hpp:31
        I(cpphdl_n1045, Vss) <+ 2e-14 * ddt(V(cpphdl_n1045, Vss)); // Bench initial voltage = 3.2999999999999998 V.
        // device 808, IC IC128, analog/basic/mos_track_hold.hpp:32
        I(IN, cpphdl_n1099) <+ cpphdl_channel(V(TRACK7, cpphdl_n1099), V(IN, cpphdl_n1099), 0.080000000000000002, 0.69999999999999996, 1.0);
        // device 809, IC IC128, analog/basic/mos_track_hold.hpp:33
        I(cpphdl_n1099, IN) <+ cpphdl_channel(V(cpphdl_n1045, IN), V(cpphdl_n1099, IN), 0.040000000000000001, 0.69999999999999996, -1.0);
        // device 810, IC IC128, analog/basic/mos_track_hold.hpp:37
        I(cpphdl_n1099, cpphdl_n1099) <+ cpphdl_channel(V(cpphdl_n1045, cpphdl_n1099), V(cpphdl_n1099, cpphdl_n1099), 0.040000000000000001, 0.69999999999999996, 1.0);
        // device 811, IC IC128, analog/basic/mos_track_hold.hpp:38
        I(cpphdl_n1099, cpphdl_n1099) <+ cpphdl_channel(V(TRACK7, cpphdl_n1099), V(cpphdl_n1099, cpphdl_n1099), 0.02, 0.69999999999999996, -1.0);
        // device 812, IC IC128, analog/basic/mos_track_hold.hpp:39
        I(cpphdl_n1099, Vss) <+ 2e-12 * ddt(V(cpphdl_n1099, Vss)); // Bench initial voltage = 1.6499999999999999 V.
        // device 813, IC IC128, analog/basic/mos_track_hold.hpp:41
        I(Vss, cpphdl_n1099) <+ V(Vss, cpphdl_n1099) / 1000000000.0;
        // device 814, IC IC128, analog/basic/mos_track_hold.hpp:42
        I(TRACK7, cpphdl_n1099) <+ 8.0000000000000006e-15 * ddt(V(TRACK7, cpphdl_n1099)); // Bench initial voltage = -1.6499999999999999 V.
        // device 815, IC IC128, analog/basic/mos_track_hold.hpp:43
        I(cpphdl_n1045, cpphdl_n1099) <+ 8.0000000000000006e-15 * ddt(V(cpphdl_n1045, cpphdl_n1099)); // Bench initial voltage = 1.6499999999999999 V.
        // device 816, IC IC128, analog/basic/mos_track_hold.hpp:44
        I(IN, cpphdl_n1099) <+ 4.0000000000000003e-15 * ddt(V(IN, cpphdl_n1099)); // Bench initial voltage = 0.0 V.
        // device 817, IC IC131, analog/basic/inverter.hpp:11
        I(cpphdl_n1060, Vdd) <+ cpphdl_channel(V(BIT_N7_0, Vdd), V(cpphdl_n1060, Vdd), 0.080000000000000002, 0.69999999999999996, -1.0);
        // device 818, IC IC131, analog/basic/inverter.hpp:12
        I(cpphdl_n1060, Vss) <+ cpphdl_channel(V(BIT_N7_0, Vss), V(cpphdl_n1060, Vss), 0.080000000000000002, 0.69999999999999996, 1.0);
        // device 819, IC IC130, analog/basic/mos_r2r_dac.hpp:27
        I(cpphdl_n1060, Vss) <+ 2.9999999999999998e-15 * ddt(V(cpphdl_n1060, Vss)); // Bench initial voltage = 0.0 V.
        // device 820, IC IC130, analog/basic/mos_r2r_dac.hpp:28
        I(cpphdl_n1060, cpphdl_n1089) <+ V(cpphdl_n1060, cpphdl_n1089) / 20000.0;
        // device 821, IC IC130, analog/basic/mos_r2r_dac.hpp:29
        I(cpphdl_n1089, Vss) <+ 2.9999999999999998e-15 * ddt(V(cpphdl_n1089, Vss)); // Bench initial voltage = 0.0 V.
        // device 822, IC IC132, analog/basic/inverter.hpp:11
        I(cpphdl_n1064, Vdd) <+ cpphdl_channel(V(BIT_N7_1, Vdd), V(cpphdl_n1064, Vdd), 0.080000000000000002, 0.69999999999999996, -1.0);
        // device 823, IC IC132, analog/basic/inverter.hpp:12
        I(cpphdl_n1064, Vss) <+ cpphdl_channel(V(BIT_N7_1, Vss), V(cpphdl_n1064, Vss), 0.080000000000000002, 0.69999999999999996, 1.0);
        // device 824, IC IC130, analog/basic/mos_r2r_dac.hpp:27
        I(cpphdl_n1064, Vss) <+ 2.9999999999999998e-15 * ddt(V(cpphdl_n1064, Vss)); // Bench initial voltage = 0.0 V.
        // device 825, IC IC130, analog/basic/mos_r2r_dac.hpp:28
        I(cpphdl_n1064, cpphdl_n1090) <+ V(cpphdl_n1064, cpphdl_n1090) / 20000.0;
        // device 826, IC IC130, analog/basic/mos_r2r_dac.hpp:29
        I(cpphdl_n1090, Vss) <+ 2.9999999999999998e-15 * ddt(V(cpphdl_n1090, Vss)); // Bench initial voltage = 0.0 V.
        // device 827, IC IC130, analog/basic/mos_r2r_dac.hpp:31
        I(cpphdl_n1089, cpphdl_n1090) <+ V(cpphdl_n1089, cpphdl_n1090) / 10000.0;
        // device 828, IC IC133, analog/basic/inverter.hpp:11
        I(cpphdl_n1068, Vdd) <+ cpphdl_channel(V(BIT_N7_2, Vdd), V(cpphdl_n1068, Vdd), 0.080000000000000002, 0.69999999999999996, -1.0);
        // device 829, IC IC133, analog/basic/inverter.hpp:12
        I(cpphdl_n1068, Vss) <+ cpphdl_channel(V(BIT_N7_2, Vss), V(cpphdl_n1068, Vss), 0.080000000000000002, 0.69999999999999996, 1.0);
        // device 830, IC IC130, analog/basic/mos_r2r_dac.hpp:27
        I(cpphdl_n1068, Vss) <+ 2.9999999999999998e-15 * ddt(V(cpphdl_n1068, Vss)); // Bench initial voltage = 0.0 V.
        // device 831, IC IC130, analog/basic/mos_r2r_dac.hpp:28
        I(cpphdl_n1068, cpphdl_n1091) <+ V(cpphdl_n1068, cpphdl_n1091) / 20000.0;
        // device 832, IC IC130, analog/basic/mos_r2r_dac.hpp:29
        I(cpphdl_n1091, Vss) <+ 2.9999999999999998e-15 * ddt(V(cpphdl_n1091, Vss)); // Bench initial voltage = 0.0 V.
        // device 833, IC IC130, analog/basic/mos_r2r_dac.hpp:31
        I(cpphdl_n1090, cpphdl_n1091) <+ V(cpphdl_n1090, cpphdl_n1091) / 10000.0;
        // device 834, IC IC134, analog/basic/inverter.hpp:11
        I(cpphdl_n1072, Vdd) <+ cpphdl_channel(V(BIT_N7_3, Vdd), V(cpphdl_n1072, Vdd), 0.080000000000000002, 0.69999999999999996, -1.0);
        // device 835, IC IC134, analog/basic/inverter.hpp:12
        I(cpphdl_n1072, Vss) <+ cpphdl_channel(V(BIT_N7_3, Vss), V(cpphdl_n1072, Vss), 0.080000000000000002, 0.69999999999999996, 1.0);
        // device 836, IC IC130, analog/basic/mos_r2r_dac.hpp:27
        I(cpphdl_n1072, Vss) <+ 2.9999999999999998e-15 * ddt(V(cpphdl_n1072, Vss)); // Bench initial voltage = 0.0 V.
        // device 837, IC IC130, analog/basic/mos_r2r_dac.hpp:28
        I(cpphdl_n1072, cpphdl_n1092) <+ V(cpphdl_n1072, cpphdl_n1092) / 20000.0;
        // device 838, IC IC130, analog/basic/mos_r2r_dac.hpp:29
        I(cpphdl_n1092, Vss) <+ 2.9999999999999998e-15 * ddt(V(cpphdl_n1092, Vss)); // Bench initial voltage = 0.0 V.
        // device 839, IC IC130, analog/basic/mos_r2r_dac.hpp:31
        I(cpphdl_n1091, cpphdl_n1092) <+ V(cpphdl_n1091, cpphdl_n1092) / 10000.0;
        // device 840, IC IC135, analog/basic/inverter.hpp:11
        I(cpphdl_n1076, Vdd) <+ cpphdl_channel(V(BIT_N7_4, Vdd), V(cpphdl_n1076, Vdd), 0.080000000000000002, 0.69999999999999996, -1.0);
        // device 841, IC IC135, analog/basic/inverter.hpp:12
        I(cpphdl_n1076, Vss) <+ cpphdl_channel(V(BIT_N7_4, Vss), V(cpphdl_n1076, Vss), 0.080000000000000002, 0.69999999999999996, 1.0);
        // device 842, IC IC130, analog/basic/mos_r2r_dac.hpp:27
        I(cpphdl_n1076, Vss) <+ 2.9999999999999998e-15 * ddt(V(cpphdl_n1076, Vss)); // Bench initial voltage = 0.0 V.
        // device 843, IC IC130, analog/basic/mos_r2r_dac.hpp:28
        I(cpphdl_n1076, cpphdl_n1093) <+ V(cpphdl_n1076, cpphdl_n1093) / 20000.0;
        // device 844, IC IC130, analog/basic/mos_r2r_dac.hpp:29
        I(cpphdl_n1093, Vss) <+ 2.9999999999999998e-15 * ddt(V(cpphdl_n1093, Vss)); // Bench initial voltage = 0.0 V.
        // device 845, IC IC130, analog/basic/mos_r2r_dac.hpp:31
        I(cpphdl_n1092, cpphdl_n1093) <+ V(cpphdl_n1092, cpphdl_n1093) / 10000.0;
        // device 846, IC IC136, analog/basic/inverter.hpp:11
        I(cpphdl_n1080, Vdd) <+ cpphdl_channel(V(BIT_N7_5, Vdd), V(cpphdl_n1080, Vdd), 0.080000000000000002, 0.69999999999999996, -1.0);
        // device 847, IC IC136, analog/basic/inverter.hpp:12
        I(cpphdl_n1080, Vss) <+ cpphdl_channel(V(BIT_N7_5, Vss), V(cpphdl_n1080, Vss), 0.080000000000000002, 0.69999999999999996, 1.0);
        // device 848, IC IC130, analog/basic/mos_r2r_dac.hpp:27
        I(cpphdl_n1080, Vss) <+ 2.9999999999999998e-15 * ddt(V(cpphdl_n1080, Vss)); // Bench initial voltage = 0.0 V.
        // device 849, IC IC130, analog/basic/mos_r2r_dac.hpp:28
        I(cpphdl_n1080, cpphdl_n1094) <+ V(cpphdl_n1080, cpphdl_n1094) / 20000.0;
        // device 850, IC IC130, analog/basic/mos_r2r_dac.hpp:29
        I(cpphdl_n1094, Vss) <+ 2.9999999999999998e-15 * ddt(V(cpphdl_n1094, Vss)); // Bench initial voltage = 0.0 V.
        // device 851, IC IC130, analog/basic/mos_r2r_dac.hpp:31
        I(cpphdl_n1093, cpphdl_n1094) <+ V(cpphdl_n1093, cpphdl_n1094) / 10000.0;
        // device 852, IC IC137, analog/basic/inverter.hpp:11
        I(cpphdl_n1084, Vdd) <+ cpphdl_channel(V(BIT_N7_6, Vdd), V(cpphdl_n1084, Vdd), 0.080000000000000002, 0.69999999999999996, -1.0);
        // device 853, IC IC137, analog/basic/inverter.hpp:12
        I(cpphdl_n1084, Vss) <+ cpphdl_channel(V(BIT_N7_6, Vss), V(cpphdl_n1084, Vss), 0.080000000000000002, 0.69999999999999996, 1.0);
        // device 854, IC IC130, analog/basic/mos_r2r_dac.hpp:27
        I(cpphdl_n1084, Vss) <+ 2.9999999999999998e-15 * ddt(V(cpphdl_n1084, Vss)); // Bench initial voltage = 0.0 V.
        // device 855, IC IC130, analog/basic/mos_r2r_dac.hpp:28
        I(cpphdl_n1084, cpphdl_n1095) <+ V(cpphdl_n1084, cpphdl_n1095) / 20000.0;
        // device 856, IC IC130, analog/basic/mos_r2r_dac.hpp:29
        I(cpphdl_n1095, Vss) <+ 2.9999999999999998e-15 * ddt(V(cpphdl_n1095, Vss)); // Bench initial voltage = 0.0 V.
        // device 857, IC IC130, analog/basic/mos_r2r_dac.hpp:31
        I(cpphdl_n1094, cpphdl_n1095) <+ V(cpphdl_n1094, cpphdl_n1095) / 10000.0;
        // device 858, IC IC138, analog/basic/inverter.hpp:11
        I(cpphdl_n1088, Vdd) <+ cpphdl_channel(V(BIT_N7_7, Vdd), V(cpphdl_n1088, Vdd), 0.080000000000000002, 0.69999999999999996, -1.0);
        // device 859, IC IC138, analog/basic/inverter.hpp:12
        I(cpphdl_n1088, Vss) <+ cpphdl_channel(V(BIT_N7_7, Vss), V(cpphdl_n1088, Vss), 0.080000000000000002, 0.69999999999999996, 1.0);
        // device 860, IC IC130, analog/basic/mos_r2r_dac.hpp:27
        I(cpphdl_n1088, Vss) <+ 2.9999999999999998e-15 * ddt(V(cpphdl_n1088, Vss)); // Bench initial voltage = 0.0 V.
        // device 861, IC IC130, analog/basic/mos_r2r_dac.hpp:28
        I(cpphdl_n1088, cpphdl_n1100) <+ V(cpphdl_n1088, cpphdl_n1100) / 20000.0;
        // device 862, IC IC130, analog/basic/mos_r2r_dac.hpp:29
        I(cpphdl_n1100, Vss) <+ 2.9999999999999998e-15 * ddt(V(cpphdl_n1100, Vss)); // Bench initial voltage = 0.0 V.
        // device 863, IC IC130, analog/basic/mos_r2r_dac.hpp:31
        I(cpphdl_n1095, cpphdl_n1100) <+ V(cpphdl_n1095, cpphdl_n1100) / 10000.0;
        // device 864, IC IC130, analog/basic/mos_r2r_dac.hpp:33
        I(Vss, cpphdl_n1089) <+ V(Vss, cpphdl_n1089) / 20000.0;
        // device 865, IC IC139, analog/basic/nmos_resistor_amplifier.hpp:23
        I(Vdd, cpphdl_n1109) <+ V(Vdd, cpphdl_n1109) / 1000.0;
        // device 866, IC IC139, analog/basic/nmos_resistor_amplifier.hpp:24
        I(Vdd, cpphdl_n1108) <+ V(Vdd, cpphdl_n1108) / 1000.0;
        // device 867, IC IC139, analog/basic/nmos_resistor_amplifier.hpp:25
        I(cpphdl_n1109, cpphdl_n1103) <+ cpphdl_channel(V(cpphdl_n1099, cpphdl_n1103), V(cpphdl_n1109, cpphdl_n1103), 0.014999999999999999, 0.69999999999999996, 1.0);
        // device 868, IC IC139, analog/basic/nmos_resistor_amplifier.hpp:26
        I(cpphdl_n1108, cpphdl_n1104) <+ cpphdl_channel(V(cpphdl_n1100, cpphdl_n1104), V(cpphdl_n1108, cpphdl_n1104), 0.014999999999999999, 0.69999999999999996, 1.0);
        // device 869, IC IC139, analog/basic/nmos_resistor_amplifier.hpp:27
        I(cpphdl_n1105, cpphdl_n1103) <+ V(cpphdl_n1105, cpphdl_n1103) / 50.0;
        // device 870, IC IC139, analog/basic/nmos_resistor_amplifier.hpp:28
        I(cpphdl_n1105, cpphdl_n1104) <+ V(cpphdl_n1105, cpphdl_n1104) / 50.0;
        // device 871, IC IC139, analog/basic/nmos_resistor_amplifier.hpp:29
        I(Vss, cpphdl_n1105) <+ V(Vss, cpphdl_n1105) / 150.0;
        // device 872, IC IC139, analog/basic/nmos_resistor_amplifier.hpp:30
        I(cpphdl_n1109, Vdd) <+ 2.9999999999999998e-13 * ddt(V(cpphdl_n1109, Vdd)); // Bench initial voltage = 0.0 V.
        // device 873, IC IC139, analog/basic/nmos_resistor_amplifier.hpp:31
        I(cpphdl_n1108, Vdd) <+ 2.9999999999999998e-13 * ddt(V(cpphdl_n1108, Vdd)); // Bench initial voltage = 0.0 V.
        // device 874, IC IC139, analog/basic/nmos_resistor_amplifier.hpp:32
        I(cpphdl_n1105, Vss) <+ 4e-14 * ddt(V(cpphdl_n1105, Vss)); // Bench initial voltage = 0.0 V.
        // device 875, IC IC139, analog/basic/nmos_resistor_amplifier.hpp:34
        I(cpphdl_n1099, cpphdl_n1103) <+ 2e-14 * ddt(V(cpphdl_n1099, cpphdl_n1103)); // Bench initial voltage = 1.6499999999999999 V.
        // device 876, IC IC139, analog/basic/nmos_resistor_amplifier.hpp:35
        I(cpphdl_n1100, cpphdl_n1104) <+ 2e-14 * ddt(V(cpphdl_n1100, cpphdl_n1104)); // Bench initial voltage = 0.0 V.
        // device 877, IC IC139, analog/basic/nmos_resistor_amplifier.hpp:36
        I(cpphdl_n1099, cpphdl_n1109) <+ 2.9999999999999998e-15 * ddt(V(cpphdl_n1099, cpphdl_n1109)); // Bench initial voltage = -1.6499999999999999 V.
        // device 878, IC IC139, analog/basic/nmos_resistor_amplifier.hpp:37
        I(cpphdl_n1100, cpphdl_n1108) <+ 2.9999999999999998e-15 * ddt(V(cpphdl_n1100, cpphdl_n1108)); // Bench initial voltage = -3.2999999999999998 V.
        // device 879, IC IC140, analog/basic/strongarm_comparator.hpp:28
        I(cpphdl_n1113, cpphdl_n1115) <+ cpphdl_channel(V(cpphdl_n1108, cpphdl_n1115), V(cpphdl_n1113, cpphdl_n1115), 0.0080000000000000002, 0.69999999999999996, 1.0);
        // device 880, IC IC140, analog/basic/strongarm_comparator.hpp:29
        I(cpphdl_n1114, cpphdl_n1115) <+ cpphdl_channel(V(cpphdl_n1109, cpphdl_n1115), V(cpphdl_n1114, cpphdl_n1115), 0.0080000000000000002, 0.69999999999999996, 1.0);
        // device 881, IC IC140, analog/basic/strongarm_comparator.hpp:30
        I(cpphdl_n1115, Vss) <+ cpphdl_channel(V(EVALUATE, Vss), V(cpphdl_n1115, Vss), 0.0080000000000000002, 0.69999999999999996, 1.0);
        // device 882, IC IC140, analog/basic/strongarm_comparator.hpp:33
        I(cpphdl_n1127, cpphdl_n1113) <+ cpphdl_channel(V(cpphdl_n1133, cpphdl_n1113), V(cpphdl_n1127, cpphdl_n1113), 0.0040000000000000001, 0.69999999999999996, 1.0);
        // device 883, IC IC140, analog/basic/strongarm_comparator.hpp:34
        I(cpphdl_n1133, cpphdl_n1114) <+ cpphdl_channel(V(cpphdl_n1127, cpphdl_n1114), V(cpphdl_n1133, cpphdl_n1114), 0.0040000000000000001, 0.69999999999999996, 1.0);
        // device 884, IC IC140, analog/basic/strongarm_comparator.hpp:35
        I(cpphdl_n1133, Vdd) <+ cpphdl_channel(V(cpphdl_n1127, Vdd), V(cpphdl_n1133, Vdd), 0.002, 0.69999999999999996, -1.0);
        // device 885, IC IC140, analog/basic/strongarm_comparator.hpp:36
        I(cpphdl_n1127, Vdd) <+ cpphdl_channel(V(cpphdl_n1133, Vdd), V(cpphdl_n1127, Vdd), 0.002, 0.69999999999999996, -1.0);
        // device 886, IC IC140, analog/basic/strongarm_comparator.hpp:38
        I(cpphdl_n1113, Vdd) <+ cpphdl_channel(V(EVALUATE, Vdd), V(cpphdl_n1113, Vdd), 0.002, 0.69999999999999996, -1.0);
        // device 887, IC IC140, analog/basic/strongarm_comparator.hpp:39
        I(cpphdl_n1114, Vdd) <+ cpphdl_channel(V(EVALUATE, Vdd), V(cpphdl_n1114, Vdd), 0.002, 0.69999999999999996, -1.0);
        // device 888, IC IC140, analog/basic/strongarm_comparator.hpp:40
        I(cpphdl_n1133, Vdd) <+ cpphdl_channel(V(EVALUATE, Vdd), V(cpphdl_n1133, Vdd), 0.002, 0.69999999999999996, -1.0);
        // device 889, IC IC140, analog/basic/strongarm_comparator.hpp:41
        I(cpphdl_n1127, Vdd) <+ cpphdl_channel(V(EVALUATE, Vdd), V(cpphdl_n1127, Vdd), 0.002, 0.69999999999999996, -1.0);
        // device 890, IC IC140, analog/basic/strongarm_comparator.hpp:42
        I(cpphdl_n1113, Vss) <+ 2.9999999999999998e-14 * ddt(V(cpphdl_n1113, Vss)); // Bench initial voltage = 0.0 V.
        // device 891, IC IC140, analog/basic/strongarm_comparator.hpp:43
        I(cpphdl_n1114, Vss) <+ 2.9999999999999998e-14 * ddt(V(cpphdl_n1114, Vss)); // Bench initial voltage = 0.0 V.
        // device 892, IC IC140, analog/basic/strongarm_comparator.hpp:44
        I(cpphdl_n1115, Vss) <+ 2.9999999999999998e-14 * ddt(V(cpphdl_n1115, Vss)); // Bench initial voltage = 0.0 V.
        // device 893, IC IC140, analog/basic/strongarm_comparator.hpp:45
        I(cpphdl_n1133, Vss) <+ 5.0000000000000002e-14 * ddt(V(cpphdl_n1133, Vss)); // Bench initial voltage = 0.0 V.
        // device 894, IC IC140, analog/basic/strongarm_comparator.hpp:46
        I(cpphdl_n1127, Vss) <+ 5.0000000000000002e-14 * ddt(V(cpphdl_n1127, Vss)); // Bench initial voltage = 0.0 V.
        // device 895, IC IC140, analog/basic/strongarm_comparator.hpp:47
        I(cpphdl_n1108, cpphdl_n1115) <+ 2e-14 * ddt(V(cpphdl_n1108, cpphdl_n1115)); // Bench initial voltage = 3.2999999999999998 V.
        // device 896, IC IC140, analog/basic/strongarm_comparator.hpp:48
        I(cpphdl_n1109, cpphdl_n1115) <+ 2e-14 * ddt(V(cpphdl_n1109, cpphdl_n1115)); // Bench initial voltage = 3.2999999999999998 V.
        // device 897, IC IC140, analog/basic/strongarm_comparator.hpp:49
        I(cpphdl_n1108, cpphdl_n1113) <+ 2.9999999999999998e-15 * ddt(V(cpphdl_n1108, cpphdl_n1113)); // Bench initial voltage = 3.2999999999999998 V.
        // device 898, IC IC140, analog/basic/strongarm_comparator.hpp:50
        I(cpphdl_n1109, cpphdl_n1114) <+ 2.9999999999999998e-15 * ddt(V(cpphdl_n1109, cpphdl_n1114)); // Bench initial voltage = 3.2999999999999998 V.
        // device 899, IC IC142, analog/basic/cmos_logic.hpp:17
        I(DECISION7, Vss) <+ 5.0000000000000002e-14 * ddt(V(DECISION7, Vss)); // Bench initial voltage = 0.0 V.
        // device 900, IC IC142, analog/basic/cmos_logic.hpp:18
        I(DECISION7, Vdd) <+ cpphdl_channel(V(cpphdl_n1127, Vdd), V(DECISION7, Vdd), 0.01, 0.69999999999999996, -1.0);
        // device 901, IC IC142, analog/basic/cmos_logic.hpp:19
        I(DECISION7, Vdd) <+ cpphdl_channel(V(DECISION_N7, Vdd), V(DECISION7, Vdd), 0.01, 0.69999999999999996, -1.0);
        // device 902, IC IC142, analog/basic/cmos_logic.hpp:20
        I(DECISION7, cpphdl_n1130) <+ cpphdl_channel(V(cpphdl_n1127, cpphdl_n1130), V(DECISION7, cpphdl_n1130), 0.01, 0.69999999999999996, 1.0);
        // device 903, IC IC142, analog/basic/cmos_logic.hpp:21
        I(cpphdl_n1130, Vss) <+ cpphdl_channel(V(DECISION_N7, Vss), V(cpphdl_n1130, Vss), 0.01, 0.69999999999999996, 1.0);
        // device 904, IC IC142, analog/basic/cmos_logic.hpp:23
        I(DECISION7, Vss) <+ V(DECISION7, Vss) / 1000000000.0;
        // device 905, IC IC142, analog/basic/cmos_logic.hpp:24
        I(cpphdl_n1130, Vss) <+ V(cpphdl_n1130, Vss) / 1000000000.0;
        // device 906, IC IC143, analog/basic/cmos_logic.hpp:17
        I(DECISION_N7, Vss) <+ 5.0000000000000002e-14 * ddt(V(DECISION_N7, Vss)); // Bench initial voltage = 0.0 V.
        // device 907, IC IC143, analog/basic/cmos_logic.hpp:18
        I(DECISION_N7, Vdd) <+ cpphdl_channel(V(cpphdl_n1133, Vdd), V(DECISION_N7, Vdd), 0.01, 0.69999999999999996, -1.0);
        // device 908, IC IC143, analog/basic/cmos_logic.hpp:19
        I(DECISION_N7, Vdd) <+ cpphdl_channel(V(DECISION7, Vdd), V(DECISION_N7, Vdd), 0.01, 0.69999999999999996, -1.0);
        // device 909, IC IC143, analog/basic/cmos_logic.hpp:20
        I(DECISION_N7, cpphdl_n1136) <+ cpphdl_channel(V(cpphdl_n1133, cpphdl_n1136), V(DECISION_N7, cpphdl_n1136), 0.01, 0.69999999999999996, 1.0);
        // device 910, IC IC143, analog/basic/cmos_logic.hpp:21
        I(cpphdl_n1136, Vss) <+ cpphdl_channel(V(DECISION7, Vss), V(cpphdl_n1136, Vss), 0.01, 0.69999999999999996, 1.0);
        // device 911, IC IC143, analog/basic/cmos_logic.hpp:23
        I(DECISION_N7, Vss) <+ V(DECISION_N7, Vss) / 1000000000.0;
        // device 912, IC IC143, analog/basic/cmos_logic.hpp:24
        I(cpphdl_n1136, Vss) <+ V(cpphdl_n1136, Vss) / 1000000000.0;
        // device 913, IC IC141, analog/basic/nand_latch.hpp:36
        I(cpphdl_n1127, Vss) <+ 2.9999999999999998e-15 * ddt(V(cpphdl_n1127, Vss)); // Bench initial voltage = 0.0 V.
        // device 914, IC IC141, analog/basic/nand_latch.hpp:37
        I(cpphdl_n1133, Vss) <+ 2.9999999999999998e-15 * ddt(V(cpphdl_n1133, Vss)); // Bench initial voltage = 0.0 V.
        // device 915, IC IC144, analog/basic/inverter.hpp:11
        I(cpphdl_n1141, Vdd) <+ cpphdl_channel(V(CLEAR, Vdd), V(cpphdl_n1141, Vdd), 0.01, 0.69999999999999996, -1.0);
        // device 916, IC IC144, analog/basic/inverter.hpp:12
        I(cpphdl_n1141, Vss) <+ cpphdl_channel(V(CLEAR, Vss), V(cpphdl_n1141, Vss), 0.01, 0.69999999999999996, 1.0);
        // device 917, IC IC141, analog/basic/nand_latch.hpp:58
        I(cpphdl_n1141, Vss) <+ 2.9999999999999998e-15 * ddt(V(cpphdl_n1141, Vss)); // Bench initial voltage = 0.0 V.
        // device 918, IC IC141, analog/basic/nand_latch.hpp:59
        I(DECISION7, Vss) <+ cpphdl_channel(V(CLEAR, Vss), V(DECISION7, Vss), 0.050000000000000003, 0.69999999999999996, 1.0);
        // device 919, IC IC141, analog/basic/nand_latch.hpp:60
        I(DECISION_N7, Vdd) <+ cpphdl_channel(V(cpphdl_n1141, Vdd), V(DECISION_N7, Vdd), 0.050000000000000003, 0.69999999999999996, -1.0);
        // device 920, IC IC147, analog/basic/inverter.hpp:11
        I(cpphdl_n1165, Vdd) <+ cpphdl_channel(V(TRACK8, Vdd), V(cpphdl_n1165, Vdd), 0.0040000000000000001, 0.69999999999999996, -1.0);
        // device 921, IC IC147, analog/basic/inverter.hpp:12
        I(cpphdl_n1165, Vss) <+ cpphdl_channel(V(TRACK8, Vss), V(cpphdl_n1165, Vss), 0.0040000000000000001, 0.69999999999999996, 1.0);
        // device 922, IC IC146, analog/basic/mos_track_hold.hpp:31
        I(cpphdl_n1165, Vss) <+ 2e-14 * ddt(V(cpphdl_n1165, Vss)); // Bench initial voltage = 3.2999999999999998 V.
        // device 923, IC IC146, analog/basic/mos_track_hold.hpp:32
        I(IN, cpphdl_n1219) <+ cpphdl_channel(V(TRACK8, cpphdl_n1219), V(IN, cpphdl_n1219), 0.080000000000000002, 0.69999999999999996, 1.0);
        // device 924, IC IC146, analog/basic/mos_track_hold.hpp:33
        I(cpphdl_n1219, IN) <+ cpphdl_channel(V(cpphdl_n1165, IN), V(cpphdl_n1219, IN), 0.040000000000000001, 0.69999999999999996, -1.0);
        // device 925, IC IC146, analog/basic/mos_track_hold.hpp:37
        I(cpphdl_n1219, cpphdl_n1219) <+ cpphdl_channel(V(cpphdl_n1165, cpphdl_n1219), V(cpphdl_n1219, cpphdl_n1219), 0.040000000000000001, 0.69999999999999996, 1.0);
        // device 926, IC IC146, analog/basic/mos_track_hold.hpp:38
        I(cpphdl_n1219, cpphdl_n1219) <+ cpphdl_channel(V(TRACK8, cpphdl_n1219), V(cpphdl_n1219, cpphdl_n1219), 0.02, 0.69999999999999996, -1.0);
        // device 927, IC IC146, analog/basic/mos_track_hold.hpp:39
        I(cpphdl_n1219, Vss) <+ 2e-12 * ddt(V(cpphdl_n1219, Vss)); // Bench initial voltage = 1.6499999999999999 V.
        // device 928, IC IC146, analog/basic/mos_track_hold.hpp:41
        I(Vss, cpphdl_n1219) <+ V(Vss, cpphdl_n1219) / 1000000000.0;
        // device 929, IC IC146, analog/basic/mos_track_hold.hpp:42
        I(TRACK8, cpphdl_n1219) <+ 8.0000000000000006e-15 * ddt(V(TRACK8, cpphdl_n1219)); // Bench initial voltage = -1.6499999999999999 V.
        // device 930, IC IC146, analog/basic/mos_track_hold.hpp:43
        I(cpphdl_n1165, cpphdl_n1219) <+ 8.0000000000000006e-15 * ddt(V(cpphdl_n1165, cpphdl_n1219)); // Bench initial voltage = 1.6499999999999999 V.
        // device 931, IC IC146, analog/basic/mos_track_hold.hpp:44
        I(IN, cpphdl_n1219) <+ 4.0000000000000003e-15 * ddt(V(IN, cpphdl_n1219)); // Bench initial voltage = 0.0 V.
        // device 932, IC IC149, analog/basic/inverter.hpp:11
        I(cpphdl_n1180, Vdd) <+ cpphdl_channel(V(BIT_N8_0, Vdd), V(cpphdl_n1180, Vdd), 0.080000000000000002, 0.69999999999999996, -1.0);
        // device 933, IC IC149, analog/basic/inverter.hpp:12
        I(cpphdl_n1180, Vss) <+ cpphdl_channel(V(BIT_N8_0, Vss), V(cpphdl_n1180, Vss), 0.080000000000000002, 0.69999999999999996, 1.0);
        // device 934, IC IC148, analog/basic/mos_r2r_dac.hpp:27
        I(cpphdl_n1180, Vss) <+ 2.9999999999999998e-15 * ddt(V(cpphdl_n1180, Vss)); // Bench initial voltage = 0.0 V.
        // device 935, IC IC148, analog/basic/mos_r2r_dac.hpp:28
        I(cpphdl_n1180, cpphdl_n1209) <+ V(cpphdl_n1180, cpphdl_n1209) / 20000.0;
        // device 936, IC IC148, analog/basic/mos_r2r_dac.hpp:29
        I(cpphdl_n1209, Vss) <+ 2.9999999999999998e-15 * ddt(V(cpphdl_n1209, Vss)); // Bench initial voltage = 0.0 V.
        // device 937, IC IC150, analog/basic/inverter.hpp:11
        I(cpphdl_n1184, Vdd) <+ cpphdl_channel(V(BIT_N8_1, Vdd), V(cpphdl_n1184, Vdd), 0.080000000000000002, 0.69999999999999996, -1.0);
        // device 938, IC IC150, analog/basic/inverter.hpp:12
        I(cpphdl_n1184, Vss) <+ cpphdl_channel(V(BIT_N8_1, Vss), V(cpphdl_n1184, Vss), 0.080000000000000002, 0.69999999999999996, 1.0);
        // device 939, IC IC148, analog/basic/mos_r2r_dac.hpp:27
        I(cpphdl_n1184, Vss) <+ 2.9999999999999998e-15 * ddt(V(cpphdl_n1184, Vss)); // Bench initial voltage = 0.0 V.
        // device 940, IC IC148, analog/basic/mos_r2r_dac.hpp:28
        I(cpphdl_n1184, cpphdl_n1210) <+ V(cpphdl_n1184, cpphdl_n1210) / 20000.0;
        // device 941, IC IC148, analog/basic/mos_r2r_dac.hpp:29
        I(cpphdl_n1210, Vss) <+ 2.9999999999999998e-15 * ddt(V(cpphdl_n1210, Vss)); // Bench initial voltage = 0.0 V.
        // device 942, IC IC148, analog/basic/mos_r2r_dac.hpp:31
        I(cpphdl_n1209, cpphdl_n1210) <+ V(cpphdl_n1209, cpphdl_n1210) / 10000.0;
        // device 943, IC IC151, analog/basic/inverter.hpp:11
        I(cpphdl_n1188, Vdd) <+ cpphdl_channel(V(BIT_N8_2, Vdd), V(cpphdl_n1188, Vdd), 0.080000000000000002, 0.69999999999999996, -1.0);
        // device 944, IC IC151, analog/basic/inverter.hpp:12
        I(cpphdl_n1188, Vss) <+ cpphdl_channel(V(BIT_N8_2, Vss), V(cpphdl_n1188, Vss), 0.080000000000000002, 0.69999999999999996, 1.0);
        // device 945, IC IC148, analog/basic/mos_r2r_dac.hpp:27
        I(cpphdl_n1188, Vss) <+ 2.9999999999999998e-15 * ddt(V(cpphdl_n1188, Vss)); // Bench initial voltage = 0.0 V.
        // device 946, IC IC148, analog/basic/mos_r2r_dac.hpp:28
        I(cpphdl_n1188, cpphdl_n1211) <+ V(cpphdl_n1188, cpphdl_n1211) / 20000.0;
        // device 947, IC IC148, analog/basic/mos_r2r_dac.hpp:29
        I(cpphdl_n1211, Vss) <+ 2.9999999999999998e-15 * ddt(V(cpphdl_n1211, Vss)); // Bench initial voltage = 0.0 V.
        // device 948, IC IC148, analog/basic/mos_r2r_dac.hpp:31
        I(cpphdl_n1210, cpphdl_n1211) <+ V(cpphdl_n1210, cpphdl_n1211) / 10000.0;
        // device 949, IC IC152, analog/basic/inverter.hpp:11
        I(cpphdl_n1192, Vdd) <+ cpphdl_channel(V(BIT_N8_3, Vdd), V(cpphdl_n1192, Vdd), 0.080000000000000002, 0.69999999999999996, -1.0);
        // device 950, IC IC152, analog/basic/inverter.hpp:12
        I(cpphdl_n1192, Vss) <+ cpphdl_channel(V(BIT_N8_3, Vss), V(cpphdl_n1192, Vss), 0.080000000000000002, 0.69999999999999996, 1.0);
        // device 951, IC IC148, analog/basic/mos_r2r_dac.hpp:27
        I(cpphdl_n1192, Vss) <+ 2.9999999999999998e-15 * ddt(V(cpphdl_n1192, Vss)); // Bench initial voltage = 0.0 V.
        // device 952, IC IC148, analog/basic/mos_r2r_dac.hpp:28
        I(cpphdl_n1192, cpphdl_n1212) <+ V(cpphdl_n1192, cpphdl_n1212) / 20000.0;
        // device 953, IC IC148, analog/basic/mos_r2r_dac.hpp:29
        I(cpphdl_n1212, Vss) <+ 2.9999999999999998e-15 * ddt(V(cpphdl_n1212, Vss)); // Bench initial voltage = 0.0 V.
        // device 954, IC IC148, analog/basic/mos_r2r_dac.hpp:31
        I(cpphdl_n1211, cpphdl_n1212) <+ V(cpphdl_n1211, cpphdl_n1212) / 10000.0;
        // device 955, IC IC153, analog/basic/inverter.hpp:11
        I(cpphdl_n1196, Vdd) <+ cpphdl_channel(V(BIT_N8_4, Vdd), V(cpphdl_n1196, Vdd), 0.080000000000000002, 0.69999999999999996, -1.0);
        // device 956, IC IC153, analog/basic/inverter.hpp:12
        I(cpphdl_n1196, Vss) <+ cpphdl_channel(V(BIT_N8_4, Vss), V(cpphdl_n1196, Vss), 0.080000000000000002, 0.69999999999999996, 1.0);
        // device 957, IC IC148, analog/basic/mos_r2r_dac.hpp:27
        I(cpphdl_n1196, Vss) <+ 2.9999999999999998e-15 * ddt(V(cpphdl_n1196, Vss)); // Bench initial voltage = 0.0 V.
        // device 958, IC IC148, analog/basic/mos_r2r_dac.hpp:28
        I(cpphdl_n1196, cpphdl_n1213) <+ V(cpphdl_n1196, cpphdl_n1213) / 20000.0;
        // device 959, IC IC148, analog/basic/mos_r2r_dac.hpp:29
        I(cpphdl_n1213, Vss) <+ 2.9999999999999998e-15 * ddt(V(cpphdl_n1213, Vss)); // Bench initial voltage = 0.0 V.
        // device 960, IC IC148, analog/basic/mos_r2r_dac.hpp:31
        I(cpphdl_n1212, cpphdl_n1213) <+ V(cpphdl_n1212, cpphdl_n1213) / 10000.0;
        // device 961, IC IC154, analog/basic/inverter.hpp:11
        I(cpphdl_n1200, Vdd) <+ cpphdl_channel(V(BIT_N8_5, Vdd), V(cpphdl_n1200, Vdd), 0.080000000000000002, 0.69999999999999996, -1.0);
        // device 962, IC IC154, analog/basic/inverter.hpp:12
        I(cpphdl_n1200, Vss) <+ cpphdl_channel(V(BIT_N8_5, Vss), V(cpphdl_n1200, Vss), 0.080000000000000002, 0.69999999999999996, 1.0);
        // device 963, IC IC148, analog/basic/mos_r2r_dac.hpp:27
        I(cpphdl_n1200, Vss) <+ 2.9999999999999998e-15 * ddt(V(cpphdl_n1200, Vss)); // Bench initial voltage = 0.0 V.
        // device 964, IC IC148, analog/basic/mos_r2r_dac.hpp:28
        I(cpphdl_n1200, cpphdl_n1214) <+ V(cpphdl_n1200, cpphdl_n1214) / 20000.0;
        // device 965, IC IC148, analog/basic/mos_r2r_dac.hpp:29
        I(cpphdl_n1214, Vss) <+ 2.9999999999999998e-15 * ddt(V(cpphdl_n1214, Vss)); // Bench initial voltage = 0.0 V.
        // device 966, IC IC148, analog/basic/mos_r2r_dac.hpp:31
        I(cpphdl_n1213, cpphdl_n1214) <+ V(cpphdl_n1213, cpphdl_n1214) / 10000.0;
        // device 967, IC IC155, analog/basic/inverter.hpp:11
        I(cpphdl_n1204, Vdd) <+ cpphdl_channel(V(BIT_N8_6, Vdd), V(cpphdl_n1204, Vdd), 0.080000000000000002, 0.69999999999999996, -1.0);
        // device 968, IC IC155, analog/basic/inverter.hpp:12
        I(cpphdl_n1204, Vss) <+ cpphdl_channel(V(BIT_N8_6, Vss), V(cpphdl_n1204, Vss), 0.080000000000000002, 0.69999999999999996, 1.0);
        // device 969, IC IC148, analog/basic/mos_r2r_dac.hpp:27
        I(cpphdl_n1204, Vss) <+ 2.9999999999999998e-15 * ddt(V(cpphdl_n1204, Vss)); // Bench initial voltage = 0.0 V.
        // device 970, IC IC148, analog/basic/mos_r2r_dac.hpp:28
        I(cpphdl_n1204, cpphdl_n1215) <+ V(cpphdl_n1204, cpphdl_n1215) / 20000.0;
        // device 971, IC IC148, analog/basic/mos_r2r_dac.hpp:29
        I(cpphdl_n1215, Vss) <+ 2.9999999999999998e-15 * ddt(V(cpphdl_n1215, Vss)); // Bench initial voltage = 0.0 V.
        // device 972, IC IC148, analog/basic/mos_r2r_dac.hpp:31
        I(cpphdl_n1214, cpphdl_n1215) <+ V(cpphdl_n1214, cpphdl_n1215) / 10000.0;
        // device 973, IC IC156, analog/basic/inverter.hpp:11
        I(cpphdl_n1208, Vdd) <+ cpphdl_channel(V(BIT_N8_7, Vdd), V(cpphdl_n1208, Vdd), 0.080000000000000002, 0.69999999999999996, -1.0);
        // device 974, IC IC156, analog/basic/inverter.hpp:12
        I(cpphdl_n1208, Vss) <+ cpphdl_channel(V(BIT_N8_7, Vss), V(cpphdl_n1208, Vss), 0.080000000000000002, 0.69999999999999996, 1.0);
        // device 975, IC IC148, analog/basic/mos_r2r_dac.hpp:27
        I(cpphdl_n1208, Vss) <+ 2.9999999999999998e-15 * ddt(V(cpphdl_n1208, Vss)); // Bench initial voltage = 0.0 V.
        // device 976, IC IC148, analog/basic/mos_r2r_dac.hpp:28
        I(cpphdl_n1208, cpphdl_n1220) <+ V(cpphdl_n1208, cpphdl_n1220) / 20000.0;
        // device 977, IC IC148, analog/basic/mos_r2r_dac.hpp:29
        I(cpphdl_n1220, Vss) <+ 2.9999999999999998e-15 * ddt(V(cpphdl_n1220, Vss)); // Bench initial voltage = 0.0 V.
        // device 978, IC IC148, analog/basic/mos_r2r_dac.hpp:31
        I(cpphdl_n1215, cpphdl_n1220) <+ V(cpphdl_n1215, cpphdl_n1220) / 10000.0;
        // device 979, IC IC148, analog/basic/mos_r2r_dac.hpp:33
        I(Vss, cpphdl_n1209) <+ V(Vss, cpphdl_n1209) / 20000.0;
        // device 980, IC IC157, analog/basic/nmos_resistor_amplifier.hpp:23
        I(Vdd, cpphdl_n1229) <+ V(Vdd, cpphdl_n1229) / 1000.0;
        // device 981, IC IC157, analog/basic/nmos_resistor_amplifier.hpp:24
        I(Vdd, cpphdl_n1228) <+ V(Vdd, cpphdl_n1228) / 1000.0;
        // device 982, IC IC157, analog/basic/nmos_resistor_amplifier.hpp:25
        I(cpphdl_n1229, cpphdl_n1223) <+ cpphdl_channel(V(cpphdl_n1219, cpphdl_n1223), V(cpphdl_n1229, cpphdl_n1223), 0.014999999999999999, 0.69999999999999996, 1.0);
        // device 983, IC IC157, analog/basic/nmos_resistor_amplifier.hpp:26
        I(cpphdl_n1228, cpphdl_n1224) <+ cpphdl_channel(V(cpphdl_n1220, cpphdl_n1224), V(cpphdl_n1228, cpphdl_n1224), 0.014999999999999999, 0.69999999999999996, 1.0);
        // device 984, IC IC157, analog/basic/nmos_resistor_amplifier.hpp:27
        I(cpphdl_n1225, cpphdl_n1223) <+ V(cpphdl_n1225, cpphdl_n1223) / 50.0;
        // device 985, IC IC157, analog/basic/nmos_resistor_amplifier.hpp:28
        I(cpphdl_n1225, cpphdl_n1224) <+ V(cpphdl_n1225, cpphdl_n1224) / 50.0;
        // device 986, IC IC157, analog/basic/nmos_resistor_amplifier.hpp:29
        I(Vss, cpphdl_n1225) <+ V(Vss, cpphdl_n1225) / 150.0;
        // device 987, IC IC157, analog/basic/nmos_resistor_amplifier.hpp:30
        I(cpphdl_n1229, Vdd) <+ 2.9999999999999998e-13 * ddt(V(cpphdl_n1229, Vdd)); // Bench initial voltage = 0.0 V.
        // device 988, IC IC157, analog/basic/nmos_resistor_amplifier.hpp:31
        I(cpphdl_n1228, Vdd) <+ 2.9999999999999998e-13 * ddt(V(cpphdl_n1228, Vdd)); // Bench initial voltage = 0.0 V.
        // device 989, IC IC157, analog/basic/nmos_resistor_amplifier.hpp:32
        I(cpphdl_n1225, Vss) <+ 4e-14 * ddt(V(cpphdl_n1225, Vss)); // Bench initial voltage = 0.0 V.
        // device 990, IC IC157, analog/basic/nmos_resistor_amplifier.hpp:34
        I(cpphdl_n1219, cpphdl_n1223) <+ 2e-14 * ddt(V(cpphdl_n1219, cpphdl_n1223)); // Bench initial voltage = 1.6499999999999999 V.
        // device 991, IC IC157, analog/basic/nmos_resistor_amplifier.hpp:35
        I(cpphdl_n1220, cpphdl_n1224) <+ 2e-14 * ddt(V(cpphdl_n1220, cpphdl_n1224)); // Bench initial voltage = 0.0 V.
        // device 992, IC IC157, analog/basic/nmos_resistor_amplifier.hpp:36
        I(cpphdl_n1219, cpphdl_n1229) <+ 2.9999999999999998e-15 * ddt(V(cpphdl_n1219, cpphdl_n1229)); // Bench initial voltage = -1.6499999999999999 V.
        // device 993, IC IC157, analog/basic/nmos_resistor_amplifier.hpp:37
        I(cpphdl_n1220, cpphdl_n1228) <+ 2.9999999999999998e-15 * ddt(V(cpphdl_n1220, cpphdl_n1228)); // Bench initial voltage = -3.2999999999999998 V.
        // device 994, IC IC158, analog/basic/strongarm_comparator.hpp:28
        I(cpphdl_n1233, cpphdl_n1235) <+ cpphdl_channel(V(cpphdl_n1228, cpphdl_n1235), V(cpphdl_n1233, cpphdl_n1235), 0.0080000000000000002, 0.69999999999999996, 1.0);
        // device 995, IC IC158, analog/basic/strongarm_comparator.hpp:29
        I(cpphdl_n1234, cpphdl_n1235) <+ cpphdl_channel(V(cpphdl_n1229, cpphdl_n1235), V(cpphdl_n1234, cpphdl_n1235), 0.0080000000000000002, 0.69999999999999996, 1.0);
        // device 996, IC IC158, analog/basic/strongarm_comparator.hpp:30
        I(cpphdl_n1235, Vss) <+ cpphdl_channel(V(EVALUATE, Vss), V(cpphdl_n1235, Vss), 0.0080000000000000002, 0.69999999999999996, 1.0);
        // device 997, IC IC158, analog/basic/strongarm_comparator.hpp:33
        I(cpphdl_n1247, cpphdl_n1233) <+ cpphdl_channel(V(cpphdl_n1253, cpphdl_n1233), V(cpphdl_n1247, cpphdl_n1233), 0.0040000000000000001, 0.69999999999999996, 1.0);
        // device 998, IC IC158, analog/basic/strongarm_comparator.hpp:34
        I(cpphdl_n1253, cpphdl_n1234) <+ cpphdl_channel(V(cpphdl_n1247, cpphdl_n1234), V(cpphdl_n1253, cpphdl_n1234), 0.0040000000000000001, 0.69999999999999996, 1.0);
        // device 999, IC IC158, analog/basic/strongarm_comparator.hpp:35
        I(cpphdl_n1253, Vdd) <+ cpphdl_channel(V(cpphdl_n1247, Vdd), V(cpphdl_n1253, Vdd), 0.002, 0.69999999999999996, -1.0);
        // device 1000, IC IC158, analog/basic/strongarm_comparator.hpp:36
        I(cpphdl_n1247, Vdd) <+ cpphdl_channel(V(cpphdl_n1253, Vdd), V(cpphdl_n1247, Vdd), 0.002, 0.69999999999999996, -1.0);
        // device 1001, IC IC158, analog/basic/strongarm_comparator.hpp:38
        I(cpphdl_n1233, Vdd) <+ cpphdl_channel(V(EVALUATE, Vdd), V(cpphdl_n1233, Vdd), 0.002, 0.69999999999999996, -1.0);
        // device 1002, IC IC158, analog/basic/strongarm_comparator.hpp:39
        I(cpphdl_n1234, Vdd) <+ cpphdl_channel(V(EVALUATE, Vdd), V(cpphdl_n1234, Vdd), 0.002, 0.69999999999999996, -1.0);
        // device 1003, IC IC158, analog/basic/strongarm_comparator.hpp:40
        I(cpphdl_n1253, Vdd) <+ cpphdl_channel(V(EVALUATE, Vdd), V(cpphdl_n1253, Vdd), 0.002, 0.69999999999999996, -1.0);
        // device 1004, IC IC158, analog/basic/strongarm_comparator.hpp:41
        I(cpphdl_n1247, Vdd) <+ cpphdl_channel(V(EVALUATE, Vdd), V(cpphdl_n1247, Vdd), 0.002, 0.69999999999999996, -1.0);
        // device 1005, IC IC158, analog/basic/strongarm_comparator.hpp:42
        I(cpphdl_n1233, Vss) <+ 2.9999999999999998e-14 * ddt(V(cpphdl_n1233, Vss)); // Bench initial voltage = 0.0 V.
        // device 1006, IC IC158, analog/basic/strongarm_comparator.hpp:43
        I(cpphdl_n1234, Vss) <+ 2.9999999999999998e-14 * ddt(V(cpphdl_n1234, Vss)); // Bench initial voltage = 0.0 V.
        // device 1007, IC IC158, analog/basic/strongarm_comparator.hpp:44
        I(cpphdl_n1235, Vss) <+ 2.9999999999999998e-14 * ddt(V(cpphdl_n1235, Vss)); // Bench initial voltage = 0.0 V.
        // device 1008, IC IC158, analog/basic/strongarm_comparator.hpp:45
        I(cpphdl_n1253, Vss) <+ 5.0000000000000002e-14 * ddt(V(cpphdl_n1253, Vss)); // Bench initial voltage = 0.0 V.
        // device 1009, IC IC158, analog/basic/strongarm_comparator.hpp:46
        I(cpphdl_n1247, Vss) <+ 5.0000000000000002e-14 * ddt(V(cpphdl_n1247, Vss)); // Bench initial voltage = 0.0 V.
        // device 1010, IC IC158, analog/basic/strongarm_comparator.hpp:47
        I(cpphdl_n1228, cpphdl_n1235) <+ 2e-14 * ddt(V(cpphdl_n1228, cpphdl_n1235)); // Bench initial voltage = 3.2999999999999998 V.
        // device 1011, IC IC158, analog/basic/strongarm_comparator.hpp:48
        I(cpphdl_n1229, cpphdl_n1235) <+ 2e-14 * ddt(V(cpphdl_n1229, cpphdl_n1235)); // Bench initial voltage = 3.2999999999999998 V.
        // device 1012, IC IC158, analog/basic/strongarm_comparator.hpp:49
        I(cpphdl_n1228, cpphdl_n1233) <+ 2.9999999999999998e-15 * ddt(V(cpphdl_n1228, cpphdl_n1233)); // Bench initial voltage = 3.2999999999999998 V.
        // device 1013, IC IC158, analog/basic/strongarm_comparator.hpp:50
        I(cpphdl_n1229, cpphdl_n1234) <+ 2.9999999999999998e-15 * ddt(V(cpphdl_n1229, cpphdl_n1234)); // Bench initial voltage = 3.2999999999999998 V.
        // device 1014, IC IC160, analog/basic/cmos_logic.hpp:17
        I(DECISION8, Vss) <+ 5.0000000000000002e-14 * ddt(V(DECISION8, Vss)); // Bench initial voltage = 0.0 V.
        // device 1015, IC IC160, analog/basic/cmos_logic.hpp:18
        I(DECISION8, Vdd) <+ cpphdl_channel(V(cpphdl_n1247, Vdd), V(DECISION8, Vdd), 0.01, 0.69999999999999996, -1.0);
        // device 1016, IC IC160, analog/basic/cmos_logic.hpp:19
        I(DECISION8, Vdd) <+ cpphdl_channel(V(DECISION_N8, Vdd), V(DECISION8, Vdd), 0.01, 0.69999999999999996, -1.0);
        // device 1017, IC IC160, analog/basic/cmos_logic.hpp:20
        I(DECISION8, cpphdl_n1250) <+ cpphdl_channel(V(cpphdl_n1247, cpphdl_n1250), V(DECISION8, cpphdl_n1250), 0.01, 0.69999999999999996, 1.0);
        // device 1018, IC IC160, analog/basic/cmos_logic.hpp:21
        I(cpphdl_n1250, Vss) <+ cpphdl_channel(V(DECISION_N8, Vss), V(cpphdl_n1250, Vss), 0.01, 0.69999999999999996, 1.0);
        // device 1019, IC IC160, analog/basic/cmos_logic.hpp:23
        I(DECISION8, Vss) <+ V(DECISION8, Vss) / 1000000000.0;
        // device 1020, IC IC160, analog/basic/cmos_logic.hpp:24
        I(cpphdl_n1250, Vss) <+ V(cpphdl_n1250, Vss) / 1000000000.0;
        // device 1021, IC IC161, analog/basic/cmos_logic.hpp:17
        I(DECISION_N8, Vss) <+ 5.0000000000000002e-14 * ddt(V(DECISION_N8, Vss)); // Bench initial voltage = 0.0 V.
        // device 1022, IC IC161, analog/basic/cmos_logic.hpp:18
        I(DECISION_N8, Vdd) <+ cpphdl_channel(V(cpphdl_n1253, Vdd), V(DECISION_N8, Vdd), 0.01, 0.69999999999999996, -1.0);
        // device 1023, IC IC161, analog/basic/cmos_logic.hpp:19
        I(DECISION_N8, Vdd) <+ cpphdl_channel(V(DECISION8, Vdd), V(DECISION_N8, Vdd), 0.01, 0.69999999999999996, -1.0);
        // device 1024, IC IC161, analog/basic/cmos_logic.hpp:20
        I(DECISION_N8, cpphdl_n1256) <+ cpphdl_channel(V(cpphdl_n1253, cpphdl_n1256), V(DECISION_N8, cpphdl_n1256), 0.01, 0.69999999999999996, 1.0);
        // device 1025, IC IC161, analog/basic/cmos_logic.hpp:21
        I(cpphdl_n1256, Vss) <+ cpphdl_channel(V(DECISION8, Vss), V(cpphdl_n1256, Vss), 0.01, 0.69999999999999996, 1.0);
        // device 1026, IC IC161, analog/basic/cmos_logic.hpp:23
        I(DECISION_N8, Vss) <+ V(DECISION_N8, Vss) / 1000000000.0;
        // device 1027, IC IC161, analog/basic/cmos_logic.hpp:24
        I(cpphdl_n1256, Vss) <+ V(cpphdl_n1256, Vss) / 1000000000.0;
        // device 1028, IC IC159, analog/basic/nand_latch.hpp:36
        I(cpphdl_n1247, Vss) <+ 2.9999999999999998e-15 * ddt(V(cpphdl_n1247, Vss)); // Bench initial voltage = 0.0 V.
        // device 1029, IC IC159, analog/basic/nand_latch.hpp:37
        I(cpphdl_n1253, Vss) <+ 2.9999999999999998e-15 * ddt(V(cpphdl_n1253, Vss)); // Bench initial voltage = 0.0 V.
        // device 1030, IC IC162, analog/basic/inverter.hpp:11
        I(cpphdl_n1261, Vdd) <+ cpphdl_channel(V(CLEAR, Vdd), V(cpphdl_n1261, Vdd), 0.01, 0.69999999999999996, -1.0);
        // device 1031, IC IC162, analog/basic/inverter.hpp:12
        I(cpphdl_n1261, Vss) <+ cpphdl_channel(V(CLEAR, Vss), V(cpphdl_n1261, Vss), 0.01, 0.69999999999999996, 1.0);
        // device 1032, IC IC159, analog/basic/nand_latch.hpp:58
        I(cpphdl_n1261, Vss) <+ 2.9999999999999998e-15 * ddt(V(cpphdl_n1261, Vss)); // Bench initial voltage = 0.0 V.
        // device 1033, IC IC159, analog/basic/nand_latch.hpp:59
        I(DECISION8, Vss) <+ cpphdl_channel(V(CLEAR, Vss), V(DECISION8, Vss), 0.050000000000000003, 0.69999999999999996, 1.0);
        // device 1034, IC IC159, analog/basic/nand_latch.hpp:60
        I(DECISION_N8, Vdd) <+ cpphdl_channel(V(cpphdl_n1261, Vdd), V(DECISION_N8, Vdd), 0.050000000000000003, 0.69999999999999996, -1.0);
        // device 1035, IC IC165, analog/basic/inverter.hpp:11
        I(cpphdl_n1285, Vdd) <+ cpphdl_channel(V(TRACK9, Vdd), V(cpphdl_n1285, Vdd), 0.0040000000000000001, 0.69999999999999996, -1.0);
        // device 1036, IC IC165, analog/basic/inverter.hpp:12
        I(cpphdl_n1285, Vss) <+ cpphdl_channel(V(TRACK9, Vss), V(cpphdl_n1285, Vss), 0.0040000000000000001, 0.69999999999999996, 1.0);
        // device 1037, IC IC164, analog/basic/mos_track_hold.hpp:31
        I(cpphdl_n1285, Vss) <+ 2e-14 * ddt(V(cpphdl_n1285, Vss)); // Bench initial voltage = 3.2999999999999998 V.
        // device 1038, IC IC164, analog/basic/mos_track_hold.hpp:32
        I(IN, cpphdl_n1339) <+ cpphdl_channel(V(TRACK9, cpphdl_n1339), V(IN, cpphdl_n1339), 0.080000000000000002, 0.69999999999999996, 1.0);
        // device 1039, IC IC164, analog/basic/mos_track_hold.hpp:33
        I(cpphdl_n1339, IN) <+ cpphdl_channel(V(cpphdl_n1285, IN), V(cpphdl_n1339, IN), 0.040000000000000001, 0.69999999999999996, -1.0);
        // device 1040, IC IC164, analog/basic/mos_track_hold.hpp:37
        I(cpphdl_n1339, cpphdl_n1339) <+ cpphdl_channel(V(cpphdl_n1285, cpphdl_n1339), V(cpphdl_n1339, cpphdl_n1339), 0.040000000000000001, 0.69999999999999996, 1.0);
        // device 1041, IC IC164, analog/basic/mos_track_hold.hpp:38
        I(cpphdl_n1339, cpphdl_n1339) <+ cpphdl_channel(V(TRACK9, cpphdl_n1339), V(cpphdl_n1339, cpphdl_n1339), 0.02, 0.69999999999999996, -1.0);
        // device 1042, IC IC164, analog/basic/mos_track_hold.hpp:39
        I(cpphdl_n1339, Vss) <+ 2e-12 * ddt(V(cpphdl_n1339, Vss)); // Bench initial voltage = 1.6499999999999999 V.
        // device 1043, IC IC164, analog/basic/mos_track_hold.hpp:41
        I(Vss, cpphdl_n1339) <+ V(Vss, cpphdl_n1339) / 1000000000.0;
        // device 1044, IC IC164, analog/basic/mos_track_hold.hpp:42
        I(TRACK9, cpphdl_n1339) <+ 8.0000000000000006e-15 * ddt(V(TRACK9, cpphdl_n1339)); // Bench initial voltage = -1.6499999999999999 V.
        // device 1045, IC IC164, analog/basic/mos_track_hold.hpp:43
        I(cpphdl_n1285, cpphdl_n1339) <+ 8.0000000000000006e-15 * ddt(V(cpphdl_n1285, cpphdl_n1339)); // Bench initial voltage = 1.6499999999999999 V.
        // device 1046, IC IC164, analog/basic/mos_track_hold.hpp:44
        I(IN, cpphdl_n1339) <+ 4.0000000000000003e-15 * ddt(V(IN, cpphdl_n1339)); // Bench initial voltage = 0.0 V.
        // device 1047, IC IC167, analog/basic/inverter.hpp:11
        I(cpphdl_n1300, Vdd) <+ cpphdl_channel(V(BIT_N9_0, Vdd), V(cpphdl_n1300, Vdd), 0.080000000000000002, 0.69999999999999996, -1.0);
        // device 1048, IC IC167, analog/basic/inverter.hpp:12
        I(cpphdl_n1300, Vss) <+ cpphdl_channel(V(BIT_N9_0, Vss), V(cpphdl_n1300, Vss), 0.080000000000000002, 0.69999999999999996, 1.0);
        // device 1049, IC IC166, analog/basic/mos_r2r_dac.hpp:27
        I(cpphdl_n1300, Vss) <+ 2.9999999999999998e-15 * ddt(V(cpphdl_n1300, Vss)); // Bench initial voltage = 0.0 V.
        // device 1050, IC IC166, analog/basic/mos_r2r_dac.hpp:28
        I(cpphdl_n1300, cpphdl_n1329) <+ V(cpphdl_n1300, cpphdl_n1329) / 20000.0;
        // device 1051, IC IC166, analog/basic/mos_r2r_dac.hpp:29
        I(cpphdl_n1329, Vss) <+ 2.9999999999999998e-15 * ddt(V(cpphdl_n1329, Vss)); // Bench initial voltage = 0.0 V.
        // device 1052, IC IC168, analog/basic/inverter.hpp:11
        I(cpphdl_n1304, Vdd) <+ cpphdl_channel(V(BIT_N9_1, Vdd), V(cpphdl_n1304, Vdd), 0.080000000000000002, 0.69999999999999996, -1.0);
        // device 1053, IC IC168, analog/basic/inverter.hpp:12
        I(cpphdl_n1304, Vss) <+ cpphdl_channel(V(BIT_N9_1, Vss), V(cpphdl_n1304, Vss), 0.080000000000000002, 0.69999999999999996, 1.0);
        // device 1054, IC IC166, analog/basic/mos_r2r_dac.hpp:27
        I(cpphdl_n1304, Vss) <+ 2.9999999999999998e-15 * ddt(V(cpphdl_n1304, Vss)); // Bench initial voltage = 0.0 V.
        // device 1055, IC IC166, analog/basic/mos_r2r_dac.hpp:28
        I(cpphdl_n1304, cpphdl_n1330) <+ V(cpphdl_n1304, cpphdl_n1330) / 20000.0;
        // device 1056, IC IC166, analog/basic/mos_r2r_dac.hpp:29
        I(cpphdl_n1330, Vss) <+ 2.9999999999999998e-15 * ddt(V(cpphdl_n1330, Vss)); // Bench initial voltage = 0.0 V.
        // device 1057, IC IC166, analog/basic/mos_r2r_dac.hpp:31
        I(cpphdl_n1329, cpphdl_n1330) <+ V(cpphdl_n1329, cpphdl_n1330) / 10000.0;
        // device 1058, IC IC169, analog/basic/inverter.hpp:11
        I(cpphdl_n1308, Vdd) <+ cpphdl_channel(V(BIT_N9_2, Vdd), V(cpphdl_n1308, Vdd), 0.080000000000000002, 0.69999999999999996, -1.0);
        // device 1059, IC IC169, analog/basic/inverter.hpp:12
        I(cpphdl_n1308, Vss) <+ cpphdl_channel(V(BIT_N9_2, Vss), V(cpphdl_n1308, Vss), 0.080000000000000002, 0.69999999999999996, 1.0);
        // device 1060, IC IC166, analog/basic/mos_r2r_dac.hpp:27
        I(cpphdl_n1308, Vss) <+ 2.9999999999999998e-15 * ddt(V(cpphdl_n1308, Vss)); // Bench initial voltage = 0.0 V.
        // device 1061, IC IC166, analog/basic/mos_r2r_dac.hpp:28
        I(cpphdl_n1308, cpphdl_n1331) <+ V(cpphdl_n1308, cpphdl_n1331) / 20000.0;
        // device 1062, IC IC166, analog/basic/mos_r2r_dac.hpp:29
        I(cpphdl_n1331, Vss) <+ 2.9999999999999998e-15 * ddt(V(cpphdl_n1331, Vss)); // Bench initial voltage = 0.0 V.
        // device 1063, IC IC166, analog/basic/mos_r2r_dac.hpp:31
        I(cpphdl_n1330, cpphdl_n1331) <+ V(cpphdl_n1330, cpphdl_n1331) / 10000.0;
        // device 1064, IC IC170, analog/basic/inverter.hpp:11
        I(cpphdl_n1312, Vdd) <+ cpphdl_channel(V(BIT_N9_3, Vdd), V(cpphdl_n1312, Vdd), 0.080000000000000002, 0.69999999999999996, -1.0);
        // device 1065, IC IC170, analog/basic/inverter.hpp:12
        I(cpphdl_n1312, Vss) <+ cpphdl_channel(V(BIT_N9_3, Vss), V(cpphdl_n1312, Vss), 0.080000000000000002, 0.69999999999999996, 1.0);
        // device 1066, IC IC166, analog/basic/mos_r2r_dac.hpp:27
        I(cpphdl_n1312, Vss) <+ 2.9999999999999998e-15 * ddt(V(cpphdl_n1312, Vss)); // Bench initial voltage = 0.0 V.
        // device 1067, IC IC166, analog/basic/mos_r2r_dac.hpp:28
        I(cpphdl_n1312, cpphdl_n1332) <+ V(cpphdl_n1312, cpphdl_n1332) / 20000.0;
        // device 1068, IC IC166, analog/basic/mos_r2r_dac.hpp:29
        I(cpphdl_n1332, Vss) <+ 2.9999999999999998e-15 * ddt(V(cpphdl_n1332, Vss)); // Bench initial voltage = 0.0 V.
        // device 1069, IC IC166, analog/basic/mos_r2r_dac.hpp:31
        I(cpphdl_n1331, cpphdl_n1332) <+ V(cpphdl_n1331, cpphdl_n1332) / 10000.0;
        // device 1070, IC IC171, analog/basic/inverter.hpp:11
        I(cpphdl_n1316, Vdd) <+ cpphdl_channel(V(BIT_N9_4, Vdd), V(cpphdl_n1316, Vdd), 0.080000000000000002, 0.69999999999999996, -1.0);
        // device 1071, IC IC171, analog/basic/inverter.hpp:12
        I(cpphdl_n1316, Vss) <+ cpphdl_channel(V(BIT_N9_4, Vss), V(cpphdl_n1316, Vss), 0.080000000000000002, 0.69999999999999996, 1.0);
        // device 1072, IC IC166, analog/basic/mos_r2r_dac.hpp:27
        I(cpphdl_n1316, Vss) <+ 2.9999999999999998e-15 * ddt(V(cpphdl_n1316, Vss)); // Bench initial voltage = 0.0 V.
        // device 1073, IC IC166, analog/basic/mos_r2r_dac.hpp:28
        I(cpphdl_n1316, cpphdl_n1333) <+ V(cpphdl_n1316, cpphdl_n1333) / 20000.0;
        // device 1074, IC IC166, analog/basic/mos_r2r_dac.hpp:29
        I(cpphdl_n1333, Vss) <+ 2.9999999999999998e-15 * ddt(V(cpphdl_n1333, Vss)); // Bench initial voltage = 0.0 V.
        // device 1075, IC IC166, analog/basic/mos_r2r_dac.hpp:31
        I(cpphdl_n1332, cpphdl_n1333) <+ V(cpphdl_n1332, cpphdl_n1333) / 10000.0;
        // device 1076, IC IC172, analog/basic/inverter.hpp:11
        I(cpphdl_n1320, Vdd) <+ cpphdl_channel(V(BIT_N9_5, Vdd), V(cpphdl_n1320, Vdd), 0.080000000000000002, 0.69999999999999996, -1.0);
        // device 1077, IC IC172, analog/basic/inverter.hpp:12
        I(cpphdl_n1320, Vss) <+ cpphdl_channel(V(BIT_N9_5, Vss), V(cpphdl_n1320, Vss), 0.080000000000000002, 0.69999999999999996, 1.0);
        // device 1078, IC IC166, analog/basic/mos_r2r_dac.hpp:27
        I(cpphdl_n1320, Vss) <+ 2.9999999999999998e-15 * ddt(V(cpphdl_n1320, Vss)); // Bench initial voltage = 0.0 V.
        // device 1079, IC IC166, analog/basic/mos_r2r_dac.hpp:28
        I(cpphdl_n1320, cpphdl_n1334) <+ V(cpphdl_n1320, cpphdl_n1334) / 20000.0;
        // device 1080, IC IC166, analog/basic/mos_r2r_dac.hpp:29
        I(cpphdl_n1334, Vss) <+ 2.9999999999999998e-15 * ddt(V(cpphdl_n1334, Vss)); // Bench initial voltage = 0.0 V.
        // device 1081, IC IC166, analog/basic/mos_r2r_dac.hpp:31
        I(cpphdl_n1333, cpphdl_n1334) <+ V(cpphdl_n1333, cpphdl_n1334) / 10000.0;
        // device 1082, IC IC173, analog/basic/inverter.hpp:11
        I(cpphdl_n1324, Vdd) <+ cpphdl_channel(V(BIT_N9_6, Vdd), V(cpphdl_n1324, Vdd), 0.080000000000000002, 0.69999999999999996, -1.0);
        // device 1083, IC IC173, analog/basic/inverter.hpp:12
        I(cpphdl_n1324, Vss) <+ cpphdl_channel(V(BIT_N9_6, Vss), V(cpphdl_n1324, Vss), 0.080000000000000002, 0.69999999999999996, 1.0);
        // device 1084, IC IC166, analog/basic/mos_r2r_dac.hpp:27
        I(cpphdl_n1324, Vss) <+ 2.9999999999999998e-15 * ddt(V(cpphdl_n1324, Vss)); // Bench initial voltage = 0.0 V.
        // device 1085, IC IC166, analog/basic/mos_r2r_dac.hpp:28
        I(cpphdl_n1324, cpphdl_n1335) <+ V(cpphdl_n1324, cpphdl_n1335) / 20000.0;
        // device 1086, IC IC166, analog/basic/mos_r2r_dac.hpp:29
        I(cpphdl_n1335, Vss) <+ 2.9999999999999998e-15 * ddt(V(cpphdl_n1335, Vss)); // Bench initial voltage = 0.0 V.
        // device 1087, IC IC166, analog/basic/mos_r2r_dac.hpp:31
        I(cpphdl_n1334, cpphdl_n1335) <+ V(cpphdl_n1334, cpphdl_n1335) / 10000.0;
        // device 1088, IC IC174, analog/basic/inverter.hpp:11
        I(cpphdl_n1328, Vdd) <+ cpphdl_channel(V(BIT_N9_7, Vdd), V(cpphdl_n1328, Vdd), 0.080000000000000002, 0.69999999999999996, -1.0);
        // device 1089, IC IC174, analog/basic/inverter.hpp:12
        I(cpphdl_n1328, Vss) <+ cpphdl_channel(V(BIT_N9_7, Vss), V(cpphdl_n1328, Vss), 0.080000000000000002, 0.69999999999999996, 1.0);
        // device 1090, IC IC166, analog/basic/mos_r2r_dac.hpp:27
        I(cpphdl_n1328, Vss) <+ 2.9999999999999998e-15 * ddt(V(cpphdl_n1328, Vss)); // Bench initial voltage = 0.0 V.
        // device 1091, IC IC166, analog/basic/mos_r2r_dac.hpp:28
        I(cpphdl_n1328, cpphdl_n1340) <+ V(cpphdl_n1328, cpphdl_n1340) / 20000.0;
        // device 1092, IC IC166, analog/basic/mos_r2r_dac.hpp:29
        I(cpphdl_n1340, Vss) <+ 2.9999999999999998e-15 * ddt(V(cpphdl_n1340, Vss)); // Bench initial voltage = 0.0 V.
        // device 1093, IC IC166, analog/basic/mos_r2r_dac.hpp:31
        I(cpphdl_n1335, cpphdl_n1340) <+ V(cpphdl_n1335, cpphdl_n1340) / 10000.0;
        // device 1094, IC IC166, analog/basic/mos_r2r_dac.hpp:33
        I(Vss, cpphdl_n1329) <+ V(Vss, cpphdl_n1329) / 20000.0;
        // device 1095, IC IC175, analog/basic/nmos_resistor_amplifier.hpp:23
        I(Vdd, cpphdl_n1349) <+ V(Vdd, cpphdl_n1349) / 1000.0;
        // device 1096, IC IC175, analog/basic/nmos_resistor_amplifier.hpp:24
        I(Vdd, cpphdl_n1348) <+ V(Vdd, cpphdl_n1348) / 1000.0;
        // device 1097, IC IC175, analog/basic/nmos_resistor_amplifier.hpp:25
        I(cpphdl_n1349, cpphdl_n1343) <+ cpphdl_channel(V(cpphdl_n1339, cpphdl_n1343), V(cpphdl_n1349, cpphdl_n1343), 0.014999999999999999, 0.69999999999999996, 1.0);
        // device 1098, IC IC175, analog/basic/nmos_resistor_amplifier.hpp:26
        I(cpphdl_n1348, cpphdl_n1344) <+ cpphdl_channel(V(cpphdl_n1340, cpphdl_n1344), V(cpphdl_n1348, cpphdl_n1344), 0.014999999999999999, 0.69999999999999996, 1.0);
        // device 1099, IC IC175, analog/basic/nmos_resistor_amplifier.hpp:27
        I(cpphdl_n1345, cpphdl_n1343) <+ V(cpphdl_n1345, cpphdl_n1343) / 50.0;
        // device 1100, IC IC175, analog/basic/nmos_resistor_amplifier.hpp:28
        I(cpphdl_n1345, cpphdl_n1344) <+ V(cpphdl_n1345, cpphdl_n1344) / 50.0;
        // device 1101, IC IC175, analog/basic/nmos_resistor_amplifier.hpp:29
        I(Vss, cpphdl_n1345) <+ V(Vss, cpphdl_n1345) / 150.0;
        // device 1102, IC IC175, analog/basic/nmos_resistor_amplifier.hpp:30
        I(cpphdl_n1349, Vdd) <+ 2.9999999999999998e-13 * ddt(V(cpphdl_n1349, Vdd)); // Bench initial voltage = 0.0 V.
        // device 1103, IC IC175, analog/basic/nmos_resistor_amplifier.hpp:31
        I(cpphdl_n1348, Vdd) <+ 2.9999999999999998e-13 * ddt(V(cpphdl_n1348, Vdd)); // Bench initial voltage = 0.0 V.
        // device 1104, IC IC175, analog/basic/nmos_resistor_amplifier.hpp:32
        I(cpphdl_n1345, Vss) <+ 4e-14 * ddt(V(cpphdl_n1345, Vss)); // Bench initial voltage = 0.0 V.
        // device 1105, IC IC175, analog/basic/nmos_resistor_amplifier.hpp:34
        I(cpphdl_n1339, cpphdl_n1343) <+ 2e-14 * ddt(V(cpphdl_n1339, cpphdl_n1343)); // Bench initial voltage = 1.6499999999999999 V.
        // device 1106, IC IC175, analog/basic/nmos_resistor_amplifier.hpp:35
        I(cpphdl_n1340, cpphdl_n1344) <+ 2e-14 * ddt(V(cpphdl_n1340, cpphdl_n1344)); // Bench initial voltage = 0.0 V.
        // device 1107, IC IC175, analog/basic/nmos_resistor_amplifier.hpp:36
        I(cpphdl_n1339, cpphdl_n1349) <+ 2.9999999999999998e-15 * ddt(V(cpphdl_n1339, cpphdl_n1349)); // Bench initial voltage = -1.6499999999999999 V.
        // device 1108, IC IC175, analog/basic/nmos_resistor_amplifier.hpp:37
        I(cpphdl_n1340, cpphdl_n1348) <+ 2.9999999999999998e-15 * ddt(V(cpphdl_n1340, cpphdl_n1348)); // Bench initial voltage = -3.2999999999999998 V.
        // device 1109, IC IC176, analog/basic/strongarm_comparator.hpp:28
        I(cpphdl_n1353, cpphdl_n1355) <+ cpphdl_channel(V(cpphdl_n1348, cpphdl_n1355), V(cpphdl_n1353, cpphdl_n1355), 0.0080000000000000002, 0.69999999999999996, 1.0);
        // device 1110, IC IC176, analog/basic/strongarm_comparator.hpp:29
        I(cpphdl_n1354, cpphdl_n1355) <+ cpphdl_channel(V(cpphdl_n1349, cpphdl_n1355), V(cpphdl_n1354, cpphdl_n1355), 0.0080000000000000002, 0.69999999999999996, 1.0);
        // device 1111, IC IC176, analog/basic/strongarm_comparator.hpp:30
        I(cpphdl_n1355, Vss) <+ cpphdl_channel(V(EVALUATE, Vss), V(cpphdl_n1355, Vss), 0.0080000000000000002, 0.69999999999999996, 1.0);
        // device 1112, IC IC176, analog/basic/strongarm_comparator.hpp:33
        I(cpphdl_n1367, cpphdl_n1353) <+ cpphdl_channel(V(cpphdl_n1373, cpphdl_n1353), V(cpphdl_n1367, cpphdl_n1353), 0.0040000000000000001, 0.69999999999999996, 1.0);
        // device 1113, IC IC176, analog/basic/strongarm_comparator.hpp:34
        I(cpphdl_n1373, cpphdl_n1354) <+ cpphdl_channel(V(cpphdl_n1367, cpphdl_n1354), V(cpphdl_n1373, cpphdl_n1354), 0.0040000000000000001, 0.69999999999999996, 1.0);
        // device 1114, IC IC176, analog/basic/strongarm_comparator.hpp:35
        I(cpphdl_n1373, Vdd) <+ cpphdl_channel(V(cpphdl_n1367, Vdd), V(cpphdl_n1373, Vdd), 0.002, 0.69999999999999996, -1.0);
        // device 1115, IC IC176, analog/basic/strongarm_comparator.hpp:36
        I(cpphdl_n1367, Vdd) <+ cpphdl_channel(V(cpphdl_n1373, Vdd), V(cpphdl_n1367, Vdd), 0.002, 0.69999999999999996, -1.0);
        // device 1116, IC IC176, analog/basic/strongarm_comparator.hpp:38
        I(cpphdl_n1353, Vdd) <+ cpphdl_channel(V(EVALUATE, Vdd), V(cpphdl_n1353, Vdd), 0.002, 0.69999999999999996, -1.0);
        // device 1117, IC IC176, analog/basic/strongarm_comparator.hpp:39
        I(cpphdl_n1354, Vdd) <+ cpphdl_channel(V(EVALUATE, Vdd), V(cpphdl_n1354, Vdd), 0.002, 0.69999999999999996, -1.0);
        // device 1118, IC IC176, analog/basic/strongarm_comparator.hpp:40
        I(cpphdl_n1373, Vdd) <+ cpphdl_channel(V(EVALUATE, Vdd), V(cpphdl_n1373, Vdd), 0.002, 0.69999999999999996, -1.0);
        // device 1119, IC IC176, analog/basic/strongarm_comparator.hpp:41
        I(cpphdl_n1367, Vdd) <+ cpphdl_channel(V(EVALUATE, Vdd), V(cpphdl_n1367, Vdd), 0.002, 0.69999999999999996, -1.0);
        // device 1120, IC IC176, analog/basic/strongarm_comparator.hpp:42
        I(cpphdl_n1353, Vss) <+ 2.9999999999999998e-14 * ddt(V(cpphdl_n1353, Vss)); // Bench initial voltage = 0.0 V.
        // device 1121, IC IC176, analog/basic/strongarm_comparator.hpp:43
        I(cpphdl_n1354, Vss) <+ 2.9999999999999998e-14 * ddt(V(cpphdl_n1354, Vss)); // Bench initial voltage = 0.0 V.
        // device 1122, IC IC176, analog/basic/strongarm_comparator.hpp:44
        I(cpphdl_n1355, Vss) <+ 2.9999999999999998e-14 * ddt(V(cpphdl_n1355, Vss)); // Bench initial voltage = 0.0 V.
        // device 1123, IC IC176, analog/basic/strongarm_comparator.hpp:45
        I(cpphdl_n1373, Vss) <+ 5.0000000000000002e-14 * ddt(V(cpphdl_n1373, Vss)); // Bench initial voltage = 0.0 V.
        // device 1124, IC IC176, analog/basic/strongarm_comparator.hpp:46
        I(cpphdl_n1367, Vss) <+ 5.0000000000000002e-14 * ddt(V(cpphdl_n1367, Vss)); // Bench initial voltage = 0.0 V.
        // device 1125, IC IC176, analog/basic/strongarm_comparator.hpp:47
        I(cpphdl_n1348, cpphdl_n1355) <+ 2e-14 * ddt(V(cpphdl_n1348, cpphdl_n1355)); // Bench initial voltage = 3.2999999999999998 V.
        // device 1126, IC IC176, analog/basic/strongarm_comparator.hpp:48
        I(cpphdl_n1349, cpphdl_n1355) <+ 2e-14 * ddt(V(cpphdl_n1349, cpphdl_n1355)); // Bench initial voltage = 3.2999999999999998 V.
        // device 1127, IC IC176, analog/basic/strongarm_comparator.hpp:49
        I(cpphdl_n1348, cpphdl_n1353) <+ 2.9999999999999998e-15 * ddt(V(cpphdl_n1348, cpphdl_n1353)); // Bench initial voltage = 3.2999999999999998 V.
        // device 1128, IC IC176, analog/basic/strongarm_comparator.hpp:50
        I(cpphdl_n1349, cpphdl_n1354) <+ 2.9999999999999998e-15 * ddt(V(cpphdl_n1349, cpphdl_n1354)); // Bench initial voltage = 3.2999999999999998 V.
        // device 1129, IC IC178, analog/basic/cmos_logic.hpp:17
        I(DECISION9, Vss) <+ 5.0000000000000002e-14 * ddt(V(DECISION9, Vss)); // Bench initial voltage = 0.0 V.
        // device 1130, IC IC178, analog/basic/cmos_logic.hpp:18
        I(DECISION9, Vdd) <+ cpphdl_channel(V(cpphdl_n1367, Vdd), V(DECISION9, Vdd), 0.01, 0.69999999999999996, -1.0);
        // device 1131, IC IC178, analog/basic/cmos_logic.hpp:19
        I(DECISION9, Vdd) <+ cpphdl_channel(V(DECISION_N9, Vdd), V(DECISION9, Vdd), 0.01, 0.69999999999999996, -1.0);
        // device 1132, IC IC178, analog/basic/cmos_logic.hpp:20
        I(DECISION9, cpphdl_n1370) <+ cpphdl_channel(V(cpphdl_n1367, cpphdl_n1370), V(DECISION9, cpphdl_n1370), 0.01, 0.69999999999999996, 1.0);
        // device 1133, IC IC178, analog/basic/cmos_logic.hpp:21
        I(cpphdl_n1370, Vss) <+ cpphdl_channel(V(DECISION_N9, Vss), V(cpphdl_n1370, Vss), 0.01, 0.69999999999999996, 1.0);
        // device 1134, IC IC178, analog/basic/cmos_logic.hpp:23
        I(DECISION9, Vss) <+ V(DECISION9, Vss) / 1000000000.0;
        // device 1135, IC IC178, analog/basic/cmos_logic.hpp:24
        I(cpphdl_n1370, Vss) <+ V(cpphdl_n1370, Vss) / 1000000000.0;
        // device 1136, IC IC179, analog/basic/cmos_logic.hpp:17
        I(DECISION_N9, Vss) <+ 5.0000000000000002e-14 * ddt(V(DECISION_N9, Vss)); // Bench initial voltage = 0.0 V.
        // device 1137, IC IC179, analog/basic/cmos_logic.hpp:18
        I(DECISION_N9, Vdd) <+ cpphdl_channel(V(cpphdl_n1373, Vdd), V(DECISION_N9, Vdd), 0.01, 0.69999999999999996, -1.0);
        // device 1138, IC IC179, analog/basic/cmos_logic.hpp:19
        I(DECISION_N9, Vdd) <+ cpphdl_channel(V(DECISION9, Vdd), V(DECISION_N9, Vdd), 0.01, 0.69999999999999996, -1.0);
        // device 1139, IC IC179, analog/basic/cmos_logic.hpp:20
        I(DECISION_N9, cpphdl_n1376) <+ cpphdl_channel(V(cpphdl_n1373, cpphdl_n1376), V(DECISION_N9, cpphdl_n1376), 0.01, 0.69999999999999996, 1.0);
        // device 1140, IC IC179, analog/basic/cmos_logic.hpp:21
        I(cpphdl_n1376, Vss) <+ cpphdl_channel(V(DECISION9, Vss), V(cpphdl_n1376, Vss), 0.01, 0.69999999999999996, 1.0);
        // device 1141, IC IC179, analog/basic/cmos_logic.hpp:23
        I(DECISION_N9, Vss) <+ V(DECISION_N9, Vss) / 1000000000.0;
        // device 1142, IC IC179, analog/basic/cmos_logic.hpp:24
        I(cpphdl_n1376, Vss) <+ V(cpphdl_n1376, Vss) / 1000000000.0;
        // device 1143, IC IC177, analog/basic/nand_latch.hpp:36
        I(cpphdl_n1367, Vss) <+ 2.9999999999999998e-15 * ddt(V(cpphdl_n1367, Vss)); // Bench initial voltage = 0.0 V.
        // device 1144, IC IC177, analog/basic/nand_latch.hpp:37
        I(cpphdl_n1373, Vss) <+ 2.9999999999999998e-15 * ddt(V(cpphdl_n1373, Vss)); // Bench initial voltage = 0.0 V.
        // device 1145, IC IC180, analog/basic/inverter.hpp:11
        I(cpphdl_n1381, Vdd) <+ cpphdl_channel(V(CLEAR, Vdd), V(cpphdl_n1381, Vdd), 0.01, 0.69999999999999996, -1.0);
        // device 1146, IC IC180, analog/basic/inverter.hpp:12
        I(cpphdl_n1381, Vss) <+ cpphdl_channel(V(CLEAR, Vss), V(cpphdl_n1381, Vss), 0.01, 0.69999999999999996, 1.0);
        // device 1147, IC IC177, analog/basic/nand_latch.hpp:58
        I(cpphdl_n1381, Vss) <+ 2.9999999999999998e-15 * ddt(V(cpphdl_n1381, Vss)); // Bench initial voltage = 0.0 V.
        // device 1148, IC IC177, analog/basic/nand_latch.hpp:59
        I(DECISION9, Vss) <+ cpphdl_channel(V(CLEAR, Vss), V(DECISION9, Vss), 0.050000000000000003, 0.69999999999999996, 1.0);
        // device 1149, IC IC177, analog/basic/nand_latch.hpp:60
        I(DECISION_N9, Vdd) <+ cpphdl_channel(V(cpphdl_n1381, Vdd), V(DECISION_N9, Vdd), 0.050000000000000003, 0.69999999999999996, -1.0);
        // device 1150, IC IC183, analog/basic/inverter.hpp:11
        I(cpphdl_n1405, Vdd) <+ cpphdl_channel(V(TRACK10, Vdd), V(cpphdl_n1405, Vdd), 0.0040000000000000001, 0.69999999999999996, -1.0);
        // device 1151, IC IC183, analog/basic/inverter.hpp:12
        I(cpphdl_n1405, Vss) <+ cpphdl_channel(V(TRACK10, Vss), V(cpphdl_n1405, Vss), 0.0040000000000000001, 0.69999999999999996, 1.0);
        // device 1152, IC IC182, analog/basic/mos_track_hold.hpp:31
        I(cpphdl_n1405, Vss) <+ 2e-14 * ddt(V(cpphdl_n1405, Vss)); // Bench initial voltage = 3.2999999999999998 V.
        // device 1153, IC IC182, analog/basic/mos_track_hold.hpp:32
        I(IN, cpphdl_n1459) <+ cpphdl_channel(V(TRACK10, cpphdl_n1459), V(IN, cpphdl_n1459), 0.080000000000000002, 0.69999999999999996, 1.0);
        // device 1154, IC IC182, analog/basic/mos_track_hold.hpp:33
        I(cpphdl_n1459, IN) <+ cpphdl_channel(V(cpphdl_n1405, IN), V(cpphdl_n1459, IN), 0.040000000000000001, 0.69999999999999996, -1.0);
        // device 1155, IC IC182, analog/basic/mos_track_hold.hpp:37
        I(cpphdl_n1459, cpphdl_n1459) <+ cpphdl_channel(V(cpphdl_n1405, cpphdl_n1459), V(cpphdl_n1459, cpphdl_n1459), 0.040000000000000001, 0.69999999999999996, 1.0);
        // device 1156, IC IC182, analog/basic/mos_track_hold.hpp:38
        I(cpphdl_n1459, cpphdl_n1459) <+ cpphdl_channel(V(TRACK10, cpphdl_n1459), V(cpphdl_n1459, cpphdl_n1459), 0.02, 0.69999999999999996, -1.0);
        // device 1157, IC IC182, analog/basic/mos_track_hold.hpp:39
        I(cpphdl_n1459, Vss) <+ 2e-12 * ddt(V(cpphdl_n1459, Vss)); // Bench initial voltage = 1.6499999999999999 V.
        // device 1158, IC IC182, analog/basic/mos_track_hold.hpp:41
        I(Vss, cpphdl_n1459) <+ V(Vss, cpphdl_n1459) / 1000000000.0;
        // device 1159, IC IC182, analog/basic/mos_track_hold.hpp:42
        I(TRACK10, cpphdl_n1459) <+ 8.0000000000000006e-15 * ddt(V(TRACK10, cpphdl_n1459)); // Bench initial voltage = -1.6499999999999999 V.
        // device 1160, IC IC182, analog/basic/mos_track_hold.hpp:43
        I(cpphdl_n1405, cpphdl_n1459) <+ 8.0000000000000006e-15 * ddt(V(cpphdl_n1405, cpphdl_n1459)); // Bench initial voltage = 1.6499999999999999 V.
        // device 1161, IC IC182, analog/basic/mos_track_hold.hpp:44
        I(IN, cpphdl_n1459) <+ 4.0000000000000003e-15 * ddt(V(IN, cpphdl_n1459)); // Bench initial voltage = 0.0 V.
        // device 1162, IC IC185, analog/basic/inverter.hpp:11
        I(cpphdl_n1420, Vdd) <+ cpphdl_channel(V(BIT_N10_0, Vdd), V(cpphdl_n1420, Vdd), 0.080000000000000002, 0.69999999999999996, -1.0);
        // device 1163, IC IC185, analog/basic/inverter.hpp:12
        I(cpphdl_n1420, Vss) <+ cpphdl_channel(V(BIT_N10_0, Vss), V(cpphdl_n1420, Vss), 0.080000000000000002, 0.69999999999999996, 1.0);
        // device 1164, IC IC184, analog/basic/mos_r2r_dac.hpp:27
        I(cpphdl_n1420, Vss) <+ 2.9999999999999998e-15 * ddt(V(cpphdl_n1420, Vss)); // Bench initial voltage = 0.0 V.
        // device 1165, IC IC184, analog/basic/mos_r2r_dac.hpp:28
        I(cpphdl_n1420, cpphdl_n1449) <+ V(cpphdl_n1420, cpphdl_n1449) / 20000.0;
        // device 1166, IC IC184, analog/basic/mos_r2r_dac.hpp:29
        I(cpphdl_n1449, Vss) <+ 2.9999999999999998e-15 * ddt(V(cpphdl_n1449, Vss)); // Bench initial voltage = 0.0 V.
        // device 1167, IC IC186, analog/basic/inverter.hpp:11
        I(cpphdl_n1424, Vdd) <+ cpphdl_channel(V(BIT_N10_1, Vdd), V(cpphdl_n1424, Vdd), 0.080000000000000002, 0.69999999999999996, -1.0);
        // device 1168, IC IC186, analog/basic/inverter.hpp:12
        I(cpphdl_n1424, Vss) <+ cpphdl_channel(V(BIT_N10_1, Vss), V(cpphdl_n1424, Vss), 0.080000000000000002, 0.69999999999999996, 1.0);
        // device 1169, IC IC184, analog/basic/mos_r2r_dac.hpp:27
        I(cpphdl_n1424, Vss) <+ 2.9999999999999998e-15 * ddt(V(cpphdl_n1424, Vss)); // Bench initial voltage = 0.0 V.
        // device 1170, IC IC184, analog/basic/mos_r2r_dac.hpp:28
        I(cpphdl_n1424, cpphdl_n1450) <+ V(cpphdl_n1424, cpphdl_n1450) / 20000.0;
        // device 1171, IC IC184, analog/basic/mos_r2r_dac.hpp:29
        I(cpphdl_n1450, Vss) <+ 2.9999999999999998e-15 * ddt(V(cpphdl_n1450, Vss)); // Bench initial voltage = 0.0 V.
        // device 1172, IC IC184, analog/basic/mos_r2r_dac.hpp:31
        I(cpphdl_n1449, cpphdl_n1450) <+ V(cpphdl_n1449, cpphdl_n1450) / 10000.0;
        // device 1173, IC IC187, analog/basic/inverter.hpp:11
        I(cpphdl_n1428, Vdd) <+ cpphdl_channel(V(BIT_N10_2, Vdd), V(cpphdl_n1428, Vdd), 0.080000000000000002, 0.69999999999999996, -1.0);
        // device 1174, IC IC187, analog/basic/inverter.hpp:12
        I(cpphdl_n1428, Vss) <+ cpphdl_channel(V(BIT_N10_2, Vss), V(cpphdl_n1428, Vss), 0.080000000000000002, 0.69999999999999996, 1.0);
        // device 1175, IC IC184, analog/basic/mos_r2r_dac.hpp:27
        I(cpphdl_n1428, Vss) <+ 2.9999999999999998e-15 * ddt(V(cpphdl_n1428, Vss)); // Bench initial voltage = 0.0 V.
        // device 1176, IC IC184, analog/basic/mos_r2r_dac.hpp:28
        I(cpphdl_n1428, cpphdl_n1451) <+ V(cpphdl_n1428, cpphdl_n1451) / 20000.0;
        // device 1177, IC IC184, analog/basic/mos_r2r_dac.hpp:29
        I(cpphdl_n1451, Vss) <+ 2.9999999999999998e-15 * ddt(V(cpphdl_n1451, Vss)); // Bench initial voltage = 0.0 V.
        // device 1178, IC IC184, analog/basic/mos_r2r_dac.hpp:31
        I(cpphdl_n1450, cpphdl_n1451) <+ V(cpphdl_n1450, cpphdl_n1451) / 10000.0;
        // device 1179, IC IC188, analog/basic/inverter.hpp:11
        I(cpphdl_n1432, Vdd) <+ cpphdl_channel(V(BIT_N10_3, Vdd), V(cpphdl_n1432, Vdd), 0.080000000000000002, 0.69999999999999996, -1.0);
        // device 1180, IC IC188, analog/basic/inverter.hpp:12
        I(cpphdl_n1432, Vss) <+ cpphdl_channel(V(BIT_N10_3, Vss), V(cpphdl_n1432, Vss), 0.080000000000000002, 0.69999999999999996, 1.0);
        // device 1181, IC IC184, analog/basic/mos_r2r_dac.hpp:27
        I(cpphdl_n1432, Vss) <+ 2.9999999999999998e-15 * ddt(V(cpphdl_n1432, Vss)); // Bench initial voltage = 0.0 V.
        // device 1182, IC IC184, analog/basic/mos_r2r_dac.hpp:28
        I(cpphdl_n1432, cpphdl_n1452) <+ V(cpphdl_n1432, cpphdl_n1452) / 20000.0;
        // device 1183, IC IC184, analog/basic/mos_r2r_dac.hpp:29
        I(cpphdl_n1452, Vss) <+ 2.9999999999999998e-15 * ddt(V(cpphdl_n1452, Vss)); // Bench initial voltage = 0.0 V.
        // device 1184, IC IC184, analog/basic/mos_r2r_dac.hpp:31
        I(cpphdl_n1451, cpphdl_n1452) <+ V(cpphdl_n1451, cpphdl_n1452) / 10000.0;
        // device 1185, IC IC189, analog/basic/inverter.hpp:11
        I(cpphdl_n1436, Vdd) <+ cpphdl_channel(V(BIT_N10_4, Vdd), V(cpphdl_n1436, Vdd), 0.080000000000000002, 0.69999999999999996, -1.0);
        // device 1186, IC IC189, analog/basic/inverter.hpp:12
        I(cpphdl_n1436, Vss) <+ cpphdl_channel(V(BIT_N10_4, Vss), V(cpphdl_n1436, Vss), 0.080000000000000002, 0.69999999999999996, 1.0);
        // device 1187, IC IC184, analog/basic/mos_r2r_dac.hpp:27
        I(cpphdl_n1436, Vss) <+ 2.9999999999999998e-15 * ddt(V(cpphdl_n1436, Vss)); // Bench initial voltage = 0.0 V.
        // device 1188, IC IC184, analog/basic/mos_r2r_dac.hpp:28
        I(cpphdl_n1436, cpphdl_n1453) <+ V(cpphdl_n1436, cpphdl_n1453) / 20000.0;
        // device 1189, IC IC184, analog/basic/mos_r2r_dac.hpp:29
        I(cpphdl_n1453, Vss) <+ 2.9999999999999998e-15 * ddt(V(cpphdl_n1453, Vss)); // Bench initial voltage = 0.0 V.
        // device 1190, IC IC184, analog/basic/mos_r2r_dac.hpp:31
        I(cpphdl_n1452, cpphdl_n1453) <+ V(cpphdl_n1452, cpphdl_n1453) / 10000.0;
        // device 1191, IC IC190, analog/basic/inverter.hpp:11
        I(cpphdl_n1440, Vdd) <+ cpphdl_channel(V(BIT_N10_5, Vdd), V(cpphdl_n1440, Vdd), 0.080000000000000002, 0.69999999999999996, -1.0);
        // device 1192, IC IC190, analog/basic/inverter.hpp:12
        I(cpphdl_n1440, Vss) <+ cpphdl_channel(V(BIT_N10_5, Vss), V(cpphdl_n1440, Vss), 0.080000000000000002, 0.69999999999999996, 1.0);
        // device 1193, IC IC184, analog/basic/mos_r2r_dac.hpp:27
        I(cpphdl_n1440, Vss) <+ 2.9999999999999998e-15 * ddt(V(cpphdl_n1440, Vss)); // Bench initial voltage = 0.0 V.
        // device 1194, IC IC184, analog/basic/mos_r2r_dac.hpp:28
        I(cpphdl_n1440, cpphdl_n1454) <+ V(cpphdl_n1440, cpphdl_n1454) / 20000.0;
        // device 1195, IC IC184, analog/basic/mos_r2r_dac.hpp:29
        I(cpphdl_n1454, Vss) <+ 2.9999999999999998e-15 * ddt(V(cpphdl_n1454, Vss)); // Bench initial voltage = 0.0 V.
        // device 1196, IC IC184, analog/basic/mos_r2r_dac.hpp:31
        I(cpphdl_n1453, cpphdl_n1454) <+ V(cpphdl_n1453, cpphdl_n1454) / 10000.0;
        // device 1197, IC IC191, analog/basic/inverter.hpp:11
        I(cpphdl_n1444, Vdd) <+ cpphdl_channel(V(BIT_N10_6, Vdd), V(cpphdl_n1444, Vdd), 0.080000000000000002, 0.69999999999999996, -1.0);
        // device 1198, IC IC191, analog/basic/inverter.hpp:12
        I(cpphdl_n1444, Vss) <+ cpphdl_channel(V(BIT_N10_6, Vss), V(cpphdl_n1444, Vss), 0.080000000000000002, 0.69999999999999996, 1.0);
        // device 1199, IC IC184, analog/basic/mos_r2r_dac.hpp:27
        I(cpphdl_n1444, Vss) <+ 2.9999999999999998e-15 * ddt(V(cpphdl_n1444, Vss)); // Bench initial voltage = 0.0 V.
        // device 1200, IC IC184, analog/basic/mos_r2r_dac.hpp:28
        I(cpphdl_n1444, cpphdl_n1455) <+ V(cpphdl_n1444, cpphdl_n1455) / 20000.0;
        // device 1201, IC IC184, analog/basic/mos_r2r_dac.hpp:29
        I(cpphdl_n1455, Vss) <+ 2.9999999999999998e-15 * ddt(V(cpphdl_n1455, Vss)); // Bench initial voltage = 0.0 V.
        // device 1202, IC IC184, analog/basic/mos_r2r_dac.hpp:31
        I(cpphdl_n1454, cpphdl_n1455) <+ V(cpphdl_n1454, cpphdl_n1455) / 10000.0;
        // device 1203, IC IC192, analog/basic/inverter.hpp:11
        I(cpphdl_n1448, Vdd) <+ cpphdl_channel(V(BIT_N10_7, Vdd), V(cpphdl_n1448, Vdd), 0.080000000000000002, 0.69999999999999996, -1.0);
        // device 1204, IC IC192, analog/basic/inverter.hpp:12
        I(cpphdl_n1448, Vss) <+ cpphdl_channel(V(BIT_N10_7, Vss), V(cpphdl_n1448, Vss), 0.080000000000000002, 0.69999999999999996, 1.0);
        // device 1205, IC IC184, analog/basic/mos_r2r_dac.hpp:27
        I(cpphdl_n1448, Vss) <+ 2.9999999999999998e-15 * ddt(V(cpphdl_n1448, Vss)); // Bench initial voltage = 0.0 V.
        // device 1206, IC IC184, analog/basic/mos_r2r_dac.hpp:28
        I(cpphdl_n1448, cpphdl_n1460) <+ V(cpphdl_n1448, cpphdl_n1460) / 20000.0;
        // device 1207, IC IC184, analog/basic/mos_r2r_dac.hpp:29
        I(cpphdl_n1460, Vss) <+ 2.9999999999999998e-15 * ddt(V(cpphdl_n1460, Vss)); // Bench initial voltage = 0.0 V.
        // device 1208, IC IC184, analog/basic/mos_r2r_dac.hpp:31
        I(cpphdl_n1455, cpphdl_n1460) <+ V(cpphdl_n1455, cpphdl_n1460) / 10000.0;
        // device 1209, IC IC184, analog/basic/mos_r2r_dac.hpp:33
        I(Vss, cpphdl_n1449) <+ V(Vss, cpphdl_n1449) / 20000.0;
        // device 1210, IC IC193, analog/basic/nmos_resistor_amplifier.hpp:23
        I(Vdd, cpphdl_n1469) <+ V(Vdd, cpphdl_n1469) / 1000.0;
        // device 1211, IC IC193, analog/basic/nmos_resistor_amplifier.hpp:24
        I(Vdd, cpphdl_n1468) <+ V(Vdd, cpphdl_n1468) / 1000.0;
        // device 1212, IC IC193, analog/basic/nmos_resistor_amplifier.hpp:25
        I(cpphdl_n1469, cpphdl_n1463) <+ cpphdl_channel(V(cpphdl_n1459, cpphdl_n1463), V(cpphdl_n1469, cpphdl_n1463), 0.014999999999999999, 0.69999999999999996, 1.0);
        // device 1213, IC IC193, analog/basic/nmos_resistor_amplifier.hpp:26
        I(cpphdl_n1468, cpphdl_n1464) <+ cpphdl_channel(V(cpphdl_n1460, cpphdl_n1464), V(cpphdl_n1468, cpphdl_n1464), 0.014999999999999999, 0.69999999999999996, 1.0);
        // device 1214, IC IC193, analog/basic/nmos_resistor_amplifier.hpp:27
        I(cpphdl_n1465, cpphdl_n1463) <+ V(cpphdl_n1465, cpphdl_n1463) / 50.0;
        // device 1215, IC IC193, analog/basic/nmos_resistor_amplifier.hpp:28
        I(cpphdl_n1465, cpphdl_n1464) <+ V(cpphdl_n1465, cpphdl_n1464) / 50.0;
        // device 1216, IC IC193, analog/basic/nmos_resistor_amplifier.hpp:29
        I(Vss, cpphdl_n1465) <+ V(Vss, cpphdl_n1465) / 150.0;
        // device 1217, IC IC193, analog/basic/nmos_resistor_amplifier.hpp:30
        I(cpphdl_n1469, Vdd) <+ 2.9999999999999998e-13 * ddt(V(cpphdl_n1469, Vdd)); // Bench initial voltage = 0.0 V.
        // device 1218, IC IC193, analog/basic/nmos_resistor_amplifier.hpp:31
        I(cpphdl_n1468, Vdd) <+ 2.9999999999999998e-13 * ddt(V(cpphdl_n1468, Vdd)); // Bench initial voltage = 0.0 V.
        // device 1219, IC IC193, analog/basic/nmos_resistor_amplifier.hpp:32
        I(cpphdl_n1465, Vss) <+ 4e-14 * ddt(V(cpphdl_n1465, Vss)); // Bench initial voltage = 0.0 V.
        // device 1220, IC IC193, analog/basic/nmos_resistor_amplifier.hpp:34
        I(cpphdl_n1459, cpphdl_n1463) <+ 2e-14 * ddt(V(cpphdl_n1459, cpphdl_n1463)); // Bench initial voltage = 1.6499999999999999 V.
        // device 1221, IC IC193, analog/basic/nmos_resistor_amplifier.hpp:35
        I(cpphdl_n1460, cpphdl_n1464) <+ 2e-14 * ddt(V(cpphdl_n1460, cpphdl_n1464)); // Bench initial voltage = 0.0 V.
        // device 1222, IC IC193, analog/basic/nmos_resistor_amplifier.hpp:36
        I(cpphdl_n1459, cpphdl_n1469) <+ 2.9999999999999998e-15 * ddt(V(cpphdl_n1459, cpphdl_n1469)); // Bench initial voltage = -1.6499999999999999 V.
        // device 1223, IC IC193, analog/basic/nmos_resistor_amplifier.hpp:37
        I(cpphdl_n1460, cpphdl_n1468) <+ 2.9999999999999998e-15 * ddt(V(cpphdl_n1460, cpphdl_n1468)); // Bench initial voltage = -3.2999999999999998 V.
        // device 1224, IC IC194, analog/basic/strongarm_comparator.hpp:28
        I(cpphdl_n1473, cpphdl_n1475) <+ cpphdl_channel(V(cpphdl_n1468, cpphdl_n1475), V(cpphdl_n1473, cpphdl_n1475), 0.0080000000000000002, 0.69999999999999996, 1.0);
        // device 1225, IC IC194, analog/basic/strongarm_comparator.hpp:29
        I(cpphdl_n1474, cpphdl_n1475) <+ cpphdl_channel(V(cpphdl_n1469, cpphdl_n1475), V(cpphdl_n1474, cpphdl_n1475), 0.0080000000000000002, 0.69999999999999996, 1.0);
        // device 1226, IC IC194, analog/basic/strongarm_comparator.hpp:30
        I(cpphdl_n1475, Vss) <+ cpphdl_channel(V(EVALUATE, Vss), V(cpphdl_n1475, Vss), 0.0080000000000000002, 0.69999999999999996, 1.0);
        // device 1227, IC IC194, analog/basic/strongarm_comparator.hpp:33
        I(cpphdl_n1487, cpphdl_n1473) <+ cpphdl_channel(V(cpphdl_n1493, cpphdl_n1473), V(cpphdl_n1487, cpphdl_n1473), 0.0040000000000000001, 0.69999999999999996, 1.0);
        // device 1228, IC IC194, analog/basic/strongarm_comparator.hpp:34
        I(cpphdl_n1493, cpphdl_n1474) <+ cpphdl_channel(V(cpphdl_n1487, cpphdl_n1474), V(cpphdl_n1493, cpphdl_n1474), 0.0040000000000000001, 0.69999999999999996, 1.0);
        // device 1229, IC IC194, analog/basic/strongarm_comparator.hpp:35
        I(cpphdl_n1493, Vdd) <+ cpphdl_channel(V(cpphdl_n1487, Vdd), V(cpphdl_n1493, Vdd), 0.002, 0.69999999999999996, -1.0);
        // device 1230, IC IC194, analog/basic/strongarm_comparator.hpp:36
        I(cpphdl_n1487, Vdd) <+ cpphdl_channel(V(cpphdl_n1493, Vdd), V(cpphdl_n1487, Vdd), 0.002, 0.69999999999999996, -1.0);
        // device 1231, IC IC194, analog/basic/strongarm_comparator.hpp:38
        I(cpphdl_n1473, Vdd) <+ cpphdl_channel(V(EVALUATE, Vdd), V(cpphdl_n1473, Vdd), 0.002, 0.69999999999999996, -1.0);
        // device 1232, IC IC194, analog/basic/strongarm_comparator.hpp:39
        I(cpphdl_n1474, Vdd) <+ cpphdl_channel(V(EVALUATE, Vdd), V(cpphdl_n1474, Vdd), 0.002, 0.69999999999999996, -1.0);
        // device 1233, IC IC194, analog/basic/strongarm_comparator.hpp:40
        I(cpphdl_n1493, Vdd) <+ cpphdl_channel(V(EVALUATE, Vdd), V(cpphdl_n1493, Vdd), 0.002, 0.69999999999999996, -1.0);
        // device 1234, IC IC194, analog/basic/strongarm_comparator.hpp:41
        I(cpphdl_n1487, Vdd) <+ cpphdl_channel(V(EVALUATE, Vdd), V(cpphdl_n1487, Vdd), 0.002, 0.69999999999999996, -1.0);
        // device 1235, IC IC194, analog/basic/strongarm_comparator.hpp:42
        I(cpphdl_n1473, Vss) <+ 2.9999999999999998e-14 * ddt(V(cpphdl_n1473, Vss)); // Bench initial voltage = 0.0 V.
        // device 1236, IC IC194, analog/basic/strongarm_comparator.hpp:43
        I(cpphdl_n1474, Vss) <+ 2.9999999999999998e-14 * ddt(V(cpphdl_n1474, Vss)); // Bench initial voltage = 0.0 V.
        // device 1237, IC IC194, analog/basic/strongarm_comparator.hpp:44
        I(cpphdl_n1475, Vss) <+ 2.9999999999999998e-14 * ddt(V(cpphdl_n1475, Vss)); // Bench initial voltage = 0.0 V.
        // device 1238, IC IC194, analog/basic/strongarm_comparator.hpp:45
        I(cpphdl_n1493, Vss) <+ 5.0000000000000002e-14 * ddt(V(cpphdl_n1493, Vss)); // Bench initial voltage = 0.0 V.
        // device 1239, IC IC194, analog/basic/strongarm_comparator.hpp:46
        I(cpphdl_n1487, Vss) <+ 5.0000000000000002e-14 * ddt(V(cpphdl_n1487, Vss)); // Bench initial voltage = 0.0 V.
        // device 1240, IC IC194, analog/basic/strongarm_comparator.hpp:47
        I(cpphdl_n1468, cpphdl_n1475) <+ 2e-14 * ddt(V(cpphdl_n1468, cpphdl_n1475)); // Bench initial voltage = 3.2999999999999998 V.
        // device 1241, IC IC194, analog/basic/strongarm_comparator.hpp:48
        I(cpphdl_n1469, cpphdl_n1475) <+ 2e-14 * ddt(V(cpphdl_n1469, cpphdl_n1475)); // Bench initial voltage = 3.2999999999999998 V.
        // device 1242, IC IC194, analog/basic/strongarm_comparator.hpp:49
        I(cpphdl_n1468, cpphdl_n1473) <+ 2.9999999999999998e-15 * ddt(V(cpphdl_n1468, cpphdl_n1473)); // Bench initial voltage = 3.2999999999999998 V.
        // device 1243, IC IC194, analog/basic/strongarm_comparator.hpp:50
        I(cpphdl_n1469, cpphdl_n1474) <+ 2.9999999999999998e-15 * ddt(V(cpphdl_n1469, cpphdl_n1474)); // Bench initial voltage = 3.2999999999999998 V.
        // device 1244, IC IC196, analog/basic/cmos_logic.hpp:17
        I(DECISION10, Vss) <+ 5.0000000000000002e-14 * ddt(V(DECISION10, Vss)); // Bench initial voltage = 0.0 V.
        // device 1245, IC IC196, analog/basic/cmos_logic.hpp:18
        I(DECISION10, Vdd) <+ cpphdl_channel(V(cpphdl_n1487, Vdd), V(DECISION10, Vdd), 0.01, 0.69999999999999996, -1.0);
        // device 1246, IC IC196, analog/basic/cmos_logic.hpp:19
        I(DECISION10, Vdd) <+ cpphdl_channel(V(DECISION_N10, Vdd), V(DECISION10, Vdd), 0.01, 0.69999999999999996, -1.0);
        // device 1247, IC IC196, analog/basic/cmos_logic.hpp:20
        I(DECISION10, cpphdl_n1490) <+ cpphdl_channel(V(cpphdl_n1487, cpphdl_n1490), V(DECISION10, cpphdl_n1490), 0.01, 0.69999999999999996, 1.0);
        // device 1248, IC IC196, analog/basic/cmos_logic.hpp:21
        I(cpphdl_n1490, Vss) <+ cpphdl_channel(V(DECISION_N10, Vss), V(cpphdl_n1490, Vss), 0.01, 0.69999999999999996, 1.0);
        // device 1249, IC IC196, analog/basic/cmos_logic.hpp:23
        I(DECISION10, Vss) <+ V(DECISION10, Vss) / 1000000000.0;
        // device 1250, IC IC196, analog/basic/cmos_logic.hpp:24
        I(cpphdl_n1490, Vss) <+ V(cpphdl_n1490, Vss) / 1000000000.0;
        // device 1251, IC IC197, analog/basic/cmos_logic.hpp:17
        I(DECISION_N10, Vss) <+ 5.0000000000000002e-14 * ddt(V(DECISION_N10, Vss)); // Bench initial voltage = 0.0 V.
        // device 1252, IC IC197, analog/basic/cmos_logic.hpp:18
        I(DECISION_N10, Vdd) <+ cpphdl_channel(V(cpphdl_n1493, Vdd), V(DECISION_N10, Vdd), 0.01, 0.69999999999999996, -1.0);
        // device 1253, IC IC197, analog/basic/cmos_logic.hpp:19
        I(DECISION_N10, Vdd) <+ cpphdl_channel(V(DECISION10, Vdd), V(DECISION_N10, Vdd), 0.01, 0.69999999999999996, -1.0);
        // device 1254, IC IC197, analog/basic/cmos_logic.hpp:20
        I(DECISION_N10, cpphdl_n1496) <+ cpphdl_channel(V(cpphdl_n1493, cpphdl_n1496), V(DECISION_N10, cpphdl_n1496), 0.01, 0.69999999999999996, 1.0);
        // device 1255, IC IC197, analog/basic/cmos_logic.hpp:21
        I(cpphdl_n1496, Vss) <+ cpphdl_channel(V(DECISION10, Vss), V(cpphdl_n1496, Vss), 0.01, 0.69999999999999996, 1.0);
        // device 1256, IC IC197, analog/basic/cmos_logic.hpp:23
        I(DECISION_N10, Vss) <+ V(DECISION_N10, Vss) / 1000000000.0;
        // device 1257, IC IC197, analog/basic/cmos_logic.hpp:24
        I(cpphdl_n1496, Vss) <+ V(cpphdl_n1496, Vss) / 1000000000.0;
        // device 1258, IC IC195, analog/basic/nand_latch.hpp:36
        I(cpphdl_n1487, Vss) <+ 2.9999999999999998e-15 * ddt(V(cpphdl_n1487, Vss)); // Bench initial voltage = 0.0 V.
        // device 1259, IC IC195, analog/basic/nand_latch.hpp:37
        I(cpphdl_n1493, Vss) <+ 2.9999999999999998e-15 * ddt(V(cpphdl_n1493, Vss)); // Bench initial voltage = 0.0 V.
        // device 1260, IC IC198, analog/basic/inverter.hpp:11
        I(cpphdl_n1501, Vdd) <+ cpphdl_channel(V(CLEAR, Vdd), V(cpphdl_n1501, Vdd), 0.01, 0.69999999999999996, -1.0);
        // device 1261, IC IC198, analog/basic/inverter.hpp:12
        I(cpphdl_n1501, Vss) <+ cpphdl_channel(V(CLEAR, Vss), V(cpphdl_n1501, Vss), 0.01, 0.69999999999999996, 1.0);
        // device 1262, IC IC195, analog/basic/nand_latch.hpp:58
        I(cpphdl_n1501, Vss) <+ 2.9999999999999998e-15 * ddt(V(cpphdl_n1501, Vss)); // Bench initial voltage = 0.0 V.
        // device 1263, IC IC195, analog/basic/nand_latch.hpp:59
        I(DECISION10, Vss) <+ cpphdl_channel(V(CLEAR, Vss), V(DECISION10, Vss), 0.050000000000000003, 0.69999999999999996, 1.0);
        // device 1264, IC IC195, analog/basic/nand_latch.hpp:60
        I(DECISION_N10, Vdd) <+ cpphdl_channel(V(cpphdl_n1501, Vdd), V(DECISION_N10, Vdd), 0.050000000000000003, 0.69999999999999996, -1.0);
        // device 1265, IC IC201, analog/basic/inverter.hpp:11
        I(cpphdl_n1525, Vdd) <+ cpphdl_channel(V(TRACK11, Vdd), V(cpphdl_n1525, Vdd), 0.0040000000000000001, 0.69999999999999996, -1.0);
        // device 1266, IC IC201, analog/basic/inverter.hpp:12
        I(cpphdl_n1525, Vss) <+ cpphdl_channel(V(TRACK11, Vss), V(cpphdl_n1525, Vss), 0.0040000000000000001, 0.69999999999999996, 1.0);
        // device 1267, IC IC200, analog/basic/mos_track_hold.hpp:31
        I(cpphdl_n1525, Vss) <+ 2e-14 * ddt(V(cpphdl_n1525, Vss)); // Bench initial voltage = 3.2999999999999998 V.
        // device 1268, IC IC200, analog/basic/mos_track_hold.hpp:32
        I(IN, cpphdl_n1579) <+ cpphdl_channel(V(TRACK11, cpphdl_n1579), V(IN, cpphdl_n1579), 0.080000000000000002, 0.69999999999999996, 1.0);
        // device 1269, IC IC200, analog/basic/mos_track_hold.hpp:33
        I(cpphdl_n1579, IN) <+ cpphdl_channel(V(cpphdl_n1525, IN), V(cpphdl_n1579, IN), 0.040000000000000001, 0.69999999999999996, -1.0);
        // device 1270, IC IC200, analog/basic/mos_track_hold.hpp:37
        I(cpphdl_n1579, cpphdl_n1579) <+ cpphdl_channel(V(cpphdl_n1525, cpphdl_n1579), V(cpphdl_n1579, cpphdl_n1579), 0.040000000000000001, 0.69999999999999996, 1.0);
        // device 1271, IC IC200, analog/basic/mos_track_hold.hpp:38
        I(cpphdl_n1579, cpphdl_n1579) <+ cpphdl_channel(V(TRACK11, cpphdl_n1579), V(cpphdl_n1579, cpphdl_n1579), 0.02, 0.69999999999999996, -1.0);
        // device 1272, IC IC200, analog/basic/mos_track_hold.hpp:39
        I(cpphdl_n1579, Vss) <+ 2e-12 * ddt(V(cpphdl_n1579, Vss)); // Bench initial voltage = 1.6499999999999999 V.
        // device 1273, IC IC200, analog/basic/mos_track_hold.hpp:41
        I(Vss, cpphdl_n1579) <+ V(Vss, cpphdl_n1579) / 1000000000.0;
        // device 1274, IC IC200, analog/basic/mos_track_hold.hpp:42
        I(TRACK11, cpphdl_n1579) <+ 8.0000000000000006e-15 * ddt(V(TRACK11, cpphdl_n1579)); // Bench initial voltage = -1.6499999999999999 V.
        // device 1275, IC IC200, analog/basic/mos_track_hold.hpp:43
        I(cpphdl_n1525, cpphdl_n1579) <+ 8.0000000000000006e-15 * ddt(V(cpphdl_n1525, cpphdl_n1579)); // Bench initial voltage = 1.6499999999999999 V.
        // device 1276, IC IC200, analog/basic/mos_track_hold.hpp:44
        I(IN, cpphdl_n1579) <+ 4.0000000000000003e-15 * ddt(V(IN, cpphdl_n1579)); // Bench initial voltage = 0.0 V.
        // device 1277, IC IC203, analog/basic/inverter.hpp:11
        I(cpphdl_n1540, Vdd) <+ cpphdl_channel(V(BIT_N11_0, Vdd), V(cpphdl_n1540, Vdd), 0.080000000000000002, 0.69999999999999996, -1.0);
        // device 1278, IC IC203, analog/basic/inverter.hpp:12
        I(cpphdl_n1540, Vss) <+ cpphdl_channel(V(BIT_N11_0, Vss), V(cpphdl_n1540, Vss), 0.080000000000000002, 0.69999999999999996, 1.0);
        // device 1279, IC IC202, analog/basic/mos_r2r_dac.hpp:27
        I(cpphdl_n1540, Vss) <+ 2.9999999999999998e-15 * ddt(V(cpphdl_n1540, Vss)); // Bench initial voltage = 0.0 V.
        // device 1280, IC IC202, analog/basic/mos_r2r_dac.hpp:28
        I(cpphdl_n1540, cpphdl_n1569) <+ V(cpphdl_n1540, cpphdl_n1569) / 20000.0;
        // device 1281, IC IC202, analog/basic/mos_r2r_dac.hpp:29
        I(cpphdl_n1569, Vss) <+ 2.9999999999999998e-15 * ddt(V(cpphdl_n1569, Vss)); // Bench initial voltage = 0.0 V.
        // device 1282, IC IC204, analog/basic/inverter.hpp:11
        I(cpphdl_n1544, Vdd) <+ cpphdl_channel(V(BIT_N11_1, Vdd), V(cpphdl_n1544, Vdd), 0.080000000000000002, 0.69999999999999996, -1.0);
        // device 1283, IC IC204, analog/basic/inverter.hpp:12
        I(cpphdl_n1544, Vss) <+ cpphdl_channel(V(BIT_N11_1, Vss), V(cpphdl_n1544, Vss), 0.080000000000000002, 0.69999999999999996, 1.0);
        // device 1284, IC IC202, analog/basic/mos_r2r_dac.hpp:27
        I(cpphdl_n1544, Vss) <+ 2.9999999999999998e-15 * ddt(V(cpphdl_n1544, Vss)); // Bench initial voltage = 0.0 V.
        // device 1285, IC IC202, analog/basic/mos_r2r_dac.hpp:28
        I(cpphdl_n1544, cpphdl_n1570) <+ V(cpphdl_n1544, cpphdl_n1570) / 20000.0;
        // device 1286, IC IC202, analog/basic/mos_r2r_dac.hpp:29
        I(cpphdl_n1570, Vss) <+ 2.9999999999999998e-15 * ddt(V(cpphdl_n1570, Vss)); // Bench initial voltage = 0.0 V.
        // device 1287, IC IC202, analog/basic/mos_r2r_dac.hpp:31
        I(cpphdl_n1569, cpphdl_n1570) <+ V(cpphdl_n1569, cpphdl_n1570) / 10000.0;
        // device 1288, IC IC205, analog/basic/inverter.hpp:11
        I(cpphdl_n1548, Vdd) <+ cpphdl_channel(V(BIT_N11_2, Vdd), V(cpphdl_n1548, Vdd), 0.080000000000000002, 0.69999999999999996, -1.0);
        // device 1289, IC IC205, analog/basic/inverter.hpp:12
        I(cpphdl_n1548, Vss) <+ cpphdl_channel(V(BIT_N11_2, Vss), V(cpphdl_n1548, Vss), 0.080000000000000002, 0.69999999999999996, 1.0);
        // device 1290, IC IC202, analog/basic/mos_r2r_dac.hpp:27
        I(cpphdl_n1548, Vss) <+ 2.9999999999999998e-15 * ddt(V(cpphdl_n1548, Vss)); // Bench initial voltage = 0.0 V.
        // device 1291, IC IC202, analog/basic/mos_r2r_dac.hpp:28
        I(cpphdl_n1548, cpphdl_n1571) <+ V(cpphdl_n1548, cpphdl_n1571) / 20000.0;
        // device 1292, IC IC202, analog/basic/mos_r2r_dac.hpp:29
        I(cpphdl_n1571, Vss) <+ 2.9999999999999998e-15 * ddt(V(cpphdl_n1571, Vss)); // Bench initial voltage = 0.0 V.
        // device 1293, IC IC202, analog/basic/mos_r2r_dac.hpp:31
        I(cpphdl_n1570, cpphdl_n1571) <+ V(cpphdl_n1570, cpphdl_n1571) / 10000.0;
        // device 1294, IC IC206, analog/basic/inverter.hpp:11
        I(cpphdl_n1552, Vdd) <+ cpphdl_channel(V(BIT_N11_3, Vdd), V(cpphdl_n1552, Vdd), 0.080000000000000002, 0.69999999999999996, -1.0);
        // device 1295, IC IC206, analog/basic/inverter.hpp:12
        I(cpphdl_n1552, Vss) <+ cpphdl_channel(V(BIT_N11_3, Vss), V(cpphdl_n1552, Vss), 0.080000000000000002, 0.69999999999999996, 1.0);
        // device 1296, IC IC202, analog/basic/mos_r2r_dac.hpp:27
        I(cpphdl_n1552, Vss) <+ 2.9999999999999998e-15 * ddt(V(cpphdl_n1552, Vss)); // Bench initial voltage = 0.0 V.
        // device 1297, IC IC202, analog/basic/mos_r2r_dac.hpp:28
        I(cpphdl_n1552, cpphdl_n1572) <+ V(cpphdl_n1552, cpphdl_n1572) / 20000.0;
        // device 1298, IC IC202, analog/basic/mos_r2r_dac.hpp:29
        I(cpphdl_n1572, Vss) <+ 2.9999999999999998e-15 * ddt(V(cpphdl_n1572, Vss)); // Bench initial voltage = 0.0 V.
        // device 1299, IC IC202, analog/basic/mos_r2r_dac.hpp:31
        I(cpphdl_n1571, cpphdl_n1572) <+ V(cpphdl_n1571, cpphdl_n1572) / 10000.0;
        // device 1300, IC IC207, analog/basic/inverter.hpp:11
        I(cpphdl_n1556, Vdd) <+ cpphdl_channel(V(BIT_N11_4, Vdd), V(cpphdl_n1556, Vdd), 0.080000000000000002, 0.69999999999999996, -1.0);
        // device 1301, IC IC207, analog/basic/inverter.hpp:12
        I(cpphdl_n1556, Vss) <+ cpphdl_channel(V(BIT_N11_4, Vss), V(cpphdl_n1556, Vss), 0.080000000000000002, 0.69999999999999996, 1.0);
        // device 1302, IC IC202, analog/basic/mos_r2r_dac.hpp:27
        I(cpphdl_n1556, Vss) <+ 2.9999999999999998e-15 * ddt(V(cpphdl_n1556, Vss)); // Bench initial voltage = 0.0 V.
        // device 1303, IC IC202, analog/basic/mos_r2r_dac.hpp:28
        I(cpphdl_n1556, cpphdl_n1573) <+ V(cpphdl_n1556, cpphdl_n1573) / 20000.0;
        // device 1304, IC IC202, analog/basic/mos_r2r_dac.hpp:29
        I(cpphdl_n1573, Vss) <+ 2.9999999999999998e-15 * ddt(V(cpphdl_n1573, Vss)); // Bench initial voltage = 0.0 V.
        // device 1305, IC IC202, analog/basic/mos_r2r_dac.hpp:31
        I(cpphdl_n1572, cpphdl_n1573) <+ V(cpphdl_n1572, cpphdl_n1573) / 10000.0;
        // device 1306, IC IC208, analog/basic/inverter.hpp:11
        I(cpphdl_n1560, Vdd) <+ cpphdl_channel(V(BIT_N11_5, Vdd), V(cpphdl_n1560, Vdd), 0.080000000000000002, 0.69999999999999996, -1.0);
        // device 1307, IC IC208, analog/basic/inverter.hpp:12
        I(cpphdl_n1560, Vss) <+ cpphdl_channel(V(BIT_N11_5, Vss), V(cpphdl_n1560, Vss), 0.080000000000000002, 0.69999999999999996, 1.0);
        // device 1308, IC IC202, analog/basic/mos_r2r_dac.hpp:27
        I(cpphdl_n1560, Vss) <+ 2.9999999999999998e-15 * ddt(V(cpphdl_n1560, Vss)); // Bench initial voltage = 0.0 V.
        // device 1309, IC IC202, analog/basic/mos_r2r_dac.hpp:28
        I(cpphdl_n1560, cpphdl_n1574) <+ V(cpphdl_n1560, cpphdl_n1574) / 20000.0;
        // device 1310, IC IC202, analog/basic/mos_r2r_dac.hpp:29
        I(cpphdl_n1574, Vss) <+ 2.9999999999999998e-15 * ddt(V(cpphdl_n1574, Vss)); // Bench initial voltage = 0.0 V.
        // device 1311, IC IC202, analog/basic/mos_r2r_dac.hpp:31
        I(cpphdl_n1573, cpphdl_n1574) <+ V(cpphdl_n1573, cpphdl_n1574) / 10000.0;
        // device 1312, IC IC209, analog/basic/inverter.hpp:11
        I(cpphdl_n1564, Vdd) <+ cpphdl_channel(V(BIT_N11_6, Vdd), V(cpphdl_n1564, Vdd), 0.080000000000000002, 0.69999999999999996, -1.0);
        // device 1313, IC IC209, analog/basic/inverter.hpp:12
        I(cpphdl_n1564, Vss) <+ cpphdl_channel(V(BIT_N11_6, Vss), V(cpphdl_n1564, Vss), 0.080000000000000002, 0.69999999999999996, 1.0);
        // device 1314, IC IC202, analog/basic/mos_r2r_dac.hpp:27
        I(cpphdl_n1564, Vss) <+ 2.9999999999999998e-15 * ddt(V(cpphdl_n1564, Vss)); // Bench initial voltage = 0.0 V.
        // device 1315, IC IC202, analog/basic/mos_r2r_dac.hpp:28
        I(cpphdl_n1564, cpphdl_n1575) <+ V(cpphdl_n1564, cpphdl_n1575) / 20000.0;
        // device 1316, IC IC202, analog/basic/mos_r2r_dac.hpp:29
        I(cpphdl_n1575, Vss) <+ 2.9999999999999998e-15 * ddt(V(cpphdl_n1575, Vss)); // Bench initial voltage = 0.0 V.
        // device 1317, IC IC202, analog/basic/mos_r2r_dac.hpp:31
        I(cpphdl_n1574, cpphdl_n1575) <+ V(cpphdl_n1574, cpphdl_n1575) / 10000.0;
        // device 1318, IC IC210, analog/basic/inverter.hpp:11
        I(cpphdl_n1568, Vdd) <+ cpphdl_channel(V(BIT_N11_7, Vdd), V(cpphdl_n1568, Vdd), 0.080000000000000002, 0.69999999999999996, -1.0);
        // device 1319, IC IC210, analog/basic/inverter.hpp:12
        I(cpphdl_n1568, Vss) <+ cpphdl_channel(V(BIT_N11_7, Vss), V(cpphdl_n1568, Vss), 0.080000000000000002, 0.69999999999999996, 1.0);
        // device 1320, IC IC202, analog/basic/mos_r2r_dac.hpp:27
        I(cpphdl_n1568, Vss) <+ 2.9999999999999998e-15 * ddt(V(cpphdl_n1568, Vss)); // Bench initial voltage = 0.0 V.
        // device 1321, IC IC202, analog/basic/mos_r2r_dac.hpp:28
        I(cpphdl_n1568, cpphdl_n1580) <+ V(cpphdl_n1568, cpphdl_n1580) / 20000.0;
        // device 1322, IC IC202, analog/basic/mos_r2r_dac.hpp:29
        I(cpphdl_n1580, Vss) <+ 2.9999999999999998e-15 * ddt(V(cpphdl_n1580, Vss)); // Bench initial voltage = 0.0 V.
        // device 1323, IC IC202, analog/basic/mos_r2r_dac.hpp:31
        I(cpphdl_n1575, cpphdl_n1580) <+ V(cpphdl_n1575, cpphdl_n1580) / 10000.0;
        // device 1324, IC IC202, analog/basic/mos_r2r_dac.hpp:33
        I(Vss, cpphdl_n1569) <+ V(Vss, cpphdl_n1569) / 20000.0;
        // device 1325, IC IC211, analog/basic/nmos_resistor_amplifier.hpp:23
        I(Vdd, cpphdl_n1589) <+ V(Vdd, cpphdl_n1589) / 1000.0;
        // device 1326, IC IC211, analog/basic/nmos_resistor_amplifier.hpp:24
        I(Vdd, cpphdl_n1588) <+ V(Vdd, cpphdl_n1588) / 1000.0;
        // device 1327, IC IC211, analog/basic/nmos_resistor_amplifier.hpp:25
        I(cpphdl_n1589, cpphdl_n1583) <+ cpphdl_channel(V(cpphdl_n1579, cpphdl_n1583), V(cpphdl_n1589, cpphdl_n1583), 0.014999999999999999, 0.69999999999999996, 1.0);
        // device 1328, IC IC211, analog/basic/nmos_resistor_amplifier.hpp:26
        I(cpphdl_n1588, cpphdl_n1584) <+ cpphdl_channel(V(cpphdl_n1580, cpphdl_n1584), V(cpphdl_n1588, cpphdl_n1584), 0.014999999999999999, 0.69999999999999996, 1.0);
        // device 1329, IC IC211, analog/basic/nmos_resistor_amplifier.hpp:27
        I(cpphdl_n1585, cpphdl_n1583) <+ V(cpphdl_n1585, cpphdl_n1583) / 50.0;
        // device 1330, IC IC211, analog/basic/nmos_resistor_amplifier.hpp:28
        I(cpphdl_n1585, cpphdl_n1584) <+ V(cpphdl_n1585, cpphdl_n1584) / 50.0;
        // device 1331, IC IC211, analog/basic/nmos_resistor_amplifier.hpp:29
        I(Vss, cpphdl_n1585) <+ V(Vss, cpphdl_n1585) / 150.0;
        // device 1332, IC IC211, analog/basic/nmos_resistor_amplifier.hpp:30
        I(cpphdl_n1589, Vdd) <+ 2.9999999999999998e-13 * ddt(V(cpphdl_n1589, Vdd)); // Bench initial voltage = 0.0 V.
        // device 1333, IC IC211, analog/basic/nmos_resistor_amplifier.hpp:31
        I(cpphdl_n1588, Vdd) <+ 2.9999999999999998e-13 * ddt(V(cpphdl_n1588, Vdd)); // Bench initial voltage = 0.0 V.
        // device 1334, IC IC211, analog/basic/nmos_resistor_amplifier.hpp:32
        I(cpphdl_n1585, Vss) <+ 4e-14 * ddt(V(cpphdl_n1585, Vss)); // Bench initial voltage = 0.0 V.
        // device 1335, IC IC211, analog/basic/nmos_resistor_amplifier.hpp:34
        I(cpphdl_n1579, cpphdl_n1583) <+ 2e-14 * ddt(V(cpphdl_n1579, cpphdl_n1583)); // Bench initial voltage = 1.6499999999999999 V.
        // device 1336, IC IC211, analog/basic/nmos_resistor_amplifier.hpp:35
        I(cpphdl_n1580, cpphdl_n1584) <+ 2e-14 * ddt(V(cpphdl_n1580, cpphdl_n1584)); // Bench initial voltage = 0.0 V.
        // device 1337, IC IC211, analog/basic/nmos_resistor_amplifier.hpp:36
        I(cpphdl_n1579, cpphdl_n1589) <+ 2.9999999999999998e-15 * ddt(V(cpphdl_n1579, cpphdl_n1589)); // Bench initial voltage = -1.6499999999999999 V.
        // device 1338, IC IC211, analog/basic/nmos_resistor_amplifier.hpp:37
        I(cpphdl_n1580, cpphdl_n1588) <+ 2.9999999999999998e-15 * ddt(V(cpphdl_n1580, cpphdl_n1588)); // Bench initial voltage = -3.2999999999999998 V.
        // device 1339, IC IC212, analog/basic/strongarm_comparator.hpp:28
        I(cpphdl_n1593, cpphdl_n1595) <+ cpphdl_channel(V(cpphdl_n1588, cpphdl_n1595), V(cpphdl_n1593, cpphdl_n1595), 0.0080000000000000002, 0.69999999999999996, 1.0);
        // device 1340, IC IC212, analog/basic/strongarm_comparator.hpp:29
        I(cpphdl_n1594, cpphdl_n1595) <+ cpphdl_channel(V(cpphdl_n1589, cpphdl_n1595), V(cpphdl_n1594, cpphdl_n1595), 0.0080000000000000002, 0.69999999999999996, 1.0);
        // device 1341, IC IC212, analog/basic/strongarm_comparator.hpp:30
        I(cpphdl_n1595, Vss) <+ cpphdl_channel(V(EVALUATE, Vss), V(cpphdl_n1595, Vss), 0.0080000000000000002, 0.69999999999999996, 1.0);
        // device 1342, IC IC212, analog/basic/strongarm_comparator.hpp:33
        I(cpphdl_n1607, cpphdl_n1593) <+ cpphdl_channel(V(cpphdl_n1613, cpphdl_n1593), V(cpphdl_n1607, cpphdl_n1593), 0.0040000000000000001, 0.69999999999999996, 1.0);
        // device 1343, IC IC212, analog/basic/strongarm_comparator.hpp:34
        I(cpphdl_n1613, cpphdl_n1594) <+ cpphdl_channel(V(cpphdl_n1607, cpphdl_n1594), V(cpphdl_n1613, cpphdl_n1594), 0.0040000000000000001, 0.69999999999999996, 1.0);
        // device 1344, IC IC212, analog/basic/strongarm_comparator.hpp:35
        I(cpphdl_n1613, Vdd) <+ cpphdl_channel(V(cpphdl_n1607, Vdd), V(cpphdl_n1613, Vdd), 0.002, 0.69999999999999996, -1.0);
        // device 1345, IC IC212, analog/basic/strongarm_comparator.hpp:36
        I(cpphdl_n1607, Vdd) <+ cpphdl_channel(V(cpphdl_n1613, Vdd), V(cpphdl_n1607, Vdd), 0.002, 0.69999999999999996, -1.0);
        // device 1346, IC IC212, analog/basic/strongarm_comparator.hpp:38
        I(cpphdl_n1593, Vdd) <+ cpphdl_channel(V(EVALUATE, Vdd), V(cpphdl_n1593, Vdd), 0.002, 0.69999999999999996, -1.0);
        // device 1347, IC IC212, analog/basic/strongarm_comparator.hpp:39
        I(cpphdl_n1594, Vdd) <+ cpphdl_channel(V(EVALUATE, Vdd), V(cpphdl_n1594, Vdd), 0.002, 0.69999999999999996, -1.0);
        // device 1348, IC IC212, analog/basic/strongarm_comparator.hpp:40
        I(cpphdl_n1613, Vdd) <+ cpphdl_channel(V(EVALUATE, Vdd), V(cpphdl_n1613, Vdd), 0.002, 0.69999999999999996, -1.0);
        // device 1349, IC IC212, analog/basic/strongarm_comparator.hpp:41
        I(cpphdl_n1607, Vdd) <+ cpphdl_channel(V(EVALUATE, Vdd), V(cpphdl_n1607, Vdd), 0.002, 0.69999999999999996, -1.0);
        // device 1350, IC IC212, analog/basic/strongarm_comparator.hpp:42
        I(cpphdl_n1593, Vss) <+ 2.9999999999999998e-14 * ddt(V(cpphdl_n1593, Vss)); // Bench initial voltage = 0.0 V.
        // device 1351, IC IC212, analog/basic/strongarm_comparator.hpp:43
        I(cpphdl_n1594, Vss) <+ 2.9999999999999998e-14 * ddt(V(cpphdl_n1594, Vss)); // Bench initial voltage = 0.0 V.
        // device 1352, IC IC212, analog/basic/strongarm_comparator.hpp:44
        I(cpphdl_n1595, Vss) <+ 2.9999999999999998e-14 * ddt(V(cpphdl_n1595, Vss)); // Bench initial voltage = 0.0 V.
        // device 1353, IC IC212, analog/basic/strongarm_comparator.hpp:45
        I(cpphdl_n1613, Vss) <+ 5.0000000000000002e-14 * ddt(V(cpphdl_n1613, Vss)); // Bench initial voltage = 0.0 V.
        // device 1354, IC IC212, analog/basic/strongarm_comparator.hpp:46
        I(cpphdl_n1607, Vss) <+ 5.0000000000000002e-14 * ddt(V(cpphdl_n1607, Vss)); // Bench initial voltage = 0.0 V.
        // device 1355, IC IC212, analog/basic/strongarm_comparator.hpp:47
        I(cpphdl_n1588, cpphdl_n1595) <+ 2e-14 * ddt(V(cpphdl_n1588, cpphdl_n1595)); // Bench initial voltage = 3.2999999999999998 V.
        // device 1356, IC IC212, analog/basic/strongarm_comparator.hpp:48
        I(cpphdl_n1589, cpphdl_n1595) <+ 2e-14 * ddt(V(cpphdl_n1589, cpphdl_n1595)); // Bench initial voltage = 3.2999999999999998 V.
        // device 1357, IC IC212, analog/basic/strongarm_comparator.hpp:49
        I(cpphdl_n1588, cpphdl_n1593) <+ 2.9999999999999998e-15 * ddt(V(cpphdl_n1588, cpphdl_n1593)); // Bench initial voltage = 3.2999999999999998 V.
        // device 1358, IC IC212, analog/basic/strongarm_comparator.hpp:50
        I(cpphdl_n1589, cpphdl_n1594) <+ 2.9999999999999998e-15 * ddt(V(cpphdl_n1589, cpphdl_n1594)); // Bench initial voltage = 3.2999999999999998 V.
        // device 1359, IC IC214, analog/basic/cmos_logic.hpp:17
        I(DECISION11, Vss) <+ 5.0000000000000002e-14 * ddt(V(DECISION11, Vss)); // Bench initial voltage = 0.0 V.
        // device 1360, IC IC214, analog/basic/cmos_logic.hpp:18
        I(DECISION11, Vdd) <+ cpphdl_channel(V(cpphdl_n1607, Vdd), V(DECISION11, Vdd), 0.01, 0.69999999999999996, -1.0);
        // device 1361, IC IC214, analog/basic/cmos_logic.hpp:19
        I(DECISION11, Vdd) <+ cpphdl_channel(V(DECISION_N11, Vdd), V(DECISION11, Vdd), 0.01, 0.69999999999999996, -1.0);
        // device 1362, IC IC214, analog/basic/cmos_logic.hpp:20
        I(DECISION11, cpphdl_n1610) <+ cpphdl_channel(V(cpphdl_n1607, cpphdl_n1610), V(DECISION11, cpphdl_n1610), 0.01, 0.69999999999999996, 1.0);
        // device 1363, IC IC214, analog/basic/cmos_logic.hpp:21
        I(cpphdl_n1610, Vss) <+ cpphdl_channel(V(DECISION_N11, Vss), V(cpphdl_n1610, Vss), 0.01, 0.69999999999999996, 1.0);
        // device 1364, IC IC214, analog/basic/cmos_logic.hpp:23
        I(DECISION11, Vss) <+ V(DECISION11, Vss) / 1000000000.0;
        // device 1365, IC IC214, analog/basic/cmos_logic.hpp:24
        I(cpphdl_n1610, Vss) <+ V(cpphdl_n1610, Vss) / 1000000000.0;
        // device 1366, IC IC215, analog/basic/cmos_logic.hpp:17
        I(DECISION_N11, Vss) <+ 5.0000000000000002e-14 * ddt(V(DECISION_N11, Vss)); // Bench initial voltage = 0.0 V.
        // device 1367, IC IC215, analog/basic/cmos_logic.hpp:18
        I(DECISION_N11, Vdd) <+ cpphdl_channel(V(cpphdl_n1613, Vdd), V(DECISION_N11, Vdd), 0.01, 0.69999999999999996, -1.0);
        // device 1368, IC IC215, analog/basic/cmos_logic.hpp:19
        I(DECISION_N11, Vdd) <+ cpphdl_channel(V(DECISION11, Vdd), V(DECISION_N11, Vdd), 0.01, 0.69999999999999996, -1.0);
        // device 1369, IC IC215, analog/basic/cmos_logic.hpp:20
        I(DECISION_N11, cpphdl_n1616) <+ cpphdl_channel(V(cpphdl_n1613, cpphdl_n1616), V(DECISION_N11, cpphdl_n1616), 0.01, 0.69999999999999996, 1.0);
        // device 1370, IC IC215, analog/basic/cmos_logic.hpp:21
        I(cpphdl_n1616, Vss) <+ cpphdl_channel(V(DECISION11, Vss), V(cpphdl_n1616, Vss), 0.01, 0.69999999999999996, 1.0);
        // device 1371, IC IC215, analog/basic/cmos_logic.hpp:23
        I(DECISION_N11, Vss) <+ V(DECISION_N11, Vss) / 1000000000.0;
        // device 1372, IC IC215, analog/basic/cmos_logic.hpp:24
        I(cpphdl_n1616, Vss) <+ V(cpphdl_n1616, Vss) / 1000000000.0;
        // device 1373, IC IC213, analog/basic/nand_latch.hpp:36
        I(cpphdl_n1607, Vss) <+ 2.9999999999999998e-15 * ddt(V(cpphdl_n1607, Vss)); // Bench initial voltage = 0.0 V.
        // device 1374, IC IC213, analog/basic/nand_latch.hpp:37
        I(cpphdl_n1613, Vss) <+ 2.9999999999999998e-15 * ddt(V(cpphdl_n1613, Vss)); // Bench initial voltage = 0.0 V.
        // device 1375, IC IC216, analog/basic/inverter.hpp:11
        I(cpphdl_n1621, Vdd) <+ cpphdl_channel(V(CLEAR, Vdd), V(cpphdl_n1621, Vdd), 0.01, 0.69999999999999996, -1.0);
        // device 1376, IC IC216, analog/basic/inverter.hpp:12
        I(cpphdl_n1621, Vss) <+ cpphdl_channel(V(CLEAR, Vss), V(cpphdl_n1621, Vss), 0.01, 0.69999999999999996, 1.0);
        // device 1377, IC IC213, analog/basic/nand_latch.hpp:58
        I(cpphdl_n1621, Vss) <+ 2.9999999999999998e-15 * ddt(V(cpphdl_n1621, Vss)); // Bench initial voltage = 0.0 V.
        // device 1378, IC IC213, analog/basic/nand_latch.hpp:59
        I(DECISION11, Vss) <+ cpphdl_channel(V(CLEAR, Vss), V(DECISION11, Vss), 0.050000000000000003, 0.69999999999999996, 1.0);
        // device 1379, IC IC213, analog/basic/nand_latch.hpp:60
        I(DECISION_N11, Vdd) <+ cpphdl_channel(V(cpphdl_n1621, Vdd), V(DECISION_N11, Vdd), 0.050000000000000003, 0.69999999999999996, -1.0);
        // device 1380, IC IC219, analog/basic/inverter.hpp:11
        I(cpphdl_n1645, Vdd) <+ cpphdl_channel(V(TRACK12, Vdd), V(cpphdl_n1645, Vdd), 0.0040000000000000001, 0.69999999999999996, -1.0);
        // device 1381, IC IC219, analog/basic/inverter.hpp:12
        I(cpphdl_n1645, Vss) <+ cpphdl_channel(V(TRACK12, Vss), V(cpphdl_n1645, Vss), 0.0040000000000000001, 0.69999999999999996, 1.0);
        // device 1382, IC IC218, analog/basic/mos_track_hold.hpp:31
        I(cpphdl_n1645, Vss) <+ 2e-14 * ddt(V(cpphdl_n1645, Vss)); // Bench initial voltage = 3.2999999999999998 V.
        // device 1383, IC IC218, analog/basic/mos_track_hold.hpp:32
        I(IN, cpphdl_n1699) <+ cpphdl_channel(V(TRACK12, cpphdl_n1699), V(IN, cpphdl_n1699), 0.080000000000000002, 0.69999999999999996, 1.0);
        // device 1384, IC IC218, analog/basic/mos_track_hold.hpp:33
        I(cpphdl_n1699, IN) <+ cpphdl_channel(V(cpphdl_n1645, IN), V(cpphdl_n1699, IN), 0.040000000000000001, 0.69999999999999996, -1.0);
        // device 1385, IC IC218, analog/basic/mos_track_hold.hpp:37
        I(cpphdl_n1699, cpphdl_n1699) <+ cpphdl_channel(V(cpphdl_n1645, cpphdl_n1699), V(cpphdl_n1699, cpphdl_n1699), 0.040000000000000001, 0.69999999999999996, 1.0);
        // device 1386, IC IC218, analog/basic/mos_track_hold.hpp:38
        I(cpphdl_n1699, cpphdl_n1699) <+ cpphdl_channel(V(TRACK12, cpphdl_n1699), V(cpphdl_n1699, cpphdl_n1699), 0.02, 0.69999999999999996, -1.0);
        // device 1387, IC IC218, analog/basic/mos_track_hold.hpp:39
        I(cpphdl_n1699, Vss) <+ 2e-12 * ddt(V(cpphdl_n1699, Vss)); // Bench initial voltage = 1.6499999999999999 V.
        // device 1388, IC IC218, analog/basic/mos_track_hold.hpp:41
        I(Vss, cpphdl_n1699) <+ V(Vss, cpphdl_n1699) / 1000000000.0;
        // device 1389, IC IC218, analog/basic/mos_track_hold.hpp:42
        I(TRACK12, cpphdl_n1699) <+ 8.0000000000000006e-15 * ddt(V(TRACK12, cpphdl_n1699)); // Bench initial voltage = -1.6499999999999999 V.
        // device 1390, IC IC218, analog/basic/mos_track_hold.hpp:43
        I(cpphdl_n1645, cpphdl_n1699) <+ 8.0000000000000006e-15 * ddt(V(cpphdl_n1645, cpphdl_n1699)); // Bench initial voltage = 1.6499999999999999 V.
        // device 1391, IC IC218, analog/basic/mos_track_hold.hpp:44
        I(IN, cpphdl_n1699) <+ 4.0000000000000003e-15 * ddt(V(IN, cpphdl_n1699)); // Bench initial voltage = 0.0 V.
        // device 1392, IC IC221, analog/basic/inverter.hpp:11
        I(cpphdl_n1660, Vdd) <+ cpphdl_channel(V(BIT_N12_0, Vdd), V(cpphdl_n1660, Vdd), 0.080000000000000002, 0.69999999999999996, -1.0);
        // device 1393, IC IC221, analog/basic/inverter.hpp:12
        I(cpphdl_n1660, Vss) <+ cpphdl_channel(V(BIT_N12_0, Vss), V(cpphdl_n1660, Vss), 0.080000000000000002, 0.69999999999999996, 1.0);
        // device 1394, IC IC220, analog/basic/mos_r2r_dac.hpp:27
        I(cpphdl_n1660, Vss) <+ 2.9999999999999998e-15 * ddt(V(cpphdl_n1660, Vss)); // Bench initial voltage = 0.0 V.
        // device 1395, IC IC220, analog/basic/mos_r2r_dac.hpp:28
        I(cpphdl_n1660, cpphdl_n1689) <+ V(cpphdl_n1660, cpphdl_n1689) / 20000.0;
        // device 1396, IC IC220, analog/basic/mos_r2r_dac.hpp:29
        I(cpphdl_n1689, Vss) <+ 2.9999999999999998e-15 * ddt(V(cpphdl_n1689, Vss)); // Bench initial voltage = 0.0 V.
        // device 1397, IC IC222, analog/basic/inverter.hpp:11
        I(cpphdl_n1664, Vdd) <+ cpphdl_channel(V(BIT_N12_1, Vdd), V(cpphdl_n1664, Vdd), 0.080000000000000002, 0.69999999999999996, -1.0);
        // device 1398, IC IC222, analog/basic/inverter.hpp:12
        I(cpphdl_n1664, Vss) <+ cpphdl_channel(V(BIT_N12_1, Vss), V(cpphdl_n1664, Vss), 0.080000000000000002, 0.69999999999999996, 1.0);
        // device 1399, IC IC220, analog/basic/mos_r2r_dac.hpp:27
        I(cpphdl_n1664, Vss) <+ 2.9999999999999998e-15 * ddt(V(cpphdl_n1664, Vss)); // Bench initial voltage = 0.0 V.
        // device 1400, IC IC220, analog/basic/mos_r2r_dac.hpp:28
        I(cpphdl_n1664, cpphdl_n1690) <+ V(cpphdl_n1664, cpphdl_n1690) / 20000.0;
        // device 1401, IC IC220, analog/basic/mos_r2r_dac.hpp:29
        I(cpphdl_n1690, Vss) <+ 2.9999999999999998e-15 * ddt(V(cpphdl_n1690, Vss)); // Bench initial voltage = 0.0 V.
        // device 1402, IC IC220, analog/basic/mos_r2r_dac.hpp:31
        I(cpphdl_n1689, cpphdl_n1690) <+ V(cpphdl_n1689, cpphdl_n1690) / 10000.0;
        // device 1403, IC IC223, analog/basic/inverter.hpp:11
        I(cpphdl_n1668, Vdd) <+ cpphdl_channel(V(BIT_N12_2, Vdd), V(cpphdl_n1668, Vdd), 0.080000000000000002, 0.69999999999999996, -1.0);
        // device 1404, IC IC223, analog/basic/inverter.hpp:12
        I(cpphdl_n1668, Vss) <+ cpphdl_channel(V(BIT_N12_2, Vss), V(cpphdl_n1668, Vss), 0.080000000000000002, 0.69999999999999996, 1.0);
        // device 1405, IC IC220, analog/basic/mos_r2r_dac.hpp:27
        I(cpphdl_n1668, Vss) <+ 2.9999999999999998e-15 * ddt(V(cpphdl_n1668, Vss)); // Bench initial voltage = 0.0 V.
        // device 1406, IC IC220, analog/basic/mos_r2r_dac.hpp:28
        I(cpphdl_n1668, cpphdl_n1691) <+ V(cpphdl_n1668, cpphdl_n1691) / 20000.0;
        // device 1407, IC IC220, analog/basic/mos_r2r_dac.hpp:29
        I(cpphdl_n1691, Vss) <+ 2.9999999999999998e-15 * ddt(V(cpphdl_n1691, Vss)); // Bench initial voltage = 0.0 V.
        // device 1408, IC IC220, analog/basic/mos_r2r_dac.hpp:31
        I(cpphdl_n1690, cpphdl_n1691) <+ V(cpphdl_n1690, cpphdl_n1691) / 10000.0;
        // device 1409, IC IC224, analog/basic/inverter.hpp:11
        I(cpphdl_n1672, Vdd) <+ cpphdl_channel(V(BIT_N12_3, Vdd), V(cpphdl_n1672, Vdd), 0.080000000000000002, 0.69999999999999996, -1.0);
        // device 1410, IC IC224, analog/basic/inverter.hpp:12
        I(cpphdl_n1672, Vss) <+ cpphdl_channel(V(BIT_N12_3, Vss), V(cpphdl_n1672, Vss), 0.080000000000000002, 0.69999999999999996, 1.0);
        // device 1411, IC IC220, analog/basic/mos_r2r_dac.hpp:27
        I(cpphdl_n1672, Vss) <+ 2.9999999999999998e-15 * ddt(V(cpphdl_n1672, Vss)); // Bench initial voltage = 0.0 V.
        // device 1412, IC IC220, analog/basic/mos_r2r_dac.hpp:28
        I(cpphdl_n1672, cpphdl_n1692) <+ V(cpphdl_n1672, cpphdl_n1692) / 20000.0;
        // device 1413, IC IC220, analog/basic/mos_r2r_dac.hpp:29
        I(cpphdl_n1692, Vss) <+ 2.9999999999999998e-15 * ddt(V(cpphdl_n1692, Vss)); // Bench initial voltage = 0.0 V.
        // device 1414, IC IC220, analog/basic/mos_r2r_dac.hpp:31
        I(cpphdl_n1691, cpphdl_n1692) <+ V(cpphdl_n1691, cpphdl_n1692) / 10000.0;
        // device 1415, IC IC225, analog/basic/inverter.hpp:11
        I(cpphdl_n1676, Vdd) <+ cpphdl_channel(V(BIT_N12_4, Vdd), V(cpphdl_n1676, Vdd), 0.080000000000000002, 0.69999999999999996, -1.0);
        // device 1416, IC IC225, analog/basic/inverter.hpp:12
        I(cpphdl_n1676, Vss) <+ cpphdl_channel(V(BIT_N12_4, Vss), V(cpphdl_n1676, Vss), 0.080000000000000002, 0.69999999999999996, 1.0);
        // device 1417, IC IC220, analog/basic/mos_r2r_dac.hpp:27
        I(cpphdl_n1676, Vss) <+ 2.9999999999999998e-15 * ddt(V(cpphdl_n1676, Vss)); // Bench initial voltage = 0.0 V.
        // device 1418, IC IC220, analog/basic/mos_r2r_dac.hpp:28
        I(cpphdl_n1676, cpphdl_n1693) <+ V(cpphdl_n1676, cpphdl_n1693) / 20000.0;
        // device 1419, IC IC220, analog/basic/mos_r2r_dac.hpp:29
        I(cpphdl_n1693, Vss) <+ 2.9999999999999998e-15 * ddt(V(cpphdl_n1693, Vss)); // Bench initial voltage = 0.0 V.
        // device 1420, IC IC220, analog/basic/mos_r2r_dac.hpp:31
        I(cpphdl_n1692, cpphdl_n1693) <+ V(cpphdl_n1692, cpphdl_n1693) / 10000.0;
        // device 1421, IC IC226, analog/basic/inverter.hpp:11
        I(cpphdl_n1680, Vdd) <+ cpphdl_channel(V(BIT_N12_5, Vdd), V(cpphdl_n1680, Vdd), 0.080000000000000002, 0.69999999999999996, -1.0);
        // device 1422, IC IC226, analog/basic/inverter.hpp:12
        I(cpphdl_n1680, Vss) <+ cpphdl_channel(V(BIT_N12_5, Vss), V(cpphdl_n1680, Vss), 0.080000000000000002, 0.69999999999999996, 1.0);
        // device 1423, IC IC220, analog/basic/mos_r2r_dac.hpp:27
        I(cpphdl_n1680, Vss) <+ 2.9999999999999998e-15 * ddt(V(cpphdl_n1680, Vss)); // Bench initial voltage = 0.0 V.
        // device 1424, IC IC220, analog/basic/mos_r2r_dac.hpp:28
        I(cpphdl_n1680, cpphdl_n1694) <+ V(cpphdl_n1680, cpphdl_n1694) / 20000.0;
        // device 1425, IC IC220, analog/basic/mos_r2r_dac.hpp:29
        I(cpphdl_n1694, Vss) <+ 2.9999999999999998e-15 * ddt(V(cpphdl_n1694, Vss)); // Bench initial voltage = 0.0 V.
        // device 1426, IC IC220, analog/basic/mos_r2r_dac.hpp:31
        I(cpphdl_n1693, cpphdl_n1694) <+ V(cpphdl_n1693, cpphdl_n1694) / 10000.0;
        // device 1427, IC IC227, analog/basic/inverter.hpp:11
        I(cpphdl_n1684, Vdd) <+ cpphdl_channel(V(BIT_N12_6, Vdd), V(cpphdl_n1684, Vdd), 0.080000000000000002, 0.69999999999999996, -1.0);
        // device 1428, IC IC227, analog/basic/inverter.hpp:12
        I(cpphdl_n1684, Vss) <+ cpphdl_channel(V(BIT_N12_6, Vss), V(cpphdl_n1684, Vss), 0.080000000000000002, 0.69999999999999996, 1.0);
        // device 1429, IC IC220, analog/basic/mos_r2r_dac.hpp:27
        I(cpphdl_n1684, Vss) <+ 2.9999999999999998e-15 * ddt(V(cpphdl_n1684, Vss)); // Bench initial voltage = 0.0 V.
        // device 1430, IC IC220, analog/basic/mos_r2r_dac.hpp:28
        I(cpphdl_n1684, cpphdl_n1695) <+ V(cpphdl_n1684, cpphdl_n1695) / 20000.0;
        // device 1431, IC IC220, analog/basic/mos_r2r_dac.hpp:29
        I(cpphdl_n1695, Vss) <+ 2.9999999999999998e-15 * ddt(V(cpphdl_n1695, Vss)); // Bench initial voltage = 0.0 V.
        // device 1432, IC IC220, analog/basic/mos_r2r_dac.hpp:31
        I(cpphdl_n1694, cpphdl_n1695) <+ V(cpphdl_n1694, cpphdl_n1695) / 10000.0;
        // device 1433, IC IC228, analog/basic/inverter.hpp:11
        I(cpphdl_n1688, Vdd) <+ cpphdl_channel(V(BIT_N12_7, Vdd), V(cpphdl_n1688, Vdd), 0.080000000000000002, 0.69999999999999996, -1.0);
        // device 1434, IC IC228, analog/basic/inverter.hpp:12
        I(cpphdl_n1688, Vss) <+ cpphdl_channel(V(BIT_N12_7, Vss), V(cpphdl_n1688, Vss), 0.080000000000000002, 0.69999999999999996, 1.0);
        // device 1435, IC IC220, analog/basic/mos_r2r_dac.hpp:27
        I(cpphdl_n1688, Vss) <+ 2.9999999999999998e-15 * ddt(V(cpphdl_n1688, Vss)); // Bench initial voltage = 0.0 V.
        // device 1436, IC IC220, analog/basic/mos_r2r_dac.hpp:28
        I(cpphdl_n1688, cpphdl_n1700) <+ V(cpphdl_n1688, cpphdl_n1700) / 20000.0;
        // device 1437, IC IC220, analog/basic/mos_r2r_dac.hpp:29
        I(cpphdl_n1700, Vss) <+ 2.9999999999999998e-15 * ddt(V(cpphdl_n1700, Vss)); // Bench initial voltage = 0.0 V.
        // device 1438, IC IC220, analog/basic/mos_r2r_dac.hpp:31
        I(cpphdl_n1695, cpphdl_n1700) <+ V(cpphdl_n1695, cpphdl_n1700) / 10000.0;
        // device 1439, IC IC220, analog/basic/mos_r2r_dac.hpp:33
        I(Vss, cpphdl_n1689) <+ V(Vss, cpphdl_n1689) / 20000.0;
        // device 1440, IC IC229, analog/basic/nmos_resistor_amplifier.hpp:23
        I(Vdd, cpphdl_n1709) <+ V(Vdd, cpphdl_n1709) / 1000.0;
        // device 1441, IC IC229, analog/basic/nmos_resistor_amplifier.hpp:24
        I(Vdd, cpphdl_n1708) <+ V(Vdd, cpphdl_n1708) / 1000.0;
        // device 1442, IC IC229, analog/basic/nmos_resistor_amplifier.hpp:25
        I(cpphdl_n1709, cpphdl_n1703) <+ cpphdl_channel(V(cpphdl_n1699, cpphdl_n1703), V(cpphdl_n1709, cpphdl_n1703), 0.014999999999999999, 0.69999999999999996, 1.0);
        // device 1443, IC IC229, analog/basic/nmos_resistor_amplifier.hpp:26
        I(cpphdl_n1708, cpphdl_n1704) <+ cpphdl_channel(V(cpphdl_n1700, cpphdl_n1704), V(cpphdl_n1708, cpphdl_n1704), 0.014999999999999999, 0.69999999999999996, 1.0);
        // device 1444, IC IC229, analog/basic/nmos_resistor_amplifier.hpp:27
        I(cpphdl_n1705, cpphdl_n1703) <+ V(cpphdl_n1705, cpphdl_n1703) / 50.0;
        // device 1445, IC IC229, analog/basic/nmos_resistor_amplifier.hpp:28
        I(cpphdl_n1705, cpphdl_n1704) <+ V(cpphdl_n1705, cpphdl_n1704) / 50.0;
        // device 1446, IC IC229, analog/basic/nmos_resistor_amplifier.hpp:29
        I(Vss, cpphdl_n1705) <+ V(Vss, cpphdl_n1705) / 150.0;
        // device 1447, IC IC229, analog/basic/nmos_resistor_amplifier.hpp:30
        I(cpphdl_n1709, Vdd) <+ 2.9999999999999998e-13 * ddt(V(cpphdl_n1709, Vdd)); // Bench initial voltage = 0.0 V.
        // device 1448, IC IC229, analog/basic/nmos_resistor_amplifier.hpp:31
        I(cpphdl_n1708, Vdd) <+ 2.9999999999999998e-13 * ddt(V(cpphdl_n1708, Vdd)); // Bench initial voltage = 0.0 V.
        // device 1449, IC IC229, analog/basic/nmos_resistor_amplifier.hpp:32
        I(cpphdl_n1705, Vss) <+ 4e-14 * ddt(V(cpphdl_n1705, Vss)); // Bench initial voltage = 0.0 V.
        // device 1450, IC IC229, analog/basic/nmos_resistor_amplifier.hpp:34
        I(cpphdl_n1699, cpphdl_n1703) <+ 2e-14 * ddt(V(cpphdl_n1699, cpphdl_n1703)); // Bench initial voltage = 1.6499999999999999 V.
        // device 1451, IC IC229, analog/basic/nmos_resistor_amplifier.hpp:35
        I(cpphdl_n1700, cpphdl_n1704) <+ 2e-14 * ddt(V(cpphdl_n1700, cpphdl_n1704)); // Bench initial voltage = 0.0 V.
        // device 1452, IC IC229, analog/basic/nmos_resistor_amplifier.hpp:36
        I(cpphdl_n1699, cpphdl_n1709) <+ 2.9999999999999998e-15 * ddt(V(cpphdl_n1699, cpphdl_n1709)); // Bench initial voltage = -1.6499999999999999 V.
        // device 1453, IC IC229, analog/basic/nmos_resistor_amplifier.hpp:37
        I(cpphdl_n1700, cpphdl_n1708) <+ 2.9999999999999998e-15 * ddt(V(cpphdl_n1700, cpphdl_n1708)); // Bench initial voltage = -3.2999999999999998 V.
        // device 1454, IC IC230, analog/basic/strongarm_comparator.hpp:28
        I(cpphdl_n1713, cpphdl_n1715) <+ cpphdl_channel(V(cpphdl_n1708, cpphdl_n1715), V(cpphdl_n1713, cpphdl_n1715), 0.0080000000000000002, 0.69999999999999996, 1.0);
        // device 1455, IC IC230, analog/basic/strongarm_comparator.hpp:29
        I(cpphdl_n1714, cpphdl_n1715) <+ cpphdl_channel(V(cpphdl_n1709, cpphdl_n1715), V(cpphdl_n1714, cpphdl_n1715), 0.0080000000000000002, 0.69999999999999996, 1.0);
        // device 1456, IC IC230, analog/basic/strongarm_comparator.hpp:30
        I(cpphdl_n1715, Vss) <+ cpphdl_channel(V(EVALUATE, Vss), V(cpphdl_n1715, Vss), 0.0080000000000000002, 0.69999999999999996, 1.0);
        // device 1457, IC IC230, analog/basic/strongarm_comparator.hpp:33
        I(cpphdl_n1727, cpphdl_n1713) <+ cpphdl_channel(V(cpphdl_n1733, cpphdl_n1713), V(cpphdl_n1727, cpphdl_n1713), 0.0040000000000000001, 0.69999999999999996, 1.0);
        // device 1458, IC IC230, analog/basic/strongarm_comparator.hpp:34
        I(cpphdl_n1733, cpphdl_n1714) <+ cpphdl_channel(V(cpphdl_n1727, cpphdl_n1714), V(cpphdl_n1733, cpphdl_n1714), 0.0040000000000000001, 0.69999999999999996, 1.0);
        // device 1459, IC IC230, analog/basic/strongarm_comparator.hpp:35
        I(cpphdl_n1733, Vdd) <+ cpphdl_channel(V(cpphdl_n1727, Vdd), V(cpphdl_n1733, Vdd), 0.002, 0.69999999999999996, -1.0);
        // device 1460, IC IC230, analog/basic/strongarm_comparator.hpp:36
        I(cpphdl_n1727, Vdd) <+ cpphdl_channel(V(cpphdl_n1733, Vdd), V(cpphdl_n1727, Vdd), 0.002, 0.69999999999999996, -1.0);
        // device 1461, IC IC230, analog/basic/strongarm_comparator.hpp:38
        I(cpphdl_n1713, Vdd) <+ cpphdl_channel(V(EVALUATE, Vdd), V(cpphdl_n1713, Vdd), 0.002, 0.69999999999999996, -1.0);
        // device 1462, IC IC230, analog/basic/strongarm_comparator.hpp:39
        I(cpphdl_n1714, Vdd) <+ cpphdl_channel(V(EVALUATE, Vdd), V(cpphdl_n1714, Vdd), 0.002, 0.69999999999999996, -1.0);
        // device 1463, IC IC230, analog/basic/strongarm_comparator.hpp:40
        I(cpphdl_n1733, Vdd) <+ cpphdl_channel(V(EVALUATE, Vdd), V(cpphdl_n1733, Vdd), 0.002, 0.69999999999999996, -1.0);
        // device 1464, IC IC230, analog/basic/strongarm_comparator.hpp:41
        I(cpphdl_n1727, Vdd) <+ cpphdl_channel(V(EVALUATE, Vdd), V(cpphdl_n1727, Vdd), 0.002, 0.69999999999999996, -1.0);
        // device 1465, IC IC230, analog/basic/strongarm_comparator.hpp:42
        I(cpphdl_n1713, Vss) <+ 2.9999999999999998e-14 * ddt(V(cpphdl_n1713, Vss)); // Bench initial voltage = 0.0 V.
        // device 1466, IC IC230, analog/basic/strongarm_comparator.hpp:43
        I(cpphdl_n1714, Vss) <+ 2.9999999999999998e-14 * ddt(V(cpphdl_n1714, Vss)); // Bench initial voltage = 0.0 V.
        // device 1467, IC IC230, analog/basic/strongarm_comparator.hpp:44
        I(cpphdl_n1715, Vss) <+ 2.9999999999999998e-14 * ddt(V(cpphdl_n1715, Vss)); // Bench initial voltage = 0.0 V.
        // device 1468, IC IC230, analog/basic/strongarm_comparator.hpp:45
        I(cpphdl_n1733, Vss) <+ 5.0000000000000002e-14 * ddt(V(cpphdl_n1733, Vss)); // Bench initial voltage = 0.0 V.
        // device 1469, IC IC230, analog/basic/strongarm_comparator.hpp:46
        I(cpphdl_n1727, Vss) <+ 5.0000000000000002e-14 * ddt(V(cpphdl_n1727, Vss)); // Bench initial voltage = 0.0 V.
        // device 1470, IC IC230, analog/basic/strongarm_comparator.hpp:47
        I(cpphdl_n1708, cpphdl_n1715) <+ 2e-14 * ddt(V(cpphdl_n1708, cpphdl_n1715)); // Bench initial voltage = 3.2999999999999998 V.
        // device 1471, IC IC230, analog/basic/strongarm_comparator.hpp:48
        I(cpphdl_n1709, cpphdl_n1715) <+ 2e-14 * ddt(V(cpphdl_n1709, cpphdl_n1715)); // Bench initial voltage = 3.2999999999999998 V.
        // device 1472, IC IC230, analog/basic/strongarm_comparator.hpp:49
        I(cpphdl_n1708, cpphdl_n1713) <+ 2.9999999999999998e-15 * ddt(V(cpphdl_n1708, cpphdl_n1713)); // Bench initial voltage = 3.2999999999999998 V.
        // device 1473, IC IC230, analog/basic/strongarm_comparator.hpp:50
        I(cpphdl_n1709, cpphdl_n1714) <+ 2.9999999999999998e-15 * ddt(V(cpphdl_n1709, cpphdl_n1714)); // Bench initial voltage = 3.2999999999999998 V.
        // device 1474, IC IC232, analog/basic/cmos_logic.hpp:17
        I(DECISION12, Vss) <+ 5.0000000000000002e-14 * ddt(V(DECISION12, Vss)); // Bench initial voltage = 0.0 V.
        // device 1475, IC IC232, analog/basic/cmos_logic.hpp:18
        I(DECISION12, Vdd) <+ cpphdl_channel(V(cpphdl_n1727, Vdd), V(DECISION12, Vdd), 0.01, 0.69999999999999996, -1.0);
        // device 1476, IC IC232, analog/basic/cmos_logic.hpp:19
        I(DECISION12, Vdd) <+ cpphdl_channel(V(DECISION_N12, Vdd), V(DECISION12, Vdd), 0.01, 0.69999999999999996, -1.0);
        // device 1477, IC IC232, analog/basic/cmos_logic.hpp:20
        I(DECISION12, cpphdl_n1730) <+ cpphdl_channel(V(cpphdl_n1727, cpphdl_n1730), V(DECISION12, cpphdl_n1730), 0.01, 0.69999999999999996, 1.0);
        // device 1478, IC IC232, analog/basic/cmos_logic.hpp:21
        I(cpphdl_n1730, Vss) <+ cpphdl_channel(V(DECISION_N12, Vss), V(cpphdl_n1730, Vss), 0.01, 0.69999999999999996, 1.0);
        // device 1479, IC IC232, analog/basic/cmos_logic.hpp:23
        I(DECISION12, Vss) <+ V(DECISION12, Vss) / 1000000000.0;
        // device 1480, IC IC232, analog/basic/cmos_logic.hpp:24
        I(cpphdl_n1730, Vss) <+ V(cpphdl_n1730, Vss) / 1000000000.0;
        // device 1481, IC IC233, analog/basic/cmos_logic.hpp:17
        I(DECISION_N12, Vss) <+ 5.0000000000000002e-14 * ddt(V(DECISION_N12, Vss)); // Bench initial voltage = 0.0 V.
        // device 1482, IC IC233, analog/basic/cmos_logic.hpp:18
        I(DECISION_N12, Vdd) <+ cpphdl_channel(V(cpphdl_n1733, Vdd), V(DECISION_N12, Vdd), 0.01, 0.69999999999999996, -1.0);
        // device 1483, IC IC233, analog/basic/cmos_logic.hpp:19
        I(DECISION_N12, Vdd) <+ cpphdl_channel(V(DECISION12, Vdd), V(DECISION_N12, Vdd), 0.01, 0.69999999999999996, -1.0);
        // device 1484, IC IC233, analog/basic/cmos_logic.hpp:20
        I(DECISION_N12, cpphdl_n1736) <+ cpphdl_channel(V(cpphdl_n1733, cpphdl_n1736), V(DECISION_N12, cpphdl_n1736), 0.01, 0.69999999999999996, 1.0);
        // device 1485, IC IC233, analog/basic/cmos_logic.hpp:21
        I(cpphdl_n1736, Vss) <+ cpphdl_channel(V(DECISION12, Vss), V(cpphdl_n1736, Vss), 0.01, 0.69999999999999996, 1.0);
        // device 1486, IC IC233, analog/basic/cmos_logic.hpp:23
        I(DECISION_N12, Vss) <+ V(DECISION_N12, Vss) / 1000000000.0;
        // device 1487, IC IC233, analog/basic/cmos_logic.hpp:24
        I(cpphdl_n1736, Vss) <+ V(cpphdl_n1736, Vss) / 1000000000.0;
        // device 1488, IC IC231, analog/basic/nand_latch.hpp:36
        I(cpphdl_n1727, Vss) <+ 2.9999999999999998e-15 * ddt(V(cpphdl_n1727, Vss)); // Bench initial voltage = 0.0 V.
        // device 1489, IC IC231, analog/basic/nand_latch.hpp:37
        I(cpphdl_n1733, Vss) <+ 2.9999999999999998e-15 * ddt(V(cpphdl_n1733, Vss)); // Bench initial voltage = 0.0 V.
        // device 1490, IC IC234, analog/basic/inverter.hpp:11
        I(cpphdl_n1741, Vdd) <+ cpphdl_channel(V(CLEAR, Vdd), V(cpphdl_n1741, Vdd), 0.01, 0.69999999999999996, -1.0);
        // device 1491, IC IC234, analog/basic/inverter.hpp:12
        I(cpphdl_n1741, Vss) <+ cpphdl_channel(V(CLEAR, Vss), V(cpphdl_n1741, Vss), 0.01, 0.69999999999999996, 1.0);
        // device 1492, IC IC231, analog/basic/nand_latch.hpp:58
        I(cpphdl_n1741, Vss) <+ 2.9999999999999998e-15 * ddt(V(cpphdl_n1741, Vss)); // Bench initial voltage = 0.0 V.
        // device 1493, IC IC231, analog/basic/nand_latch.hpp:59
        I(DECISION12, Vss) <+ cpphdl_channel(V(CLEAR, Vss), V(DECISION12, Vss), 0.050000000000000003, 0.69999999999999996, 1.0);
        // device 1494, IC IC231, analog/basic/nand_latch.hpp:60
        I(DECISION_N12, Vdd) <+ cpphdl_channel(V(cpphdl_n1741, Vdd), V(DECISION_N12, Vdd), 0.050000000000000003, 0.69999999999999996, -1.0);
        // device 1495, IC IC237, analog/basic/inverter.hpp:11
        I(cpphdl_n1765, Vdd) <+ cpphdl_channel(V(TRACK13, Vdd), V(cpphdl_n1765, Vdd), 0.0040000000000000001, 0.69999999999999996, -1.0);
        // device 1496, IC IC237, analog/basic/inverter.hpp:12
        I(cpphdl_n1765, Vss) <+ cpphdl_channel(V(TRACK13, Vss), V(cpphdl_n1765, Vss), 0.0040000000000000001, 0.69999999999999996, 1.0);
        // device 1497, IC IC236, analog/basic/mos_track_hold.hpp:31
        I(cpphdl_n1765, Vss) <+ 2e-14 * ddt(V(cpphdl_n1765, Vss)); // Bench initial voltage = 3.2999999999999998 V.
        // device 1498, IC IC236, analog/basic/mos_track_hold.hpp:32
        I(IN, cpphdl_n1819) <+ cpphdl_channel(V(TRACK13, cpphdl_n1819), V(IN, cpphdl_n1819), 0.080000000000000002, 0.69999999999999996, 1.0);
        // device 1499, IC IC236, analog/basic/mos_track_hold.hpp:33
        I(cpphdl_n1819, IN) <+ cpphdl_channel(V(cpphdl_n1765, IN), V(cpphdl_n1819, IN), 0.040000000000000001, 0.69999999999999996, -1.0);
        // device 1500, IC IC236, analog/basic/mos_track_hold.hpp:37
        I(cpphdl_n1819, cpphdl_n1819) <+ cpphdl_channel(V(cpphdl_n1765, cpphdl_n1819), V(cpphdl_n1819, cpphdl_n1819), 0.040000000000000001, 0.69999999999999996, 1.0);
        // device 1501, IC IC236, analog/basic/mos_track_hold.hpp:38
        I(cpphdl_n1819, cpphdl_n1819) <+ cpphdl_channel(V(TRACK13, cpphdl_n1819), V(cpphdl_n1819, cpphdl_n1819), 0.02, 0.69999999999999996, -1.0);
        // device 1502, IC IC236, analog/basic/mos_track_hold.hpp:39
        I(cpphdl_n1819, Vss) <+ 2e-12 * ddt(V(cpphdl_n1819, Vss)); // Bench initial voltage = 1.6499999999999999 V.
        // device 1503, IC IC236, analog/basic/mos_track_hold.hpp:41
        I(Vss, cpphdl_n1819) <+ V(Vss, cpphdl_n1819) / 1000000000.0;
        // device 1504, IC IC236, analog/basic/mos_track_hold.hpp:42
        I(TRACK13, cpphdl_n1819) <+ 8.0000000000000006e-15 * ddt(V(TRACK13, cpphdl_n1819)); // Bench initial voltage = -1.6499999999999999 V.
        // device 1505, IC IC236, analog/basic/mos_track_hold.hpp:43
        I(cpphdl_n1765, cpphdl_n1819) <+ 8.0000000000000006e-15 * ddt(V(cpphdl_n1765, cpphdl_n1819)); // Bench initial voltage = 1.6499999999999999 V.
        // device 1506, IC IC236, analog/basic/mos_track_hold.hpp:44
        I(IN, cpphdl_n1819) <+ 4.0000000000000003e-15 * ddt(V(IN, cpphdl_n1819)); // Bench initial voltage = 0.0 V.
        // device 1507, IC IC239, analog/basic/inverter.hpp:11
        I(cpphdl_n1780, Vdd) <+ cpphdl_channel(V(BIT_N13_0, Vdd), V(cpphdl_n1780, Vdd), 0.080000000000000002, 0.69999999999999996, -1.0);
        // device 1508, IC IC239, analog/basic/inverter.hpp:12
        I(cpphdl_n1780, Vss) <+ cpphdl_channel(V(BIT_N13_0, Vss), V(cpphdl_n1780, Vss), 0.080000000000000002, 0.69999999999999996, 1.0);
        // device 1509, IC IC238, analog/basic/mos_r2r_dac.hpp:27
        I(cpphdl_n1780, Vss) <+ 2.9999999999999998e-15 * ddt(V(cpphdl_n1780, Vss)); // Bench initial voltage = 0.0 V.
        // device 1510, IC IC238, analog/basic/mos_r2r_dac.hpp:28
        I(cpphdl_n1780, cpphdl_n1809) <+ V(cpphdl_n1780, cpphdl_n1809) / 20000.0;
        // device 1511, IC IC238, analog/basic/mos_r2r_dac.hpp:29
        I(cpphdl_n1809, Vss) <+ 2.9999999999999998e-15 * ddt(V(cpphdl_n1809, Vss)); // Bench initial voltage = 0.0 V.
        // device 1512, IC IC240, analog/basic/inverter.hpp:11
        I(cpphdl_n1784, Vdd) <+ cpphdl_channel(V(BIT_N13_1, Vdd), V(cpphdl_n1784, Vdd), 0.080000000000000002, 0.69999999999999996, -1.0);
        // device 1513, IC IC240, analog/basic/inverter.hpp:12
        I(cpphdl_n1784, Vss) <+ cpphdl_channel(V(BIT_N13_1, Vss), V(cpphdl_n1784, Vss), 0.080000000000000002, 0.69999999999999996, 1.0);
        // device 1514, IC IC238, analog/basic/mos_r2r_dac.hpp:27
        I(cpphdl_n1784, Vss) <+ 2.9999999999999998e-15 * ddt(V(cpphdl_n1784, Vss)); // Bench initial voltage = 0.0 V.
        // device 1515, IC IC238, analog/basic/mos_r2r_dac.hpp:28
        I(cpphdl_n1784, cpphdl_n1810) <+ V(cpphdl_n1784, cpphdl_n1810) / 20000.0;
        // device 1516, IC IC238, analog/basic/mos_r2r_dac.hpp:29
        I(cpphdl_n1810, Vss) <+ 2.9999999999999998e-15 * ddt(V(cpphdl_n1810, Vss)); // Bench initial voltage = 0.0 V.
        // device 1517, IC IC238, analog/basic/mos_r2r_dac.hpp:31
        I(cpphdl_n1809, cpphdl_n1810) <+ V(cpphdl_n1809, cpphdl_n1810) / 10000.0;
        // device 1518, IC IC241, analog/basic/inverter.hpp:11
        I(cpphdl_n1788, Vdd) <+ cpphdl_channel(V(BIT_N13_2, Vdd), V(cpphdl_n1788, Vdd), 0.080000000000000002, 0.69999999999999996, -1.0);
        // device 1519, IC IC241, analog/basic/inverter.hpp:12
        I(cpphdl_n1788, Vss) <+ cpphdl_channel(V(BIT_N13_2, Vss), V(cpphdl_n1788, Vss), 0.080000000000000002, 0.69999999999999996, 1.0);
        // device 1520, IC IC238, analog/basic/mos_r2r_dac.hpp:27
        I(cpphdl_n1788, Vss) <+ 2.9999999999999998e-15 * ddt(V(cpphdl_n1788, Vss)); // Bench initial voltage = 0.0 V.
        // device 1521, IC IC238, analog/basic/mos_r2r_dac.hpp:28
        I(cpphdl_n1788, cpphdl_n1811) <+ V(cpphdl_n1788, cpphdl_n1811) / 20000.0;
        // device 1522, IC IC238, analog/basic/mos_r2r_dac.hpp:29
        I(cpphdl_n1811, Vss) <+ 2.9999999999999998e-15 * ddt(V(cpphdl_n1811, Vss)); // Bench initial voltage = 0.0 V.
        // device 1523, IC IC238, analog/basic/mos_r2r_dac.hpp:31
        I(cpphdl_n1810, cpphdl_n1811) <+ V(cpphdl_n1810, cpphdl_n1811) / 10000.0;
        // device 1524, IC IC242, analog/basic/inverter.hpp:11
        I(cpphdl_n1792, Vdd) <+ cpphdl_channel(V(BIT_N13_3, Vdd), V(cpphdl_n1792, Vdd), 0.080000000000000002, 0.69999999999999996, -1.0);
        // device 1525, IC IC242, analog/basic/inverter.hpp:12
        I(cpphdl_n1792, Vss) <+ cpphdl_channel(V(BIT_N13_3, Vss), V(cpphdl_n1792, Vss), 0.080000000000000002, 0.69999999999999996, 1.0);
        // device 1526, IC IC238, analog/basic/mos_r2r_dac.hpp:27
        I(cpphdl_n1792, Vss) <+ 2.9999999999999998e-15 * ddt(V(cpphdl_n1792, Vss)); // Bench initial voltage = 0.0 V.
        // device 1527, IC IC238, analog/basic/mos_r2r_dac.hpp:28
        I(cpphdl_n1792, cpphdl_n1812) <+ V(cpphdl_n1792, cpphdl_n1812) / 20000.0;
        // device 1528, IC IC238, analog/basic/mos_r2r_dac.hpp:29
        I(cpphdl_n1812, Vss) <+ 2.9999999999999998e-15 * ddt(V(cpphdl_n1812, Vss)); // Bench initial voltage = 0.0 V.
        // device 1529, IC IC238, analog/basic/mos_r2r_dac.hpp:31
        I(cpphdl_n1811, cpphdl_n1812) <+ V(cpphdl_n1811, cpphdl_n1812) / 10000.0;
        // device 1530, IC IC243, analog/basic/inverter.hpp:11
        I(cpphdl_n1796, Vdd) <+ cpphdl_channel(V(BIT_N13_4, Vdd), V(cpphdl_n1796, Vdd), 0.080000000000000002, 0.69999999999999996, -1.0);
        // device 1531, IC IC243, analog/basic/inverter.hpp:12
        I(cpphdl_n1796, Vss) <+ cpphdl_channel(V(BIT_N13_4, Vss), V(cpphdl_n1796, Vss), 0.080000000000000002, 0.69999999999999996, 1.0);
        // device 1532, IC IC238, analog/basic/mos_r2r_dac.hpp:27
        I(cpphdl_n1796, Vss) <+ 2.9999999999999998e-15 * ddt(V(cpphdl_n1796, Vss)); // Bench initial voltage = 0.0 V.
        // device 1533, IC IC238, analog/basic/mos_r2r_dac.hpp:28
        I(cpphdl_n1796, cpphdl_n1813) <+ V(cpphdl_n1796, cpphdl_n1813) / 20000.0;
        // device 1534, IC IC238, analog/basic/mos_r2r_dac.hpp:29
        I(cpphdl_n1813, Vss) <+ 2.9999999999999998e-15 * ddt(V(cpphdl_n1813, Vss)); // Bench initial voltage = 0.0 V.
        // device 1535, IC IC238, analog/basic/mos_r2r_dac.hpp:31
        I(cpphdl_n1812, cpphdl_n1813) <+ V(cpphdl_n1812, cpphdl_n1813) / 10000.0;
        // device 1536, IC IC244, analog/basic/inverter.hpp:11
        I(cpphdl_n1800, Vdd) <+ cpphdl_channel(V(BIT_N13_5, Vdd), V(cpphdl_n1800, Vdd), 0.080000000000000002, 0.69999999999999996, -1.0);
        // device 1537, IC IC244, analog/basic/inverter.hpp:12
        I(cpphdl_n1800, Vss) <+ cpphdl_channel(V(BIT_N13_5, Vss), V(cpphdl_n1800, Vss), 0.080000000000000002, 0.69999999999999996, 1.0);
        // device 1538, IC IC238, analog/basic/mos_r2r_dac.hpp:27
        I(cpphdl_n1800, Vss) <+ 2.9999999999999998e-15 * ddt(V(cpphdl_n1800, Vss)); // Bench initial voltage = 0.0 V.
        // device 1539, IC IC238, analog/basic/mos_r2r_dac.hpp:28
        I(cpphdl_n1800, cpphdl_n1814) <+ V(cpphdl_n1800, cpphdl_n1814) / 20000.0;
        // device 1540, IC IC238, analog/basic/mos_r2r_dac.hpp:29
        I(cpphdl_n1814, Vss) <+ 2.9999999999999998e-15 * ddt(V(cpphdl_n1814, Vss)); // Bench initial voltage = 0.0 V.
        // device 1541, IC IC238, analog/basic/mos_r2r_dac.hpp:31
        I(cpphdl_n1813, cpphdl_n1814) <+ V(cpphdl_n1813, cpphdl_n1814) / 10000.0;
        // device 1542, IC IC245, analog/basic/inverter.hpp:11
        I(cpphdl_n1804, Vdd) <+ cpphdl_channel(V(BIT_N13_6, Vdd), V(cpphdl_n1804, Vdd), 0.080000000000000002, 0.69999999999999996, -1.0);
        // device 1543, IC IC245, analog/basic/inverter.hpp:12
        I(cpphdl_n1804, Vss) <+ cpphdl_channel(V(BIT_N13_6, Vss), V(cpphdl_n1804, Vss), 0.080000000000000002, 0.69999999999999996, 1.0);
        // device 1544, IC IC238, analog/basic/mos_r2r_dac.hpp:27
        I(cpphdl_n1804, Vss) <+ 2.9999999999999998e-15 * ddt(V(cpphdl_n1804, Vss)); // Bench initial voltage = 0.0 V.
        // device 1545, IC IC238, analog/basic/mos_r2r_dac.hpp:28
        I(cpphdl_n1804, cpphdl_n1815) <+ V(cpphdl_n1804, cpphdl_n1815) / 20000.0;
        // device 1546, IC IC238, analog/basic/mos_r2r_dac.hpp:29
        I(cpphdl_n1815, Vss) <+ 2.9999999999999998e-15 * ddt(V(cpphdl_n1815, Vss)); // Bench initial voltage = 0.0 V.
        // device 1547, IC IC238, analog/basic/mos_r2r_dac.hpp:31
        I(cpphdl_n1814, cpphdl_n1815) <+ V(cpphdl_n1814, cpphdl_n1815) / 10000.0;
        // device 1548, IC IC246, analog/basic/inverter.hpp:11
        I(cpphdl_n1808, Vdd) <+ cpphdl_channel(V(BIT_N13_7, Vdd), V(cpphdl_n1808, Vdd), 0.080000000000000002, 0.69999999999999996, -1.0);
        // device 1549, IC IC246, analog/basic/inverter.hpp:12
        I(cpphdl_n1808, Vss) <+ cpphdl_channel(V(BIT_N13_7, Vss), V(cpphdl_n1808, Vss), 0.080000000000000002, 0.69999999999999996, 1.0);
        // device 1550, IC IC238, analog/basic/mos_r2r_dac.hpp:27
        I(cpphdl_n1808, Vss) <+ 2.9999999999999998e-15 * ddt(V(cpphdl_n1808, Vss)); // Bench initial voltage = 0.0 V.
        // device 1551, IC IC238, analog/basic/mos_r2r_dac.hpp:28
        I(cpphdl_n1808, cpphdl_n1820) <+ V(cpphdl_n1808, cpphdl_n1820) / 20000.0;
        // device 1552, IC IC238, analog/basic/mos_r2r_dac.hpp:29
        I(cpphdl_n1820, Vss) <+ 2.9999999999999998e-15 * ddt(V(cpphdl_n1820, Vss)); // Bench initial voltage = 0.0 V.
        // device 1553, IC IC238, analog/basic/mos_r2r_dac.hpp:31
        I(cpphdl_n1815, cpphdl_n1820) <+ V(cpphdl_n1815, cpphdl_n1820) / 10000.0;
        // device 1554, IC IC238, analog/basic/mos_r2r_dac.hpp:33
        I(Vss, cpphdl_n1809) <+ V(Vss, cpphdl_n1809) / 20000.0;
        // device 1555, IC IC247, analog/basic/nmos_resistor_amplifier.hpp:23
        I(Vdd, cpphdl_n1829) <+ V(Vdd, cpphdl_n1829) / 1000.0;
        // device 1556, IC IC247, analog/basic/nmos_resistor_amplifier.hpp:24
        I(Vdd, cpphdl_n1828) <+ V(Vdd, cpphdl_n1828) / 1000.0;
        // device 1557, IC IC247, analog/basic/nmos_resistor_amplifier.hpp:25
        I(cpphdl_n1829, cpphdl_n1823) <+ cpphdl_channel(V(cpphdl_n1819, cpphdl_n1823), V(cpphdl_n1829, cpphdl_n1823), 0.014999999999999999, 0.69999999999999996, 1.0);
        // device 1558, IC IC247, analog/basic/nmos_resistor_amplifier.hpp:26
        I(cpphdl_n1828, cpphdl_n1824) <+ cpphdl_channel(V(cpphdl_n1820, cpphdl_n1824), V(cpphdl_n1828, cpphdl_n1824), 0.014999999999999999, 0.69999999999999996, 1.0);
        // device 1559, IC IC247, analog/basic/nmos_resistor_amplifier.hpp:27
        I(cpphdl_n1825, cpphdl_n1823) <+ V(cpphdl_n1825, cpphdl_n1823) / 50.0;
        // device 1560, IC IC247, analog/basic/nmos_resistor_amplifier.hpp:28
        I(cpphdl_n1825, cpphdl_n1824) <+ V(cpphdl_n1825, cpphdl_n1824) / 50.0;
        // device 1561, IC IC247, analog/basic/nmos_resistor_amplifier.hpp:29
        I(Vss, cpphdl_n1825) <+ V(Vss, cpphdl_n1825) / 150.0;
        // device 1562, IC IC247, analog/basic/nmos_resistor_amplifier.hpp:30
        I(cpphdl_n1829, Vdd) <+ 2.9999999999999998e-13 * ddt(V(cpphdl_n1829, Vdd)); // Bench initial voltage = 0.0 V.
        // device 1563, IC IC247, analog/basic/nmos_resistor_amplifier.hpp:31
        I(cpphdl_n1828, Vdd) <+ 2.9999999999999998e-13 * ddt(V(cpphdl_n1828, Vdd)); // Bench initial voltage = 0.0 V.
        // device 1564, IC IC247, analog/basic/nmos_resistor_amplifier.hpp:32
        I(cpphdl_n1825, Vss) <+ 4e-14 * ddt(V(cpphdl_n1825, Vss)); // Bench initial voltage = 0.0 V.
        // device 1565, IC IC247, analog/basic/nmos_resistor_amplifier.hpp:34
        I(cpphdl_n1819, cpphdl_n1823) <+ 2e-14 * ddt(V(cpphdl_n1819, cpphdl_n1823)); // Bench initial voltage = 1.6499999999999999 V.
        // device 1566, IC IC247, analog/basic/nmos_resistor_amplifier.hpp:35
        I(cpphdl_n1820, cpphdl_n1824) <+ 2e-14 * ddt(V(cpphdl_n1820, cpphdl_n1824)); // Bench initial voltage = 0.0 V.
        // device 1567, IC IC247, analog/basic/nmos_resistor_amplifier.hpp:36
        I(cpphdl_n1819, cpphdl_n1829) <+ 2.9999999999999998e-15 * ddt(V(cpphdl_n1819, cpphdl_n1829)); // Bench initial voltage = -1.6499999999999999 V.
        // device 1568, IC IC247, analog/basic/nmos_resistor_amplifier.hpp:37
        I(cpphdl_n1820, cpphdl_n1828) <+ 2.9999999999999998e-15 * ddt(V(cpphdl_n1820, cpphdl_n1828)); // Bench initial voltage = -3.2999999999999998 V.
        // device 1569, IC IC248, analog/basic/strongarm_comparator.hpp:28
        I(cpphdl_n1833, cpphdl_n1835) <+ cpphdl_channel(V(cpphdl_n1828, cpphdl_n1835), V(cpphdl_n1833, cpphdl_n1835), 0.0080000000000000002, 0.69999999999999996, 1.0);
        // device 1570, IC IC248, analog/basic/strongarm_comparator.hpp:29
        I(cpphdl_n1834, cpphdl_n1835) <+ cpphdl_channel(V(cpphdl_n1829, cpphdl_n1835), V(cpphdl_n1834, cpphdl_n1835), 0.0080000000000000002, 0.69999999999999996, 1.0);
        // device 1571, IC IC248, analog/basic/strongarm_comparator.hpp:30
        I(cpphdl_n1835, Vss) <+ cpphdl_channel(V(EVALUATE, Vss), V(cpphdl_n1835, Vss), 0.0080000000000000002, 0.69999999999999996, 1.0);
        // device 1572, IC IC248, analog/basic/strongarm_comparator.hpp:33
        I(cpphdl_n1847, cpphdl_n1833) <+ cpphdl_channel(V(cpphdl_n1853, cpphdl_n1833), V(cpphdl_n1847, cpphdl_n1833), 0.0040000000000000001, 0.69999999999999996, 1.0);
        // device 1573, IC IC248, analog/basic/strongarm_comparator.hpp:34
        I(cpphdl_n1853, cpphdl_n1834) <+ cpphdl_channel(V(cpphdl_n1847, cpphdl_n1834), V(cpphdl_n1853, cpphdl_n1834), 0.0040000000000000001, 0.69999999999999996, 1.0);
        // device 1574, IC IC248, analog/basic/strongarm_comparator.hpp:35
        I(cpphdl_n1853, Vdd) <+ cpphdl_channel(V(cpphdl_n1847, Vdd), V(cpphdl_n1853, Vdd), 0.002, 0.69999999999999996, -1.0);
        // device 1575, IC IC248, analog/basic/strongarm_comparator.hpp:36
        I(cpphdl_n1847, Vdd) <+ cpphdl_channel(V(cpphdl_n1853, Vdd), V(cpphdl_n1847, Vdd), 0.002, 0.69999999999999996, -1.0);
        // device 1576, IC IC248, analog/basic/strongarm_comparator.hpp:38
        I(cpphdl_n1833, Vdd) <+ cpphdl_channel(V(EVALUATE, Vdd), V(cpphdl_n1833, Vdd), 0.002, 0.69999999999999996, -1.0);
        // device 1577, IC IC248, analog/basic/strongarm_comparator.hpp:39
        I(cpphdl_n1834, Vdd) <+ cpphdl_channel(V(EVALUATE, Vdd), V(cpphdl_n1834, Vdd), 0.002, 0.69999999999999996, -1.0);
        // device 1578, IC IC248, analog/basic/strongarm_comparator.hpp:40
        I(cpphdl_n1853, Vdd) <+ cpphdl_channel(V(EVALUATE, Vdd), V(cpphdl_n1853, Vdd), 0.002, 0.69999999999999996, -1.0);
        // device 1579, IC IC248, analog/basic/strongarm_comparator.hpp:41
        I(cpphdl_n1847, Vdd) <+ cpphdl_channel(V(EVALUATE, Vdd), V(cpphdl_n1847, Vdd), 0.002, 0.69999999999999996, -1.0);
        // device 1580, IC IC248, analog/basic/strongarm_comparator.hpp:42
        I(cpphdl_n1833, Vss) <+ 2.9999999999999998e-14 * ddt(V(cpphdl_n1833, Vss)); // Bench initial voltage = 0.0 V.
        // device 1581, IC IC248, analog/basic/strongarm_comparator.hpp:43
        I(cpphdl_n1834, Vss) <+ 2.9999999999999998e-14 * ddt(V(cpphdl_n1834, Vss)); // Bench initial voltage = 0.0 V.
        // device 1582, IC IC248, analog/basic/strongarm_comparator.hpp:44
        I(cpphdl_n1835, Vss) <+ 2.9999999999999998e-14 * ddt(V(cpphdl_n1835, Vss)); // Bench initial voltage = 0.0 V.
        // device 1583, IC IC248, analog/basic/strongarm_comparator.hpp:45
        I(cpphdl_n1853, Vss) <+ 5.0000000000000002e-14 * ddt(V(cpphdl_n1853, Vss)); // Bench initial voltage = 0.0 V.
        // device 1584, IC IC248, analog/basic/strongarm_comparator.hpp:46
        I(cpphdl_n1847, Vss) <+ 5.0000000000000002e-14 * ddt(V(cpphdl_n1847, Vss)); // Bench initial voltage = 0.0 V.
        // device 1585, IC IC248, analog/basic/strongarm_comparator.hpp:47
        I(cpphdl_n1828, cpphdl_n1835) <+ 2e-14 * ddt(V(cpphdl_n1828, cpphdl_n1835)); // Bench initial voltage = 3.2999999999999998 V.
        // device 1586, IC IC248, analog/basic/strongarm_comparator.hpp:48
        I(cpphdl_n1829, cpphdl_n1835) <+ 2e-14 * ddt(V(cpphdl_n1829, cpphdl_n1835)); // Bench initial voltage = 3.2999999999999998 V.
        // device 1587, IC IC248, analog/basic/strongarm_comparator.hpp:49
        I(cpphdl_n1828, cpphdl_n1833) <+ 2.9999999999999998e-15 * ddt(V(cpphdl_n1828, cpphdl_n1833)); // Bench initial voltage = 3.2999999999999998 V.
        // device 1588, IC IC248, analog/basic/strongarm_comparator.hpp:50
        I(cpphdl_n1829, cpphdl_n1834) <+ 2.9999999999999998e-15 * ddt(V(cpphdl_n1829, cpphdl_n1834)); // Bench initial voltage = 3.2999999999999998 V.
        // device 1589, IC IC250, analog/basic/cmos_logic.hpp:17
        I(DECISION13, Vss) <+ 5.0000000000000002e-14 * ddt(V(DECISION13, Vss)); // Bench initial voltage = 0.0 V.
        // device 1590, IC IC250, analog/basic/cmos_logic.hpp:18
        I(DECISION13, Vdd) <+ cpphdl_channel(V(cpphdl_n1847, Vdd), V(DECISION13, Vdd), 0.01, 0.69999999999999996, -1.0);
        // device 1591, IC IC250, analog/basic/cmos_logic.hpp:19
        I(DECISION13, Vdd) <+ cpphdl_channel(V(DECISION_N13, Vdd), V(DECISION13, Vdd), 0.01, 0.69999999999999996, -1.0);
        // device 1592, IC IC250, analog/basic/cmos_logic.hpp:20
        I(DECISION13, cpphdl_n1850) <+ cpphdl_channel(V(cpphdl_n1847, cpphdl_n1850), V(DECISION13, cpphdl_n1850), 0.01, 0.69999999999999996, 1.0);
        // device 1593, IC IC250, analog/basic/cmos_logic.hpp:21
        I(cpphdl_n1850, Vss) <+ cpphdl_channel(V(DECISION_N13, Vss), V(cpphdl_n1850, Vss), 0.01, 0.69999999999999996, 1.0);
        // device 1594, IC IC250, analog/basic/cmos_logic.hpp:23
        I(DECISION13, Vss) <+ V(DECISION13, Vss) / 1000000000.0;
        // device 1595, IC IC250, analog/basic/cmos_logic.hpp:24
        I(cpphdl_n1850, Vss) <+ V(cpphdl_n1850, Vss) / 1000000000.0;
        // device 1596, IC IC251, analog/basic/cmos_logic.hpp:17
        I(DECISION_N13, Vss) <+ 5.0000000000000002e-14 * ddt(V(DECISION_N13, Vss)); // Bench initial voltage = 0.0 V.
        // device 1597, IC IC251, analog/basic/cmos_logic.hpp:18
        I(DECISION_N13, Vdd) <+ cpphdl_channel(V(cpphdl_n1853, Vdd), V(DECISION_N13, Vdd), 0.01, 0.69999999999999996, -1.0);
        // device 1598, IC IC251, analog/basic/cmos_logic.hpp:19
        I(DECISION_N13, Vdd) <+ cpphdl_channel(V(DECISION13, Vdd), V(DECISION_N13, Vdd), 0.01, 0.69999999999999996, -1.0);
        // device 1599, IC IC251, analog/basic/cmos_logic.hpp:20
        I(DECISION_N13, cpphdl_n1856) <+ cpphdl_channel(V(cpphdl_n1853, cpphdl_n1856), V(DECISION_N13, cpphdl_n1856), 0.01, 0.69999999999999996, 1.0);
        // device 1600, IC IC251, analog/basic/cmos_logic.hpp:21
        I(cpphdl_n1856, Vss) <+ cpphdl_channel(V(DECISION13, Vss), V(cpphdl_n1856, Vss), 0.01, 0.69999999999999996, 1.0);
        // device 1601, IC IC251, analog/basic/cmos_logic.hpp:23
        I(DECISION_N13, Vss) <+ V(DECISION_N13, Vss) / 1000000000.0;
        // device 1602, IC IC251, analog/basic/cmos_logic.hpp:24
        I(cpphdl_n1856, Vss) <+ V(cpphdl_n1856, Vss) / 1000000000.0;
        // device 1603, IC IC249, analog/basic/nand_latch.hpp:36
        I(cpphdl_n1847, Vss) <+ 2.9999999999999998e-15 * ddt(V(cpphdl_n1847, Vss)); // Bench initial voltage = 0.0 V.
        // device 1604, IC IC249, analog/basic/nand_latch.hpp:37
        I(cpphdl_n1853, Vss) <+ 2.9999999999999998e-15 * ddt(V(cpphdl_n1853, Vss)); // Bench initial voltage = 0.0 V.
        // device 1605, IC IC252, analog/basic/inverter.hpp:11
        I(cpphdl_n1861, Vdd) <+ cpphdl_channel(V(CLEAR, Vdd), V(cpphdl_n1861, Vdd), 0.01, 0.69999999999999996, -1.0);
        // device 1606, IC IC252, analog/basic/inverter.hpp:12
        I(cpphdl_n1861, Vss) <+ cpphdl_channel(V(CLEAR, Vss), V(cpphdl_n1861, Vss), 0.01, 0.69999999999999996, 1.0);
        // device 1607, IC IC249, analog/basic/nand_latch.hpp:58
        I(cpphdl_n1861, Vss) <+ 2.9999999999999998e-15 * ddt(V(cpphdl_n1861, Vss)); // Bench initial voltage = 0.0 V.
        // device 1608, IC IC249, analog/basic/nand_latch.hpp:59
        I(DECISION13, Vss) <+ cpphdl_channel(V(CLEAR, Vss), V(DECISION13, Vss), 0.050000000000000003, 0.69999999999999996, 1.0);
        // device 1609, IC IC249, analog/basic/nand_latch.hpp:60
        I(DECISION_N13, Vdd) <+ cpphdl_channel(V(cpphdl_n1861, Vdd), V(DECISION_N13, Vdd), 0.050000000000000003, 0.69999999999999996, -1.0);
        // device 1610, IC IC255, analog/basic/inverter.hpp:11
        I(cpphdl_n1885, Vdd) <+ cpphdl_channel(V(TRACK14, Vdd), V(cpphdl_n1885, Vdd), 0.0040000000000000001, 0.69999999999999996, -1.0);
        // device 1611, IC IC255, analog/basic/inverter.hpp:12
        I(cpphdl_n1885, Vss) <+ cpphdl_channel(V(TRACK14, Vss), V(cpphdl_n1885, Vss), 0.0040000000000000001, 0.69999999999999996, 1.0);
        // device 1612, IC IC254, analog/basic/mos_track_hold.hpp:31
        I(cpphdl_n1885, Vss) <+ 2e-14 * ddt(V(cpphdl_n1885, Vss)); // Bench initial voltage = 3.2999999999999998 V.
        // device 1613, IC IC254, analog/basic/mos_track_hold.hpp:32
        I(IN, cpphdl_n1939) <+ cpphdl_channel(V(TRACK14, cpphdl_n1939), V(IN, cpphdl_n1939), 0.080000000000000002, 0.69999999999999996, 1.0);
        // device 1614, IC IC254, analog/basic/mos_track_hold.hpp:33
        I(cpphdl_n1939, IN) <+ cpphdl_channel(V(cpphdl_n1885, IN), V(cpphdl_n1939, IN), 0.040000000000000001, 0.69999999999999996, -1.0);
        // device 1615, IC IC254, analog/basic/mos_track_hold.hpp:37
        I(cpphdl_n1939, cpphdl_n1939) <+ cpphdl_channel(V(cpphdl_n1885, cpphdl_n1939), V(cpphdl_n1939, cpphdl_n1939), 0.040000000000000001, 0.69999999999999996, 1.0);
        // device 1616, IC IC254, analog/basic/mos_track_hold.hpp:38
        I(cpphdl_n1939, cpphdl_n1939) <+ cpphdl_channel(V(TRACK14, cpphdl_n1939), V(cpphdl_n1939, cpphdl_n1939), 0.02, 0.69999999999999996, -1.0);
        // device 1617, IC IC254, analog/basic/mos_track_hold.hpp:39
        I(cpphdl_n1939, Vss) <+ 2e-12 * ddt(V(cpphdl_n1939, Vss)); // Bench initial voltage = 1.6499999999999999 V.
        // device 1618, IC IC254, analog/basic/mos_track_hold.hpp:41
        I(Vss, cpphdl_n1939) <+ V(Vss, cpphdl_n1939) / 1000000000.0;
        // device 1619, IC IC254, analog/basic/mos_track_hold.hpp:42
        I(TRACK14, cpphdl_n1939) <+ 8.0000000000000006e-15 * ddt(V(TRACK14, cpphdl_n1939)); // Bench initial voltage = -1.6499999999999999 V.
        // device 1620, IC IC254, analog/basic/mos_track_hold.hpp:43
        I(cpphdl_n1885, cpphdl_n1939) <+ 8.0000000000000006e-15 * ddt(V(cpphdl_n1885, cpphdl_n1939)); // Bench initial voltage = 1.6499999999999999 V.
        // device 1621, IC IC254, analog/basic/mos_track_hold.hpp:44
        I(IN, cpphdl_n1939) <+ 4.0000000000000003e-15 * ddt(V(IN, cpphdl_n1939)); // Bench initial voltage = 0.0 V.
        // device 1622, IC IC257, analog/basic/inverter.hpp:11
        I(cpphdl_n1900, Vdd) <+ cpphdl_channel(V(BIT_N14_0, Vdd), V(cpphdl_n1900, Vdd), 0.080000000000000002, 0.69999999999999996, -1.0);
        // device 1623, IC IC257, analog/basic/inverter.hpp:12
        I(cpphdl_n1900, Vss) <+ cpphdl_channel(V(BIT_N14_0, Vss), V(cpphdl_n1900, Vss), 0.080000000000000002, 0.69999999999999996, 1.0);
        // device 1624, IC IC256, analog/basic/mos_r2r_dac.hpp:27
        I(cpphdl_n1900, Vss) <+ 2.9999999999999998e-15 * ddt(V(cpphdl_n1900, Vss)); // Bench initial voltage = 0.0 V.
        // device 1625, IC IC256, analog/basic/mos_r2r_dac.hpp:28
        I(cpphdl_n1900, cpphdl_n1929) <+ V(cpphdl_n1900, cpphdl_n1929) / 20000.0;
        // device 1626, IC IC256, analog/basic/mos_r2r_dac.hpp:29
        I(cpphdl_n1929, Vss) <+ 2.9999999999999998e-15 * ddt(V(cpphdl_n1929, Vss)); // Bench initial voltage = 0.0 V.
        // device 1627, IC IC258, analog/basic/inverter.hpp:11
        I(cpphdl_n1904, Vdd) <+ cpphdl_channel(V(BIT_N14_1, Vdd), V(cpphdl_n1904, Vdd), 0.080000000000000002, 0.69999999999999996, -1.0);
        // device 1628, IC IC258, analog/basic/inverter.hpp:12
        I(cpphdl_n1904, Vss) <+ cpphdl_channel(V(BIT_N14_1, Vss), V(cpphdl_n1904, Vss), 0.080000000000000002, 0.69999999999999996, 1.0);
        // device 1629, IC IC256, analog/basic/mos_r2r_dac.hpp:27
        I(cpphdl_n1904, Vss) <+ 2.9999999999999998e-15 * ddt(V(cpphdl_n1904, Vss)); // Bench initial voltage = 0.0 V.
        // device 1630, IC IC256, analog/basic/mos_r2r_dac.hpp:28
        I(cpphdl_n1904, cpphdl_n1930) <+ V(cpphdl_n1904, cpphdl_n1930) / 20000.0;
        // device 1631, IC IC256, analog/basic/mos_r2r_dac.hpp:29
        I(cpphdl_n1930, Vss) <+ 2.9999999999999998e-15 * ddt(V(cpphdl_n1930, Vss)); // Bench initial voltage = 0.0 V.
        // device 1632, IC IC256, analog/basic/mos_r2r_dac.hpp:31
        I(cpphdl_n1929, cpphdl_n1930) <+ V(cpphdl_n1929, cpphdl_n1930) / 10000.0;
        // device 1633, IC IC259, analog/basic/inverter.hpp:11
        I(cpphdl_n1908, Vdd) <+ cpphdl_channel(V(BIT_N14_2, Vdd), V(cpphdl_n1908, Vdd), 0.080000000000000002, 0.69999999999999996, -1.0);
        // device 1634, IC IC259, analog/basic/inverter.hpp:12
        I(cpphdl_n1908, Vss) <+ cpphdl_channel(V(BIT_N14_2, Vss), V(cpphdl_n1908, Vss), 0.080000000000000002, 0.69999999999999996, 1.0);
        // device 1635, IC IC256, analog/basic/mos_r2r_dac.hpp:27
        I(cpphdl_n1908, Vss) <+ 2.9999999999999998e-15 * ddt(V(cpphdl_n1908, Vss)); // Bench initial voltage = 0.0 V.
        // device 1636, IC IC256, analog/basic/mos_r2r_dac.hpp:28
        I(cpphdl_n1908, cpphdl_n1931) <+ V(cpphdl_n1908, cpphdl_n1931) / 20000.0;
        // device 1637, IC IC256, analog/basic/mos_r2r_dac.hpp:29
        I(cpphdl_n1931, Vss) <+ 2.9999999999999998e-15 * ddt(V(cpphdl_n1931, Vss)); // Bench initial voltage = 0.0 V.
        // device 1638, IC IC256, analog/basic/mos_r2r_dac.hpp:31
        I(cpphdl_n1930, cpphdl_n1931) <+ V(cpphdl_n1930, cpphdl_n1931) / 10000.0;
        // device 1639, IC IC260, analog/basic/inverter.hpp:11
        I(cpphdl_n1912, Vdd) <+ cpphdl_channel(V(BIT_N14_3, Vdd), V(cpphdl_n1912, Vdd), 0.080000000000000002, 0.69999999999999996, -1.0);
        // device 1640, IC IC260, analog/basic/inverter.hpp:12
        I(cpphdl_n1912, Vss) <+ cpphdl_channel(V(BIT_N14_3, Vss), V(cpphdl_n1912, Vss), 0.080000000000000002, 0.69999999999999996, 1.0);
        // device 1641, IC IC256, analog/basic/mos_r2r_dac.hpp:27
        I(cpphdl_n1912, Vss) <+ 2.9999999999999998e-15 * ddt(V(cpphdl_n1912, Vss)); // Bench initial voltage = 0.0 V.
        // device 1642, IC IC256, analog/basic/mos_r2r_dac.hpp:28
        I(cpphdl_n1912, cpphdl_n1932) <+ V(cpphdl_n1912, cpphdl_n1932) / 20000.0;
        // device 1643, IC IC256, analog/basic/mos_r2r_dac.hpp:29
        I(cpphdl_n1932, Vss) <+ 2.9999999999999998e-15 * ddt(V(cpphdl_n1932, Vss)); // Bench initial voltage = 0.0 V.
        // device 1644, IC IC256, analog/basic/mos_r2r_dac.hpp:31
        I(cpphdl_n1931, cpphdl_n1932) <+ V(cpphdl_n1931, cpphdl_n1932) / 10000.0;
        // device 1645, IC IC261, analog/basic/inverter.hpp:11
        I(cpphdl_n1916, Vdd) <+ cpphdl_channel(V(BIT_N14_4, Vdd), V(cpphdl_n1916, Vdd), 0.080000000000000002, 0.69999999999999996, -1.0);
        // device 1646, IC IC261, analog/basic/inverter.hpp:12
        I(cpphdl_n1916, Vss) <+ cpphdl_channel(V(BIT_N14_4, Vss), V(cpphdl_n1916, Vss), 0.080000000000000002, 0.69999999999999996, 1.0);
        // device 1647, IC IC256, analog/basic/mos_r2r_dac.hpp:27
        I(cpphdl_n1916, Vss) <+ 2.9999999999999998e-15 * ddt(V(cpphdl_n1916, Vss)); // Bench initial voltage = 0.0 V.
        // device 1648, IC IC256, analog/basic/mos_r2r_dac.hpp:28
        I(cpphdl_n1916, cpphdl_n1933) <+ V(cpphdl_n1916, cpphdl_n1933) / 20000.0;
        // device 1649, IC IC256, analog/basic/mos_r2r_dac.hpp:29
        I(cpphdl_n1933, Vss) <+ 2.9999999999999998e-15 * ddt(V(cpphdl_n1933, Vss)); // Bench initial voltage = 0.0 V.
        // device 1650, IC IC256, analog/basic/mos_r2r_dac.hpp:31
        I(cpphdl_n1932, cpphdl_n1933) <+ V(cpphdl_n1932, cpphdl_n1933) / 10000.0;
        // device 1651, IC IC262, analog/basic/inverter.hpp:11
        I(cpphdl_n1920, Vdd) <+ cpphdl_channel(V(BIT_N14_5, Vdd), V(cpphdl_n1920, Vdd), 0.080000000000000002, 0.69999999999999996, -1.0);
        // device 1652, IC IC262, analog/basic/inverter.hpp:12
        I(cpphdl_n1920, Vss) <+ cpphdl_channel(V(BIT_N14_5, Vss), V(cpphdl_n1920, Vss), 0.080000000000000002, 0.69999999999999996, 1.0);
        // device 1653, IC IC256, analog/basic/mos_r2r_dac.hpp:27
        I(cpphdl_n1920, Vss) <+ 2.9999999999999998e-15 * ddt(V(cpphdl_n1920, Vss)); // Bench initial voltage = 0.0 V.
        // device 1654, IC IC256, analog/basic/mos_r2r_dac.hpp:28
        I(cpphdl_n1920, cpphdl_n1934) <+ V(cpphdl_n1920, cpphdl_n1934) / 20000.0;
        // device 1655, IC IC256, analog/basic/mos_r2r_dac.hpp:29
        I(cpphdl_n1934, Vss) <+ 2.9999999999999998e-15 * ddt(V(cpphdl_n1934, Vss)); // Bench initial voltage = 0.0 V.
        // device 1656, IC IC256, analog/basic/mos_r2r_dac.hpp:31
        I(cpphdl_n1933, cpphdl_n1934) <+ V(cpphdl_n1933, cpphdl_n1934) / 10000.0;
        // device 1657, IC IC263, analog/basic/inverter.hpp:11
        I(cpphdl_n1924, Vdd) <+ cpphdl_channel(V(BIT_N14_6, Vdd), V(cpphdl_n1924, Vdd), 0.080000000000000002, 0.69999999999999996, -1.0);
        // device 1658, IC IC263, analog/basic/inverter.hpp:12
        I(cpphdl_n1924, Vss) <+ cpphdl_channel(V(BIT_N14_6, Vss), V(cpphdl_n1924, Vss), 0.080000000000000002, 0.69999999999999996, 1.0);
        // device 1659, IC IC256, analog/basic/mos_r2r_dac.hpp:27
        I(cpphdl_n1924, Vss) <+ 2.9999999999999998e-15 * ddt(V(cpphdl_n1924, Vss)); // Bench initial voltage = 0.0 V.
        // device 1660, IC IC256, analog/basic/mos_r2r_dac.hpp:28
        I(cpphdl_n1924, cpphdl_n1935) <+ V(cpphdl_n1924, cpphdl_n1935) / 20000.0;
        // device 1661, IC IC256, analog/basic/mos_r2r_dac.hpp:29
        I(cpphdl_n1935, Vss) <+ 2.9999999999999998e-15 * ddt(V(cpphdl_n1935, Vss)); // Bench initial voltage = 0.0 V.
        // device 1662, IC IC256, analog/basic/mos_r2r_dac.hpp:31
        I(cpphdl_n1934, cpphdl_n1935) <+ V(cpphdl_n1934, cpphdl_n1935) / 10000.0;
        // device 1663, IC IC264, analog/basic/inverter.hpp:11
        I(cpphdl_n1928, Vdd) <+ cpphdl_channel(V(BIT_N14_7, Vdd), V(cpphdl_n1928, Vdd), 0.080000000000000002, 0.69999999999999996, -1.0);
        // device 1664, IC IC264, analog/basic/inverter.hpp:12
        I(cpphdl_n1928, Vss) <+ cpphdl_channel(V(BIT_N14_7, Vss), V(cpphdl_n1928, Vss), 0.080000000000000002, 0.69999999999999996, 1.0);
        // device 1665, IC IC256, analog/basic/mos_r2r_dac.hpp:27
        I(cpphdl_n1928, Vss) <+ 2.9999999999999998e-15 * ddt(V(cpphdl_n1928, Vss)); // Bench initial voltage = 0.0 V.
        // device 1666, IC IC256, analog/basic/mos_r2r_dac.hpp:28
        I(cpphdl_n1928, cpphdl_n1940) <+ V(cpphdl_n1928, cpphdl_n1940) / 20000.0;
        // device 1667, IC IC256, analog/basic/mos_r2r_dac.hpp:29
        I(cpphdl_n1940, Vss) <+ 2.9999999999999998e-15 * ddt(V(cpphdl_n1940, Vss)); // Bench initial voltage = 0.0 V.
        // device 1668, IC IC256, analog/basic/mos_r2r_dac.hpp:31
        I(cpphdl_n1935, cpphdl_n1940) <+ V(cpphdl_n1935, cpphdl_n1940) / 10000.0;
        // device 1669, IC IC256, analog/basic/mos_r2r_dac.hpp:33
        I(Vss, cpphdl_n1929) <+ V(Vss, cpphdl_n1929) / 20000.0;
        // device 1670, IC IC265, analog/basic/nmos_resistor_amplifier.hpp:23
        I(Vdd, cpphdl_n1949) <+ V(Vdd, cpphdl_n1949) / 1000.0;
        // device 1671, IC IC265, analog/basic/nmos_resistor_amplifier.hpp:24
        I(Vdd, cpphdl_n1948) <+ V(Vdd, cpphdl_n1948) / 1000.0;
        // device 1672, IC IC265, analog/basic/nmos_resistor_amplifier.hpp:25
        I(cpphdl_n1949, cpphdl_n1943) <+ cpphdl_channel(V(cpphdl_n1939, cpphdl_n1943), V(cpphdl_n1949, cpphdl_n1943), 0.014999999999999999, 0.69999999999999996, 1.0);
        // device 1673, IC IC265, analog/basic/nmos_resistor_amplifier.hpp:26
        I(cpphdl_n1948, cpphdl_n1944) <+ cpphdl_channel(V(cpphdl_n1940, cpphdl_n1944), V(cpphdl_n1948, cpphdl_n1944), 0.014999999999999999, 0.69999999999999996, 1.0);
        // device 1674, IC IC265, analog/basic/nmos_resistor_amplifier.hpp:27
        I(cpphdl_n1945, cpphdl_n1943) <+ V(cpphdl_n1945, cpphdl_n1943) / 50.0;
        // device 1675, IC IC265, analog/basic/nmos_resistor_amplifier.hpp:28
        I(cpphdl_n1945, cpphdl_n1944) <+ V(cpphdl_n1945, cpphdl_n1944) / 50.0;
        // device 1676, IC IC265, analog/basic/nmos_resistor_amplifier.hpp:29
        I(Vss, cpphdl_n1945) <+ V(Vss, cpphdl_n1945) / 150.0;
        // device 1677, IC IC265, analog/basic/nmos_resistor_amplifier.hpp:30
        I(cpphdl_n1949, Vdd) <+ 2.9999999999999998e-13 * ddt(V(cpphdl_n1949, Vdd)); // Bench initial voltage = 0.0 V.
        // device 1678, IC IC265, analog/basic/nmos_resistor_amplifier.hpp:31
        I(cpphdl_n1948, Vdd) <+ 2.9999999999999998e-13 * ddt(V(cpphdl_n1948, Vdd)); // Bench initial voltage = 0.0 V.
        // device 1679, IC IC265, analog/basic/nmos_resistor_amplifier.hpp:32
        I(cpphdl_n1945, Vss) <+ 4e-14 * ddt(V(cpphdl_n1945, Vss)); // Bench initial voltage = 0.0 V.
        // device 1680, IC IC265, analog/basic/nmos_resistor_amplifier.hpp:34
        I(cpphdl_n1939, cpphdl_n1943) <+ 2e-14 * ddt(V(cpphdl_n1939, cpphdl_n1943)); // Bench initial voltage = 1.6499999999999999 V.
        // device 1681, IC IC265, analog/basic/nmos_resistor_amplifier.hpp:35
        I(cpphdl_n1940, cpphdl_n1944) <+ 2e-14 * ddt(V(cpphdl_n1940, cpphdl_n1944)); // Bench initial voltage = 0.0 V.
        // device 1682, IC IC265, analog/basic/nmos_resistor_amplifier.hpp:36
        I(cpphdl_n1939, cpphdl_n1949) <+ 2.9999999999999998e-15 * ddt(V(cpphdl_n1939, cpphdl_n1949)); // Bench initial voltage = -1.6499999999999999 V.
        // device 1683, IC IC265, analog/basic/nmos_resistor_amplifier.hpp:37
        I(cpphdl_n1940, cpphdl_n1948) <+ 2.9999999999999998e-15 * ddt(V(cpphdl_n1940, cpphdl_n1948)); // Bench initial voltage = -3.2999999999999998 V.
        // device 1684, IC IC266, analog/basic/strongarm_comparator.hpp:28
        I(cpphdl_n1953, cpphdl_n1955) <+ cpphdl_channel(V(cpphdl_n1948, cpphdl_n1955), V(cpphdl_n1953, cpphdl_n1955), 0.0080000000000000002, 0.69999999999999996, 1.0);
        // device 1685, IC IC266, analog/basic/strongarm_comparator.hpp:29
        I(cpphdl_n1954, cpphdl_n1955) <+ cpphdl_channel(V(cpphdl_n1949, cpphdl_n1955), V(cpphdl_n1954, cpphdl_n1955), 0.0080000000000000002, 0.69999999999999996, 1.0);
        // device 1686, IC IC266, analog/basic/strongarm_comparator.hpp:30
        I(cpphdl_n1955, Vss) <+ cpphdl_channel(V(EVALUATE, Vss), V(cpphdl_n1955, Vss), 0.0080000000000000002, 0.69999999999999996, 1.0);
        // device 1687, IC IC266, analog/basic/strongarm_comparator.hpp:33
        I(cpphdl_n1967, cpphdl_n1953) <+ cpphdl_channel(V(cpphdl_n1973, cpphdl_n1953), V(cpphdl_n1967, cpphdl_n1953), 0.0040000000000000001, 0.69999999999999996, 1.0);
        // device 1688, IC IC266, analog/basic/strongarm_comparator.hpp:34
        I(cpphdl_n1973, cpphdl_n1954) <+ cpphdl_channel(V(cpphdl_n1967, cpphdl_n1954), V(cpphdl_n1973, cpphdl_n1954), 0.0040000000000000001, 0.69999999999999996, 1.0);
        // device 1689, IC IC266, analog/basic/strongarm_comparator.hpp:35
        I(cpphdl_n1973, Vdd) <+ cpphdl_channel(V(cpphdl_n1967, Vdd), V(cpphdl_n1973, Vdd), 0.002, 0.69999999999999996, -1.0);
        // device 1690, IC IC266, analog/basic/strongarm_comparator.hpp:36
        I(cpphdl_n1967, Vdd) <+ cpphdl_channel(V(cpphdl_n1973, Vdd), V(cpphdl_n1967, Vdd), 0.002, 0.69999999999999996, -1.0);
        // device 1691, IC IC266, analog/basic/strongarm_comparator.hpp:38
        I(cpphdl_n1953, Vdd) <+ cpphdl_channel(V(EVALUATE, Vdd), V(cpphdl_n1953, Vdd), 0.002, 0.69999999999999996, -1.0);
        // device 1692, IC IC266, analog/basic/strongarm_comparator.hpp:39
        I(cpphdl_n1954, Vdd) <+ cpphdl_channel(V(EVALUATE, Vdd), V(cpphdl_n1954, Vdd), 0.002, 0.69999999999999996, -1.0);
        // device 1693, IC IC266, analog/basic/strongarm_comparator.hpp:40
        I(cpphdl_n1973, Vdd) <+ cpphdl_channel(V(EVALUATE, Vdd), V(cpphdl_n1973, Vdd), 0.002, 0.69999999999999996, -1.0);
        // device 1694, IC IC266, analog/basic/strongarm_comparator.hpp:41
        I(cpphdl_n1967, Vdd) <+ cpphdl_channel(V(EVALUATE, Vdd), V(cpphdl_n1967, Vdd), 0.002, 0.69999999999999996, -1.0);
        // device 1695, IC IC266, analog/basic/strongarm_comparator.hpp:42
        I(cpphdl_n1953, Vss) <+ 2.9999999999999998e-14 * ddt(V(cpphdl_n1953, Vss)); // Bench initial voltage = 0.0 V.
        // device 1696, IC IC266, analog/basic/strongarm_comparator.hpp:43
        I(cpphdl_n1954, Vss) <+ 2.9999999999999998e-14 * ddt(V(cpphdl_n1954, Vss)); // Bench initial voltage = 0.0 V.
        // device 1697, IC IC266, analog/basic/strongarm_comparator.hpp:44
        I(cpphdl_n1955, Vss) <+ 2.9999999999999998e-14 * ddt(V(cpphdl_n1955, Vss)); // Bench initial voltage = 0.0 V.
        // device 1698, IC IC266, analog/basic/strongarm_comparator.hpp:45
        I(cpphdl_n1973, Vss) <+ 5.0000000000000002e-14 * ddt(V(cpphdl_n1973, Vss)); // Bench initial voltage = 0.0 V.
        // device 1699, IC IC266, analog/basic/strongarm_comparator.hpp:46
        I(cpphdl_n1967, Vss) <+ 5.0000000000000002e-14 * ddt(V(cpphdl_n1967, Vss)); // Bench initial voltage = 0.0 V.
        // device 1700, IC IC266, analog/basic/strongarm_comparator.hpp:47
        I(cpphdl_n1948, cpphdl_n1955) <+ 2e-14 * ddt(V(cpphdl_n1948, cpphdl_n1955)); // Bench initial voltage = 3.2999999999999998 V.
        // device 1701, IC IC266, analog/basic/strongarm_comparator.hpp:48
        I(cpphdl_n1949, cpphdl_n1955) <+ 2e-14 * ddt(V(cpphdl_n1949, cpphdl_n1955)); // Bench initial voltage = 3.2999999999999998 V.
        // device 1702, IC IC266, analog/basic/strongarm_comparator.hpp:49
        I(cpphdl_n1948, cpphdl_n1953) <+ 2.9999999999999998e-15 * ddt(V(cpphdl_n1948, cpphdl_n1953)); // Bench initial voltage = 3.2999999999999998 V.
        // device 1703, IC IC266, analog/basic/strongarm_comparator.hpp:50
        I(cpphdl_n1949, cpphdl_n1954) <+ 2.9999999999999998e-15 * ddt(V(cpphdl_n1949, cpphdl_n1954)); // Bench initial voltage = 3.2999999999999998 V.
        // device 1704, IC IC268, analog/basic/cmos_logic.hpp:17
        I(DECISION14, Vss) <+ 5.0000000000000002e-14 * ddt(V(DECISION14, Vss)); // Bench initial voltage = 0.0 V.
        // device 1705, IC IC268, analog/basic/cmos_logic.hpp:18
        I(DECISION14, Vdd) <+ cpphdl_channel(V(cpphdl_n1967, Vdd), V(DECISION14, Vdd), 0.01, 0.69999999999999996, -1.0);
        // device 1706, IC IC268, analog/basic/cmos_logic.hpp:19
        I(DECISION14, Vdd) <+ cpphdl_channel(V(DECISION_N14, Vdd), V(DECISION14, Vdd), 0.01, 0.69999999999999996, -1.0);
        // device 1707, IC IC268, analog/basic/cmos_logic.hpp:20
        I(DECISION14, cpphdl_n1970) <+ cpphdl_channel(V(cpphdl_n1967, cpphdl_n1970), V(DECISION14, cpphdl_n1970), 0.01, 0.69999999999999996, 1.0);
        // device 1708, IC IC268, analog/basic/cmos_logic.hpp:21
        I(cpphdl_n1970, Vss) <+ cpphdl_channel(V(DECISION_N14, Vss), V(cpphdl_n1970, Vss), 0.01, 0.69999999999999996, 1.0);
        // device 1709, IC IC268, analog/basic/cmos_logic.hpp:23
        I(DECISION14, Vss) <+ V(DECISION14, Vss) / 1000000000.0;
        // device 1710, IC IC268, analog/basic/cmos_logic.hpp:24
        I(cpphdl_n1970, Vss) <+ V(cpphdl_n1970, Vss) / 1000000000.0;
        // device 1711, IC IC269, analog/basic/cmos_logic.hpp:17
        I(DECISION_N14, Vss) <+ 5.0000000000000002e-14 * ddt(V(DECISION_N14, Vss)); // Bench initial voltage = 0.0 V.
        // device 1712, IC IC269, analog/basic/cmos_logic.hpp:18
        I(DECISION_N14, Vdd) <+ cpphdl_channel(V(cpphdl_n1973, Vdd), V(DECISION_N14, Vdd), 0.01, 0.69999999999999996, -1.0);
        // device 1713, IC IC269, analog/basic/cmos_logic.hpp:19
        I(DECISION_N14, Vdd) <+ cpphdl_channel(V(DECISION14, Vdd), V(DECISION_N14, Vdd), 0.01, 0.69999999999999996, -1.0);
        // device 1714, IC IC269, analog/basic/cmos_logic.hpp:20
        I(DECISION_N14, cpphdl_n1976) <+ cpphdl_channel(V(cpphdl_n1973, cpphdl_n1976), V(DECISION_N14, cpphdl_n1976), 0.01, 0.69999999999999996, 1.0);
        // device 1715, IC IC269, analog/basic/cmos_logic.hpp:21
        I(cpphdl_n1976, Vss) <+ cpphdl_channel(V(DECISION14, Vss), V(cpphdl_n1976, Vss), 0.01, 0.69999999999999996, 1.0);
        // device 1716, IC IC269, analog/basic/cmos_logic.hpp:23
        I(DECISION_N14, Vss) <+ V(DECISION_N14, Vss) / 1000000000.0;
        // device 1717, IC IC269, analog/basic/cmos_logic.hpp:24
        I(cpphdl_n1976, Vss) <+ V(cpphdl_n1976, Vss) / 1000000000.0;
        // device 1718, IC IC267, analog/basic/nand_latch.hpp:36
        I(cpphdl_n1967, Vss) <+ 2.9999999999999998e-15 * ddt(V(cpphdl_n1967, Vss)); // Bench initial voltage = 0.0 V.
        // device 1719, IC IC267, analog/basic/nand_latch.hpp:37
        I(cpphdl_n1973, Vss) <+ 2.9999999999999998e-15 * ddt(V(cpphdl_n1973, Vss)); // Bench initial voltage = 0.0 V.
        // device 1720, IC IC270, analog/basic/inverter.hpp:11
        I(cpphdl_n1981, Vdd) <+ cpphdl_channel(V(CLEAR, Vdd), V(cpphdl_n1981, Vdd), 0.01, 0.69999999999999996, -1.0);
        // device 1721, IC IC270, analog/basic/inverter.hpp:12
        I(cpphdl_n1981, Vss) <+ cpphdl_channel(V(CLEAR, Vss), V(cpphdl_n1981, Vss), 0.01, 0.69999999999999996, 1.0);
        // device 1722, IC IC267, analog/basic/nand_latch.hpp:58
        I(cpphdl_n1981, Vss) <+ 2.9999999999999998e-15 * ddt(V(cpphdl_n1981, Vss)); // Bench initial voltage = 0.0 V.
        // device 1723, IC IC267, analog/basic/nand_latch.hpp:59
        I(DECISION14, Vss) <+ cpphdl_channel(V(CLEAR, Vss), V(DECISION14, Vss), 0.050000000000000003, 0.69999999999999996, 1.0);
        // device 1724, IC IC267, analog/basic/nand_latch.hpp:60
        I(DECISION_N14, Vdd) <+ cpphdl_channel(V(cpphdl_n1981, Vdd), V(DECISION_N14, Vdd), 0.050000000000000003, 0.69999999999999996, -1.0);
        // device 1725, IC IC273, analog/basic/inverter.hpp:11
        I(cpphdl_n2005, Vdd) <+ cpphdl_channel(V(TRACK15, Vdd), V(cpphdl_n2005, Vdd), 0.0040000000000000001, 0.69999999999999996, -1.0);
        // device 1726, IC IC273, analog/basic/inverter.hpp:12
        I(cpphdl_n2005, Vss) <+ cpphdl_channel(V(TRACK15, Vss), V(cpphdl_n2005, Vss), 0.0040000000000000001, 0.69999999999999996, 1.0);
        // device 1727, IC IC272, analog/basic/mos_track_hold.hpp:31
        I(cpphdl_n2005, Vss) <+ 2e-14 * ddt(V(cpphdl_n2005, Vss)); // Bench initial voltage = 3.2999999999999998 V.
        // device 1728, IC IC272, analog/basic/mos_track_hold.hpp:32
        I(IN, cpphdl_n2059) <+ cpphdl_channel(V(TRACK15, cpphdl_n2059), V(IN, cpphdl_n2059), 0.080000000000000002, 0.69999999999999996, 1.0);
        // device 1729, IC IC272, analog/basic/mos_track_hold.hpp:33
        I(cpphdl_n2059, IN) <+ cpphdl_channel(V(cpphdl_n2005, IN), V(cpphdl_n2059, IN), 0.040000000000000001, 0.69999999999999996, -1.0);
        // device 1730, IC IC272, analog/basic/mos_track_hold.hpp:37
        I(cpphdl_n2059, cpphdl_n2059) <+ cpphdl_channel(V(cpphdl_n2005, cpphdl_n2059), V(cpphdl_n2059, cpphdl_n2059), 0.040000000000000001, 0.69999999999999996, 1.0);
        // device 1731, IC IC272, analog/basic/mos_track_hold.hpp:38
        I(cpphdl_n2059, cpphdl_n2059) <+ cpphdl_channel(V(TRACK15, cpphdl_n2059), V(cpphdl_n2059, cpphdl_n2059), 0.02, 0.69999999999999996, -1.0);
        // device 1732, IC IC272, analog/basic/mos_track_hold.hpp:39
        I(cpphdl_n2059, Vss) <+ 2e-12 * ddt(V(cpphdl_n2059, Vss)); // Bench initial voltage = 1.6499999999999999 V.
        // device 1733, IC IC272, analog/basic/mos_track_hold.hpp:41
        I(Vss, cpphdl_n2059) <+ V(Vss, cpphdl_n2059) / 1000000000.0;
        // device 1734, IC IC272, analog/basic/mos_track_hold.hpp:42
        I(TRACK15, cpphdl_n2059) <+ 8.0000000000000006e-15 * ddt(V(TRACK15, cpphdl_n2059)); // Bench initial voltage = -1.6499999999999999 V.
        // device 1735, IC IC272, analog/basic/mos_track_hold.hpp:43
        I(cpphdl_n2005, cpphdl_n2059) <+ 8.0000000000000006e-15 * ddt(V(cpphdl_n2005, cpphdl_n2059)); // Bench initial voltage = 1.6499999999999999 V.
        // device 1736, IC IC272, analog/basic/mos_track_hold.hpp:44
        I(IN, cpphdl_n2059) <+ 4.0000000000000003e-15 * ddt(V(IN, cpphdl_n2059)); // Bench initial voltage = 0.0 V.
        // device 1737, IC IC275, analog/basic/inverter.hpp:11
        I(cpphdl_n2020, Vdd) <+ cpphdl_channel(V(BIT_N15_0, Vdd), V(cpphdl_n2020, Vdd), 0.080000000000000002, 0.69999999999999996, -1.0);
        // device 1738, IC IC275, analog/basic/inverter.hpp:12
        I(cpphdl_n2020, Vss) <+ cpphdl_channel(V(BIT_N15_0, Vss), V(cpphdl_n2020, Vss), 0.080000000000000002, 0.69999999999999996, 1.0);
        // device 1739, IC IC274, analog/basic/mos_r2r_dac.hpp:27
        I(cpphdl_n2020, Vss) <+ 2.9999999999999998e-15 * ddt(V(cpphdl_n2020, Vss)); // Bench initial voltage = 0.0 V.
        // device 1740, IC IC274, analog/basic/mos_r2r_dac.hpp:28
        I(cpphdl_n2020, cpphdl_n2049) <+ V(cpphdl_n2020, cpphdl_n2049) / 20000.0;
        // device 1741, IC IC274, analog/basic/mos_r2r_dac.hpp:29
        I(cpphdl_n2049, Vss) <+ 2.9999999999999998e-15 * ddt(V(cpphdl_n2049, Vss)); // Bench initial voltage = 0.0 V.
        // device 1742, IC IC276, analog/basic/inverter.hpp:11
        I(cpphdl_n2024, Vdd) <+ cpphdl_channel(V(BIT_N15_1, Vdd), V(cpphdl_n2024, Vdd), 0.080000000000000002, 0.69999999999999996, -1.0);
        // device 1743, IC IC276, analog/basic/inverter.hpp:12
        I(cpphdl_n2024, Vss) <+ cpphdl_channel(V(BIT_N15_1, Vss), V(cpphdl_n2024, Vss), 0.080000000000000002, 0.69999999999999996, 1.0);
        // device 1744, IC IC274, analog/basic/mos_r2r_dac.hpp:27
        I(cpphdl_n2024, Vss) <+ 2.9999999999999998e-15 * ddt(V(cpphdl_n2024, Vss)); // Bench initial voltage = 0.0 V.
        // device 1745, IC IC274, analog/basic/mos_r2r_dac.hpp:28
        I(cpphdl_n2024, cpphdl_n2050) <+ V(cpphdl_n2024, cpphdl_n2050) / 20000.0;
        // device 1746, IC IC274, analog/basic/mos_r2r_dac.hpp:29
        I(cpphdl_n2050, Vss) <+ 2.9999999999999998e-15 * ddt(V(cpphdl_n2050, Vss)); // Bench initial voltage = 0.0 V.
        // device 1747, IC IC274, analog/basic/mos_r2r_dac.hpp:31
        I(cpphdl_n2049, cpphdl_n2050) <+ V(cpphdl_n2049, cpphdl_n2050) / 10000.0;
        // device 1748, IC IC277, analog/basic/inverter.hpp:11
        I(cpphdl_n2028, Vdd) <+ cpphdl_channel(V(BIT_N15_2, Vdd), V(cpphdl_n2028, Vdd), 0.080000000000000002, 0.69999999999999996, -1.0);
        // device 1749, IC IC277, analog/basic/inverter.hpp:12
        I(cpphdl_n2028, Vss) <+ cpphdl_channel(V(BIT_N15_2, Vss), V(cpphdl_n2028, Vss), 0.080000000000000002, 0.69999999999999996, 1.0);
        // device 1750, IC IC274, analog/basic/mos_r2r_dac.hpp:27
        I(cpphdl_n2028, Vss) <+ 2.9999999999999998e-15 * ddt(V(cpphdl_n2028, Vss)); // Bench initial voltage = 0.0 V.
        // device 1751, IC IC274, analog/basic/mos_r2r_dac.hpp:28
        I(cpphdl_n2028, cpphdl_n2051) <+ V(cpphdl_n2028, cpphdl_n2051) / 20000.0;
        // device 1752, IC IC274, analog/basic/mos_r2r_dac.hpp:29
        I(cpphdl_n2051, Vss) <+ 2.9999999999999998e-15 * ddt(V(cpphdl_n2051, Vss)); // Bench initial voltage = 0.0 V.
        // device 1753, IC IC274, analog/basic/mos_r2r_dac.hpp:31
        I(cpphdl_n2050, cpphdl_n2051) <+ V(cpphdl_n2050, cpphdl_n2051) / 10000.0;
        // device 1754, IC IC278, analog/basic/inverter.hpp:11
        I(cpphdl_n2032, Vdd) <+ cpphdl_channel(V(BIT_N15_3, Vdd), V(cpphdl_n2032, Vdd), 0.080000000000000002, 0.69999999999999996, -1.0);
        // device 1755, IC IC278, analog/basic/inverter.hpp:12
        I(cpphdl_n2032, Vss) <+ cpphdl_channel(V(BIT_N15_3, Vss), V(cpphdl_n2032, Vss), 0.080000000000000002, 0.69999999999999996, 1.0);
        // device 1756, IC IC274, analog/basic/mos_r2r_dac.hpp:27
        I(cpphdl_n2032, Vss) <+ 2.9999999999999998e-15 * ddt(V(cpphdl_n2032, Vss)); // Bench initial voltage = 0.0 V.
        // device 1757, IC IC274, analog/basic/mos_r2r_dac.hpp:28
        I(cpphdl_n2032, cpphdl_n2052) <+ V(cpphdl_n2032, cpphdl_n2052) / 20000.0;
        // device 1758, IC IC274, analog/basic/mos_r2r_dac.hpp:29
        I(cpphdl_n2052, Vss) <+ 2.9999999999999998e-15 * ddt(V(cpphdl_n2052, Vss)); // Bench initial voltage = 0.0 V.
        // device 1759, IC IC274, analog/basic/mos_r2r_dac.hpp:31
        I(cpphdl_n2051, cpphdl_n2052) <+ V(cpphdl_n2051, cpphdl_n2052) / 10000.0;
        // device 1760, IC IC279, analog/basic/inverter.hpp:11
        I(cpphdl_n2036, Vdd) <+ cpphdl_channel(V(BIT_N15_4, Vdd), V(cpphdl_n2036, Vdd), 0.080000000000000002, 0.69999999999999996, -1.0);
        // device 1761, IC IC279, analog/basic/inverter.hpp:12
        I(cpphdl_n2036, Vss) <+ cpphdl_channel(V(BIT_N15_4, Vss), V(cpphdl_n2036, Vss), 0.080000000000000002, 0.69999999999999996, 1.0);
        // device 1762, IC IC274, analog/basic/mos_r2r_dac.hpp:27
        I(cpphdl_n2036, Vss) <+ 2.9999999999999998e-15 * ddt(V(cpphdl_n2036, Vss)); // Bench initial voltage = 0.0 V.
        // device 1763, IC IC274, analog/basic/mos_r2r_dac.hpp:28
        I(cpphdl_n2036, cpphdl_n2053) <+ V(cpphdl_n2036, cpphdl_n2053) / 20000.0;
        // device 1764, IC IC274, analog/basic/mos_r2r_dac.hpp:29
        I(cpphdl_n2053, Vss) <+ 2.9999999999999998e-15 * ddt(V(cpphdl_n2053, Vss)); // Bench initial voltage = 0.0 V.
        // device 1765, IC IC274, analog/basic/mos_r2r_dac.hpp:31
        I(cpphdl_n2052, cpphdl_n2053) <+ V(cpphdl_n2052, cpphdl_n2053) / 10000.0;
        // device 1766, IC IC280, analog/basic/inverter.hpp:11
        I(cpphdl_n2040, Vdd) <+ cpphdl_channel(V(BIT_N15_5, Vdd), V(cpphdl_n2040, Vdd), 0.080000000000000002, 0.69999999999999996, -1.0);
        // device 1767, IC IC280, analog/basic/inverter.hpp:12
        I(cpphdl_n2040, Vss) <+ cpphdl_channel(V(BIT_N15_5, Vss), V(cpphdl_n2040, Vss), 0.080000000000000002, 0.69999999999999996, 1.0);
        // device 1768, IC IC274, analog/basic/mos_r2r_dac.hpp:27
        I(cpphdl_n2040, Vss) <+ 2.9999999999999998e-15 * ddt(V(cpphdl_n2040, Vss)); // Bench initial voltage = 0.0 V.
        // device 1769, IC IC274, analog/basic/mos_r2r_dac.hpp:28
        I(cpphdl_n2040, cpphdl_n2054) <+ V(cpphdl_n2040, cpphdl_n2054) / 20000.0;
        // device 1770, IC IC274, analog/basic/mos_r2r_dac.hpp:29
        I(cpphdl_n2054, Vss) <+ 2.9999999999999998e-15 * ddt(V(cpphdl_n2054, Vss)); // Bench initial voltage = 0.0 V.
        // device 1771, IC IC274, analog/basic/mos_r2r_dac.hpp:31
        I(cpphdl_n2053, cpphdl_n2054) <+ V(cpphdl_n2053, cpphdl_n2054) / 10000.0;
        // device 1772, IC IC281, analog/basic/inverter.hpp:11
        I(cpphdl_n2044, Vdd) <+ cpphdl_channel(V(BIT_N15_6, Vdd), V(cpphdl_n2044, Vdd), 0.080000000000000002, 0.69999999999999996, -1.0);
        // device 1773, IC IC281, analog/basic/inverter.hpp:12
        I(cpphdl_n2044, Vss) <+ cpphdl_channel(V(BIT_N15_6, Vss), V(cpphdl_n2044, Vss), 0.080000000000000002, 0.69999999999999996, 1.0);
        // device 1774, IC IC274, analog/basic/mos_r2r_dac.hpp:27
        I(cpphdl_n2044, Vss) <+ 2.9999999999999998e-15 * ddt(V(cpphdl_n2044, Vss)); // Bench initial voltage = 0.0 V.
        // device 1775, IC IC274, analog/basic/mos_r2r_dac.hpp:28
        I(cpphdl_n2044, cpphdl_n2055) <+ V(cpphdl_n2044, cpphdl_n2055) / 20000.0;
        // device 1776, IC IC274, analog/basic/mos_r2r_dac.hpp:29
        I(cpphdl_n2055, Vss) <+ 2.9999999999999998e-15 * ddt(V(cpphdl_n2055, Vss)); // Bench initial voltage = 0.0 V.
        // device 1777, IC IC274, analog/basic/mos_r2r_dac.hpp:31
        I(cpphdl_n2054, cpphdl_n2055) <+ V(cpphdl_n2054, cpphdl_n2055) / 10000.0;
        // device 1778, IC IC282, analog/basic/inverter.hpp:11
        I(cpphdl_n2048, Vdd) <+ cpphdl_channel(V(BIT_N15_7, Vdd), V(cpphdl_n2048, Vdd), 0.080000000000000002, 0.69999999999999996, -1.0);
        // device 1779, IC IC282, analog/basic/inverter.hpp:12
        I(cpphdl_n2048, Vss) <+ cpphdl_channel(V(BIT_N15_7, Vss), V(cpphdl_n2048, Vss), 0.080000000000000002, 0.69999999999999996, 1.0);
        // device 1780, IC IC274, analog/basic/mos_r2r_dac.hpp:27
        I(cpphdl_n2048, Vss) <+ 2.9999999999999998e-15 * ddt(V(cpphdl_n2048, Vss)); // Bench initial voltage = 0.0 V.
        // device 1781, IC IC274, analog/basic/mos_r2r_dac.hpp:28
        I(cpphdl_n2048, cpphdl_n2060) <+ V(cpphdl_n2048, cpphdl_n2060) / 20000.0;
        // device 1782, IC IC274, analog/basic/mos_r2r_dac.hpp:29
        I(cpphdl_n2060, Vss) <+ 2.9999999999999998e-15 * ddt(V(cpphdl_n2060, Vss)); // Bench initial voltage = 0.0 V.
        // device 1783, IC IC274, analog/basic/mos_r2r_dac.hpp:31
        I(cpphdl_n2055, cpphdl_n2060) <+ V(cpphdl_n2055, cpphdl_n2060) / 10000.0;
        // device 1784, IC IC274, analog/basic/mos_r2r_dac.hpp:33
        I(Vss, cpphdl_n2049) <+ V(Vss, cpphdl_n2049) / 20000.0;
        // device 1785, IC IC283, analog/basic/nmos_resistor_amplifier.hpp:23
        I(Vdd, cpphdl_n2069) <+ V(Vdd, cpphdl_n2069) / 1000.0;
        // device 1786, IC IC283, analog/basic/nmos_resistor_amplifier.hpp:24
        I(Vdd, cpphdl_n2068) <+ V(Vdd, cpphdl_n2068) / 1000.0;
        // device 1787, IC IC283, analog/basic/nmos_resistor_amplifier.hpp:25
        I(cpphdl_n2069, cpphdl_n2063) <+ cpphdl_channel(V(cpphdl_n2059, cpphdl_n2063), V(cpphdl_n2069, cpphdl_n2063), 0.014999999999999999, 0.69999999999999996, 1.0);
        // device 1788, IC IC283, analog/basic/nmos_resistor_amplifier.hpp:26
        I(cpphdl_n2068, cpphdl_n2064) <+ cpphdl_channel(V(cpphdl_n2060, cpphdl_n2064), V(cpphdl_n2068, cpphdl_n2064), 0.014999999999999999, 0.69999999999999996, 1.0);
        // device 1789, IC IC283, analog/basic/nmos_resistor_amplifier.hpp:27
        I(cpphdl_n2065, cpphdl_n2063) <+ V(cpphdl_n2065, cpphdl_n2063) / 50.0;
        // device 1790, IC IC283, analog/basic/nmos_resistor_amplifier.hpp:28
        I(cpphdl_n2065, cpphdl_n2064) <+ V(cpphdl_n2065, cpphdl_n2064) / 50.0;
        // device 1791, IC IC283, analog/basic/nmos_resistor_amplifier.hpp:29
        I(Vss, cpphdl_n2065) <+ V(Vss, cpphdl_n2065) / 150.0;
        // device 1792, IC IC283, analog/basic/nmos_resistor_amplifier.hpp:30
        I(cpphdl_n2069, Vdd) <+ 2.9999999999999998e-13 * ddt(V(cpphdl_n2069, Vdd)); // Bench initial voltage = 0.0 V.
        // device 1793, IC IC283, analog/basic/nmos_resistor_amplifier.hpp:31
        I(cpphdl_n2068, Vdd) <+ 2.9999999999999998e-13 * ddt(V(cpphdl_n2068, Vdd)); // Bench initial voltage = 0.0 V.
        // device 1794, IC IC283, analog/basic/nmos_resistor_amplifier.hpp:32
        I(cpphdl_n2065, Vss) <+ 4e-14 * ddt(V(cpphdl_n2065, Vss)); // Bench initial voltage = 0.0 V.
        // device 1795, IC IC283, analog/basic/nmos_resistor_amplifier.hpp:34
        I(cpphdl_n2059, cpphdl_n2063) <+ 2e-14 * ddt(V(cpphdl_n2059, cpphdl_n2063)); // Bench initial voltage = 1.6499999999999999 V.
        // device 1796, IC IC283, analog/basic/nmos_resistor_amplifier.hpp:35
        I(cpphdl_n2060, cpphdl_n2064) <+ 2e-14 * ddt(V(cpphdl_n2060, cpphdl_n2064)); // Bench initial voltage = 0.0 V.
        // device 1797, IC IC283, analog/basic/nmos_resistor_amplifier.hpp:36
        I(cpphdl_n2059, cpphdl_n2069) <+ 2.9999999999999998e-15 * ddt(V(cpphdl_n2059, cpphdl_n2069)); // Bench initial voltage = -1.6499999999999999 V.
        // device 1798, IC IC283, analog/basic/nmos_resistor_amplifier.hpp:37
        I(cpphdl_n2060, cpphdl_n2068) <+ 2.9999999999999998e-15 * ddt(V(cpphdl_n2060, cpphdl_n2068)); // Bench initial voltage = -3.2999999999999998 V.
        // device 1799, IC IC284, analog/basic/strongarm_comparator.hpp:28
        I(cpphdl_n2073, cpphdl_n2075) <+ cpphdl_channel(V(cpphdl_n2068, cpphdl_n2075), V(cpphdl_n2073, cpphdl_n2075), 0.0080000000000000002, 0.69999999999999996, 1.0);
        // device 1800, IC IC284, analog/basic/strongarm_comparator.hpp:29
        I(cpphdl_n2074, cpphdl_n2075) <+ cpphdl_channel(V(cpphdl_n2069, cpphdl_n2075), V(cpphdl_n2074, cpphdl_n2075), 0.0080000000000000002, 0.69999999999999996, 1.0);
        // device 1801, IC IC284, analog/basic/strongarm_comparator.hpp:30
        I(cpphdl_n2075, Vss) <+ cpphdl_channel(V(EVALUATE, Vss), V(cpphdl_n2075, Vss), 0.0080000000000000002, 0.69999999999999996, 1.0);
        // device 1802, IC IC284, analog/basic/strongarm_comparator.hpp:33
        I(cpphdl_n2087, cpphdl_n2073) <+ cpphdl_channel(V(cpphdl_n2093, cpphdl_n2073), V(cpphdl_n2087, cpphdl_n2073), 0.0040000000000000001, 0.69999999999999996, 1.0);
        // device 1803, IC IC284, analog/basic/strongarm_comparator.hpp:34
        I(cpphdl_n2093, cpphdl_n2074) <+ cpphdl_channel(V(cpphdl_n2087, cpphdl_n2074), V(cpphdl_n2093, cpphdl_n2074), 0.0040000000000000001, 0.69999999999999996, 1.0);
        // device 1804, IC IC284, analog/basic/strongarm_comparator.hpp:35
        I(cpphdl_n2093, Vdd) <+ cpphdl_channel(V(cpphdl_n2087, Vdd), V(cpphdl_n2093, Vdd), 0.002, 0.69999999999999996, -1.0);
        // device 1805, IC IC284, analog/basic/strongarm_comparator.hpp:36
        I(cpphdl_n2087, Vdd) <+ cpphdl_channel(V(cpphdl_n2093, Vdd), V(cpphdl_n2087, Vdd), 0.002, 0.69999999999999996, -1.0);
        // device 1806, IC IC284, analog/basic/strongarm_comparator.hpp:38
        I(cpphdl_n2073, Vdd) <+ cpphdl_channel(V(EVALUATE, Vdd), V(cpphdl_n2073, Vdd), 0.002, 0.69999999999999996, -1.0);
        // device 1807, IC IC284, analog/basic/strongarm_comparator.hpp:39
        I(cpphdl_n2074, Vdd) <+ cpphdl_channel(V(EVALUATE, Vdd), V(cpphdl_n2074, Vdd), 0.002, 0.69999999999999996, -1.0);
        // device 1808, IC IC284, analog/basic/strongarm_comparator.hpp:40
        I(cpphdl_n2093, Vdd) <+ cpphdl_channel(V(EVALUATE, Vdd), V(cpphdl_n2093, Vdd), 0.002, 0.69999999999999996, -1.0);
        // device 1809, IC IC284, analog/basic/strongarm_comparator.hpp:41
        I(cpphdl_n2087, Vdd) <+ cpphdl_channel(V(EVALUATE, Vdd), V(cpphdl_n2087, Vdd), 0.002, 0.69999999999999996, -1.0);
        // device 1810, IC IC284, analog/basic/strongarm_comparator.hpp:42
        I(cpphdl_n2073, Vss) <+ 2.9999999999999998e-14 * ddt(V(cpphdl_n2073, Vss)); // Bench initial voltage = 0.0 V.
        // device 1811, IC IC284, analog/basic/strongarm_comparator.hpp:43
        I(cpphdl_n2074, Vss) <+ 2.9999999999999998e-14 * ddt(V(cpphdl_n2074, Vss)); // Bench initial voltage = 0.0 V.
        // device 1812, IC IC284, analog/basic/strongarm_comparator.hpp:44
        I(cpphdl_n2075, Vss) <+ 2.9999999999999998e-14 * ddt(V(cpphdl_n2075, Vss)); // Bench initial voltage = 0.0 V.
        // device 1813, IC IC284, analog/basic/strongarm_comparator.hpp:45
        I(cpphdl_n2093, Vss) <+ 5.0000000000000002e-14 * ddt(V(cpphdl_n2093, Vss)); // Bench initial voltage = 0.0 V.
        // device 1814, IC IC284, analog/basic/strongarm_comparator.hpp:46
        I(cpphdl_n2087, Vss) <+ 5.0000000000000002e-14 * ddt(V(cpphdl_n2087, Vss)); // Bench initial voltage = 0.0 V.
        // device 1815, IC IC284, analog/basic/strongarm_comparator.hpp:47
        I(cpphdl_n2068, cpphdl_n2075) <+ 2e-14 * ddt(V(cpphdl_n2068, cpphdl_n2075)); // Bench initial voltage = 3.2999999999999998 V.
        // device 1816, IC IC284, analog/basic/strongarm_comparator.hpp:48
        I(cpphdl_n2069, cpphdl_n2075) <+ 2e-14 * ddt(V(cpphdl_n2069, cpphdl_n2075)); // Bench initial voltage = 3.2999999999999998 V.
        // device 1817, IC IC284, analog/basic/strongarm_comparator.hpp:49
        I(cpphdl_n2068, cpphdl_n2073) <+ 2.9999999999999998e-15 * ddt(V(cpphdl_n2068, cpphdl_n2073)); // Bench initial voltage = 3.2999999999999998 V.
        // device 1818, IC IC284, analog/basic/strongarm_comparator.hpp:50
        I(cpphdl_n2069, cpphdl_n2074) <+ 2.9999999999999998e-15 * ddt(V(cpphdl_n2069, cpphdl_n2074)); // Bench initial voltage = 3.2999999999999998 V.
        // device 1819, IC IC286, analog/basic/cmos_logic.hpp:17
        I(DECISION15, Vss) <+ 5.0000000000000002e-14 * ddt(V(DECISION15, Vss)); // Bench initial voltage = 0.0 V.
        // device 1820, IC IC286, analog/basic/cmos_logic.hpp:18
        I(DECISION15, Vdd) <+ cpphdl_channel(V(cpphdl_n2087, Vdd), V(DECISION15, Vdd), 0.01, 0.69999999999999996, -1.0);
        // device 1821, IC IC286, analog/basic/cmos_logic.hpp:19
        I(DECISION15, Vdd) <+ cpphdl_channel(V(DECISION_N15, Vdd), V(DECISION15, Vdd), 0.01, 0.69999999999999996, -1.0);
        // device 1822, IC IC286, analog/basic/cmos_logic.hpp:20
        I(DECISION15, cpphdl_n2090) <+ cpphdl_channel(V(cpphdl_n2087, cpphdl_n2090), V(DECISION15, cpphdl_n2090), 0.01, 0.69999999999999996, 1.0);
        // device 1823, IC IC286, analog/basic/cmos_logic.hpp:21
        I(cpphdl_n2090, Vss) <+ cpphdl_channel(V(DECISION_N15, Vss), V(cpphdl_n2090, Vss), 0.01, 0.69999999999999996, 1.0);
        // device 1824, IC IC286, analog/basic/cmos_logic.hpp:23
        I(DECISION15, Vss) <+ V(DECISION15, Vss) / 1000000000.0;
        // device 1825, IC IC286, analog/basic/cmos_logic.hpp:24
        I(cpphdl_n2090, Vss) <+ V(cpphdl_n2090, Vss) / 1000000000.0;
        // device 1826, IC IC287, analog/basic/cmos_logic.hpp:17
        I(DECISION_N15, Vss) <+ 5.0000000000000002e-14 * ddt(V(DECISION_N15, Vss)); // Bench initial voltage = 0.0 V.
        // device 1827, IC IC287, analog/basic/cmos_logic.hpp:18
        I(DECISION_N15, Vdd) <+ cpphdl_channel(V(cpphdl_n2093, Vdd), V(DECISION_N15, Vdd), 0.01, 0.69999999999999996, -1.0);
        // device 1828, IC IC287, analog/basic/cmos_logic.hpp:19
        I(DECISION_N15, Vdd) <+ cpphdl_channel(V(DECISION15, Vdd), V(DECISION_N15, Vdd), 0.01, 0.69999999999999996, -1.0);
        // device 1829, IC IC287, analog/basic/cmos_logic.hpp:20
        I(DECISION_N15, cpphdl_n2096) <+ cpphdl_channel(V(cpphdl_n2093, cpphdl_n2096), V(DECISION_N15, cpphdl_n2096), 0.01, 0.69999999999999996, 1.0);
        // device 1830, IC IC287, analog/basic/cmos_logic.hpp:21
        I(cpphdl_n2096, Vss) <+ cpphdl_channel(V(DECISION15, Vss), V(cpphdl_n2096, Vss), 0.01, 0.69999999999999996, 1.0);
        // device 1831, IC IC287, analog/basic/cmos_logic.hpp:23
        I(DECISION_N15, Vss) <+ V(DECISION_N15, Vss) / 1000000000.0;
        // device 1832, IC IC287, analog/basic/cmos_logic.hpp:24
        I(cpphdl_n2096, Vss) <+ V(cpphdl_n2096, Vss) / 1000000000.0;
        // device 1833, IC IC285, analog/basic/nand_latch.hpp:36
        I(cpphdl_n2087, Vss) <+ 2.9999999999999998e-15 * ddt(V(cpphdl_n2087, Vss)); // Bench initial voltage = 0.0 V.
        // device 1834, IC IC285, analog/basic/nand_latch.hpp:37
        I(cpphdl_n2093, Vss) <+ 2.9999999999999998e-15 * ddt(V(cpphdl_n2093, Vss)); // Bench initial voltage = 0.0 V.
        // device 1835, IC IC288, analog/basic/inverter.hpp:11
        I(cpphdl_n2101, Vdd) <+ cpphdl_channel(V(CLEAR, Vdd), V(cpphdl_n2101, Vdd), 0.01, 0.69999999999999996, -1.0);
        // device 1836, IC IC288, analog/basic/inverter.hpp:12
        I(cpphdl_n2101, Vss) <+ cpphdl_channel(V(CLEAR, Vss), V(cpphdl_n2101, Vss), 0.01, 0.69999999999999996, 1.0);
        // device 1837, IC IC285, analog/basic/nand_latch.hpp:58
        I(cpphdl_n2101, Vss) <+ 2.9999999999999998e-15 * ddt(V(cpphdl_n2101, Vss)); // Bench initial voltage = 0.0 V.
        // device 1838, IC IC285, analog/basic/nand_latch.hpp:59
        I(DECISION15, Vss) <+ cpphdl_channel(V(CLEAR, Vss), V(DECISION15, Vss), 0.050000000000000003, 0.69999999999999996, 1.0);
        // device 1839, IC IC285, analog/basic/nand_latch.hpp:60
        I(DECISION_N15, Vdd) <+ cpphdl_channel(V(cpphdl_n2101, Vdd), V(DECISION_N15, Vdd), 0.050000000000000003, 0.69999999999999996, -1.0);
        // device 1840, IC IC289, analog/basic/level_down.hpp:23
        I(cpphdl_n2123, Vlogic) <+ cpphdl_channel(V(Vss, Vlogic), V(cpphdl_n2123, Vlogic), 0.00050000000000000001, 0.34999999999999998, -1.0);
        // device 1841, IC IC289, analog/basic/level_down.hpp:24
        I(cpphdl_n2123, Vss) <+ cpphdl_channel(V(DECISION0, Vss), V(cpphdl_n2123, Vss), 0.0040000000000000001, 0.69999999999999996, 1.0);
        // device 1842, IC IC289, analog/basic/level_down.hpp:25
        I(CORE_DECISION0, Vlogic) <+ cpphdl_channel(V(cpphdl_n2123, Vlogic), V(CORE_DECISION0, Vlogic), 0.0050000000000000001, 0.34999999999999998, -1.0);
        // device 1843, IC IC289, analog/basic/level_down.hpp:26
        I(CORE_DECISION0, Vss) <+ cpphdl_channel(V(cpphdl_n2123, Vss), V(CORE_DECISION0, Vss), 0.01, 0.34999999999999998, 1.0);
        // device 1844, IC IC289, analog/basic/level_down.hpp:27
        I(DECISION0, Vss) <+ 5e-15 * ddt(V(DECISION0, Vss)); // Bench initial voltage = 0.0 V.
        // device 1845, IC IC289, analog/basic/level_down.hpp:28
        I(DECISION0, Vlogic) <+ 5e-15 * ddt(V(DECISION0, Vlogic)); // Bench initial voltage = 0.0 V.
        // device 1846, IC IC289, analog/basic/level_down.hpp:29
        I(DECISION0, cpphdl_n2123) <+ 2.0000000000000002e-15 * ddt(V(DECISION0, cpphdl_n2123)); // Bench initial voltage = 0.0 V.
        // device 1847, IC IC289, analog/basic/level_down.hpp:30
        I(cpphdl_n2123, Vss) <+ 8e-14 * ddt(V(cpphdl_n2123, Vss)); // Bench initial voltage = 0.0 V.
        // device 1848, IC IC289, analog/basic/level_down.hpp:31
        I(cpphdl_n2123, Vlogic) <+ 5e-15 * ddt(V(cpphdl_n2123, Vlogic)); // Bench initial voltage = 0.0 V.
        // device 1849, IC IC289, analog/basic/level_down.hpp:32
        I(cpphdl_n2123, CORE_DECISION0) <+ 2.0000000000000002e-15 * ddt(V(cpphdl_n2123, CORE_DECISION0)); // Bench initial voltage = 0.0 V.
        // device 1850, IC IC289, analog/basic/level_down.hpp:33
        I(CORE_DECISION0, Vss) <+ 1e-14 * ddt(V(CORE_DECISION0, Vss)); // Bench initial voltage = 0.0 V.
        // device 1851, IC IC290, analog/basic/level_down.hpp:23
        I(cpphdl_n2128, Vlogic) <+ cpphdl_channel(V(Vss, Vlogic), V(cpphdl_n2128, Vlogic), 0.00050000000000000001, 0.34999999999999998, -1.0);
        // device 1852, IC IC290, analog/basic/level_down.hpp:24
        I(cpphdl_n2128, Vss) <+ cpphdl_channel(V(DECISION1, Vss), V(cpphdl_n2128, Vss), 0.0040000000000000001, 0.69999999999999996, 1.0);
        // device 1853, IC IC290, analog/basic/level_down.hpp:25
        I(CORE_DECISION1, Vlogic) <+ cpphdl_channel(V(cpphdl_n2128, Vlogic), V(CORE_DECISION1, Vlogic), 0.0050000000000000001, 0.34999999999999998, -1.0);
        // device 1854, IC IC290, analog/basic/level_down.hpp:26
        I(CORE_DECISION1, Vss) <+ cpphdl_channel(V(cpphdl_n2128, Vss), V(CORE_DECISION1, Vss), 0.01, 0.34999999999999998, 1.0);
        // device 1855, IC IC290, analog/basic/level_down.hpp:27
        I(DECISION1, Vss) <+ 5e-15 * ddt(V(DECISION1, Vss)); // Bench initial voltage = 0.0 V.
        // device 1856, IC IC290, analog/basic/level_down.hpp:28
        I(DECISION1, Vlogic) <+ 5e-15 * ddt(V(DECISION1, Vlogic)); // Bench initial voltage = 0.0 V.
        // device 1857, IC IC290, analog/basic/level_down.hpp:29
        I(DECISION1, cpphdl_n2128) <+ 2.0000000000000002e-15 * ddt(V(DECISION1, cpphdl_n2128)); // Bench initial voltage = 0.0 V.
        // device 1858, IC IC290, analog/basic/level_down.hpp:30
        I(cpphdl_n2128, Vss) <+ 8e-14 * ddt(V(cpphdl_n2128, Vss)); // Bench initial voltage = 0.0 V.
        // device 1859, IC IC290, analog/basic/level_down.hpp:31
        I(cpphdl_n2128, Vlogic) <+ 5e-15 * ddt(V(cpphdl_n2128, Vlogic)); // Bench initial voltage = 0.0 V.
        // device 1860, IC IC290, analog/basic/level_down.hpp:32
        I(cpphdl_n2128, CORE_DECISION1) <+ 2.0000000000000002e-15 * ddt(V(cpphdl_n2128, CORE_DECISION1)); // Bench initial voltage = 0.0 V.
        // device 1861, IC IC290, analog/basic/level_down.hpp:33
        I(CORE_DECISION1, Vss) <+ 1e-14 * ddt(V(CORE_DECISION1, Vss)); // Bench initial voltage = 0.0 V.
        // device 1862, IC IC291, analog/basic/level_down.hpp:23
        I(cpphdl_n2133, Vlogic) <+ cpphdl_channel(V(Vss, Vlogic), V(cpphdl_n2133, Vlogic), 0.00050000000000000001, 0.34999999999999998, -1.0);
        // device 1863, IC IC291, analog/basic/level_down.hpp:24
        I(cpphdl_n2133, Vss) <+ cpphdl_channel(V(DECISION2, Vss), V(cpphdl_n2133, Vss), 0.0040000000000000001, 0.69999999999999996, 1.0);
        // device 1864, IC IC291, analog/basic/level_down.hpp:25
        I(CORE_DECISION2, Vlogic) <+ cpphdl_channel(V(cpphdl_n2133, Vlogic), V(CORE_DECISION2, Vlogic), 0.0050000000000000001, 0.34999999999999998, -1.0);
        // device 1865, IC IC291, analog/basic/level_down.hpp:26
        I(CORE_DECISION2, Vss) <+ cpphdl_channel(V(cpphdl_n2133, Vss), V(CORE_DECISION2, Vss), 0.01, 0.34999999999999998, 1.0);
        // device 1866, IC IC291, analog/basic/level_down.hpp:27
        I(DECISION2, Vss) <+ 5e-15 * ddt(V(DECISION2, Vss)); // Bench initial voltage = 0.0 V.
        // device 1867, IC IC291, analog/basic/level_down.hpp:28
        I(DECISION2, Vlogic) <+ 5e-15 * ddt(V(DECISION2, Vlogic)); // Bench initial voltage = 0.0 V.
        // device 1868, IC IC291, analog/basic/level_down.hpp:29
        I(DECISION2, cpphdl_n2133) <+ 2.0000000000000002e-15 * ddt(V(DECISION2, cpphdl_n2133)); // Bench initial voltage = 0.0 V.
        // device 1869, IC IC291, analog/basic/level_down.hpp:30
        I(cpphdl_n2133, Vss) <+ 8e-14 * ddt(V(cpphdl_n2133, Vss)); // Bench initial voltage = 0.0 V.
        // device 1870, IC IC291, analog/basic/level_down.hpp:31
        I(cpphdl_n2133, Vlogic) <+ 5e-15 * ddt(V(cpphdl_n2133, Vlogic)); // Bench initial voltage = 0.0 V.
        // device 1871, IC IC291, analog/basic/level_down.hpp:32
        I(cpphdl_n2133, CORE_DECISION2) <+ 2.0000000000000002e-15 * ddt(V(cpphdl_n2133, CORE_DECISION2)); // Bench initial voltage = 0.0 V.
        // device 1872, IC IC291, analog/basic/level_down.hpp:33
        I(CORE_DECISION2, Vss) <+ 1e-14 * ddt(V(CORE_DECISION2, Vss)); // Bench initial voltage = 0.0 V.
        // device 1873, IC IC292, analog/basic/level_down.hpp:23
        I(cpphdl_n2138, Vlogic) <+ cpphdl_channel(V(Vss, Vlogic), V(cpphdl_n2138, Vlogic), 0.00050000000000000001, 0.34999999999999998, -1.0);
        // device 1874, IC IC292, analog/basic/level_down.hpp:24
        I(cpphdl_n2138, Vss) <+ cpphdl_channel(V(DECISION3, Vss), V(cpphdl_n2138, Vss), 0.0040000000000000001, 0.69999999999999996, 1.0);
        // device 1875, IC IC292, analog/basic/level_down.hpp:25
        I(CORE_DECISION3, Vlogic) <+ cpphdl_channel(V(cpphdl_n2138, Vlogic), V(CORE_DECISION3, Vlogic), 0.0050000000000000001, 0.34999999999999998, -1.0);
        // device 1876, IC IC292, analog/basic/level_down.hpp:26
        I(CORE_DECISION3, Vss) <+ cpphdl_channel(V(cpphdl_n2138, Vss), V(CORE_DECISION3, Vss), 0.01, 0.34999999999999998, 1.0);
        // device 1877, IC IC292, analog/basic/level_down.hpp:27
        I(DECISION3, Vss) <+ 5e-15 * ddt(V(DECISION3, Vss)); // Bench initial voltage = 0.0 V.
        // device 1878, IC IC292, analog/basic/level_down.hpp:28
        I(DECISION3, Vlogic) <+ 5e-15 * ddt(V(DECISION3, Vlogic)); // Bench initial voltage = 0.0 V.
        // device 1879, IC IC292, analog/basic/level_down.hpp:29
        I(DECISION3, cpphdl_n2138) <+ 2.0000000000000002e-15 * ddt(V(DECISION3, cpphdl_n2138)); // Bench initial voltage = 0.0 V.
        // device 1880, IC IC292, analog/basic/level_down.hpp:30
        I(cpphdl_n2138, Vss) <+ 8e-14 * ddt(V(cpphdl_n2138, Vss)); // Bench initial voltage = 0.0 V.
        // device 1881, IC IC292, analog/basic/level_down.hpp:31
        I(cpphdl_n2138, Vlogic) <+ 5e-15 * ddt(V(cpphdl_n2138, Vlogic)); // Bench initial voltage = 0.0 V.
        // device 1882, IC IC292, analog/basic/level_down.hpp:32
        I(cpphdl_n2138, CORE_DECISION3) <+ 2.0000000000000002e-15 * ddt(V(cpphdl_n2138, CORE_DECISION3)); // Bench initial voltage = 0.0 V.
        // device 1883, IC IC292, analog/basic/level_down.hpp:33
        I(CORE_DECISION3, Vss) <+ 1e-14 * ddt(V(CORE_DECISION3, Vss)); // Bench initial voltage = 0.0 V.
        // device 1884, IC IC293, analog/basic/level_down.hpp:23
        I(cpphdl_n2143, Vlogic) <+ cpphdl_channel(V(Vss, Vlogic), V(cpphdl_n2143, Vlogic), 0.00050000000000000001, 0.34999999999999998, -1.0);
        // device 1885, IC IC293, analog/basic/level_down.hpp:24
        I(cpphdl_n2143, Vss) <+ cpphdl_channel(V(DECISION4, Vss), V(cpphdl_n2143, Vss), 0.0040000000000000001, 0.69999999999999996, 1.0);
        // device 1886, IC IC293, analog/basic/level_down.hpp:25
        I(CORE_DECISION4, Vlogic) <+ cpphdl_channel(V(cpphdl_n2143, Vlogic), V(CORE_DECISION4, Vlogic), 0.0050000000000000001, 0.34999999999999998, -1.0);
        // device 1887, IC IC293, analog/basic/level_down.hpp:26
        I(CORE_DECISION4, Vss) <+ cpphdl_channel(V(cpphdl_n2143, Vss), V(CORE_DECISION4, Vss), 0.01, 0.34999999999999998, 1.0);
        // device 1888, IC IC293, analog/basic/level_down.hpp:27
        I(DECISION4, Vss) <+ 5e-15 * ddt(V(DECISION4, Vss)); // Bench initial voltage = 0.0 V.
        // device 1889, IC IC293, analog/basic/level_down.hpp:28
        I(DECISION4, Vlogic) <+ 5e-15 * ddt(V(DECISION4, Vlogic)); // Bench initial voltage = 0.0 V.
        // device 1890, IC IC293, analog/basic/level_down.hpp:29
        I(DECISION4, cpphdl_n2143) <+ 2.0000000000000002e-15 * ddt(V(DECISION4, cpphdl_n2143)); // Bench initial voltage = 0.0 V.
        // device 1891, IC IC293, analog/basic/level_down.hpp:30
        I(cpphdl_n2143, Vss) <+ 8e-14 * ddt(V(cpphdl_n2143, Vss)); // Bench initial voltage = 0.0 V.
        // device 1892, IC IC293, analog/basic/level_down.hpp:31
        I(cpphdl_n2143, Vlogic) <+ 5e-15 * ddt(V(cpphdl_n2143, Vlogic)); // Bench initial voltage = 0.0 V.
        // device 1893, IC IC293, analog/basic/level_down.hpp:32
        I(cpphdl_n2143, CORE_DECISION4) <+ 2.0000000000000002e-15 * ddt(V(cpphdl_n2143, CORE_DECISION4)); // Bench initial voltage = 0.0 V.
        // device 1894, IC IC293, analog/basic/level_down.hpp:33
        I(CORE_DECISION4, Vss) <+ 1e-14 * ddt(V(CORE_DECISION4, Vss)); // Bench initial voltage = 0.0 V.
        // device 1895, IC IC294, analog/basic/level_down.hpp:23
        I(cpphdl_n2148, Vlogic) <+ cpphdl_channel(V(Vss, Vlogic), V(cpphdl_n2148, Vlogic), 0.00050000000000000001, 0.34999999999999998, -1.0);
        // device 1896, IC IC294, analog/basic/level_down.hpp:24
        I(cpphdl_n2148, Vss) <+ cpphdl_channel(V(DECISION5, Vss), V(cpphdl_n2148, Vss), 0.0040000000000000001, 0.69999999999999996, 1.0);
        // device 1897, IC IC294, analog/basic/level_down.hpp:25
        I(CORE_DECISION5, Vlogic) <+ cpphdl_channel(V(cpphdl_n2148, Vlogic), V(CORE_DECISION5, Vlogic), 0.0050000000000000001, 0.34999999999999998, -1.0);
        // device 1898, IC IC294, analog/basic/level_down.hpp:26
        I(CORE_DECISION5, Vss) <+ cpphdl_channel(V(cpphdl_n2148, Vss), V(CORE_DECISION5, Vss), 0.01, 0.34999999999999998, 1.0);
        // device 1899, IC IC294, analog/basic/level_down.hpp:27
        I(DECISION5, Vss) <+ 5e-15 * ddt(V(DECISION5, Vss)); // Bench initial voltage = 0.0 V.
        // device 1900, IC IC294, analog/basic/level_down.hpp:28
        I(DECISION5, Vlogic) <+ 5e-15 * ddt(V(DECISION5, Vlogic)); // Bench initial voltage = 0.0 V.
        // device 1901, IC IC294, analog/basic/level_down.hpp:29
        I(DECISION5, cpphdl_n2148) <+ 2.0000000000000002e-15 * ddt(V(DECISION5, cpphdl_n2148)); // Bench initial voltage = 0.0 V.
        // device 1902, IC IC294, analog/basic/level_down.hpp:30
        I(cpphdl_n2148, Vss) <+ 8e-14 * ddt(V(cpphdl_n2148, Vss)); // Bench initial voltage = 0.0 V.
        // device 1903, IC IC294, analog/basic/level_down.hpp:31
        I(cpphdl_n2148, Vlogic) <+ 5e-15 * ddt(V(cpphdl_n2148, Vlogic)); // Bench initial voltage = 0.0 V.
        // device 1904, IC IC294, analog/basic/level_down.hpp:32
        I(cpphdl_n2148, CORE_DECISION5) <+ 2.0000000000000002e-15 * ddt(V(cpphdl_n2148, CORE_DECISION5)); // Bench initial voltage = 0.0 V.
        // device 1905, IC IC294, analog/basic/level_down.hpp:33
        I(CORE_DECISION5, Vss) <+ 1e-14 * ddt(V(CORE_DECISION5, Vss)); // Bench initial voltage = 0.0 V.
        // device 1906, IC IC295, analog/basic/level_down.hpp:23
        I(cpphdl_n2153, Vlogic) <+ cpphdl_channel(V(Vss, Vlogic), V(cpphdl_n2153, Vlogic), 0.00050000000000000001, 0.34999999999999998, -1.0);
        // device 1907, IC IC295, analog/basic/level_down.hpp:24
        I(cpphdl_n2153, Vss) <+ cpphdl_channel(V(DECISION6, Vss), V(cpphdl_n2153, Vss), 0.0040000000000000001, 0.69999999999999996, 1.0);
        // device 1908, IC IC295, analog/basic/level_down.hpp:25
        I(CORE_DECISION6, Vlogic) <+ cpphdl_channel(V(cpphdl_n2153, Vlogic), V(CORE_DECISION6, Vlogic), 0.0050000000000000001, 0.34999999999999998, -1.0);
        // device 1909, IC IC295, analog/basic/level_down.hpp:26
        I(CORE_DECISION6, Vss) <+ cpphdl_channel(V(cpphdl_n2153, Vss), V(CORE_DECISION6, Vss), 0.01, 0.34999999999999998, 1.0);
        // device 1910, IC IC295, analog/basic/level_down.hpp:27
        I(DECISION6, Vss) <+ 5e-15 * ddt(V(DECISION6, Vss)); // Bench initial voltage = 0.0 V.
        // device 1911, IC IC295, analog/basic/level_down.hpp:28
        I(DECISION6, Vlogic) <+ 5e-15 * ddt(V(DECISION6, Vlogic)); // Bench initial voltage = 0.0 V.
        // device 1912, IC IC295, analog/basic/level_down.hpp:29
        I(DECISION6, cpphdl_n2153) <+ 2.0000000000000002e-15 * ddt(V(DECISION6, cpphdl_n2153)); // Bench initial voltage = 0.0 V.
        // device 1913, IC IC295, analog/basic/level_down.hpp:30
        I(cpphdl_n2153, Vss) <+ 8e-14 * ddt(V(cpphdl_n2153, Vss)); // Bench initial voltage = 0.0 V.
        // device 1914, IC IC295, analog/basic/level_down.hpp:31
        I(cpphdl_n2153, Vlogic) <+ 5e-15 * ddt(V(cpphdl_n2153, Vlogic)); // Bench initial voltage = 0.0 V.
        // device 1915, IC IC295, analog/basic/level_down.hpp:32
        I(cpphdl_n2153, CORE_DECISION6) <+ 2.0000000000000002e-15 * ddt(V(cpphdl_n2153, CORE_DECISION6)); // Bench initial voltage = 0.0 V.
        // device 1916, IC IC295, analog/basic/level_down.hpp:33
        I(CORE_DECISION6, Vss) <+ 1e-14 * ddt(V(CORE_DECISION6, Vss)); // Bench initial voltage = 0.0 V.
        // device 1917, IC IC296, analog/basic/level_down.hpp:23
        I(cpphdl_n2158, Vlogic) <+ cpphdl_channel(V(Vss, Vlogic), V(cpphdl_n2158, Vlogic), 0.00050000000000000001, 0.34999999999999998, -1.0);
        // device 1918, IC IC296, analog/basic/level_down.hpp:24
        I(cpphdl_n2158, Vss) <+ cpphdl_channel(V(DECISION7, Vss), V(cpphdl_n2158, Vss), 0.0040000000000000001, 0.69999999999999996, 1.0);
        // device 1919, IC IC296, analog/basic/level_down.hpp:25
        I(CORE_DECISION7, Vlogic) <+ cpphdl_channel(V(cpphdl_n2158, Vlogic), V(CORE_DECISION7, Vlogic), 0.0050000000000000001, 0.34999999999999998, -1.0);
        // device 1920, IC IC296, analog/basic/level_down.hpp:26
        I(CORE_DECISION7, Vss) <+ cpphdl_channel(V(cpphdl_n2158, Vss), V(CORE_DECISION7, Vss), 0.01, 0.34999999999999998, 1.0);
        // device 1921, IC IC296, analog/basic/level_down.hpp:27
        I(DECISION7, Vss) <+ 5e-15 * ddt(V(DECISION7, Vss)); // Bench initial voltage = 0.0 V.
        // device 1922, IC IC296, analog/basic/level_down.hpp:28
        I(DECISION7, Vlogic) <+ 5e-15 * ddt(V(DECISION7, Vlogic)); // Bench initial voltage = 0.0 V.
        // device 1923, IC IC296, analog/basic/level_down.hpp:29
        I(DECISION7, cpphdl_n2158) <+ 2.0000000000000002e-15 * ddt(V(DECISION7, cpphdl_n2158)); // Bench initial voltage = 0.0 V.
        // device 1924, IC IC296, analog/basic/level_down.hpp:30
        I(cpphdl_n2158, Vss) <+ 8e-14 * ddt(V(cpphdl_n2158, Vss)); // Bench initial voltage = 0.0 V.
        // device 1925, IC IC296, analog/basic/level_down.hpp:31
        I(cpphdl_n2158, Vlogic) <+ 5e-15 * ddt(V(cpphdl_n2158, Vlogic)); // Bench initial voltage = 0.0 V.
        // device 1926, IC IC296, analog/basic/level_down.hpp:32
        I(cpphdl_n2158, CORE_DECISION7) <+ 2.0000000000000002e-15 * ddt(V(cpphdl_n2158, CORE_DECISION7)); // Bench initial voltage = 0.0 V.
        // device 1927, IC IC296, analog/basic/level_down.hpp:33
        I(CORE_DECISION7, Vss) <+ 1e-14 * ddt(V(CORE_DECISION7, Vss)); // Bench initial voltage = 0.0 V.
        // device 1928, IC IC297, analog/basic/level_down.hpp:23
        I(cpphdl_n2163, Vlogic) <+ cpphdl_channel(V(Vss, Vlogic), V(cpphdl_n2163, Vlogic), 0.00050000000000000001, 0.34999999999999998, -1.0);
        // device 1929, IC IC297, analog/basic/level_down.hpp:24
        I(cpphdl_n2163, Vss) <+ cpphdl_channel(V(DECISION8, Vss), V(cpphdl_n2163, Vss), 0.0040000000000000001, 0.69999999999999996, 1.0);
        // device 1930, IC IC297, analog/basic/level_down.hpp:25
        I(CORE_DECISION8, Vlogic) <+ cpphdl_channel(V(cpphdl_n2163, Vlogic), V(CORE_DECISION8, Vlogic), 0.0050000000000000001, 0.34999999999999998, -1.0);
        // device 1931, IC IC297, analog/basic/level_down.hpp:26
        I(CORE_DECISION8, Vss) <+ cpphdl_channel(V(cpphdl_n2163, Vss), V(CORE_DECISION8, Vss), 0.01, 0.34999999999999998, 1.0);
        // device 1932, IC IC297, analog/basic/level_down.hpp:27
        I(DECISION8, Vss) <+ 5e-15 * ddt(V(DECISION8, Vss)); // Bench initial voltage = 0.0 V.
        // device 1933, IC IC297, analog/basic/level_down.hpp:28
        I(DECISION8, Vlogic) <+ 5e-15 * ddt(V(DECISION8, Vlogic)); // Bench initial voltage = 0.0 V.
        // device 1934, IC IC297, analog/basic/level_down.hpp:29
        I(DECISION8, cpphdl_n2163) <+ 2.0000000000000002e-15 * ddt(V(DECISION8, cpphdl_n2163)); // Bench initial voltage = 0.0 V.
        // device 1935, IC IC297, analog/basic/level_down.hpp:30
        I(cpphdl_n2163, Vss) <+ 8e-14 * ddt(V(cpphdl_n2163, Vss)); // Bench initial voltage = 0.0 V.
        // device 1936, IC IC297, analog/basic/level_down.hpp:31
        I(cpphdl_n2163, Vlogic) <+ 5e-15 * ddt(V(cpphdl_n2163, Vlogic)); // Bench initial voltage = 0.0 V.
        // device 1937, IC IC297, analog/basic/level_down.hpp:32
        I(cpphdl_n2163, CORE_DECISION8) <+ 2.0000000000000002e-15 * ddt(V(cpphdl_n2163, CORE_DECISION8)); // Bench initial voltage = 0.0 V.
        // device 1938, IC IC297, analog/basic/level_down.hpp:33
        I(CORE_DECISION8, Vss) <+ 1e-14 * ddt(V(CORE_DECISION8, Vss)); // Bench initial voltage = 0.0 V.
        // device 1939, IC IC298, analog/basic/level_down.hpp:23
        I(cpphdl_n2168, Vlogic) <+ cpphdl_channel(V(Vss, Vlogic), V(cpphdl_n2168, Vlogic), 0.00050000000000000001, 0.34999999999999998, -1.0);
        // device 1940, IC IC298, analog/basic/level_down.hpp:24
        I(cpphdl_n2168, Vss) <+ cpphdl_channel(V(DECISION9, Vss), V(cpphdl_n2168, Vss), 0.0040000000000000001, 0.69999999999999996, 1.0);
        // device 1941, IC IC298, analog/basic/level_down.hpp:25
        I(CORE_DECISION9, Vlogic) <+ cpphdl_channel(V(cpphdl_n2168, Vlogic), V(CORE_DECISION9, Vlogic), 0.0050000000000000001, 0.34999999999999998, -1.0);
        // device 1942, IC IC298, analog/basic/level_down.hpp:26
        I(CORE_DECISION9, Vss) <+ cpphdl_channel(V(cpphdl_n2168, Vss), V(CORE_DECISION9, Vss), 0.01, 0.34999999999999998, 1.0);
        // device 1943, IC IC298, analog/basic/level_down.hpp:27
        I(DECISION9, Vss) <+ 5e-15 * ddt(V(DECISION9, Vss)); // Bench initial voltage = 0.0 V.
        // device 1944, IC IC298, analog/basic/level_down.hpp:28
        I(DECISION9, Vlogic) <+ 5e-15 * ddt(V(DECISION9, Vlogic)); // Bench initial voltage = 0.0 V.
        // device 1945, IC IC298, analog/basic/level_down.hpp:29
        I(DECISION9, cpphdl_n2168) <+ 2.0000000000000002e-15 * ddt(V(DECISION9, cpphdl_n2168)); // Bench initial voltage = 0.0 V.
        // device 1946, IC IC298, analog/basic/level_down.hpp:30
        I(cpphdl_n2168, Vss) <+ 8e-14 * ddt(V(cpphdl_n2168, Vss)); // Bench initial voltage = 0.0 V.
        // device 1947, IC IC298, analog/basic/level_down.hpp:31
        I(cpphdl_n2168, Vlogic) <+ 5e-15 * ddt(V(cpphdl_n2168, Vlogic)); // Bench initial voltage = 0.0 V.
        // device 1948, IC IC298, analog/basic/level_down.hpp:32
        I(cpphdl_n2168, CORE_DECISION9) <+ 2.0000000000000002e-15 * ddt(V(cpphdl_n2168, CORE_DECISION9)); // Bench initial voltage = 0.0 V.
        // device 1949, IC IC298, analog/basic/level_down.hpp:33
        I(CORE_DECISION9, Vss) <+ 1e-14 * ddt(V(CORE_DECISION9, Vss)); // Bench initial voltage = 0.0 V.
        // device 1950, IC IC299, analog/basic/level_down.hpp:23
        I(cpphdl_n2173, Vlogic) <+ cpphdl_channel(V(Vss, Vlogic), V(cpphdl_n2173, Vlogic), 0.00050000000000000001, 0.34999999999999998, -1.0);
        // device 1951, IC IC299, analog/basic/level_down.hpp:24
        I(cpphdl_n2173, Vss) <+ cpphdl_channel(V(DECISION10, Vss), V(cpphdl_n2173, Vss), 0.0040000000000000001, 0.69999999999999996, 1.0);
        // device 1952, IC IC299, analog/basic/level_down.hpp:25
        I(CORE_DECISION10, Vlogic) <+ cpphdl_channel(V(cpphdl_n2173, Vlogic), V(CORE_DECISION10, Vlogic), 0.0050000000000000001, 0.34999999999999998, -1.0);
        // device 1953, IC IC299, analog/basic/level_down.hpp:26
        I(CORE_DECISION10, Vss) <+ cpphdl_channel(V(cpphdl_n2173, Vss), V(CORE_DECISION10, Vss), 0.01, 0.34999999999999998, 1.0);
        // device 1954, IC IC299, analog/basic/level_down.hpp:27
        I(DECISION10, Vss) <+ 5e-15 * ddt(V(DECISION10, Vss)); // Bench initial voltage = 0.0 V.
        // device 1955, IC IC299, analog/basic/level_down.hpp:28
        I(DECISION10, Vlogic) <+ 5e-15 * ddt(V(DECISION10, Vlogic)); // Bench initial voltage = 0.0 V.
        // device 1956, IC IC299, analog/basic/level_down.hpp:29
        I(DECISION10, cpphdl_n2173) <+ 2.0000000000000002e-15 * ddt(V(DECISION10, cpphdl_n2173)); // Bench initial voltage = 0.0 V.
        // device 1957, IC IC299, analog/basic/level_down.hpp:30
        I(cpphdl_n2173, Vss) <+ 8e-14 * ddt(V(cpphdl_n2173, Vss)); // Bench initial voltage = 0.0 V.
        // device 1958, IC IC299, analog/basic/level_down.hpp:31
        I(cpphdl_n2173, Vlogic) <+ 5e-15 * ddt(V(cpphdl_n2173, Vlogic)); // Bench initial voltage = 0.0 V.
        // device 1959, IC IC299, analog/basic/level_down.hpp:32
        I(cpphdl_n2173, CORE_DECISION10) <+ 2.0000000000000002e-15 * ddt(V(cpphdl_n2173, CORE_DECISION10)); // Bench initial voltage = 0.0 V.
        // device 1960, IC IC299, analog/basic/level_down.hpp:33
        I(CORE_DECISION10, Vss) <+ 1e-14 * ddt(V(CORE_DECISION10, Vss)); // Bench initial voltage = 0.0 V.
        // device 1961, IC IC300, analog/basic/level_down.hpp:23
        I(cpphdl_n2178, Vlogic) <+ cpphdl_channel(V(Vss, Vlogic), V(cpphdl_n2178, Vlogic), 0.00050000000000000001, 0.34999999999999998, -1.0);
        // device 1962, IC IC300, analog/basic/level_down.hpp:24
        I(cpphdl_n2178, Vss) <+ cpphdl_channel(V(DECISION11, Vss), V(cpphdl_n2178, Vss), 0.0040000000000000001, 0.69999999999999996, 1.0);
        // device 1963, IC IC300, analog/basic/level_down.hpp:25
        I(CORE_DECISION11, Vlogic) <+ cpphdl_channel(V(cpphdl_n2178, Vlogic), V(CORE_DECISION11, Vlogic), 0.0050000000000000001, 0.34999999999999998, -1.0);
        // device 1964, IC IC300, analog/basic/level_down.hpp:26
        I(CORE_DECISION11, Vss) <+ cpphdl_channel(V(cpphdl_n2178, Vss), V(CORE_DECISION11, Vss), 0.01, 0.34999999999999998, 1.0);
        // device 1965, IC IC300, analog/basic/level_down.hpp:27
        I(DECISION11, Vss) <+ 5e-15 * ddt(V(DECISION11, Vss)); // Bench initial voltage = 0.0 V.
        // device 1966, IC IC300, analog/basic/level_down.hpp:28
        I(DECISION11, Vlogic) <+ 5e-15 * ddt(V(DECISION11, Vlogic)); // Bench initial voltage = 0.0 V.
        // device 1967, IC IC300, analog/basic/level_down.hpp:29
        I(DECISION11, cpphdl_n2178) <+ 2.0000000000000002e-15 * ddt(V(DECISION11, cpphdl_n2178)); // Bench initial voltage = 0.0 V.
        // device 1968, IC IC300, analog/basic/level_down.hpp:30
        I(cpphdl_n2178, Vss) <+ 8e-14 * ddt(V(cpphdl_n2178, Vss)); // Bench initial voltage = 0.0 V.
        // device 1969, IC IC300, analog/basic/level_down.hpp:31
        I(cpphdl_n2178, Vlogic) <+ 5e-15 * ddt(V(cpphdl_n2178, Vlogic)); // Bench initial voltage = 0.0 V.
        // device 1970, IC IC300, analog/basic/level_down.hpp:32
        I(cpphdl_n2178, CORE_DECISION11) <+ 2.0000000000000002e-15 * ddt(V(cpphdl_n2178, CORE_DECISION11)); // Bench initial voltage = 0.0 V.
        // device 1971, IC IC300, analog/basic/level_down.hpp:33
        I(CORE_DECISION11, Vss) <+ 1e-14 * ddt(V(CORE_DECISION11, Vss)); // Bench initial voltage = 0.0 V.
        // device 1972, IC IC301, analog/basic/level_down.hpp:23
        I(cpphdl_n2183, Vlogic) <+ cpphdl_channel(V(Vss, Vlogic), V(cpphdl_n2183, Vlogic), 0.00050000000000000001, 0.34999999999999998, -1.0);
        // device 1973, IC IC301, analog/basic/level_down.hpp:24
        I(cpphdl_n2183, Vss) <+ cpphdl_channel(V(DECISION12, Vss), V(cpphdl_n2183, Vss), 0.0040000000000000001, 0.69999999999999996, 1.0);
        // device 1974, IC IC301, analog/basic/level_down.hpp:25
        I(CORE_DECISION12, Vlogic) <+ cpphdl_channel(V(cpphdl_n2183, Vlogic), V(CORE_DECISION12, Vlogic), 0.0050000000000000001, 0.34999999999999998, -1.0);
        // device 1975, IC IC301, analog/basic/level_down.hpp:26
        I(CORE_DECISION12, Vss) <+ cpphdl_channel(V(cpphdl_n2183, Vss), V(CORE_DECISION12, Vss), 0.01, 0.34999999999999998, 1.0);
        // device 1976, IC IC301, analog/basic/level_down.hpp:27
        I(DECISION12, Vss) <+ 5e-15 * ddt(V(DECISION12, Vss)); // Bench initial voltage = 0.0 V.
        // device 1977, IC IC301, analog/basic/level_down.hpp:28
        I(DECISION12, Vlogic) <+ 5e-15 * ddt(V(DECISION12, Vlogic)); // Bench initial voltage = 0.0 V.
        // device 1978, IC IC301, analog/basic/level_down.hpp:29
        I(DECISION12, cpphdl_n2183) <+ 2.0000000000000002e-15 * ddt(V(DECISION12, cpphdl_n2183)); // Bench initial voltage = 0.0 V.
        // device 1979, IC IC301, analog/basic/level_down.hpp:30
        I(cpphdl_n2183, Vss) <+ 8e-14 * ddt(V(cpphdl_n2183, Vss)); // Bench initial voltage = 0.0 V.
        // device 1980, IC IC301, analog/basic/level_down.hpp:31
        I(cpphdl_n2183, Vlogic) <+ 5e-15 * ddt(V(cpphdl_n2183, Vlogic)); // Bench initial voltage = 0.0 V.
        // device 1981, IC IC301, analog/basic/level_down.hpp:32
        I(cpphdl_n2183, CORE_DECISION12) <+ 2.0000000000000002e-15 * ddt(V(cpphdl_n2183, CORE_DECISION12)); // Bench initial voltage = 0.0 V.
        // device 1982, IC IC301, analog/basic/level_down.hpp:33
        I(CORE_DECISION12, Vss) <+ 1e-14 * ddt(V(CORE_DECISION12, Vss)); // Bench initial voltage = 0.0 V.
        // device 1983, IC IC302, analog/basic/level_down.hpp:23
        I(cpphdl_n2188, Vlogic) <+ cpphdl_channel(V(Vss, Vlogic), V(cpphdl_n2188, Vlogic), 0.00050000000000000001, 0.34999999999999998, -1.0);
        // device 1984, IC IC302, analog/basic/level_down.hpp:24
        I(cpphdl_n2188, Vss) <+ cpphdl_channel(V(DECISION13, Vss), V(cpphdl_n2188, Vss), 0.0040000000000000001, 0.69999999999999996, 1.0);
        // device 1985, IC IC302, analog/basic/level_down.hpp:25
        I(CORE_DECISION13, Vlogic) <+ cpphdl_channel(V(cpphdl_n2188, Vlogic), V(CORE_DECISION13, Vlogic), 0.0050000000000000001, 0.34999999999999998, -1.0);
        // device 1986, IC IC302, analog/basic/level_down.hpp:26
        I(CORE_DECISION13, Vss) <+ cpphdl_channel(V(cpphdl_n2188, Vss), V(CORE_DECISION13, Vss), 0.01, 0.34999999999999998, 1.0);
        // device 1987, IC IC302, analog/basic/level_down.hpp:27
        I(DECISION13, Vss) <+ 5e-15 * ddt(V(DECISION13, Vss)); // Bench initial voltage = 0.0 V.
        // device 1988, IC IC302, analog/basic/level_down.hpp:28
        I(DECISION13, Vlogic) <+ 5e-15 * ddt(V(DECISION13, Vlogic)); // Bench initial voltage = 0.0 V.
        // device 1989, IC IC302, analog/basic/level_down.hpp:29
        I(DECISION13, cpphdl_n2188) <+ 2.0000000000000002e-15 * ddt(V(DECISION13, cpphdl_n2188)); // Bench initial voltage = 0.0 V.
        // device 1990, IC IC302, analog/basic/level_down.hpp:30
        I(cpphdl_n2188, Vss) <+ 8e-14 * ddt(V(cpphdl_n2188, Vss)); // Bench initial voltage = 0.0 V.
        // device 1991, IC IC302, analog/basic/level_down.hpp:31
        I(cpphdl_n2188, Vlogic) <+ 5e-15 * ddt(V(cpphdl_n2188, Vlogic)); // Bench initial voltage = 0.0 V.
        // device 1992, IC IC302, analog/basic/level_down.hpp:32
        I(cpphdl_n2188, CORE_DECISION13) <+ 2.0000000000000002e-15 * ddt(V(cpphdl_n2188, CORE_DECISION13)); // Bench initial voltage = 0.0 V.
        // device 1993, IC IC302, analog/basic/level_down.hpp:33
        I(CORE_DECISION13, Vss) <+ 1e-14 * ddt(V(CORE_DECISION13, Vss)); // Bench initial voltage = 0.0 V.
        // device 1994, IC IC303, analog/basic/level_down.hpp:23
        I(cpphdl_n2193, Vlogic) <+ cpphdl_channel(V(Vss, Vlogic), V(cpphdl_n2193, Vlogic), 0.00050000000000000001, 0.34999999999999998, -1.0);
        // device 1995, IC IC303, analog/basic/level_down.hpp:24
        I(cpphdl_n2193, Vss) <+ cpphdl_channel(V(DECISION14, Vss), V(cpphdl_n2193, Vss), 0.0040000000000000001, 0.69999999999999996, 1.0);
        // device 1996, IC IC303, analog/basic/level_down.hpp:25
        I(CORE_DECISION14, Vlogic) <+ cpphdl_channel(V(cpphdl_n2193, Vlogic), V(CORE_DECISION14, Vlogic), 0.0050000000000000001, 0.34999999999999998, -1.0);
        // device 1997, IC IC303, analog/basic/level_down.hpp:26
        I(CORE_DECISION14, Vss) <+ cpphdl_channel(V(cpphdl_n2193, Vss), V(CORE_DECISION14, Vss), 0.01, 0.34999999999999998, 1.0);
        // device 1998, IC IC303, analog/basic/level_down.hpp:27
        I(DECISION14, Vss) <+ 5e-15 * ddt(V(DECISION14, Vss)); // Bench initial voltage = 0.0 V.
        // device 1999, IC IC303, analog/basic/level_down.hpp:28
        I(DECISION14, Vlogic) <+ 5e-15 * ddt(V(DECISION14, Vlogic)); // Bench initial voltage = 0.0 V.
        // device 2000, IC IC303, analog/basic/level_down.hpp:29
        I(DECISION14, cpphdl_n2193) <+ 2.0000000000000002e-15 * ddt(V(DECISION14, cpphdl_n2193)); // Bench initial voltage = 0.0 V.
        // device 2001, IC IC303, analog/basic/level_down.hpp:30
        I(cpphdl_n2193, Vss) <+ 8e-14 * ddt(V(cpphdl_n2193, Vss)); // Bench initial voltage = 0.0 V.
        // device 2002, IC IC303, analog/basic/level_down.hpp:31
        I(cpphdl_n2193, Vlogic) <+ 5e-15 * ddt(V(cpphdl_n2193, Vlogic)); // Bench initial voltage = 0.0 V.
        // device 2003, IC IC303, analog/basic/level_down.hpp:32
        I(cpphdl_n2193, CORE_DECISION14) <+ 2.0000000000000002e-15 * ddt(V(cpphdl_n2193, CORE_DECISION14)); // Bench initial voltage = 0.0 V.
        // device 2004, IC IC303, analog/basic/level_down.hpp:33
        I(CORE_DECISION14, Vss) <+ 1e-14 * ddt(V(CORE_DECISION14, Vss)); // Bench initial voltage = 0.0 V.
        // device 2005, IC IC304, analog/basic/level_down.hpp:23
        I(cpphdl_n2198, Vlogic) <+ cpphdl_channel(V(Vss, Vlogic), V(cpphdl_n2198, Vlogic), 0.00050000000000000001, 0.34999999999999998, -1.0);
        // device 2006, IC IC304, analog/basic/level_down.hpp:24
        I(cpphdl_n2198, Vss) <+ cpphdl_channel(V(DECISION15, Vss), V(cpphdl_n2198, Vss), 0.0040000000000000001, 0.69999999999999996, 1.0);
        // device 2007, IC IC304, analog/basic/level_down.hpp:25
        I(CORE_DECISION15, Vlogic) <+ cpphdl_channel(V(cpphdl_n2198, Vlogic), V(CORE_DECISION15, Vlogic), 0.0050000000000000001, 0.34999999999999998, -1.0);
        // device 2008, IC IC304, analog/basic/level_down.hpp:26
        I(CORE_DECISION15, Vss) <+ cpphdl_channel(V(cpphdl_n2198, Vss), V(CORE_DECISION15, Vss), 0.01, 0.34999999999999998, 1.0);
        // device 2009, IC IC304, analog/basic/level_down.hpp:27
        I(DECISION15, Vss) <+ 5e-15 * ddt(V(DECISION15, Vss)); // Bench initial voltage = 0.0 V.
        // device 2010, IC IC304, analog/basic/level_down.hpp:28
        I(DECISION15, Vlogic) <+ 5e-15 * ddt(V(DECISION15, Vlogic)); // Bench initial voltage = 0.0 V.
        // device 2011, IC IC304, analog/basic/level_down.hpp:29
        I(DECISION15, cpphdl_n2198) <+ 2.0000000000000002e-15 * ddt(V(DECISION15, cpphdl_n2198)); // Bench initial voltage = 0.0 V.
        // device 2012, IC IC304, analog/basic/level_down.hpp:30
        I(cpphdl_n2198, Vss) <+ 8e-14 * ddt(V(cpphdl_n2198, Vss)); // Bench initial voltage = 0.0 V.
        // device 2013, IC IC304, analog/basic/level_down.hpp:31
        I(cpphdl_n2198, Vlogic) <+ 5e-15 * ddt(V(cpphdl_n2198, Vlogic)); // Bench initial voltage = 0.0 V.
        // device 2014, IC IC304, analog/basic/level_down.hpp:32
        I(cpphdl_n2198, CORE_DECISION15) <+ 2.0000000000000002e-15 * ddt(V(cpphdl_n2198, CORE_DECISION15)); // Bench initial voltage = 0.0 V.
        // device 2015, IC IC304, analog/basic/level_down.hpp:33
        I(CORE_DECISION15, Vss) <+ 1e-14 * ddt(V(CORE_DECISION15, Vss)); // Bench initial voltage = 0.0 V.
    end
endmodule
