// Generated from elaborated C++HDL IC purposes; all contributions coexist.
// Capacitor initialization belongs to the host analysis; declared initial voltages appear below.
`include "disciplines.vams"

module cascode_opamp(Vdd, Vss, PLUS, MINUS, OUT, BIAS_N, BIAS_P, TAIL_BIAS);
    inout Vdd, Vss, PLUS, MINUS, OUT, BIAS_N, BIAS_P, TAIL_BIAS;
    electrical Vdd, Vss, PLUS, MINUS, OUT, BIAS_N, BIAS_P, TAIL_BIAS;
    electrical cpphdl_n9;
    electrical cpphdl_n10;
    electrical cpphdl_n11;
    electrical cpphdl_n12;
    electrical cpphdl_n13;
    electrical cpphdl_n14;

    // Square-law channel, including reverse conduction. This is not a BSIM model.
    analog function real cpphdl_channel;
        input vgs, vds, beta, threshold, polarity;
        real vgs, vds, beta, threshold, polarity;
        real gate, drain, direction, overdrive, current;
        begin
            gate = polarity * vgs;
            drain = polarity * vds;
            direction = 1.0;
            if (drain < 0.0) begin
                gate = gate - drain;
                drain = -drain;
                direction = -1.0;
            end
            overdrive = gate - threshold;
            current = 0.0;
            if (overdrive > 0.0) begin
                if (drain < overdrive)
                    current = beta * (overdrive * drain - drain * drain / 2.0);
                else
                    current = beta * overdrive * overdrive / 2.0;
            end
            cpphdl_channel = polarity * direction * current;
        end
    endfunction

    analog begin
        // device 0, IC cascode_opamp, analog/basic/cascode_opamp.hpp:29
        I(cpphdl_n9, cpphdl_n14) <+ cpphdl_channel(V(PLUS, cpphdl_n14), V(cpphdl_n9, cpphdl_n14), 0.029999999999999999, 0.69999999999999996, 1.0);
        // device 1, IC cascode_opamp, analog/basic/cascode_opamp.hpp:30
        I(cpphdl_n10, cpphdl_n14) <+ cpphdl_channel(V(MINUS, cpphdl_n14), V(cpphdl_n10, cpphdl_n14), 0.029999999999999999, 0.69999999999999996, 1.0);
        // device 2, IC cascode_opamp, analog/basic/cascode_opamp.hpp:31
        I(cpphdl_n11, cpphdl_n9) <+ cpphdl_channel(V(BIAS_N, cpphdl_n9), V(cpphdl_n11, cpphdl_n9), 0.059999999999999998, 0.69999999999999996, 1.0);
        // device 3, IC cascode_opamp, analog/basic/cascode_opamp.hpp:32
        I(OUT, cpphdl_n10) <+ cpphdl_channel(V(BIAS_N, cpphdl_n10), V(OUT, cpphdl_n10), 0.059999999999999998, 0.69999999999999996, 1.0);
        // device 4, IC cascode_opamp, analog/basic/cascode_opamp.hpp:33
        I(cpphdl_n12, Vdd) <+ cpphdl_channel(V(cpphdl_n11, Vdd), V(cpphdl_n12, Vdd), 0.029999999999999999, 0.69999999999999996, -1.0);
        // device 5, IC cascode_opamp, analog/basic/cascode_opamp.hpp:34
        I(cpphdl_n13, Vdd) <+ cpphdl_channel(V(cpphdl_n11, Vdd), V(cpphdl_n13, Vdd), 0.029999999999999999, 0.69999999999999996, -1.0);
        // device 6, IC cascode_opamp, analog/basic/cascode_opamp.hpp:35
        I(cpphdl_n11, cpphdl_n12) <+ cpphdl_channel(V(BIAS_P, cpphdl_n12), V(cpphdl_n11, cpphdl_n12), 0.059999999999999998, 0.69999999999999996, -1.0);
        // device 7, IC cascode_opamp, analog/basic/cascode_opamp.hpp:36
        I(OUT, cpphdl_n13) <+ cpphdl_channel(V(BIAS_P, cpphdl_n13), V(OUT, cpphdl_n13), 0.059999999999999998, 0.69999999999999996, -1.0);
        // device 8, IC cascode_opamp, analog/basic/cascode_opamp.hpp:37
        I(cpphdl_n14, Vss) <+ cpphdl_channel(V(TAIL_BIAS, Vss), V(cpphdl_n14, Vss), 0.059999999999999998, 0.69999999999999996, 1.0);
        // device 9, IC cascode_opamp, analog/basic/cascode_opamp.hpp:38
        I(Vss, OUT) <+ V(Vss, OUT) / 100000.0;
        // device 10, IC cascode_opamp, analog/basic/cascode_opamp.hpp:39
        I(OUT, Vss) <+ 9.9999999999999998e-13 * ddt(V(OUT, Vss)); // Bench initial voltage = 0.0 V.
        // device 11, IC cascode_opamp, analog/basic/cascode_opamp.hpp:40
        I(cpphdl_n9, Vss) <+ 4e-14 * ddt(V(cpphdl_n9, Vss)); // Bench initial voltage = 0.0 V.
        // device 12, IC cascode_opamp, analog/basic/cascode_opamp.hpp:41
        I(cpphdl_n10, Vss) <+ 4e-14 * ddt(V(cpphdl_n10, Vss)); // Bench initial voltage = 0.0 V.
        // device 13, IC cascode_opamp, analog/basic/cascode_opamp.hpp:42
        I(cpphdl_n14, Vss) <+ 4e-14 * ddt(V(cpphdl_n14, Vss)); // Bench initial voltage = 0.0 V.
        // device 14, IC cascode_opamp, analog/basic/cascode_opamp.hpp:43
        I(cpphdl_n12, Vdd) <+ 4e-14 * ddt(V(cpphdl_n12, Vdd)); // Bench initial voltage = 0.0 V.
        // device 15, IC cascode_opamp, analog/basic/cascode_opamp.hpp:44
        I(cpphdl_n13, Vdd) <+ 4e-14 * ddt(V(cpphdl_n13, Vdd)); // Bench initial voltage = 0.0 V.
        // device 16, IC cascode_opamp, analog/basic/cascode_opamp.hpp:45
        I(cpphdl_n11, Vss) <+ 4e-14 * ddt(V(cpphdl_n11, Vss)); // Bench initial voltage = 0.0 V.
        // device 17, IC cascode_opamp, analog/basic/cascode_opamp.hpp:46
        I(PLUS, cpphdl_n14) <+ 4e-14 * ddt(V(PLUS, cpphdl_n14)); // Bench initial voltage = 0.0 V.
        // device 18, IC cascode_opamp, analog/basic/cascode_opamp.hpp:47
        I(MINUS, cpphdl_n14) <+ 4e-14 * ddt(V(MINUS, cpphdl_n14)); // Bench initial voltage = 0.0 V.
        // device 19, IC cascode_opamp, analog/basic/cascode_opamp.hpp:48
        I(PLUS, cpphdl_n9) <+ 1e-14 * ddt(V(PLUS, cpphdl_n9)); // Bench initial voltage = 0.0 V.
        // device 20, IC cascode_opamp, analog/basic/cascode_opamp.hpp:49
        I(MINUS, cpphdl_n10) <+ 1e-14 * ddt(V(MINUS, cpphdl_n10)); // Bench initial voltage = 0.0 V.
    end
endmodule
