// Generated from elaborated C++HDL IC purposes; all contributions coexist.
// Capacitor initialization belongs to the host analysis; declared initial voltages appear below.
`include "disciplines.vams"

module cascode_voltage_buffer(Vdd, Vss, IN, OUT, BIAS_N, BIAS_P, TAIL_BIAS);
    inout Vdd, Vss, IN, OUT, BIAS_N, BIAS_P, TAIL_BIAS;
    electrical Vdd, Vss, IN, OUT, BIAS_N, BIAS_P, TAIL_BIAS;
    electrical cpphdl_n16;
    electrical cpphdl_n17;
    electrical cpphdl_n18;
    electrical cpphdl_n19;
    electrical cpphdl_n20;
    electrical cpphdl_n21;
    electrical cpphdl_n24;

    // Square-law channel, including reverse conduction. This is not a BSIM model.
    analog function real cpphdl_channel;
        input vgs, vds, beta, threshold, polarity;
        real vgs, vds, beta, threshold, polarity;
        real gate, drain, direction, overdrive, current;
        begin
            gate = polarity * vgs;
            drain = polarity * vds;
            direction = 1.0;
            if (drain < 0.0) begin
                gate = gate - drain;
                drain = -drain;
                direction = -1.0;
            end
            overdrive = gate - threshold;
            current = 0.0;
            if (overdrive > 0.0) begin
                if (drain < overdrive)
                    current = beta * (overdrive * drain - drain * drain / 2.0);
                else
                    current = beta * overdrive * overdrive / 2.0;
            end
            cpphdl_channel = polarity * direction * current;
        end
    endfunction

    analog begin
        // device 0, IC IC1, analog/basic/cascode_ota.hpp:29
        I(cpphdl_n16, cpphdl_n21) <+ cpphdl_channel(V(IN, cpphdl_n21), V(cpphdl_n16, cpphdl_n21), 0.029999999999999999, 0.69999999999999996, 1.0);
        // device 1, IC IC1, analog/basic/cascode_ota.hpp:30
        I(cpphdl_n17, cpphdl_n21) <+ cpphdl_channel(V(OUT, cpphdl_n21), V(cpphdl_n17, cpphdl_n21), 0.029999999999999999, 0.69999999999999996, 1.0);
        // device 2, IC IC1, analog/basic/cascode_ota.hpp:31
        I(cpphdl_n18, cpphdl_n16) <+ cpphdl_channel(V(BIAS_N, cpphdl_n16), V(cpphdl_n18, cpphdl_n16), 0.059999999999999998, 0.69999999999999996, 1.0);
        // device 3, IC IC1, analog/basic/cascode_ota.hpp:32
        I(cpphdl_n24, cpphdl_n17) <+ cpphdl_channel(V(BIAS_N, cpphdl_n17), V(cpphdl_n24, cpphdl_n17), 0.059999999999999998, 0.69999999999999996, 1.0);
        // device 4, IC IC1, analog/basic/cascode_ota.hpp:33
        I(cpphdl_n19, Vdd) <+ cpphdl_channel(V(cpphdl_n18, Vdd), V(cpphdl_n19, Vdd), 0.029999999999999999, 0.69999999999999996, -1.0);
        // device 5, IC IC1, analog/basic/cascode_ota.hpp:34
        I(cpphdl_n20, Vdd) <+ cpphdl_channel(V(cpphdl_n18, Vdd), V(cpphdl_n20, Vdd), 0.029999999999999999, 0.69999999999999996, -1.0);
        // device 6, IC IC1, analog/basic/cascode_ota.hpp:35
        I(cpphdl_n18, cpphdl_n19) <+ cpphdl_channel(V(BIAS_P, cpphdl_n19), V(cpphdl_n18, cpphdl_n19), 0.059999999999999998, 0.69999999999999996, -1.0);
        // device 7, IC IC1, analog/basic/cascode_ota.hpp:36
        I(cpphdl_n24, cpphdl_n20) <+ cpphdl_channel(V(BIAS_P, cpphdl_n20), V(cpphdl_n24, cpphdl_n20), 0.059999999999999998, 0.69999999999999996, -1.0);
        // device 8, IC IC1, analog/basic/cascode_ota.hpp:37
        I(cpphdl_n21, Vss) <+ cpphdl_channel(V(TAIL_BIAS, Vss), V(cpphdl_n21, Vss), 0.059999999999999998, 0.69999999999999996, 1.0);
        // device 9, IC IC1, analog/basic/cascode_ota.hpp:38
        I(cpphdl_n24, Vss) <+ 2.4999999999999999e-13 * ddt(V(cpphdl_n24, Vss)); // Bench initial voltage = 0.0 V.
        // device 10, IC IC1, analog/basic/cascode_ota.hpp:39
        I(cpphdl_n16, Vss) <+ 4e-14 * ddt(V(cpphdl_n16, Vss)); // Bench initial voltage = 0.0 V.
        // device 11, IC IC1, analog/basic/cascode_ota.hpp:40
        I(cpphdl_n17, Vss) <+ 4e-14 * ddt(V(cpphdl_n17, Vss)); // Bench initial voltage = 0.0 V.
        // device 12, IC IC1, analog/basic/cascode_ota.hpp:41
        I(cpphdl_n21, Vss) <+ 4e-14 * ddt(V(cpphdl_n21, Vss)); // Bench initial voltage = 0.0 V.
        // device 13, IC IC1, analog/basic/cascode_ota.hpp:42
        I(cpphdl_n19, Vdd) <+ 4e-14 * ddt(V(cpphdl_n19, Vdd)); // Bench initial voltage = 0.0 V.
        // device 14, IC IC1, analog/basic/cascode_ota.hpp:43
        I(cpphdl_n20, Vdd) <+ 4e-14 * ddt(V(cpphdl_n20, Vdd)); // Bench initial voltage = 0.0 V.
        // device 15, IC IC1, analog/basic/cascode_ota.hpp:44
        I(cpphdl_n18, Vss) <+ 4e-14 * ddt(V(cpphdl_n18, Vss)); // Bench initial voltage = 0.0 V.
        // device 16, IC IC1, analog/basic/cascode_ota.hpp:45
        I(IN, cpphdl_n21) <+ 4e-14 * ddt(V(IN, cpphdl_n21)); // Bench initial voltage = 0.0 V.
        // device 17, IC IC1, analog/basic/cascode_ota.hpp:46
        I(OUT, cpphdl_n21) <+ 4e-14 * ddt(V(OUT, cpphdl_n21)); // Bench initial voltage = 0.0 V.
        // device 18, IC IC1, analog/basic/cascode_ota.hpp:47
        I(IN, cpphdl_n16) <+ 1e-14 * ddt(V(IN, cpphdl_n16)); // Bench initial voltage = 0.0 V.
        // device 19, IC IC1, analog/basic/cascode_ota.hpp:48
        I(OUT, cpphdl_n17) <+ 1e-14 * ddt(V(OUT, cpphdl_n17)); // Bench initial voltage = 0.0 V.
        // device 20, IC IC2, analog/basic/nmos_source_follower.hpp:19
        I(Vdd, OUT) <+ cpphdl_channel(V(cpphdl_n24, OUT), V(Vdd, OUT), 0.20000000000000001, 0.69999999999999996, 1.0);
        // device 21, IC IC2, analog/basic/nmos_source_follower.hpp:20
        I(Vss, OUT) <+ V(Vss, OUT) / 250.0;
        // device 22, IC IC2, analog/basic/nmos_source_follower.hpp:23
        I(cpphdl_n24, OUT) <+ 8e-14 * ddt(V(cpphdl_n24, OUT)); // Bench initial voltage = 0.0 V.
        // device 23, IC IC2, analog/basic/nmos_source_follower.hpp:24
        I(cpphdl_n24, Vdd) <+ 2e-14 * ddt(V(cpphdl_n24, Vdd)); // Bench initial voltage = 0.0 V.
        // device 24, IC IC2, analog/basic/nmos_source_follower.hpp:25
        I(OUT, Vss) <+ 8e-14 * ddt(V(OUT, Vss)); // Bench initial voltage = 0.0 V.
    end
endmodule
