// Generated from elaborated C++HDL IC purposes; all contributions coexist.
// Capacitor initialization belongs to the host analysis; declared initial voltages appear below.
`include "disciplines.vams"

module variable_gain_amplifier(Vdd, Vss, IN, OUT, BIAS, CONTROL);
    inout Vdd, Vss, IN, OUT, BIAS, CONTROL;
    electrical Vdd, Vss, IN, OUT, BIAS, CONTROL;
    electrical cpphdl_n22;
    electrical cpphdl_n23;
    electrical cpphdl_n26;
    electrical cpphdl_n29;

    // Square-law channel, including reverse conduction. This is not a BSIM model.
    analog function real cpphdl_channel;
        input vgs, vds, beta, threshold, polarity;
        real vgs, vds, beta, threshold, polarity;
        real gate, drain, direction, overdrive, current;
        begin
            gate = polarity * vgs;
            drain = polarity * vds;
            direction = 1.0;
            if (drain < 0.0) begin
                gate = gate - drain;
                drain = -drain;
                direction = -1.0;
            end
            overdrive = gate - threshold;
            current = 0.0;
            if (overdrive > 0.0) begin
                if (drain < overdrive)
                    current = beta * (overdrive * drain - drain * drain / 2.0);
                else
                    current = beta * overdrive * overdrive / 2.0;
            end
            cpphdl_channel = polarity * direction * current;
        end
    endfunction

    analog begin
        // device 0, IC variable_gain_amplifier, analog/basic/agc.hpp:18
        I(IN, cpphdl_n22) <+ cpphdl_channel(V(CONTROL, cpphdl_n22), V(IN, cpphdl_n22), 0.00040000000000000002, 0.34999999999999998, 1.0);
        // device 1, IC variable_gain_amplifier, analog/basic/agc.hpp:19
        I(cpphdl_n22, BIAS) <+ V(cpphdl_n22, BIAS) / 10000.0;
        // device 2, IC IC1, analog/basic/resistor_divider.hpp:15
        I(OUT, cpphdl_n23) <+ V(OUT, cpphdl_n23) / 30000.0;
        // device 3, IC IC1, analog/basic/resistor_divider.hpp:16
        I(cpphdl_n23, BIAS) <+ V(cpphdl_n23, BIAS) / 10000.0;
        // device 4, IC IC3, analog/basic/nmos_differential_pair.hpp:16
        I(cpphdl_n29, cpphdl_n26) <+ cpphdl_channel(V(cpphdl_n22, cpphdl_n26), V(cpphdl_n29, cpphdl_n26), 0.20000000000000001, 0.34999999999999998, 1.0);
        // device 5, IC IC3, analog/basic/nmos_differential_pair.hpp:17
        I(OUT, cpphdl_n26) <+ cpphdl_channel(V(cpphdl_n23, cpphdl_n26), V(OUT, cpphdl_n26), 0.20000000000000001, 0.34999999999999998, 1.0);
        // device 6, IC IC2, analog/basic/opamp.hpp:31
        I(cpphdl_n26, Vss) <+ V(cpphdl_n26, Vss) / 10.0;
        // device 7, IC IC4, analog/basic/pmos_current_mirror.hpp:14
        I(cpphdl_n29, Vdd) <+ cpphdl_channel(V(cpphdl_n29, Vdd), V(cpphdl_n29, Vdd), 0.20000000000000001, 0.34999999999999998, -1.0);
        // device 8, IC IC4, analog/basic/pmos_current_mirror.hpp:15
        I(OUT, Vdd) <+ cpphdl_channel(V(cpphdl_n29, Vdd), V(OUT, Vdd), 0.20000000000000001, 0.34999999999999998, -1.0);
        // device 9, IC IC4, analog/basic/pmos_current_mirror.hpp:16
        I(cpphdl_n29, Vdd) <+ V(cpphdl_n29, Vdd) / 1000000000.0;
        // device 10, IC IC2, analog/basic/opamp.hpp:39
        I(OUT, Vss) <+ 1e-08 * ddt(V(OUT, Vss)); // Bench initial voltage = 0.0 V.
        // device 11, IC IC2, analog/basic/opamp.hpp:40
        I(OUT, Vss) <+ V(OUT, Vss) / 100000.0;
    end
endmodule
