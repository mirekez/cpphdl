// Generated from elaborated C++HDL IC purposes; all contributions coexist.
// Capacitor initialization belongs to the host analysis; declared initial voltages appear below.
`include "disciplines.vams"

module mos_peak_detector(Vdd, Vss, IN, OUT);
    inout Vdd, Vss, IN, OUT;
    electrical Vdd, Vss, IN, OUT;

    // Square-law channel, including reverse conduction. This is not a BSIM model.
    analog function real cpphdl_channel;
        input vgs, vds, beta, threshold, polarity;
        real vgs, vds, beta, threshold, polarity;
        real gate, drain, direction, overdrive, current;
        begin
            gate = polarity * vgs;
            drain = polarity * vds;
            direction = 1.0;
            if (drain < 0.0) begin
                gate = gate - drain;
                drain = -drain;
                direction = -1.0;
            end
            overdrive = gate - threshold;
            current = 0.0;
            if (overdrive > 0.0) begin
                if (drain < overdrive)
                    current = beta * (overdrive * drain - drain * drain / 2.0);
                else
                    current = beta * overdrive * overdrive / 2.0;
            end
            cpphdl_channel = polarity * direction * current;
        end
    endfunction

    analog begin
        // device 0, IC mos_peak_detector, analog/basic/agc.hpp:44
        I(IN, OUT) <+ cpphdl_channel(V(IN, OUT), V(IN, OUT), 0.02, 0.34999999999999998, 1.0);
        // device 1, IC mos_peak_detector, analog/basic/agc.hpp:45
        I(OUT, Vss) <+ 1e-08 * ddt(V(OUT, Vss)); // Bench initial voltage = 0.0 V.
        // device 2, IC mos_peak_detector, analog/basic/agc.hpp:46
        I(OUT, Vss) <+ V(OUT, Vss) / 500000.0;
    end
endmodule
