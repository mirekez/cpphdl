// Generated from elaborated C++HDL IC purposes; all contributions coexist.
// Capacitor initialization belongs to the host analysis; declared initial voltages appear below.
`include "disciplines.vams"

module mos_track_hold(Vdd, Vss, IN, CLOCK, OUT);
    inout Vdd, Vss, IN, CLOCK, OUT;
    electrical Vdd, Vss, IN, CLOCK, OUT;
    electrical cpphdl_n9;

    // Square-law channel, including reverse conduction. This is not a BSIM model.
    analog function real cpphdl_channel;
        input vgs, vds, beta, threshold, polarity;
        real vgs, vds, beta, threshold, polarity;
        real gate, drain, direction, overdrive, current;
        begin
            gate = polarity * vgs;
            drain = polarity * vds;
            direction = 1.0;
            if (drain < 0.0) begin
                gate = gate - drain;
                drain = -drain;
                direction = -1.0;
            end
            overdrive = gate - threshold;
            current = 0.0;
            if (overdrive > 0.0) begin
                if (drain < overdrive)
                    current = beta * (overdrive * drain - drain * drain / 2.0);
                else
                    current = beta * overdrive * overdrive / 2.0;
            end
            cpphdl_channel = polarity * direction * current;
        end
    endfunction

    analog begin
        // device 0, IC IC1, analog/basic/inverter.hpp:11
        I(cpphdl_n9, Vdd) <+ cpphdl_channel(V(CLOCK, Vdd), V(cpphdl_n9, Vdd), 0.0040000000000000001, 0.69999999999999996, -1.0);
        // device 1, IC IC1, analog/basic/inverter.hpp:12
        I(cpphdl_n9, Vss) <+ cpphdl_channel(V(CLOCK, Vss), V(cpphdl_n9, Vss), 0.0040000000000000001, 0.69999999999999996, 1.0);
        // device 2, IC mos_track_hold, analog/basic/mos_track_hold.hpp:31
        I(cpphdl_n9, Vss) <+ 5e-15 * ddt(V(cpphdl_n9, Vss)); // Bench initial voltage = 3.2999999999999998 V.
        // device 3, IC mos_track_hold, analog/basic/mos_track_hold.hpp:32
        I(IN, OUT) <+ cpphdl_channel(V(CLOCK, OUT), V(IN, OUT), 0.02, 0.69999999999999996, 1.0);
        // device 4, IC mos_track_hold, analog/basic/mos_track_hold.hpp:33
        I(OUT, IN) <+ cpphdl_channel(V(cpphdl_n9, IN), V(OUT, IN), 0.01, 0.69999999999999996, -1.0);
        // device 5, IC mos_track_hold, analog/basic/mos_track_hold.hpp:37
        I(OUT, OUT) <+ cpphdl_channel(V(cpphdl_n9, OUT), V(OUT, OUT), 0.01, 0.69999999999999996, 1.0);
        // device 6, IC mos_track_hold, analog/basic/mos_track_hold.hpp:38
        I(OUT, OUT) <+ cpphdl_channel(V(CLOCK, OUT), V(OUT, OUT), 0.0050000000000000001, 0.69999999999999996, -1.0);
        // device 7, IC mos_track_hold, analog/basic/mos_track_hold.hpp:39
        I(OUT, Vss) <+ 2e-12 * ddt(V(OUT, Vss)); // Bench initial voltage = 1.6499999999999999 V.
        // device 8, IC mos_track_hold, analog/basic/mos_track_hold.hpp:41
        I(Vss, OUT) <+ V(Vss, OUT) / 1000000000.0;
        // device 9, IC mos_track_hold, analog/basic/mos_track_hold.hpp:42
        I(CLOCK, OUT) <+ 2.0000000000000002e-15 * ddt(V(CLOCK, OUT)); // Bench initial voltage = -1.6499999999999999 V.
        // device 10, IC mos_track_hold, analog/basic/mos_track_hold.hpp:43
        I(cpphdl_n9, OUT) <+ 2.0000000000000002e-15 * ddt(V(cpphdl_n9, OUT)); // Bench initial voltage = 1.6499999999999999 V.
        // device 11, IC mos_track_hold, analog/basic/mos_track_hold.hpp:44
        I(IN, OUT) <+ 1.0000000000000001e-15 * ddt(V(IN, OUT)); // Bench initial voltage = 0.0 V.
    end
endmodule
