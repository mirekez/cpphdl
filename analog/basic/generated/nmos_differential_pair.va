// Generated from elaborated C++HDL IC purposes; all contributions coexist.
// Capacitor initialization belongs to the host analysis; declared initial voltages appear below.
`include "disciplines.vams"

module nmos_differential_pair(Vdd, Vss, PLUS, MINUS, LEFT, RIGHT, TAIL);
    inout Vdd, Vss, PLUS, MINUS, LEFT, RIGHT, TAIL;
    electrical Vdd, Vss, PLUS, MINUS, LEFT, RIGHT, TAIL;

    // Square-law channel, including reverse conduction. This is not a BSIM model.
    analog function real cpphdl_channel;
        input vgs, vds, beta, threshold, polarity;
        real vgs, vds, beta, threshold, polarity;
        real gate, drain, direction, overdrive, current;
        begin
            gate = polarity * vgs;
            drain = polarity * vds;
            direction = 1.0;
            if (drain < 0.0) begin
                gate = gate - drain;
                drain = -drain;
                direction = -1.0;
            end
            overdrive = gate - threshold;
            current = 0.0;
            if (overdrive > 0.0) begin
                if (drain < overdrive)
                    current = beta * (overdrive * drain - drain * drain / 2.0);
                else
                    current = beta * overdrive * overdrive / 2.0;
            end
            cpphdl_channel = polarity * direction * current;
        end
    endfunction

    analog begin
        // device 0, IC nmos_differential_pair, analog/basic/nmos_differential_pair.hpp:16
        I(LEFT, TAIL) <+ cpphdl_channel(V(PLUS, TAIL), V(LEFT, TAIL), 0.20000000000000001, 0.34999999999999998, 1.0);
        // device 1, IC nmos_differential_pair, analog/basic/nmos_differential_pair.hpp:17
        I(RIGHT, TAIL) <+ cpphdl_channel(V(MINUS, TAIL), V(RIGHT, TAIL), 0.20000000000000001, 0.34999999999999998, 1.0);
    end
endmodule
