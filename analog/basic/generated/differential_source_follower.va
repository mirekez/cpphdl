// Generated from elaborated C++HDL IC purposes; all contributions coexist.
// Capacitor initialization belongs to the host analysis; declared initial voltages appear below.
`include "disciplines.vams"

module differential_source_follower(Vdd, Vss, PLUS, MINUS, OUTP, OUTN);
    inout Vdd, Vss, PLUS, MINUS, OUTP, OUTN;
    electrical Vdd, Vss, PLUS, MINUS, OUTP, OUTN;

    // Square-law channel, including reverse conduction. This is not a BSIM model.
    analog function real cpphdl_channel;
        input vgs, vds, beta, threshold, polarity;
        real vgs, vds, beta, threshold, polarity;
        real gate, drain, direction, overdrive, current;
        begin
            gate = polarity * vgs;
            drain = polarity * vds;
            direction = 1.0;
            if (drain < 0.0) begin
                gate = gate - drain;
                drain = -drain;
                direction = -1.0;
            end
            overdrive = gate - threshold;
            current = 0.0;
            if (overdrive > 0.0) begin
                if (drain < overdrive)
                    current = beta * (overdrive * drain - drain * drain / 2.0);
                else
                    current = beta * overdrive * overdrive / 2.0;
            end
            cpphdl_channel = polarity * direction * current;
        end
    endfunction

    analog begin
        // device 0, IC IC1, analog/basic/nmos_source_follower.hpp:19
        I(Vdd, OUTP) <+ cpphdl_channel(V(PLUS, OUTP), V(Vdd, OUTP), 0.050000000000000003, 0.69999999999999996, 1.0);
        // device 1, IC IC1, analog/basic/nmos_source_follower.hpp:20
        I(Vss, OUTP) <+ V(Vss, OUTP) / 500.0;
        // device 2, IC IC1, analog/basic/nmos_source_follower.hpp:23
        I(PLUS, OUTP) <+ 2e-14 * ddt(V(PLUS, OUTP)); // Bench initial voltage = 1.1499999999999999 V.
        // device 3, IC IC1, analog/basic/nmos_source_follower.hpp:24
        I(PLUS, Vdd) <+ 5e-15 * ddt(V(PLUS, Vdd)); // Bench initial voltage = -0.5 V.
        // device 4, IC IC1, analog/basic/nmos_source_follower.hpp:25
        I(OUTP, Vss) <+ 2e-14 * ddt(V(OUTP, Vss)); // Bench initial voltage = 1.6499999999999999 V.
        // device 5, IC IC2, analog/basic/nmos_source_follower.hpp:19
        I(Vdd, OUTN) <+ cpphdl_channel(V(MINUS, OUTN), V(Vdd, OUTN), 0.050000000000000003, 0.69999999999999996, 1.0);
        // device 6, IC IC2, analog/basic/nmos_source_follower.hpp:20
        I(Vss, OUTN) <+ V(Vss, OUTN) / 500.0;
        // device 7, IC IC2, analog/basic/nmos_source_follower.hpp:23
        I(MINUS, OUTN) <+ 2e-14 * ddt(V(MINUS, OUTN)); // Bench initial voltage = 1.1499999999999999 V.
        // device 8, IC IC2, analog/basic/nmos_source_follower.hpp:24
        I(MINUS, Vdd) <+ 5e-15 * ddt(V(MINUS, Vdd)); // Bench initial voltage = -0.5 V.
        // device 9, IC IC2, analog/basic/nmos_source_follower.hpp:25
        I(OUTN, Vss) <+ 2e-14 * ddt(V(OUTN, Vss)); // Bench initial voltage = 1.6499999999999999 V.
    end
endmodule
