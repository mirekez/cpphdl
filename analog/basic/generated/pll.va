// Generated from elaborated C++HDL IC purposes; all contributions coexist.
// Capacitor initialization belongs to the host analysis; declared initial voltages appear below.
`include "disciplines.vams"

module pll(Vdd, Vss, REF, OUT);
    inout Vdd, Vss, REF, OUT;
    electrical Vdd, Vss, REF, OUT;
    electrical cpphdl_n16;
    electrical cpphdl_n22;
    electrical cpphdl_n26;
    electrical cpphdl_n28;
    electrical cpphdl_n31;
    electrical cpphdl_n32;
    electrical cpphdl_n34;
    electrical cpphdl_n37;
    electrical cpphdl_n39;
    electrical cpphdl_n49;
    electrical cpphdl_n52;
    electrical cpphdl_n55;
    electrical cpphdl_n58;
    electrical cpphdl_n60;
    electrical cpphdl_n61;

    // Square-law channel, including reverse conduction. This is not a BSIM model.
    analog function real cpphdl_channel;
        input vgs, vds, beta, threshold, polarity;
        real vgs, vds, beta, threshold, polarity;
        real gate, drain, direction, overdrive, current;
        begin
            gate = polarity * vgs;
            drain = polarity * vds;
            direction = 1.0;
            if (drain < 0.0) begin
                gate = gate - drain;
                drain = -drain;
                direction = -1.0;
            end
            overdrive = gate - threshold;
            current = 0.0;
            if (overdrive > 0.0) begin
                if (drain < overdrive)
                    current = beta * (overdrive * drain - drain * drain / 2.0);
                else
                    current = beta * overdrive * overdrive / 2.0;
            end
            cpphdl_channel = polarity * direction * current;
        end
    endfunction

    analog begin
        // device 0, IC IC2, analog/basic/cmos_logic.hpp:17
        I(cpphdl_n26, Vss) <+ 1.0000000000000001e-09 * ddt(V(cpphdl_n26, Vss)); // Bench initial voltage = 0.0 V.
        // device 1, IC IC2, analog/basic/cmos_logic.hpp:18
        I(cpphdl_n26, Vdd) <+ cpphdl_channel(V(REF, Vdd), V(cpphdl_n26, Vdd), 0.002, 0.34999999999999998, -1.0);
        // device 2, IC IC2, analog/basic/cmos_logic.hpp:19
        I(cpphdl_n26, Vdd) <+ cpphdl_channel(V(OUT, Vdd), V(cpphdl_n26, Vdd), 0.002, 0.34999999999999998, -1.0);
        // device 3, IC IC2, analog/basic/cmos_logic.hpp:20
        I(cpphdl_n26, cpphdl_n16) <+ cpphdl_channel(V(REF, cpphdl_n16), V(cpphdl_n26, cpphdl_n16), 0.002, 0.34999999999999998, 1.0);
        // device 4, IC IC2, analog/basic/cmos_logic.hpp:21
        I(cpphdl_n16, Vss) <+ cpphdl_channel(V(OUT, Vss), V(cpphdl_n16, Vss), 0.002, 0.34999999999999998, 1.0);
        // device 5, IC IC2, analog/basic/cmos_logic.hpp:23
        I(cpphdl_n26, Vss) <+ V(cpphdl_n26, Vss) / 1000000000.0;
        // device 6, IC IC2, analog/basic/cmos_logic.hpp:24
        I(cpphdl_n16, Vss) <+ V(cpphdl_n16, Vss) / 1000000000.0;
        // device 7, IC IC3, analog/basic/cmos_logic.hpp:17
        I(cpphdl_n31, Vss) <+ 1.0000000000000001e-09 * ddt(V(cpphdl_n31, Vss)); // Bench initial voltage = 0.0 V.
        // device 8, IC IC3, analog/basic/cmos_logic.hpp:18
        I(cpphdl_n31, Vdd) <+ cpphdl_channel(V(REF, Vdd), V(cpphdl_n31, Vdd), 0.002, 0.34999999999999998, -1.0);
        // device 9, IC IC3, analog/basic/cmos_logic.hpp:19
        I(cpphdl_n31, Vdd) <+ cpphdl_channel(V(cpphdl_n26, Vdd), V(cpphdl_n31, Vdd), 0.002, 0.34999999999999998, -1.0);
        // device 10, IC IC3, analog/basic/cmos_logic.hpp:20
        I(cpphdl_n31, cpphdl_n22) <+ cpphdl_channel(V(REF, cpphdl_n22), V(cpphdl_n31, cpphdl_n22), 0.002, 0.34999999999999998, 1.0);
        // device 11, IC IC3, analog/basic/cmos_logic.hpp:21
        I(cpphdl_n22, Vss) <+ cpphdl_channel(V(cpphdl_n26, Vss), V(cpphdl_n22, Vss), 0.002, 0.34999999999999998, 1.0);
        // device 12, IC IC3, analog/basic/cmos_logic.hpp:23
        I(cpphdl_n31, Vss) <+ V(cpphdl_n31, Vss) / 1000000000.0;
        // device 13, IC IC3, analog/basic/cmos_logic.hpp:24
        I(cpphdl_n22, Vss) <+ V(cpphdl_n22, Vss) / 1000000000.0;
        // device 14, IC IC4, analog/basic/cmos_logic.hpp:17
        I(cpphdl_n32, Vss) <+ 1.0000000000000001e-09 * ddt(V(cpphdl_n32, Vss)); // Bench initial voltage = 0.0 V.
        // device 15, IC IC4, analog/basic/cmos_logic.hpp:18
        I(cpphdl_n32, Vdd) <+ cpphdl_channel(V(OUT, Vdd), V(cpphdl_n32, Vdd), 0.002, 0.34999999999999998, -1.0);
        // device 16, IC IC4, analog/basic/cmos_logic.hpp:19
        I(cpphdl_n32, Vdd) <+ cpphdl_channel(V(cpphdl_n26, Vdd), V(cpphdl_n32, Vdd), 0.002, 0.34999999999999998, -1.0);
        // device 17, IC IC4, analog/basic/cmos_logic.hpp:20
        I(cpphdl_n32, cpphdl_n28) <+ cpphdl_channel(V(OUT, cpphdl_n28), V(cpphdl_n32, cpphdl_n28), 0.002, 0.34999999999999998, 1.0);
        // device 18, IC IC4, analog/basic/cmos_logic.hpp:21
        I(cpphdl_n28, Vss) <+ cpphdl_channel(V(cpphdl_n26, Vss), V(cpphdl_n28, Vss), 0.002, 0.34999999999999998, 1.0);
        // device 19, IC IC4, analog/basic/cmos_logic.hpp:23
        I(cpphdl_n32, Vss) <+ V(cpphdl_n32, Vss) / 1000000000.0;
        // device 20, IC IC4, analog/basic/cmos_logic.hpp:24
        I(cpphdl_n28, Vss) <+ V(cpphdl_n28, Vss) / 1000000000.0;
        // device 21, IC IC5, analog/basic/cmos_logic.hpp:17
        I(cpphdl_n37, Vss) <+ 1.0000000000000001e-09 * ddt(V(cpphdl_n37, Vss)); // Bench initial voltage = 0.0 V.
        // device 22, IC IC5, analog/basic/cmos_logic.hpp:18
        I(cpphdl_n37, Vdd) <+ cpphdl_channel(V(cpphdl_n31, Vdd), V(cpphdl_n37, Vdd), 0.002, 0.34999999999999998, -1.0);
        // device 23, IC IC5, analog/basic/cmos_logic.hpp:19
        I(cpphdl_n37, Vdd) <+ cpphdl_channel(V(cpphdl_n32, Vdd), V(cpphdl_n37, Vdd), 0.002, 0.34999999999999998, -1.0);
        // device 24, IC IC5, analog/basic/cmos_logic.hpp:20
        I(cpphdl_n37, cpphdl_n34) <+ cpphdl_channel(V(cpphdl_n31, cpphdl_n34), V(cpphdl_n37, cpphdl_n34), 0.002, 0.34999999999999998, 1.0);
        // device 25, IC IC5, analog/basic/cmos_logic.hpp:21
        I(cpphdl_n34, Vss) <+ cpphdl_channel(V(cpphdl_n32, Vss), V(cpphdl_n34, Vss), 0.002, 0.34999999999999998, 1.0);
        // device 26, IC IC5, analog/basic/cmos_logic.hpp:23
        I(cpphdl_n37, Vss) <+ V(cpphdl_n37, Vss) / 1000000000.0;
        // device 27, IC IC5, analog/basic/cmos_logic.hpp:24
        I(cpphdl_n34, Vss) <+ V(cpphdl_n34, Vss) / 1000000000.0;
        // device 28, IC IC6, analog/basic/pll.hpp:16
        I(cpphdl_n37, cpphdl_n60) <+ V(cpphdl_n37, cpphdl_n60) / 10000.0;
        // device 29, IC IC6, analog/basic/pll.hpp:17
        I(cpphdl_n60, cpphdl_n39) <+ 9.9999999999999995e-08 * ddt(V(cpphdl_n60, cpphdl_n39)); // Bench initial voltage = 0.59999999999999998 V.
        // device 30, IC IC6, analog/basic/pll.hpp:18
        I(cpphdl_n39, Vss) <+ V(cpphdl_n39, Vss) / 470.0;
        // device 31, IC IC8, analog/basic/ring_vco.hpp:18
        I(cpphdl_n52, Vdd) <+ cpphdl_channel(V(OUT, Vdd), V(cpphdl_n52, Vdd), 0.001, 0.34999999999999998, -1.0);
        // device 32, IC IC8, analog/basic/ring_vco.hpp:19
        I(cpphdl_n52, cpphdl_n49) <+ cpphdl_channel(V(OUT, cpphdl_n49), V(cpphdl_n52, cpphdl_n49), 0.001, 0.34999999999999998, 1.0);
        // device 33, IC IC8, analog/basic/ring_vco.hpp:20
        I(cpphdl_n49, Vss) <+ cpphdl_channel(V(cpphdl_n60, Vss), V(cpphdl_n49, Vss), 0.001, 0.34999999999999998, 1.0);
        // device 34, IC IC8, analog/basic/ring_vco.hpp:21
        I(cpphdl_n49, Vss) <+ V(cpphdl_n49, Vss) / 1000000000.0;
        // device 35, IC IC8, analog/basic/ring_vco.hpp:22
        I(cpphdl_n52, Vss) <+ 1.0000000000000001e-09 * ddt(V(cpphdl_n52, Vss)); // Bench initial voltage = 0.0 V.
        // device 36, IC IC9, analog/basic/ring_vco.hpp:18
        I(cpphdl_n58, Vdd) <+ cpphdl_channel(V(cpphdl_n52, Vdd), V(cpphdl_n58, Vdd), 0.001, 0.34999999999999998, -1.0);
        // device 37, IC IC9, analog/basic/ring_vco.hpp:19
        I(cpphdl_n58, cpphdl_n55) <+ cpphdl_channel(V(cpphdl_n52, cpphdl_n55), V(cpphdl_n58, cpphdl_n55), 0.001, 0.34999999999999998, 1.0);
        // device 38, IC IC9, analog/basic/ring_vco.hpp:20
        I(cpphdl_n55, Vss) <+ cpphdl_channel(V(cpphdl_n60, Vss), V(cpphdl_n55, Vss), 0.001, 0.34999999999999998, 1.0);
        // device 39, IC IC9, analog/basic/ring_vco.hpp:21
        I(cpphdl_n55, Vss) <+ V(cpphdl_n55, Vss) / 1000000000.0;
        // device 40, IC IC9, analog/basic/ring_vco.hpp:22
        I(cpphdl_n58, Vss) <+ 1.0000000000000001e-09 * ddt(V(cpphdl_n58, Vss)); // Bench initial voltage = 0.0 V.
        // device 41, IC IC10, analog/basic/ring_vco.hpp:18
        I(OUT, Vdd) <+ cpphdl_channel(V(cpphdl_n58, Vdd), V(OUT, Vdd), 0.001, 0.34999999999999998, -1.0);
        // device 42, IC IC10, analog/basic/ring_vco.hpp:19
        I(OUT, cpphdl_n61) <+ cpphdl_channel(V(cpphdl_n58, cpphdl_n61), V(OUT, cpphdl_n61), 0.001, 0.34999999999999998, 1.0);
        // device 43, IC IC10, analog/basic/ring_vco.hpp:20
        I(cpphdl_n61, Vss) <+ cpphdl_channel(V(cpphdl_n60, Vss), V(cpphdl_n61, Vss), 0.001, 0.34999999999999998, 1.0);
        // device 44, IC IC10, analog/basic/ring_vco.hpp:21
        I(cpphdl_n61, Vss) <+ V(cpphdl_n61, Vss) / 1000000000.0;
        // device 45, IC IC10, analog/basic/ring_vco.hpp:22
        I(OUT, Vss) <+ 1.0000000000000001e-09 * ddt(V(OUT, Vss)); // Bench initial voltage = 0.0 V.
    end
endmodule
